* NGSPICE file created from neuron_ctrl.ext - technology: gf180mcuD

* Black-box entry subcircuit for gf180mcu_fd_sc_mcu7t5v0__endcap abstract view
.subckt gf180mcu_fd_sc_mcu7t5v0__endcap VDD VSS
.ends

* Black-box entry subcircuit for gf180mcu_fd_sc_mcu7t5v0__filltie abstract view
.subckt gf180mcu_fd_sc_mcu7t5v0__filltie VDD VSS
.ends

* Black-box entry subcircuit for gf180mcu_fd_sc_mcu7t5v0__aoi22_1 abstract view
.subckt gf180mcu_fd_sc_mcu7t5v0__aoi22_1 A1 A2 B1 B2 ZN VDD VNW VPW VSS
.ends

* Black-box entry subcircuit for gf180mcu_fd_sc_mcu7t5v0__nor2_1 abstract view
.subckt gf180mcu_fd_sc_mcu7t5v0__nor2_1 A1 A2 ZN VDD VNW VPW VSS
.ends

* Black-box entry subcircuit for gf180mcu_fd_sc_mcu7t5v0__nand3_1 abstract view
.subckt gf180mcu_fd_sc_mcu7t5v0__nand3_1 A1 A2 A3 ZN VDD VNW VPW VSS
.ends

* Black-box entry subcircuit for gf180mcu_fd_sc_mcu7t5v0__fill_2 abstract view
.subckt gf180mcu_fd_sc_mcu7t5v0__fill_2 VDD VNW VPW VSS
.ends

* Black-box entry subcircuit for gf180mcu_fd_sc_mcu7t5v0__nand2_1 abstract view
.subckt gf180mcu_fd_sc_mcu7t5v0__nand2_1 A1 A2 ZN VDD VNW VPW VSS
.ends

* Black-box entry subcircuit for gf180mcu_fd_sc_mcu7t5v0__or2_1 abstract view
.subckt gf180mcu_fd_sc_mcu7t5v0__or2_1 A1 A2 Z VDD VNW VPW VSS
.ends

* Black-box entry subcircuit for gf180mcu_fd_sc_mcu7t5v0__clkinv_1 abstract view
.subckt gf180mcu_fd_sc_mcu7t5v0__clkinv_1 I ZN VDD VNW VPW VSS
.ends

* Black-box entry subcircuit for gf180mcu_fd_sc_mcu7t5v0__latrnq_1 abstract view
.subckt gf180mcu_fd_sc_mcu7t5v0__latrnq_1 D E RN Q VDD VNW VPW VSS
.ends

* Black-box entry subcircuit for gf180mcu_fd_sc_mcu7t5v0__dffrnq_1 abstract view
.subckt gf180mcu_fd_sc_mcu7t5v0__dffrnq_1 D RN CLK Q VDD VNW VPW VSS
.ends

* Black-box entry subcircuit for gf180mcu_fd_sc_mcu7t5v0__buf_4 abstract view
.subckt gf180mcu_fd_sc_mcu7t5v0__buf_4 I Z VDD VNW VPW VSS
.ends

* Black-box entry subcircuit for gf180mcu_fd_sc_mcu7t5v0__fill_1 abstract view
.subckt gf180mcu_fd_sc_mcu7t5v0__fill_1 VDD VNW VPW VSS
.ends

* Black-box entry subcircuit for gf180mcu_fd_sc_mcu7t5v0__tiel abstract view
.subckt gf180mcu_fd_sc_mcu7t5v0__tiel ZN VDD VNW VPW VSS
.ends

* Black-box entry subcircuit for gf180mcu_fd_sc_mcu7t5v0__tieh abstract view
.subckt gf180mcu_fd_sc_mcu7t5v0__tieh Z VDD VNW VPW VSS
.ends

* Black-box entry subcircuit for gf180mcu_fd_sc_mcu7t5v0__dlyc_1 abstract view
.subckt gf180mcu_fd_sc_mcu7t5v0__dlyc_1 I Z VDD VNW VPW VSS
.ends

* Black-box entry subcircuit for gf180mcu_fd_sc_mcu7t5v0__aoi211_1 abstract view
.subckt gf180mcu_fd_sc_mcu7t5v0__aoi211_1 A1 A2 B C ZN VDD VNW VPW VSS
.ends

* Black-box entry subcircuit for gf180mcu_fd_sc_mcu7t5v0__dffq_1 abstract view
.subckt gf180mcu_fd_sc_mcu7t5v0__dffq_1 D CLK Q VDD VNW VPW VSS
.ends

* Black-box entry subcircuit for gf180mcu_fd_sc_mcu7t5v0__aoi21_1 abstract view
.subckt gf180mcu_fd_sc_mcu7t5v0__aoi21_1 A1 A2 B ZN VDD VNW VPW VSS
.ends

* Black-box entry subcircuit for gf180mcu_fd_sc_mcu7t5v0__and2_1 abstract view
.subckt gf180mcu_fd_sc_mcu7t5v0__and2_1 A1 A2 Z VDD VNW VPW VSS
.ends

* Black-box entry subcircuit for gf180mcu_fd_sc_mcu7t5v0__buf_8 abstract view
.subckt gf180mcu_fd_sc_mcu7t5v0__buf_8 I Z VDD VNW VPW VSS
.ends

* Black-box entry subcircuit for gf180mcu_fd_sc_mcu7t5v0__aoi221_1 abstract view
.subckt gf180mcu_fd_sc_mcu7t5v0__aoi221_1 A1 A2 B1 B2 C ZN VDD VNW VPW VSS
.ends

* Black-box entry subcircuit for gf180mcu_fd_sc_mcu7t5v0__clkbuf_4 abstract view
.subckt gf180mcu_fd_sc_mcu7t5v0__clkbuf_4 I Z VDD VNW VPW VSS
.ends

* Black-box entry subcircuit for gf180mcu_fd_sc_mcu7t5v0__oai211_1 abstract view
.subckt gf180mcu_fd_sc_mcu7t5v0__oai211_1 A1 A2 B C ZN VDD VNW VPW VSS
.ends

* Black-box entry subcircuit for gf180mcu_fd_sc_mcu7t5v0__nor3_1 abstract view
.subckt gf180mcu_fd_sc_mcu7t5v0__nor3_1 A1 A2 A3 ZN VDD VNW VPW VSS
.ends

* Black-box entry subcircuit for gf180mcu_fd_sc_mcu7t5v0__fillcap_4 abstract view
.subckt gf180mcu_fd_sc_mcu7t5v0__fillcap_4 VDD VNW VPW VSS
.ends

* Black-box entry subcircuit for gf180mcu_fd_sc_mcu7t5v0__fillcap_8 abstract view
.subckt gf180mcu_fd_sc_mcu7t5v0__fillcap_8 VDD VNW VPW VSS
.ends

* Black-box entry subcircuit for gf180mcu_fd_sc_mcu7t5v0__oai21_1 abstract view
.subckt gf180mcu_fd_sc_mcu7t5v0__oai21_1 A1 A2 B ZN VDD VNW VPW VSS
.ends

* Black-box entry subcircuit for gf180mcu_fd_sc_mcu7t5v0__buf_12 abstract view
.subckt gf180mcu_fd_sc_mcu7t5v0__buf_12 I Z VDD VNW VPW VSS
.ends

* Black-box entry subcircuit for gf180mcu_fd_sc_mcu7t5v0__inv_3 abstract view
.subckt gf180mcu_fd_sc_mcu7t5v0__inv_3 I ZN VDD VNW VPW VSS
.ends

* Black-box entry subcircuit for gf180mcu_fd_sc_mcu7t5v0__mux2_2 abstract view
.subckt gf180mcu_fd_sc_mcu7t5v0__mux2_2 I0 I1 S Z VDD VNW VPW VSS
.ends

* Black-box entry subcircuit for gf180mcu_fd_sc_mcu7t5v0__clkbuf_2 abstract view
.subckt gf180mcu_fd_sc_mcu7t5v0__clkbuf_2 I Z VDD VNW VPW VSS
.ends

* Black-box entry subcircuit for gf180mcu_fd_sc_mcu7t5v0__oai22_1 abstract view
.subckt gf180mcu_fd_sc_mcu7t5v0__oai22_1 A1 A2 B1 B2 ZN VDD VNW VPW VSS
.ends

* Black-box entry subcircuit for gf180mcu_fd_sc_mcu7t5v0__oai221_1 abstract view
.subckt gf180mcu_fd_sc_mcu7t5v0__oai221_1 A1 A2 B1 B2 C ZN VDD VNW VPW VSS
.ends

* Black-box entry subcircuit for gf180mcu_fd_sc_mcu7t5v0__nand4_1 abstract view
.subckt gf180mcu_fd_sc_mcu7t5v0__nand4_1 A1 A2 A3 A4 ZN VDD VNW VPW VSS
.ends

* Black-box entry subcircuit for gf180mcu_fd_sc_mcu7t5v0__xor2_1 abstract view
.subckt gf180mcu_fd_sc_mcu7t5v0__xor2_1 A1 A2 Z VDD VNW VPW VSS
.ends

* Black-box entry subcircuit for gf180mcu_fd_sc_mcu7t5v0__fillcap_32 abstract view
.subckt gf180mcu_fd_sc_mcu7t5v0__fillcap_32 VDD VNW VPW VSS
.ends

* Black-box entry subcircuit for gf180mcu_fd_sc_mcu7t5v0__fillcap_16 abstract view
.subckt gf180mcu_fd_sc_mcu7t5v0__fillcap_16 VDD VNW VPW VSS
.ends

* Black-box entry subcircuit for gf180mcu_fd_sc_mcu7t5v0__oai32_1 abstract view
.subckt gf180mcu_fd_sc_mcu7t5v0__oai32_1 A1 A2 A3 B1 B2 ZN VDD VNW VPW VSS
.ends

* Black-box entry subcircuit for gf180mcu_fd_sc_mcu7t5v0__nor4_1 abstract view
.subckt gf180mcu_fd_sc_mcu7t5v0__nor4_1 A1 A2 A3 A4 ZN VDD VNW VPW VSS
.ends

* Black-box entry subcircuit for gf180mcu_fd_sc_mcu7t5v0__buf_1 abstract view
.subckt gf180mcu_fd_sc_mcu7t5v0__buf_1 I Z VDD VNW VPW VSS
.ends

* Black-box entry subcircuit for gf180mcu_fd_sc_mcu7t5v0__oai31_1 abstract view
.subckt gf180mcu_fd_sc_mcu7t5v0__oai31_1 A1 A2 A3 B ZN VDD VNW VPW VSS
.ends

* Black-box entry subcircuit for gf180mcu_fd_sc_mcu7t5v0__clkbuf_3 abstract view
.subckt gf180mcu_fd_sc_mcu7t5v0__clkbuf_3 I Z VDD VNW VPW VSS
.ends

* Black-box entry subcircuit for gf180mcu_fd_sc_mcu7t5v0__dffsnq_1 abstract view
.subckt gf180mcu_fd_sc_mcu7t5v0__dffsnq_1 D SETN CLK Q VDD VNW VPW VSS
.ends

* Black-box entry subcircuit for gf180mcu_fd_sc_mcu7t5v0__or3_1 abstract view
.subckt gf180mcu_fd_sc_mcu7t5v0__or3_1 A1 A2 A3 Z VDD VNW VPW VSS
.ends

* Black-box entry subcircuit for gf180mcu_fd_sc_mcu7t5v0__dffrnq_2 abstract view
.subckt gf180mcu_fd_sc_mcu7t5v0__dffrnq_2 D RN CLK Q VDD VNW VPW VSS
.ends

* Black-box entry subcircuit for gf180mcu_fd_sc_mcu7t5v0__and3_1 abstract view
.subckt gf180mcu_fd_sc_mcu7t5v0__and3_1 A1 A2 A3 Z VDD VNW VPW VSS
.ends

* Black-box entry subcircuit for gf180mcu_fd_sc_mcu7t5v0__icgtp_1 abstract view
.subckt gf180mcu_fd_sc_mcu7t5v0__icgtp_1 CLK E TE Q VDD VNW VPW VSS
.ends

* Black-box entry subcircuit for gf180mcu_fd_sc_mcu7t5v0__or4_1 abstract view
.subckt gf180mcu_fd_sc_mcu7t5v0__or4_1 A1 A2 A3 A4 Z VDD VNW VPW VSS
.ends

* Black-box entry subcircuit for gf180mcu_fd_sc_mcu7t5v0__xor3_1 abstract view
.subckt gf180mcu_fd_sc_mcu7t5v0__xor3_1 A1 A2 A3 Z VDD VNW VPW VSS
.ends

* Black-box entry subcircuit for gf180mcu_fd_sc_mcu7t5v0__xnor2_1 abstract view
.subckt gf180mcu_fd_sc_mcu7t5v0__xnor2_1 A1 A2 ZN VDD VNW VPW VSS
.ends

.subckt neuron_ctrl VDD VSS bias_en cfg_out[0] cfg_out[10] cfg_out[11] cfg_out[12]
+ cfg_out[13] cfg_out[14] cfg_out[15] cfg_out[16] cfg_out[17] cfg_out[18] cfg_out[19]
+ cfg_out[1] cfg_out[20] cfg_out[21] cfg_out[22] cfg_out[23] cfg_out[24] cfg_out[25]
+ cfg_out[26] cfg_out[27] cfg_out[28] cfg_out[29] cfg_out[2] cfg_out[30] cfg_out[31]
+ cfg_out[32] cfg_out[33] cfg_out[34] cfg_out[35] cfg_out[36] cfg_out[37] cfg_out[38]
+ cfg_out[39] cfg_out[3] cfg_out[40] cfg_out[41] cfg_out[42] cfg_out[43] cfg_out[44]
+ cfg_out[45] cfg_out[46] cfg_out[47] cfg_out[48] cfg_out[49] cfg_out[4] cfg_out[50]
+ cfg_out[51] cfg_out[52] cfg_out[53] cfg_out[54] cfg_out[55] cfg_out[56] cfg_out[57]
+ cfg_out[58] cfg_out[59] cfg_out[5] cfg_out[60] cfg_out[61] cfg_out[62] cfg_out[63]
+ cfg_out[64] cfg_out[65] cfg_out[66] cfg_out[67] cfg_out[68] cfg_out[69] cfg_out[6]
+ cfg_out[70] cfg_out[7] cfg_out[8] cfg_out[9] clk i0_b0 i0_b1 i0_b2 i0_b3 i0_b4 i1_b0
+ i1_b1 i1_b2 i1_b3 i1_b4 i2_b0 i2_b1 i2_b2 i2_b3 i2_b4 i3_b0 i3_b1 i3_b2 i3_b3 i3_b4
+ i4_b0 i4_b1 i4_b2 i4_b3 i4_b4 ib_x2 probe_en_c4 probe_en_c[0] probe_en_c[1] probe_en_c[2]
+ probe_en_c[3] probe_rsel[0] probe_rsel[1] probe_rsel[2] probe_rsel[3] probe_sel_adex
+ probe_sel_bay[0] probe_sel_bay[1] probe_sel_bay[2] probe_sel_d1 probe_sub probe_sub_b
+ probe_sub_raw[0] probe_sub_raw[1] r0_b0 r0_b1 r0_b2 r0_b3 r0_b4 r1_b0 r1_b1 r1_b2
+ r1_b3 r1_b4 r2_b0 r2_b1 r2_b2 r2_b3 r2_b4 rst_n rt_out[0] rt_out[1] rt_out[2] rt_out[3]
+ spk_in[0] spk_in[10] spk_in[11] spk_in[12] spk_in[13] spk_in[14] spk_in[15] spk_in[16]
+ spk_in[17] spk_in[18] spk_in[19] spk_in[1] spk_in[20] spk_in[21] spk_in[22] spk_in[23]
+ spk_in[2] spk_in[3] spk_in[4] spk_in[5] spk_in[6] spk_in[7] spk_in[8] spk_in[9]
+ ua0_int ua0_s0 ua0_s1 ua0_stim ui_in[0] ui_in[1] ui_in[2] ui_in[3] ui_in[4] ui_in[5]
+ ui_in[6] ui_in[7] uio_in[0] uio_in[1] uio_in[2] uio_in[3] uio_in[4] uio_in[5] uio_in[6]
+ uio_in[7] uio_oe[0] uio_oe[1] uio_oe[2] uio_oe[3] uio_oe[4] uio_oe[5] uio_oe[6]
+ uio_oe[7] uio_out[0] uio_out[1] uio_out[2] uio_out[3] uio_out[4] uio_out[5] uio_out[6]
+ uio_out[7] uo_out[0] uo_out[1] uo_out[2] uo_out[3] uo_out[4] uo_out[5] uo_out[6]
+ uo_out[7] v0_c0 v0_c1 v0_c2 v0_c3 v0_c4 v0_c5
XPHY_EDGE_ROW_21_Left_59 VDD VSS gf180mcu_fd_sc_mcu7t5v0__endcap
XPHY_EDGE_ROW_37_Left_75 VDD VSS gf180mcu_fd_sc_mcu7t5v0__endcap
XTAP_TAPCELL_ROW_23_172 VDD VSS gf180mcu_fd_sc_mcu7t5v0__filltie
X_363_ probe_sub_raw[1] probe_sub _376_/B2 _363_/B2 _404_/A3 VDD VDD VSS VSS gf180mcu_fd_sc_mcu7t5v0__aoi22_1
X_432_ _440_/A2 _430_/Z _432_/ZN VDD VDD VSS VSS gf180mcu_fd_sc_mcu7t5v0__nor2_1
X_501_ _500_/B _501_/A2 _501_/A3 _625_/B VDD VDD VSS VSS gf180mcu_fd_sc_mcu7t5v0__nand3_1
XTAP_TAPCELL_ROW_37_231 VDD VSS gf180mcu_fd_sc_mcu7t5v0__filltie
XTAP_TAPCELL_ROW_6_107 VDD VSS gf180mcu_fd_sc_mcu7t5v0__filltie
XFILLER_6_107 VDD VDD VSS VSS gf180mcu_fd_sc_mcu7t5v0__fill_2
X_346_ _659_/Q _658_/Q _645_/B VDD VDD VSS VSS gf180mcu_fd_sc_mcu7t5v0__nand2_1
X_415_ _415_/A1 _414_/Z _415_/Z VDD VDD VSS VSS gf180mcu_fd_sc_mcu7t5v0__or2_1
XPHY_EDGE_ROW_24_Left_62 VDD VSS gf180mcu_fd_sc_mcu7t5v0__endcap
XTAP_TAPCELL_ROW_31_204 VDD VSS gf180mcu_fd_sc_mcu7t5v0__filltie
X_329_ _705_/Q _531_/A1 VDD VDD VSS VSS gf180mcu_fd_sc_mcu7t5v0__clkinv_1
Xg_reg\[8\].g_bit\[1\].genblk1.g_l.genblk1.g_d.u_l _710_/D _434_/ZN l_v0_c5/RN _353_/A1
+ VDD VDD VSS VSS gf180mcu_fd_sc_mcu7t5v0__latrnq_1
X_680_ _680_/D _698_/RN _698_/CLK _680_/Q VDD VDD VSS VSS gf180mcu_fd_sc_mcu7t5v0__dffrnq_1
Xload_slew30 _707_/Q _724_/RN VDD VDD VSS VSS gf180mcu_fd_sc_mcu7t5v0__buf_4
XFILLER_20_32 VDD VDD VSS VSS gf180mcu_fd_sc_mcu7t5v0__fill_2
XFILLER_20_43 VDD VDD VSS VSS gf180mcu_fd_sc_mcu7t5v0__fill_1
X_594_ _677_/Q _597_/A3 _632_/A1 VDD VDD VSS VSS gf180mcu_fd_sc_mcu7t5v0__nor2_1
Xneuron_ctrl_43 cfg_out[45] VDD VDD VSS VSS gf180mcu_fd_sc_mcu7t5v0__tiel
Xneuron_ctrl_54 cfg_out[56] VDD VDD VSS VSS gf180mcu_fd_sc_mcu7t5v0__tiel
Xneuron_ctrl_65 uio_oe[3] VDD VDD VSS VSS gf180mcu_fd_sc_mcu7t5v0__tieh
Xhold85 _684_/Q _683_/D VDD VDD VSS VSS gf180mcu_fd_sc_mcu7t5v0__dlyc_1
Xhold74 _685_/Q _684_/D VDD VDD VSS VSS gf180mcu_fd_sc_mcu7t5v0__dlyc_1
X_663_ _663_/D _677_/RN _705_/CLK _663_/Q VDD VDD VSS VSS gf180mcu_fd_sc_mcu7t5v0__dffrnq_1
XFILLER_25_142 VDD VDD VSS VSS gf180mcu_fd_sc_mcu7t5v0__fill_1
X_577_ _327_/I _631_/C _577_/B _577_/C _578_/B VDD VDD VSS VSS gf180mcu_fd_sc_mcu7t5v0__aoi211_1
X_715_ _715_/D _715_/CLK _716_/D VDD VDD VSS VSS gf180mcu_fd_sc_mcu7t5v0__dffq_1
X_646_ _646_/A1 _646_/A2 _647_/A2 VDD VDD VSS VSS gf180mcu_fd_sc_mcu7t5v0__nor2_1
XTAP_TAPCELL_ROW_9_116 VDD VSS gf180mcu_fd_sc_mcu7t5v0__filltie
XTAP_TAPCELL_ROW_23_173 VDD VSS gf180mcu_fd_sc_mcu7t5v0__filltie
X_362_ _362_/A1 _404_/A2 _371_/B _363_/B2 VDD VDD VSS VSS gf180mcu_fd_sc_mcu7t5v0__aoi21_1
X_431_ _439_/A2 _430_/Z _431_/ZN VDD VDD VSS VSS gf180mcu_fd_sc_mcu7t5v0__nor2_1
X_500_ _501_/A2 _501_/A3 _500_/B _625_/A2 VDD VDD VSS VSS gf180mcu_fd_sc_mcu7t5v0__aoi21_1
X_706__61 _706_/D VDD VDD VSS VSS gf180mcu_fd_sc_mcu7t5v0__tieh
X_629_ _629_/A1 _629_/A2 _629_/B1 _629_/B2 _676_/D VDD VDD VSS VSS gf180mcu_fd_sc_mcu7t5v0__aoi22_1
XFILLER_10_115 VDD VDD VSS VSS gf180mcu_fd_sc_mcu7t5v0__fill_1
XTAP_TAPCELL_ROW_37_232 VDD VSS gf180mcu_fd_sc_mcu7t5v0__filltie
XFILLER_26_281 VDD VDD VSS VSS gf180mcu_fd_sc_mcu7t5v0__fill_1
X_345_ _659_/Q _658_/Q _653_/C VDD VDD VSS VSS gf180mcu_fd_sc_mcu7t5v0__and2_1
X_414_ _719_/D _720_/D _414_/Z VDD VDD VSS VSS gf180mcu_fd_sc_mcu7t5v0__or2_1
XFILLER_15_207 VDD VDD VSS VSS gf180mcu_fd_sc_mcu7t5v0__fill_2
XPHY_EDGE_ROW_12_Right_12 VDD VSS gf180mcu_fd_sc_mcu7t5v0__endcap
XPHY_EDGE_ROW_21_Right_21 VDD VSS gf180mcu_fd_sc_mcu7t5v0__endcap
XFILLER_3_2 VDD VDD VSS VSS gf180mcu_fd_sc_mcu7t5v0__fill_2
XPHY_EDGE_ROW_30_Right_30 VDD VSS gf180mcu_fd_sc_mcu7t5v0__endcap
XTAP_TAPCELL_ROW_31_205 VDD VSS gf180mcu_fd_sc_mcu7t5v0__filltie
X_328_ _672_/Q _607_/A1 VDD VDD VSS VSS gf180mcu_fd_sc_mcu7t5v0__clkinv_1
XFILLER_36_2 VDD VDD VSS VSS gf180mcu_fd_sc_mcu7t5v0__fill_1
XFILLER_7_214 VDD VDD VSS VSS gf180mcu_fd_sc_mcu7t5v0__fill_1
Xg_reg\[11\].g_bit\[2\].genblk1.g_l.genblk1.g_d.u_l _711_/D _431_/ZN load_slew33/Z
+ _496_/B VDD VDD VSS VSS gf180mcu_fd_sc_mcu7t5v0__latrnq_1
Xload_slew31 _707_/RN load_slew31/Z VDD VDD VSS VSS gf180mcu_fd_sc_mcu7t5v0__buf_8
Xneuron_ctrl_44 cfg_out[46] VDD VDD VSS VSS gf180mcu_fd_sc_mcu7t5v0__tiel
Xneuron_ctrl_55 cfg_out[57] VDD VDD VSS VSS gf180mcu_fd_sc_mcu7t5v0__tiel
Xneuron_ctrl_66 uio_oe[4] VDD VDD VSS VSS gf180mcu_fd_sc_mcu7t5v0__tieh
Xhold86 _655_/Q _693_/D VDD VDD VSS VSS gf180mcu_fd_sc_mcu7t5v0__dlyc_1
Xhold75 _691_/Q _690_/D VDD VDD VSS VSS gf180mcu_fd_sc_mcu7t5v0__dlyc_1
X_662_ _662_/D _677_/RN _705_/CLK _662_/Q VDD VDD VSS VSS gf180mcu_fd_sc_mcu7t5v0__dffrnq_1
X_593_ _593_/A1 _593_/A2 _593_/B1 _593_/B2 _593_/C _597_/A3 VDD VDD VSS VSS gf180mcu_fd_sc_mcu7t5v0__aoi221_1
Xclkbuf_1_1__f_u_lif.d_clk clkbuf_0_u_lif.d_clk/Z _693_/CLK VDD VDD VSS VSS gf180mcu_fd_sc_mcu7t5v0__clkbuf_4
XPHY_EDGE_ROW_6_Right_6 VDD VSS gf180mcu_fd_sc_mcu7t5v0__endcap
X_576_ _576_/A1 _576_/A2 _577_/C VDD VDD VSS VSS gf180mcu_fd_sc_mcu7t5v0__nor2_1
X_714_ _714_/D _720_/CLK _715_/D VDD VDD VSS VSS gf180mcu_fd_sc_mcu7t5v0__dffq_1
X_645_ _656_/Q _645_/A2 _645_/B _657_/Q _646_/A2 VDD VDD VSS VSS gf180mcu_fd_sc_mcu7t5v0__oai211_1
Xg_reg\[15\].g_bit\[1\].genblk1.g_l.g_c.u_l _710_/D _423_/ZN load_slew31/Z cfg_out[8]
+ VDD VDD VSS VSS gf180mcu_fd_sc_mcu7t5v0__latrnq_1
XFILLER_26_32 VDD VDD VSS VSS gf180mcu_fd_sc_mcu7t5v0__fill_2
XTAP_TAPCELL_ROW_23_174 VDD VSS gf180mcu_fd_sc_mcu7t5v0__filltie
XTAP_TAPCELL_ROW_9_117 VDD VSS gf180mcu_fd_sc_mcu7t5v0__filltie
X_361_ _306_/I _373_/B _404_/A2 VDD VDD VSS VSS gf180mcu_fd_sc_mcu7t5v0__nor2_1
X_430_ _719_/D _430_/A2 _430_/Z VDD VDD VSS VSS gf180mcu_fd_sc_mcu7t5v0__or2_1
Xg_reg\[10\].g_bit\[5\].genblk1.g_l.genblk1.g_d.u_l _714_/D _432_/ZN _707_/RN _611_/A2
+ VDD VDD VSS VSS gf180mcu_fd_sc_mcu7t5v0__latrnq_1
X_559_ _496_/B _631_/C _577_/B _559_/C _560_/B VDD VDD VSS VSS gf180mcu_fd_sc_mcu7t5v0__aoi211_1
X_628_ _479_/C _629_/A2 _628_/A3 _629_/B2 VDD VDD VSS VSS gf180mcu_fd_sc_mcu7t5v0__nor3_1
XFILLER_12_34 VDD VDD VSS VSS gf180mcu_fd_sc_mcu7t5v0__fill_1
XTAP_TAPCELL_ROW_37_233 VDD VSS gf180mcu_fd_sc_mcu7t5v0__filltie
XFILLER_33_208 VDD VDD VSS VSS gf180mcu_fd_sc_mcu7t5v0__fill_2
X_344_ _723_/Q _723_/D _631_/C VDD VDD VSS VSS gf180mcu_fd_sc_mcu7t5v0__nand2_1
X_413_ _438_/A1 _415_/A1 _417_/A1 _413_/ZN VDD VDD VSS VSS gf180mcu_fd_sc_mcu7t5v0__nor3_1
XFILLER_23_66 VDD VDD VSS VSS gf180mcu_fd_sc_mcu7t5v0__fillcap_4
XFILLER_23_88 VDD VDD VSS VSS gf180mcu_fd_sc_mcu7t5v0__fillcap_8
XTAP_TAPCELL_ROW_31_206 VDD VSS gf180mcu_fd_sc_mcu7t5v0__filltie
XFILLER_29_2 VDD VDD VSS VSS gf180mcu_fd_sc_mcu7t5v0__fill_2
XTAP_TAPCELL_ROW_0_80 VDD VSS gf180mcu_fd_sc_mcu7t5v0__filltie
X_327_ _327_/I _490_/A2 VDD VDD VSS VSS gf180mcu_fd_sc_mcu7t5v0__clkinv_1
XFILLER_6_281 VDD VDD VSS VSS gf180mcu_fd_sc_mcu7t5v0__fill_1
Xload_slew32 l_r1_b1/RN l_r0_b4/RN VDD VDD VSS VSS gf180mcu_fd_sc_mcu7t5v0__buf_8
XFILLER_20_34 VDD VDD VSS VSS gf180mcu_fd_sc_mcu7t5v0__fill_1
XFILLER_29_98 VDD VDD VSS VSS gf180mcu_fd_sc_mcu7t5v0__fill_2
X_592_ _524_/C _678_/Q _593_/C VDD VDD VSS VSS gf180mcu_fd_sc_mcu7t5v0__nand2_1
Xneuron_ctrl_45 cfg_out[47] VDD VDD VSS VSS gf180mcu_fd_sc_mcu7t5v0__tiel
Xneuron_ctrl_56 cfg_out[58] VDD VDD VSS VSS gf180mcu_fd_sc_mcu7t5v0__tiel
Xneuron_ctrl_67 uio_oe[5] VDD VDD VSS VSS gf180mcu_fd_sc_mcu7t5v0__tieh
Xhold76 _687_/Q _686_/D VDD VDD VSS VSS gf180mcu_fd_sc_mcu7t5v0__dlyc_1
X_661_ _661_/D _677_/RN _705_/CLK _661_/Q VDD VDD VSS VSS gf180mcu_fd_sc_mcu7t5v0__dffrnq_1
Xg_reg\[6\].g_bit\[2\].genblk1.g_l.g_c.u_l _711_/D _436_/ZN l_r0_b4/RN cfg_out[2]
+ VDD VDD VSS VSS gf180mcu_fd_sc_mcu7t5v0__latrnq_1
X_575_ _575_/A1 _444_/Z _622_/C _576_/A2 VDD VDD VSS VSS gf180mcu_fd_sc_mcu7t5v0__oai21_1
Xl_r0_b0 _710_/D _439_/ZN l_r1_b1/RN r0_b0 VDD VDD VSS VSS gf180mcu_fd_sc_mcu7t5v0__latrnq_1
X_713_ _713_/D _720_/CLK _714_/D VDD VDD VSS VSS gf180mcu_fd_sc_mcu7t5v0__dffq_1
X_644_ _644_/A1 _644_/A2 _646_/A1 VDD VDD VSS VSS gf180mcu_fd_sc_mcu7t5v0__nor2_1
XFILLER_11_2 VDD VDD VSS VSS gf180mcu_fd_sc_mcu7t5v0__fill_2
XTAP_TAPCELL_ROW_17_150 VDD VSS gf180mcu_fd_sc_mcu7t5v0__filltie
XFILLER_13_125 VDD VDD VSS VSS gf180mcu_fd_sc_mcu7t5v0__fill_2
XTAP_TAPCELL_ROW_23_175 VDD VSS gf180mcu_fd_sc_mcu7t5v0__filltie
XTAP_TAPCELL_ROW_9_118 VDD VSS gf180mcu_fd_sc_mcu7t5v0__filltie
X_360_ _407_/A1 _406_/A2 _362_/A1 VDD VDD VSS VSS gf180mcu_fd_sc_mcu7t5v0__nor2_1
X_489_ _657_/Q _645_/B _643_/B1 _572_/A1 _489_/C _492_/A1 VDD VDD VSS VSS gf180mcu_fd_sc_mcu7t5v0__aoi221_1
X_558_ _558_/A1 _558_/A2 _559_/C VDD VDD VSS VSS gf180mcu_fd_sc_mcu7t5v0__nor2_1
X_627_ _629_/A1 _627_/A2 _627_/B _628_/A3 VDD VDD VSS VSS gf180mcu_fd_sc_mcu7t5v0__aoi21_1
XFILLER_12_24 VDD VDD VSS VSS gf180mcu_fd_sc_mcu7t5v0__fill_2
XTAP_TAPCELL_ROW_37_234 VDD VSS gf180mcu_fd_sc_mcu7t5v0__filltie
XFILLER_37_10 VDD VDD VSS VSS gf180mcu_fd_sc_mcu7t5v0__fill_2
X_343_ _723_/Q _723_/D _622_/C VDD VDD VSS VSS gf180mcu_fd_sc_mcu7t5v0__and2_1
X_412_ _428_/A1 _718_/D _417_/A1 VDD VDD VSS VSS gf180mcu_fd_sc_mcu7t5v0__nand2_1
Xg_reg\[16\].g_bit\[2\].genblk1.g_l.g_c.u_l _711_/D _419_/ZN load_slew31/Z cfg_out[17]
+ VDD VDD VSS VSS gf180mcu_fd_sc_mcu7t5v0__latrnq_1
Xg_reg\[22\].g_bit\[3\].genblk1.g_l.g_c.u_l _712_/D _413_/ZN l_r0_b4/RN cfg_out[66]
+ VDD VDD VSS VSS gf180mcu_fd_sc_mcu7t5v0__latrnq_1
XFILLER_15_209 VDD VDD VSS VSS gf180mcu_fd_sc_mcu7t5v0__fill_1
XFILLER_23_45 VDD VDD VSS VSS gf180mcu_fd_sc_mcu7t5v0__fill_2
XFILLER_9_69 VDD VDD VSS VSS gf180mcu_fd_sc_mcu7t5v0__fill_1
XTAP_TAPCELL_ROW_0_81 VDD VSS gf180mcu_fd_sc_mcu7t5v0__filltie
XTAP_TAPCELL_ROW_31_207 VDD VSS gf180mcu_fd_sc_mcu7t5v0__filltie
X_326_ _326_/I _490_/B2 VDD VDD VSS VSS gf180mcu_fd_sc_mcu7t5v0__clkinv_1
XFILLER_18_34 VDD VDD VSS VSS gf180mcu_fd_sc_mcu7t5v0__fill_1
XFILLER_34_66 VDD VDD VSS VSS gf180mcu_fd_sc_mcu7t5v0__fill_2
Xg_reg\[14\].g_bit\[0\].genblk1.g_l.genblk1.g_d.u_l _709_/D _425_/ZN l_v0_c5/RN _588_/A1
+ VDD VDD VSS VSS gf180mcu_fd_sc_mcu7t5v0__latrnq_1
XFILLER_11_234 VDD VDD VSS VSS gf180mcu_fd_sc_mcu7t5v0__fill_2
XPHY_EDGE_ROW_28_Left_66 VDD VSS gf180mcu_fd_sc_mcu7t5v0__endcap
X_309_ _371_/B _372_/A1 VDD VDD VSS VSS gf180mcu_fd_sc_mcu7t5v0__clkinv_1
Xload_slew33 l_r1_b1/RN load_slew33/Z VDD VDD VSS VSS gf180mcu_fd_sc_mcu7t5v0__buf_12
X_591_ _591_/A1 _591_/A2 _641_/B _593_/B2 VDD VDD VSS VSS gf180mcu_fd_sc_mcu7t5v0__aoi21_1
Xneuron_ctrl_46 cfg_out[48] VDD VDD VSS VSS gf180mcu_fd_sc_mcu7t5v0__tiel
Xneuron_ctrl_57 cfg_out[59] VDD VDD VSS VSS gf180mcu_fd_sc_mcu7t5v0__tiel
Xneuron_ctrl_68 uio_oe[6] VDD VDD VSS VSS gf180mcu_fd_sc_mcu7t5v0__tieh
Xhold77 _706_/Q _707_/D VDD VDD VSS VSS gf180mcu_fd_sc_mcu7t5v0__dlyc_1
X_660_ _660_/D _677_/RN _705_/CLK _660_/Q VDD VDD VSS VSS gf180mcu_fd_sc_mcu7t5v0__dffrnq_1
Xl_r0_b1 _711_/D _439_/ZN l_r1_b1/RN r0_b1 VDD VDD VSS VSS gf180mcu_fd_sc_mcu7t5v0__latrnq_1
X_712_ _712_/D _715_/CLK _713_/D VDD VDD VSS VSS gf180mcu_fd_sc_mcu7t5v0__dffq_1
XTAP_TAPCELL_ROW_26_184 VDD VSS gf180mcu_fd_sc_mcu7t5v0__filltie
X_574_ _671_/Q _600_/A2 _576_/A1 VDD VDD VSS VSS gf180mcu_fd_sc_mcu7t5v0__nor2_1
X_643_ _657_/Q _645_/B _643_/B1 _643_/B2 _643_/C _647_/A1 VDD VDD VSS VSS gf180mcu_fd_sc_mcu7t5v0__aoi221_1
XFILLER_26_34 VDD VDD VSS VSS gf180mcu_fd_sc_mcu7t5v0__fill_1
XFILLER_26_67 VDD VDD VSS VSS gf180mcu_fd_sc_mcu7t5v0__fill_2
XPHY_EDGE_ROW_15_Left_53 VDD VSS gf180mcu_fd_sc_mcu7t5v0__endcap
XTAP_TAPCELL_ROW_17_151 VDD VSS gf180mcu_fd_sc_mcu7t5v0__filltie
XTAP_TAPCELL_ROW_9_119 VDD VSS gf180mcu_fd_sc_mcu7t5v0__filltie
Xg_reg\[13\].g_bit\[3\].genblk1.g_l.genblk1.g_d.u_l _712_/D _427_/ZN _707_/RN _562_/A1
+ VDD VDD VSS VSS gf180mcu_fd_sc_mcu7t5v0__latrnq_1
X_488_ _657_/Q _645_/B _588_/B VDD VDD VSS VSS gf180mcu_fd_sc_mcu7t5v0__nand2_1
X_557_ _557_/A1 _444_/Z _622_/C _558_/A2 VDD VDD VSS VSS gf180mcu_fd_sc_mcu7t5v0__oai21_1
X_626_ _681_/Q _500_/B _698_/Q _627_/B VDD VDD VSS VSS gf180mcu_fd_sc_mcu7t5v0__oai21_1
XTAP_TAPCELL_ROW_37_235 VDD VSS gf180mcu_fd_sc_mcu7t5v0__filltie
XTAP_TAPCELL_ROW_3_92 VDD VSS gf180mcu_fd_sc_mcu7t5v0__filltie
XPHY_EDGE_ROW_0_Left_38 VDD VSS gf180mcu_fd_sc_mcu7t5v0__endcap
XTAP_TAPCELL_ROW_11_124 VDD VSS gf180mcu_fd_sc_mcu7t5v0__filltie
XTAP_TAPCELL_ROW_5_100 VDD VSS gf180mcu_fd_sc_mcu7t5v0__filltie
X_342_ _702_/Q _702_/D VDD VDD VSS VSS gf180mcu_fd_sc_mcu7t5v0__clkinv_1
X_411_ _416_/A1 _438_/A1 _415_/A1 _411_/ZN VDD VDD VSS VSS gf180mcu_fd_sc_mcu7t5v0__nor3_1
Xg_reg\[6\].g_bit\[7\].genblk1.g_l.g_c.u_l _716_/D _436_/ZN load_slew33/Z cfg_out[6]
+ VDD VDD VSS VSS gf180mcu_fd_sc_mcu7t5v0__latrnq_1
XTAP_TAPCELL_ROW_34_216 VDD VSS gf180mcu_fd_sc_mcu7t5v0__filltie
X_609_ _694_/Q _452_/Z _621_/B _610_/B VDD VDD VSS VSS gf180mcu_fd_sc_mcu7t5v0__aoi21_1
XFILLER_14_221 VDD VDD VSS VSS gf180mcu_fd_sc_mcu7t5v0__fill_2
XFILLER_29_4 VDD VDD VSS VSS gf180mcu_fd_sc_mcu7t5v0__fill_1
XTAP_TAPCELL_ROW_0_82 VDD VSS gf180mcu_fd_sc_mcu7t5v0__filltie
X_325_ _325_/I _572_/A1 VDD VDD VSS VSS gf180mcu_fd_sc_mcu7t5v0__clkinv_1
Xg_reg\[17\].g_bit\[3\].genblk1.g_l.g_c.u_l _712_/D _418_/ZN load_slew31/Z cfg_out[26]
+ VDD VDD VSS VSS gf180mcu_fd_sc_mcu7t5v0__latrnq_1
Xg_reg\[12\].g_bit\[6\].genblk1.g_l.genblk1.g_d.u_l _715_/D _429_/ZN l_r1_b1/RN _645_/A2
+ VDD VDD VSS VSS gf180mcu_fd_sc_mcu7t5v0__latrnq_1
XFILLER_1_2 VDD VDD VSS VSS gf180mcu_fd_sc_mcu7t5v0__fill_2
XPHY_EDGE_ROW_3_Left_41 VDD VSS gf180mcu_fd_sc_mcu7t5v0__endcap
Xload_slew34 input1/Z l_r1_b1/RN VDD VDD VSS VSS gf180mcu_fd_sc_mcu7t5v0__buf_8
Xg_reg\[16\].g_bit\[7\].genblk1.g_l.g_c.u_l _716_/D _419_/ZN load_slew31/Z cfg_out[22]
+ VDD VDD VSS VSS gf180mcu_fd_sc_mcu7t5v0__latrnq_1
Xclkload0 _725_/CLK clkload0/ZN VDD VDD VSS VSS gf180mcu_fd_sc_mcu7t5v0__inv_3
XFILLER_34_2 VDD VDD VSS VSS gf180mcu_fd_sc_mcu7t5v0__fill_2
XFILLER_37_165 VDD VDD VSS VSS gf180mcu_fd_sc_mcu7t5v0__fill_1
X_308_ _385_/B _407_/A1 VDD VDD VSS VSS gf180mcu_fd_sc_mcu7t5v0__clkinv_1
X_590_ _656_/Q _590_/A2 _653_/C _590_/C _591_/A2 VDD VDD VSS VSS gf180mcu_fd_sc_mcu7t5v0__aoi211_1
Xneuron_ctrl_47 cfg_out[49] VDD VDD VSS VSS gf180mcu_fd_sc_mcu7t5v0__tiel
Xneuron_ctrl_58 cfg_out[60] VDD VDD VSS VSS gf180mcu_fd_sc_mcu7t5v0__tiel
Xneuron_ctrl_69 uio_oe[7] VDD VDD VSS VSS gf180mcu_fd_sc_mcu7t5v0__tieh
Xhold78 _682_/Q _681_/D VDD VDD VSS VSS gf180mcu_fd_sc_mcu7t5v0__dlyc_1
XFILLER_15_47 VDD VDD VSS VSS gf180mcu_fd_sc_mcu7t5v0__fill_2
XFILLER_31_24 VDD VDD VSS VSS gf180mcu_fd_sc_mcu7t5v0__fill_2
Xl_r0_b2 _712_/D _439_/ZN l_r1_b1/RN r0_b2 VDD VDD VSS VSS gf180mcu_fd_sc_mcu7t5v0__latrnq_1
XFILLER_16_113 VDD VDD VSS VSS gf180mcu_fd_sc_mcu7t5v0__fill_2
XPHY_EDGE_ROW_19_Right_19 VDD VSS gf180mcu_fd_sc_mcu7t5v0__endcap
XPHY_EDGE_ROW_28_Right_28 VDD VSS gf180mcu_fd_sc_mcu7t5v0__endcap
XTAP_TAPCELL_ROW_26_185 VDD VSS gf180mcu_fd_sc_mcu7t5v0__filltie
X_573_ _573_/I0 _669_/Q _577_/B _669_/D VDD VDD VSS VSS gf180mcu_fd_sc_mcu7t5v0__mux2_2
X_711_ _711_/D _715_/CLK _712_/D VDD VDD VSS VSS gf180mcu_fd_sc_mcu7t5v0__dffq_1
X_642_ _656_/Q _645_/B _642_/B _643_/C VDD VDD VSS VSS gf180mcu_fd_sc_mcu7t5v0__aoi21_1
XPHY_EDGE_ROW_37_Right_37 VDD VSS gf180mcu_fd_sc_mcu7t5v0__endcap
XFILLER_13_127 VDD VDD VSS VSS gf180mcu_fd_sc_mcu7t5v0__fill_1
X_625_ _676_/Q _625_/A2 _625_/B _697_/Q _629_/B1 VDD VDD VSS VSS gf180mcu_fd_sc_mcu7t5v0__oai211_1
XPHY_EDGE_ROW_32_Left_70 VDD VSS gf180mcu_fd_sc_mcu7t5v0__endcap
XTAP_TAPCELL_ROW_3_93 VDD VSS gf180mcu_fd_sc_mcu7t5v0__filltie
X_487_ _656_/Q _645_/B _487_/B _489_/C VDD VDD VSS VSS gf180mcu_fd_sc_mcu7t5v0__aoi21_1
X_556_ _667_/Q _600_/A2 _558_/A1 VDD VDD VSS VSS gf180mcu_fd_sc_mcu7t5v0__nor2_1
Xg_reg\[8\].g_bit\[0\].genblk1.g_l.genblk1.g_d.u_l _709_/D _434_/ZN l_v0_c5/RN _305_/I
+ VDD VDD VSS VSS gf180mcu_fd_sc_mcu7t5v0__latrnq_1
XFILLER_26_252 VDD VDD VSS VSS gf180mcu_fd_sc_mcu7t5v0__fill_2
XTAP_TAPCELL_ROW_5_101 VDD VSS gf180mcu_fd_sc_mcu7t5v0__filltie
X_341_ _341_/I _525_/A1 VDD VDD VSS VSS gf180mcu_fd_sc_mcu7t5v0__clkinv_1
X_410_ _720_/Q _317_/I _415_/A1 VDD VDD VSS VSS gf180mcu_fd_sc_mcu7t5v0__nand2_1
XFILLER_32_244 VDD VDD VSS VSS gf180mcu_fd_sc_mcu7t5v0__fill_1
XTAP_TAPCELL_ROW_11_125 VDD VSS gf180mcu_fd_sc_mcu7t5v0__filltie
XTAP_TAPCELL_ROW_34_217 VDD VSS gf180mcu_fd_sc_mcu7t5v0__filltie
X_539_ _660_/Q _577_/B _545_/B1 _661_/Q _540_/I VDD VDD VSS VSS gf180mcu_fd_sc_mcu7t5v0__aoi22_1
X_608_ _673_/Q _621_/B _612_/B VDD VDD VSS VSS gf180mcu_fd_sc_mcu7t5v0__nand2_1
XFILLER_23_47 VDD VDD VSS VSS gf180mcu_fd_sc_mcu7t5v0__fill_1
X_324_ _324_/I _563_/A1 VDD VDD VSS VSS gf180mcu_fd_sc_mcu7t5v0__clkinv_1
XFILLER_20_247 VDD VDD VSS VSS gf180mcu_fd_sc_mcu7t5v0__fill_2
XTAP_TAPCELL_ROW_0_83 VDD VSS gf180mcu_fd_sc_mcu7t5v0__filltie
XFILLER_11_236 VDD VDD VSS VSS gf180mcu_fd_sc_mcu7t5v0__fill_1
XFILLER_18_25 VDD VDD VSS VSS gf180mcu_fd_sc_mcu7t5v0__fill_1
Xg_reg\[19\].g_bit\[0\].genblk1.g_l.g_c.u_l _709_/D _416_/ZN load_slew33/Z cfg_out[39]
+ VDD VDD VSS VSS gf180mcu_fd_sc_mcu7t5v0__latrnq_1
Xclkload1 _724_/CLK clkload1/Z VDD VDD VSS VSS gf180mcu_fd_sc_mcu7t5v0__clkbuf_2
XFILLER_1_72 VDD VDD VSS VSS gf180mcu_fd_sc_mcu7t5v0__fill_2
XFILLER_27_2 VDD VDD VSS VSS gf180mcu_fd_sc_mcu7t5v0__fill_2
XFILLER_37_133 VDD VDD VSS VSS gf180mcu_fd_sc_mcu7t5v0__fill_2
X_307_ _373_/B _375_/B VDD VDD VSS VSS gf180mcu_fd_sc_mcu7t5v0__clkinv_1
Xload_slew35 input1/Z l_v0_c5/RN VDD VDD VSS VSS gf180mcu_fd_sc_mcu7t5v0__buf_8
Xg_reg\[7\].g_bit\[3\].genblk1.g_l.genblk1.g_d.u_l _712_/D _435_/ZN load_slew33/Z
+ _373_/B VDD VDD VSS VSS gf180mcu_fd_sc_mcu7t5v0__latrnq_1
XFILLER_20_59 VDD VDD VSS VSS gf180mcu_fd_sc_mcu7t5v0__fill_1
XFILLER_28_177 VDD VDD VSS VSS gf180mcu_fd_sc_mcu7t5v0__fill_1
Xneuron_ctrl_48 cfg_out[50] VDD VDD VSS VSS gf180mcu_fd_sc_mcu7t5v0__tiel
Xneuron_ctrl_59 cfg_out[61] VDD VDD VSS VSS gf180mcu_fd_sc_mcu7t5v0__tiel
Xhold79 _699_/Q _700_/D VDD VDD VSS VSS gf180mcu_fd_sc_mcu7t5v0__dlyc_1
Xg_reg\[18\].g_bit\[4\].genblk1.g_l.g_c.u_l _713_/D _417_/ZN load_slew33/Z cfg_out[35]
+ VDD VDD VSS VSS gf180mcu_fd_sc_mcu7t5v0__latrnq_1
XFILLER_10_92 VDD VDD VSS VSS gf180mcu_fd_sc_mcu7t5v0__fill_1
Xl_r0_b3 _713_/D _439_/ZN l_r0_b4/RN r0_b3 VDD VDD VSS VSS gf180mcu_fd_sc_mcu7t5v0__latrnq_1
XTAP_TAPCELL_ROW_26_186 VDD VSS gf180mcu_fd_sc_mcu7t5v0__filltie
X_572_ _572_/A1 _622_/C _572_/B1 _572_/B2 _573_/I0 VDD VDD VSS VSS gf180mcu_fd_sc_mcu7t5v0__oai22_1
X_710_ _710_/D _715_/CLK _711_/D VDD VDD VSS VSS gf180mcu_fd_sc_mcu7t5v0__dffq_1
X_641_ _641_/A1 _641_/A2 _641_/B _648_/A1 VDD VDD VSS VSS gf180mcu_fd_sc_mcu7t5v0__oai21_1
XFILLER_26_69 VDD VDD VSS VSS gf180mcu_fd_sc_mcu7t5v0__fill_1
XFILLER_29_272 VDD VDD VSS VSS gf180mcu_fd_sc_mcu7t5v0__fill_2
XTAP_TAPCELL_ROW_3_94 VDD VSS gf180mcu_fd_sc_mcu7t5v0__filltie
X_486_ _644_/A1 _653_/C _643_/B1 VDD VDD VSS VSS gf180mcu_fd_sc_mcu7t5v0__nor2_1
X_555_ _555_/I0 _665_/Q _577_/B _665_/D VDD VDD VSS VSS gf180mcu_fd_sc_mcu7t5v0__mux2_2
X_624_ _634_/S _479_/B _478_/Z _694_/Q _624_/C _629_/A2 VDD VDD VSS VSS gf180mcu_fd_sc_mcu7t5v0__oai221_1
XTAP_TAPCELL_ROW_5_102 VDD VSS gf180mcu_fd_sc_mcu7t5v0__filltie
XTAP_TAPCELL_ROW_11_126 VDD VSS gf180mcu_fd_sc_mcu7t5v0__filltie
XTAP_TAPCELL_ROW_34_218 VDD VSS gf180mcu_fd_sc_mcu7t5v0__filltie
X_340_ _340_/I _521_/A1 VDD VDD VSS VSS gf180mcu_fd_sc_mcu7t5v0__clkinv_1
X_538_ _631_/C _600_/A2 _577_/B _545_/B1 VDD VDD VSS VSS gf180mcu_fd_sc_mcu7t5v0__nor3_1
X_607_ _607_/A1 _621_/B _607_/B _672_/D VDD VDD VSS VSS gf180mcu_fd_sc_mcu7t5v0__aoi21_1
Xg_reg\[11\].g_bit\[1\].genblk1.g_l.genblk1.g_d.u_l _710_/D _431_/ZN l_r1_b1/RN _323_/I
+ VDD VDD VSS VSS gf180mcu_fd_sc_mcu7t5v0__latrnq_1
X_469_ _469_/I0 _469_/I1 _470_/S uo_out[6] VDD VDD VSS VSS gf180mcu_fd_sc_mcu7t5v0__mux2_2
X_323_ _323_/I _554_/A1 VDD VDD VSS VSS gf180mcu_fd_sc_mcu7t5v0__clkinv_1
Xl_i1_b0 _714_/D _442_/ZN l_r0_b4/RN i1_b0 VDD VDD VSS VSS gf180mcu_fd_sc_mcu7t5v0__latrnq_1
Xclkload2 _698_/CLK clkload2/ZN VDD VDD VSS VSS gf180mcu_fd_sc_mcu7t5v0__inv_3
XFILLER_34_4 VDD VDD VSS VSS gf180mcu_fd_sc_mcu7t5v0__fill_1
X_306_ _306_/I _374_/B VDD VDD VSS VSS gf180mcu_fd_sc_mcu7t5v0__clkinv_1
Xload_slew36 input1/Z _707_/RN VDD VDD VSS VSS gf180mcu_fd_sc_mcu7t5v0__buf_8
XFILLER_37_178 VDD VDD VSS VSS gf180mcu_fd_sc_mcu7t5v0__fill_1
Xneuron_ctrl_38 cfg_out[12] VDD VDD VSS VSS gf180mcu_fd_sc_mcu7t5v0__tiel
Xneuron_ctrl_49 cfg_out[51] VDD VDD VSS VSS gf180mcu_fd_sc_mcu7t5v0__tiel
Xg_reg\[10\].g_bit\[4\].genblk1.g_l.genblk1.g_d.u_l _713_/D _432_/ZN input1/Z _606_/A1
+ VDD VDD VSS VSS gf180mcu_fd_sc_mcu7t5v0__latrnq_1
XFILLER_19_123 VDD VDD VSS VSS gf180mcu_fd_sc_mcu7t5v0__fill_2
XFILLER_3_222 VDD VDD VSS VSS gf180mcu_fd_sc_mcu7t5v0__fill_1
XFILLER_15_49 VDD VDD VSS VSS gf180mcu_fd_sc_mcu7t5v0__fill_1
Xl_r0_b4 _714_/D _439_/ZN l_r0_b4/RN r0_b4 VDD VDD VSS VSS gf180mcu_fd_sc_mcu7t5v0__latrnq_1
XFILLER_16_115 VDD VDD VSS VSS gf180mcu_fd_sc_mcu7t5v0__fill_1
XPHY_EDGE_ROW_1_Right_1 VDD VSS gf180mcu_fd_sc_mcu7t5v0__endcap
XTAP_TAPCELL_ROW_26_187 VDD VSS gf180mcu_fd_sc_mcu7t5v0__filltie
X_571_ _571_/A1 _444_/Z _622_/C _572_/B2 VDD VDD VSS VSS gf180mcu_fd_sc_mcu7t5v0__oai21_1
X_640_ _588_/B _640_/A2 _640_/A3 _641_/A2 VDD VDD VSS VSS gf180mcu_fd_sc_mcu7t5v0__nor3_1
XFILLER_21_92 VDD VDD VSS VSS gf180mcu_fd_sc_mcu7t5v0__fill_2
XFILLER_22_107 VDD VDD VSS VSS gf180mcu_fd_sc_mcu7t5v0__fill_2
Xg_reg\[14\].g_bit\[7\].genblk1.g_l.genblk1.g_d.u_l _716_/D _425_/ZN l_v0_c5/RN _583_/A2
+ VDD VDD VSS VSS gf180mcu_fd_sc_mcu7t5v0__latrnq_1
XFILLER_26_59 VDD VDD VSS VSS gf180mcu_fd_sc_mcu7t5v0__fillcap_8
XFILLER_8_155 VDD VDD VSS VSS gf180mcu_fd_sc_mcu7t5v0__fill_2
XFILLER_8_199 VDD VDD VSS VSS gf180mcu_fd_sc_mcu7t5v0__fill_2
XTAP_TAPCELL_ROW_3_95 VDD VSS gf180mcu_fd_sc_mcu7t5v0__filltie
X_485_ _485_/I _500_/B VDD VDD VSS VSS gf180mcu_fd_sc_mcu7t5v0__clkinv_1
X_554_ _554_/A1 _622_/C _554_/B1 _554_/B2 _555_/I0 VDD VDD VSS VSS gf180mcu_fd_sc_mcu7t5v0__oai22_1
X_623_ _623_/A1 _623_/A2 _675_/D VDD VDD VSS VSS gf180mcu_fd_sc_mcu7t5v0__nand2_1
XPHY_EDGE_ROW_19_Left_57 VDD VSS gf180mcu_fd_sc_mcu7t5v0__endcap
XTAP_TAPCELL_ROW_5_103 VDD VSS gf180mcu_fd_sc_mcu7t5v0__filltie
Xl_i4_b0 _713_/D _440_/ZN l_r1_b1/RN i4_b0 VDD VDD VSS VSS gf180mcu_fd_sc_mcu7t5v0__latrnq_1
XFILLER_26_254 VDD VDD VSS VSS gf180mcu_fd_sc_mcu7t5v0__fill_1
XTAP_TAPCELL_ROW_11_127 VDD VSS gf180mcu_fd_sc_mcu7t5v0__filltie
XTAP_TAPCELL_ROW_34_219 VDD VSS gf180mcu_fd_sc_mcu7t5v0__filltie
X_399_ _388_/B _403_/A2 probe_en_c[1] VDD VDD VSS VSS gf180mcu_fd_sc_mcu7t5v0__nor2_1
X_468_ _468_/I0 _468_/I1 _470_/S uo_out[5] VDD VDD VSS VSS gf180mcu_fd_sc_mcu7t5v0__mux2_2
X_537_ _605_/A1 _537_/A2 _537_/A3 _577_/B VDD VDD VSS VSS gf180mcu_fd_sc_mcu7t5v0__nand3_1
X_606_ _606_/A1 _479_/B _530_/Z _607_/A1 _621_/B _607_/B VDD VDD VSS VSS gf180mcu_fd_sc_mcu7t5v0__aoi221_1
X_322_ _322_/I _633_/A2 VDD VDD VSS VSS gf180mcu_fd_sc_mcu7t5v0__clkinv_1
XFILLER_1_172 VDD VDD VSS VSS gf180mcu_fd_sc_mcu7t5v0__fill_1
XTAP_TAPCELL_ROW_30_200 VDD VSS gf180mcu_fd_sc_mcu7t5v0__filltie
XFILLER_34_37 VDD VDD VSS VSS gf180mcu_fd_sc_mcu7t5v0__fill_2
Xl_i1_b1 _715_/D _442_/ZN l_r0_b4/RN i1_b1 VDD VDD VSS VSS gf180mcu_fd_sc_mcu7t5v0__latrnq_1
Xclkload3 _693_/CLK clkload3/Z VDD VDD VSS VSS gf180mcu_fd_sc_mcu7t5v0__clkbuf_4
XFILLER_24_70 VDD VDD VSS VSS gf180mcu_fd_sc_mcu7t5v0__fill_1
X_305_ _305_/I _351_/A1 VDD VDD VSS VSS gf180mcu_fd_sc_mcu7t5v0__clkinv_1
XFILLER_37_135 VDD VDD VSS VSS gf180mcu_fd_sc_mcu7t5v0__fill_1
XFILLER_29_59 VDD VDD VSS VSS gf180mcu_fd_sc_mcu7t5v0__fill_2
XPHY_EDGE_ROW_7_Left_45 VDD VSS gf180mcu_fd_sc_mcu7t5v0__endcap
Xneuron_ctrl_39 cfg_out[13] VDD VDD VSS VSS gf180mcu_fd_sc_mcu7t5v0__tiel
Xg_reg\[7\].g_bit\[5\].genblk1.g_l.genblk1.g_p.u_l _714_/D _435_/ZN load_slew33/Z
+ probe_sub_raw[1] VDD VDD VSS VSS gf180mcu_fd_sc_mcu7t5v0__latrnq_1
XFILLER_32_2 VDD VDD VSS VSS gf180mcu_fd_sc_mcu7t5v0__fillcap_8
XTAP_TAPCELL_ROW_29_196 VDD VSS gf180mcu_fd_sc_mcu7t5v0__filltie
X_570_ _670_/Q _600_/A2 _572_/B1 VDD VDD VSS VSS gf180mcu_fd_sc_mcu7t5v0__nor2_1
Xclkbuf_0_clk clk clkbuf_0_clk/Z VDD VDD VSS VSS gf180mcu_fd_sc_mcu7t5v0__clkbuf_4
X_699_ _702_/Q _707_/Q _724_/CLK _699_/Q VDD VDD VSS VSS gf180mcu_fd_sc_mcu7t5v0__dffrnq_1
XFILLER_30_174 VDD VDD VSS VSS gf180mcu_fd_sc_mcu7t5v0__fill_1
XPHY_EDGE_ROW_15_Right_15 VDD VSS gf180mcu_fd_sc_mcu7t5v0__endcap
XPHY_EDGE_ROW_24_Right_24 VDD VSS gf180mcu_fd_sc_mcu7t5v0__endcap
XPHY_EDGE_ROW_33_Right_33 VDD VSS gf180mcu_fd_sc_mcu7t5v0__endcap
XTAP_TAPCELL_ROW_14_136 VDD VSS gf180mcu_fd_sc_mcu7t5v0__filltie
XTAP_TAPCELL_ROW_8_112 VDD VSS gf180mcu_fd_sc_mcu7t5v0__filltie
X_484_ _660_/Q _645_/B _485_/I VDD VDD VSS VSS gf180mcu_fd_sc_mcu7t5v0__nand2_1
X_553_ _553_/A1 _444_/Z _622_/C _554_/B2 VDD VDD VSS VSS gf180mcu_fd_sc_mcu7t5v0__oai21_1
X_622_ _694_/Q _622_/A2 _622_/B1 _622_/B2 _622_/C _623_/A2 VDD VDD VSS VSS gf180mcu_fd_sc_mcu7t5v0__oai221_1
XTAP_TAPCELL_ROW_37_228 VDD VSS gf180mcu_fd_sc_mcu7t5v0__filltie
Xl_i4_b1 _714_/D _440_/ZN l_r1_b1/RN i4_b1 VDD VDD VSS VSS gf180mcu_fd_sc_mcu7t5v0__latrnq_1
XPHY_EDGE_ROW_36_Left_74 VDD VSS gf180mcu_fd_sc_mcu7t5v0__endcap
XFILLER_32_247 VDD VDD VSS VSS gf180mcu_fd_sc_mcu7t5v0__fill_1
XPHY_EDGE_ROW_20_Left_58 VDD VSS gf180mcu_fd_sc_mcu7t5v0__endcap
X_398_ _398_/A1 _391_/Z _398_/A3 _398_/A4 _403_/A2 VDD VDD VSS VSS gf180mcu_fd_sc_mcu7t5v0__nand4_1
X_467_ _467_/I0 _467_/I1 _470_/S uo_out[4] VDD VDD VSS VSS gf180mcu_fd_sc_mcu7t5v0__mux2_2
X_536_ _600_/A2 _604_/A2 _537_/A3 VDD VDD VSS VSS gf180mcu_fd_sc_mcu7t5v0__nand2_1
X_605_ _605_/A1 _605_/A2 _621_/B VDD VDD VSS VSS gf180mcu_fd_sc_mcu7t5v0__nand2_1
XFILLER_23_269 VDD VDD VSS VSS gf180mcu_fd_sc_mcu7t5v0__fill_2
X_321_ _676_/Q _629_/A1 VDD VDD VSS VSS gf180mcu_fd_sc_mcu7t5v0__clkinv_1
XFILLER_34_27 VDD VDD VSS VSS gf180mcu_fd_sc_mcu7t5v0__fillcap_8
XTAP_TAPCELL_ROW_30_201 VDD VSS gf180mcu_fd_sc_mcu7t5v0__filltie
X_519_ _658_/Q _519_/A2 _519_/Z VDD VDD VSS VSS gf180mcu_fd_sc_mcu7t5v0__xor2_1
Xl_i1_b2 _716_/D _442_/ZN l_r0_b4/RN i1_b2 VDD VDD VSS VSS gf180mcu_fd_sc_mcu7t5v0__latrnq_1
X_304_ _698_/Q _654_/A1 VDD VDD VSS VSS gf180mcu_fd_sc_mcu7t5v0__clkinv_1
Xload_slew27 _724_/RN _698_/RN VDD VDD VSS VSS gf180mcu_fd_sc_mcu7t5v0__buf_4
Xg_reg\[8\].g_bit\[7\].genblk1.g_l.genblk1.g_d.u_l _716_/D _434_/ZN _707_/RN _370_/A2
+ VDD VDD VSS VSS gf180mcu_fd_sc_mcu7t5v0__latrnq_1
Xclkload4 _715_/CLK clkload4/Z VDD VDD VSS VSS gf180mcu_fd_sc_mcu7t5v0__clkbuf_2
XPHY_EDGE_ROW_23_Left_61 VDD VSS gf180mcu_fd_sc_mcu7t5v0__endcap
Xg_reg\[13\].g_bit\[2\].genblk1.g_l.genblk1.g_d.u_l _711_/D _427_/ZN _707_/RN _557_/A1
+ VDD VDD VSS VSS gf180mcu_fd_sc_mcu7t5v0__latrnq_1
XFILLER_29_27 VDD VDD VSS VSS gf180mcu_fd_sc_mcu7t5v0__fillcap_32
XFILLER_19_82 VDD VDD VSS VSS gf180mcu_fd_sc_mcu7t5v0__fillcap_4
XTAP_TAPCELL_ROW_29_197 VDD VSS gf180mcu_fd_sc_mcu7t5v0__filltie
Xclkbuf_regs_0_clk clk clkbuf_regs_0_clk/Z VDD VDD VSS VSS gf180mcu_fd_sc_mcu7t5v0__clkbuf_4
XFILLER_25_139 VDD VDD VSS VSS gf180mcu_fd_sc_mcu7t5v0__fill_1
XFILLER_25_2 VDD VDD VSS VSS gf180mcu_fd_sc_mcu7t5v0__fill_2
XFILLER_33_150 VDD VDD VSS VSS gf180mcu_fd_sc_mcu7t5v0__fill_2
XFILLER_21_72 VDD VDD VSS VSS gf180mcu_fd_sc_mcu7t5v0__fillcap_16
XFILLER_21_94 VDD VDD VSS VSS gf180mcu_fd_sc_mcu7t5v0__fill_1
XFILLER_24_172 VDD VDD VSS VSS gf180mcu_fd_sc_mcu7t5v0__fill_2
XFILLER_24_183 VDD VDD VSS VSS gf180mcu_fd_sc_mcu7t5v0__fill_2
Xg_reg\[15\].g_bit\[0\].genblk1.g_l.g_c.u_l _709_/D _423_/ZN load_slew31/Z cfg_out[7]
+ VDD VDD VSS VSS gf180mcu_fd_sc_mcu7t5v0__latrnq_1
XFILLER_15_183 VDD VDD VSS VSS gf180mcu_fd_sc_mcu7t5v0__fill_2
XFILLER_26_28 VDD VDD VSS VSS gf180mcu_fd_sc_mcu7t5v0__fillcap_4
XFILLER_30_131 VDD VDD VSS VSS gf180mcu_fd_sc_mcu7t5v0__fill_1
X_698_ _698_/D _698_/RN _698_/CLK _698_/Q VDD VDD VSS VSS gf180mcu_fd_sc_mcu7t5v0__dffrnq_1
XFILLER_21_175 VDD VDD VSS VSS gf180mcu_fd_sc_mcu7t5v0__fill_1
XFILLER_29_220 VDD VDD VSS VSS gf180mcu_fd_sc_mcu7t5v0__fill_2
XTAP_TAPCELL_ROW_14_137 VDD VSS gf180mcu_fd_sc_mcu7t5v0__filltie
XTAP_TAPCELL_ROW_8_113 VDD VSS gf180mcu_fd_sc_mcu7t5v0__filltie
X_483_ _483_/A1 _482_/B _322_/I _483_/B1 _483_/B2 _483_/ZN VDD VDD VSS VSS gf180mcu_fd_sc_mcu7t5v0__oai32_1
X_552_ _666_/Q _600_/A2 _554_/B1 VDD VDD VSS VSS gf180mcu_fd_sc_mcu7t5v0__nor2_1
X_621_ _694_/Q _453_/Z _621_/B _622_/B2 VDD VDD VSS VSS gf180mcu_fd_sc_mcu7t5v0__aoi21_1
XFILLER_8_168 VDD VDD VSS VSS gf180mcu_fd_sc_mcu7t5v0__fill_1
XTAP_TAPCELL_ROW_22_170 VDD VSS gf180mcu_fd_sc_mcu7t5v0__filltie
XTAP_TAPCELL_ROW_37_229 VDD VSS gf180mcu_fd_sc_mcu7t5v0__filltie
Xl_i4_b2 _715_/D _440_/ZN l_r0_b4/RN i4_b2 VDD VDD VSS VSS gf180mcu_fd_sc_mcu7t5v0__latrnq_1
Xg_reg\[12\].g_bit\[5\].genblk1.g_l.genblk1.g_d.u_l _714_/D _429_/ZN l_r1_b1/RN _333_/I
+ VDD VDD VSS VSS gf180mcu_fd_sc_mcu7t5v0__latrnq_1
XFILLER_17_278 VDD VDD VSS VSS gf180mcu_fd_sc_mcu7t5v0__fill_2
X_397_ _377_/Z _382_/I probe_rsel[1] VDD VDD VSS VSS gf180mcu_fd_sc_mcu7t5v0__nor2_1
X_466_ _466_/I0 input8/Z _470_/S uo_out[3] VDD VDD VSS VSS gf180mcu_fd_sc_mcu7t5v0__mux2_2
X_535_ _694_/Q _679_/Q _680_/Q _631_/C _604_/A2 VDD VDD VSS VSS gf180mcu_fd_sc_mcu7t5v0__nor4_1
X_604_ _534_/B _604_/A2 _605_/A2 VDD VDD VSS VSS gf180mcu_fd_sc_mcu7t5v0__nor2_1
XFILLER_2_119 VDD VDD VSS VSS gf180mcu_fd_sc_mcu7t5v0__fill_1
XTAP_TAPCELL_ROW_0_76 VDD VSS gf180mcu_fd_sc_mcu7t5v0__filltie
X_320_ _677_/Q _632_/B2 VDD VDD VSS VSS gf180mcu_fd_sc_mcu7t5v0__clkinv_1
XTAP_TAPCELL_ROW_30_202 VDD VSS gf180mcu_fd_sc_mcu7t5v0__filltie
X_449_ _524_/C _586_/C _696_/Q _519_/A2 _505_/C VDD VDD VSS VSS gf180mcu_fd_sc_mcu7t5v0__nand4_1
X_518_ _518_/A1 _524_/B _518_/Z VDD VDD VSS VSS gf180mcu_fd_sc_mcu7t5v0__or2_1
Xl_i1_b3 _709_/D _441_/ZN l_r1_b1/RN i1_b3 VDD VDD VSS VSS gf180mcu_fd_sc_mcu7t5v0__latrnq_1
Xl_ib_x2 _712_/D _434_/ZN l_v0_c5/RN ib_x2 VDD VDD VSS VSS gf180mcu_fd_sc_mcu7t5v0__latrnq_1
XFILLER_34_39 VDD VDD VSS VSS gf180mcu_fd_sc_mcu7t5v0__fill_1
Xload_slew28 _724_/RN _725_/RN VDD VDD VSS VSS gf180mcu_fd_sc_mcu7t5v0__buf_4
X_303_ _658_/Q _586_/C VDD VDD VSS VSS gf180mcu_fd_sc_mcu7t5v0__clkinv_1
Xl_bias_en _715_/D _436_/ZN l_v0_c5/RN bias_en VDD VDD VSS VSS gf180mcu_fd_sc_mcu7t5v0__latrnq_1
XFILLER_34_107 VDD VDD VSS VSS gf180mcu_fd_sc_mcu7t5v0__fill_2
XTAP_TAPCELL_ROW_29_198 VDD VSS gf180mcu_fd_sc_mcu7t5v0__filltie
Xg_reg\[6\].g_bit\[1\].genblk1.g_l.g_c.u_l _710_/D _436_/ZN l_r0_b4/RN cfg_out[1]
+ VDD VDD VSS VSS gf180mcu_fd_sc_mcu7t5v0__latrnq_1
XFILLER_0_206 VDD VDD VSS VSS gf180mcu_fd_sc_mcu7t5v0__fill_2
XFILLER_18_2 VDD VDD VSS VSS gf180mcu_fd_sc_mcu7t5v0__fill_1
X_766_ spk_in[13] uio_out[5] VDD VDD VSS VSS gf180mcu_fd_sc_mcu7t5v0__buf_1
X_697_ _697_/D _724_/RN _705_/CLK _697_/Q VDD VDD VSS VSS gf180mcu_fd_sc_mcu7t5v0__dffrnq_1
XPHY_EDGE_ROW_5_Right_5 VDD VSS gf180mcu_fd_sc_mcu7t5v0__endcap
XTAP_TAPCELL_ROW_8_114 VDD VSS gf180mcu_fd_sc_mcu7t5v0__filltie
X_551_ _551_/A1 _577_/B _551_/B _664_/D VDD VDD VSS VSS gf180mcu_fd_sc_mcu7t5v0__aoi21_1
X_620_ _620_/I _622_/B1 VDD VDD VSS VSS gf180mcu_fd_sc_mcu7t5v0__clkinv_1
XTAP_TAPCELL_ROW_14_138 VDD VSS gf180mcu_fd_sc_mcu7t5v0__filltie
XTAP_TAPCELL_ROW_22_171 VDD VSS gf180mcu_fd_sc_mcu7t5v0__filltie
X_482_ _633_/A2 input2/Z _482_/B _483_/B2 VDD VDD VSS VSS gf180mcu_fd_sc_mcu7t5v0__oai21_1
Xl_i4_b3 _716_/D _440_/ZN l_r0_b4/RN i4_b3 VDD VDD VSS VSS gf180mcu_fd_sc_mcu7t5v0__latrnq_1
XFILLER_26_235 VDD VDD VSS VSS gf180mcu_fd_sc_mcu7t5v0__fill_2
Xg_reg\[16\].g_bit\[1\].genblk1.g_l.g_c.u_l _710_/D _419_/ZN load_slew31/Z cfg_out[16]
+ VDD VDD VSS VSS gf180mcu_fd_sc_mcu7t5v0__latrnq_1
XFILLER_27_94 VDD VDD VSS VSS gf180mcu_fd_sc_mcu7t5v0__fill_2
X_396_ _398_/A1 _396_/A2 _396_/B probe_en_c[0] VDD VDD VSS VSS gf180mcu_fd_sc_mcu7t5v0__aoi21_1
X_465_ _465_/I0 input7/Z _470_/S uo_out[2] VDD VDD VSS VSS gf180mcu_fd_sc_mcu7t5v0__mux2_2
X_534_ _696_/Q _653_/C _534_/B _537_/A2 VDD VDD VSS VSS gf180mcu_fd_sc_mcu7t5v0__oai21_1
X_603_ _577_/B _603_/A2 _603_/A3 _603_/B _671_/D VDD VDD VSS VSS gf180mcu_fd_sc_mcu7t5v0__oai31_1
Xg_reg\[7\].g_bit\[2\].genblk1.g_l.genblk1.g_d.u_l _711_/D _435_/ZN load_slew33/Z
+ _306_/I VDD VDD VSS VSS gf180mcu_fd_sc_mcu7t5v0__latrnq_1
Xg_reg\[22\].g_bit\[2\].genblk1.g_l.g_c.u_l _711_/D _413_/ZN l_r0_b4/RN cfg_out[65]
+ VDD VDD VSS VSS gf180mcu_fd_sc_mcu7t5v0__latrnq_1
XFILLER_31_271 VDD VDD VSS VSS gf180mcu_fd_sc_mcu7t5v0__fill_1
XTAP_TAPCELL_ROW_0_77 VDD VSS gf180mcu_fd_sc_mcu7t5v0__filltie
XTAP_TAPCELL_ROW_30_203 VDD VSS gf180mcu_fd_sc_mcu7t5v0__filltie
X_379_ _377_/Z _402_/A2 _400_/A1 VDD VDD VSS VSS gf180mcu_fd_sc_mcu7t5v0__nand2_1
X_448_ _600_/A2 _624_/C _448_/ZN VDD VDD VSS VSS gf180mcu_fd_sc_mcu7t5v0__nand2_1
X_517_ _644_/A1 _590_/C _586_/C _524_/B VDD VDD VSS VSS gf180mcu_fd_sc_mcu7t5v0__nor3_1
Xl_i1_b4 _710_/D _441_/ZN l_r1_b1/RN i1_b4 VDD VDD VSS VSS gf180mcu_fd_sc_mcu7t5v0__latrnq_1
Xload_slew29 _707_/Q _677_/RN VDD VDD VSS VSS gf180mcu_fd_sc_mcu7t5v0__buf_4
XFILLER_37_138 VDD VDD VSS VSS gf180mcu_fd_sc_mcu7t5v0__fill_2
X_302_ _659_/Q _524_/C VDD VDD VSS VSS gf180mcu_fd_sc_mcu7t5v0__clkinv_1
XFILLER_35_72 VDD VDD VSS VSS gf180mcu_fd_sc_mcu7t5v0__fill_1
XTAP_TAPCELL_ROW_29_199 VDD VSS gf180mcu_fd_sc_mcu7t5v0__filltie
XFILLER_25_4 VDD VDD VSS VSS gf180mcu_fd_sc_mcu7t5v0__fill_1
XFILLER_24_174 VDD VDD VSS VSS gf180mcu_fd_sc_mcu7t5v0__fill_1
Xg_reg\[11\].g_bit\[0\].genblk1.g_l.genblk1.g_d.u_l _709_/D _431_/ZN input1/Z _494_/B
+ VDD VDD VSS VSS gf180mcu_fd_sc_mcu7t5v0__latrnq_1
XFILLER_30_177 VDD VDD VSS VSS gf180mcu_fd_sc_mcu7t5v0__fill_2
XFILLER_30_2 VDD VDD VSS VSS gf180mcu_fd_sc_mcu7t5v0__fillcap_4
XTAP_TAPCELL_ROW_25_180 VDD VSS gf180mcu_fd_sc_mcu7t5v0__filltie
X_765_ spk_in[12] uio_out[4] VDD VDD VSS VSS gf180mcu_fd_sc_mcu7t5v0__buf_1
X_696_ _696_/D _698_/RN _698_/CLK _696_/Q VDD VDD VSS VSS gf180mcu_fd_sc_mcu7t5v0__dffrnq_1
XTAP_TAPCELL_ROW_8_115 VDD VSS gf180mcu_fd_sc_mcu7t5v0__filltie
XFILLER_12_122 VDD VDD VSS VSS gf180mcu_fd_sc_mcu7t5v0__fill_2
XFILLER_12_155 VDD VDD VSS VSS gf180mcu_fd_sc_mcu7t5v0__fill_1
XFILLER_29_222 VDD VDD VSS VSS gf180mcu_fd_sc_mcu7t5v0__fill_1
XPHY_EDGE_ROW_11_Right_11 VDD VSS gf180mcu_fd_sc_mcu7t5v0__endcap
XPHY_EDGE_ROW_20_Right_20 VDD VSS gf180mcu_fd_sc_mcu7t5v0__endcap
XTAP_TAPCELL_ROW_14_139 VDD VSS gf180mcu_fd_sc_mcu7t5v0__filltie
X_481_ _481_/A1 _322_/I _483_/B1 VDD VDD VSS VSS gf180mcu_fd_sc_mcu7t5v0__nor2_1
X_550_ _494_/B _631_/C _577_/B _550_/C _551_/B VDD VDD VSS VSS gf180mcu_fd_sc_mcu7t5v0__aoi211_1
Xl_i4_b4 _709_/D _439_/ZN l_r1_b1/RN i4_b4 VDD VDD VSS VSS gf180mcu_fd_sc_mcu7t5v0__latrnq_1
X_679_ _679_/D _698_/RN _725_/CLK _679_/Q VDD VDD VSS VSS gf180mcu_fd_sc_mcu7t5v0__dffrnq_1
XFILLER_34_280 VDD VDD VSS VSS gf180mcu_fd_sc_mcu7t5v0__fill_2
X_464_ input9/Z input6/Z _470_/S uo_out[1] VDD VDD VSS VSS gf180mcu_fd_sc_mcu7t5v0__mux2_2
X_533_ _631_/C _479_/C _534_/B VDD VDD VSS VSS gf180mcu_fd_sc_mcu7t5v0__nor2_1
X_602_ _671_/Q _577_/B _603_/B VDD VDD VSS VSS gf180mcu_fd_sc_mcu7t5v0__nand2_1
XFILLER_4_151 VDD VDD VSS VSS gf180mcu_fd_sc_mcu7t5v0__fill_2
XTAP_TAPCELL_ROW_10_120 VDD VSS gf180mcu_fd_sc_mcu7t5v0__filltie
XTAP_TAPCELL_ROW_33_212 VDD VSS gf180mcu_fd_sc_mcu7t5v0__filltie
X_395_ _395_/A1 _398_/A4 _396_/B VDD VDD VSS VSS gf180mcu_fd_sc_mcu7t5v0__nand2_1
Xclkbuf_1_0__f_u_lif.d_clk clkbuf_0_u_lif.d_clk/Z _692_/CLK VDD VDD VSS VSS gf180mcu_fd_sc_mcu7t5v0__clkbuf_4
Xg_reg\[17\].g_bit\[2\].genblk1.g_l.g_c.u_l _711_/D _418_/ZN load_slew31/Z cfg_out[25]
+ VDD VDD VSS VSS gf180mcu_fd_sc_mcu7t5v0__latrnq_1
Xg_reg\[10\].g_bit\[3\].genblk1.g_l.genblk1.g_d.u_l _712_/D _432_/ZN l_v0_c5/RN _341_/I
+ VDD VDD VSS VSS gf180mcu_fd_sc_mcu7t5v0__latrnq_1
XFILLER_8_2 VDD VDD VSS VSS gf180mcu_fd_sc_mcu7t5v0__fill_2
XFILLER_9_265 VDD VDD VSS VSS gf180mcu_fd_sc_mcu7t5v0__fill_1
XTAP_TAPCELL_ROW_0_78 VDD VSS gf180mcu_fd_sc_mcu7t5v0__filltie
X_378_ _312_/I _381_/A1 _402_/A2 VDD VDD VSS VSS gf180mcu_fd_sc_mcu7t5v0__nand2_1
X_447_ _696_/Q _631_/A2 _624_/C VDD VDD VSS VSS gf180mcu_fd_sc_mcu7t5v0__nand2_1
X_516_ _697_/Q _516_/A2 _698_/Q _518_/A1 VDD VDD VSS VSS gf180mcu_fd_sc_mcu7t5v0__aoi21_1
Xg_reg\[16\].g_bit\[6\].genblk1.g_l.g_c.u_l _715_/D _419_/ZN load_slew31/Z cfg_out[21]
+ VDD VDD VSS VSS gf180mcu_fd_sc_mcu7t5v0__latrnq_1
X_301_ _657_/Q _590_/C VDD VDD VSS VSS gf180mcu_fd_sc_mcu7t5v0__clkinv_1
Xg_reg\[22\].g_bit\[7\].genblk1.g_l.g_c.u_l _716_/D _413_/ZN load_slew33/Z cfg_out[70]
+ VDD VDD VSS VSS gf180mcu_fd_sc_mcu7t5v0__latrnq_1
Xg_reg\[14\].g_bit\[6\].genblk1.g_l.genblk1.g_d.u_l _715_/D _425_/ZN l_v0_c5/RN _584_/A2
+ VDD VDD VSS VSS gf180mcu_fd_sc_mcu7t5v0__latrnq_1
XFILLER_19_139 VDD VDD VSS VSS gf180mcu_fd_sc_mcu7t5v0__fill_1
XFILLER_34_109 VDD VDD VSS VSS gf180mcu_fd_sc_mcu7t5v0__fill_1
XPHY_EDGE_ROW_11_Left_49 VDD VSS gf180mcu_fd_sc_mcu7t5v0__endcap
XPHY_EDGE_ROW_27_Left_65 VDD VSS gf180mcu_fd_sc_mcu7t5v0__endcap
XFILLER_0_208 VDD VDD VSS VSS gf180mcu_fd_sc_mcu7t5v0__fill_1
XFILLER_21_20 VDD VDD VSS VSS gf180mcu_fd_sc_mcu7t5v0__fill_1
XTAP_TAPCELL_ROW_17_148 VDD VSS gf180mcu_fd_sc_mcu7t5v0__filltie
XTAP_TAPCELL_ROW_25_181 VDD VSS gf180mcu_fd_sc_mcu7t5v0__filltie
X_764_ spk_in[11] uio_out[3] VDD VDD VSS VSS gf180mcu_fd_sc_mcu7t5v0__buf_1
X_695_ _695_/D _724_/RN _705_/CLK _695_/Q VDD VDD VSS VSS gf180mcu_fd_sc_mcu7t5v0__dffrnq_1
XFILLER_23_2 VDD VDD VSS VSS gf180mcu_fd_sc_mcu7t5v0__fill_2
XFILLER_29_278 VDD VDD VSS VSS gf180mcu_fd_sc_mcu7t5v0__fill_2
X_480_ _480_/I _725_/D VDD VDD VSS VSS gf180mcu_fd_sc_mcu7t5v0__clkinv_1
X_678_ _678_/D _724_/RN _724_/CLK _678_/Q VDD VDD VSS VSS gf180mcu_fd_sc_mcu7t5v0__dffrnq_1
XPHY_EDGE_ROW_14_Left_52 VDD VSS gf180mcu_fd_sc_mcu7t5v0__endcap
X_601_ _326_/I _622_/C _603_/A3 VDD VDD VSS VSS gf180mcu_fd_sc_mcu7t5v0__nor2_1
XTAP_TAPCELL_ROW_10_121 VDD VSS gf180mcu_fd_sc_mcu7t5v0__filltie
X_394_ _394_/A1 _404_/A3 _398_/A4 VDD VDD VSS VSS gf180mcu_fd_sc_mcu7t5v0__nor2_1
X_463_ input2/Z input5/Z _470_/S uo_out[0] VDD VDD VSS VSS gf180mcu_fd_sc_mcu7t5v0__mux2_2
X_532_ _530_/Z _532_/A2 _605_/A1 VDD VDD VSS VSS gf180mcu_fd_sc_mcu7t5v0__nand2_1
XTAP_TAPCELL_ROW_33_213 VDD VSS gf180mcu_fd_sc_mcu7t5v0__filltie
XTAP_TAPCELL_ROW_0_79 VDD VSS gf180mcu_fd_sc_mcu7t5v0__filltie
X_377_ _380_/B _377_/A2 _377_/Z VDD VDD VSS VSS gf180mcu_fd_sc_mcu7t5v0__or2_1
X_446_ _524_/C _586_/C _519_/A2 _631_/A2 VDD VDD VSS VSS gf180mcu_fd_sc_mcu7t5v0__nand3_1
X_515_ _656_/Q _657_/Q _658_/Q _521_/B1 VDD VDD VSS VSS gf180mcu_fd_sc_mcu7t5v0__aoi21_1
Xg_reg\[7\].g_bit\[4\].genblk1.g_l.genblk1.g_p.u_l _713_/D _435_/ZN load_slew33/Z
+ probe_sub VDD VDD VSS VSS gf180mcu_fd_sc_mcu7t5v0__latrnq_1
XFILLER_24_42 VDD VDD VSS VSS gf180mcu_fd_sc_mcu7t5v0__fill_2
X_300_ _656_/Q _644_/A1 VDD VDD VSS VSS gf180mcu_fd_sc_mcu7t5v0__clkinv_1
Xg_reg\[18\].g_bit\[3\].genblk1.g_l.g_c.u_l _712_/D _417_/ZN load_slew31/Z cfg_out[34]
+ VDD VDD VSS VSS gf180mcu_fd_sc_mcu7t5v0__latrnq_1
X_429_ _429_/A1 _442_/A2 _429_/ZN VDD VDD VSS VSS gf180mcu_fd_sc_mcu7t5v0__nor2_1
Xinput1 rst_n input1/Z VDD VDD VSS VSS gf180mcu_fd_sc_mcu7t5v0__clkbuf_3
Xg_reg\[17\].g_bit\[7\].genblk1.g_l.g_c.u_l _716_/D _418_/ZN load_slew31/Z cfg_out[30]
+ VDD VDD VSS VSS gf180mcu_fd_sc_mcu7t5v0__latrnq_1
XFILLER_19_86 VDD VDD VSS VSS gf180mcu_fd_sc_mcu7t5v0__fill_2
XPHY_EDGE_ROW_2_Left_40 VDD VSS gf180mcu_fd_sc_mcu7t5v0__endcap
XFILLER_24_154 VDD VDD VSS VSS gf180mcu_fd_sc_mcu7t5v0__fill_2
XTAP_TAPCELL_ROW_17_149 VDD VSS gf180mcu_fd_sc_mcu7t5v0__filltie
XTAP_TAPCELL_ROW_25_182 VDD VSS gf180mcu_fd_sc_mcu7t5v0__filltie
X_763_ spk_in[10] uio_out[2] VDD VDD VSS VSS gf180mcu_fd_sc_mcu7t5v0__buf_1
X_694_ _694_/D _724_/RN _705_/CLK _694_/Q VDD VDD VSS VSS gf180mcu_fd_sc_mcu7t5v0__dffsnq_1
XFILLER_30_179 VDD VDD VSS VSS gf180mcu_fd_sc_mcu7t5v0__fill_1
XFILLER_7_78 VDD VDD VSS VSS gf180mcu_fd_sc_mcu7t5v0__fill_2
XFILLER_12_124 VDD VDD VSS VSS gf180mcu_fd_sc_mcu7t5v0__fill_1
XFILLER_32_53 VDD VDD VSS VSS gf180mcu_fd_sc_mcu7t5v0__fill_1
XPHY_EDGE_ROW_9_Right_9 VDD VSS gf180mcu_fd_sc_mcu7t5v0__endcap
X_677_ _677_/D _677_/RN _698_/CLK _677_/Q VDD VDD VSS VSS gf180mcu_fd_sc_mcu7t5v0__dffrnq_1
Xg_reg\[8\].g_bit\[6\].genblk1.g_l.genblk1.g_d.u_l _715_/D _434_/ZN _707_/RN _369_/A2
+ VDD VDD VSS VSS gf180mcu_fd_sc_mcu7t5v0__latrnq_1
XTAP_TAPCELL_ROW_10_122 VDD VSS gf180mcu_fd_sc_mcu7t5v0__filltie
X_393_ _398_/A1 _391_/Z _398_/A3 _395_/A1 VDD VDD VSS VSS gf180mcu_fd_sc_mcu7t5v0__nand3_1
X_462_ _634_/S _479_/B _462_/B _694_/D VDD VDD VSS VSS gf180mcu_fd_sc_mcu7t5v0__oai21_1
X_531_ _531_/A1 _705_/D _453_/Z _532_/A2 VDD VDD VSS VSS gf180mcu_fd_sc_mcu7t5v0__nand3_1
X_600_ _600_/A1 _600_/A2 _597_/Z _698_/Q _600_/C _603_/A2 VDD VDD VSS VSS gf180mcu_fd_sc_mcu7t5v0__aoi221_1
XTAP_TAPCELL_ROW_33_214 VDD VSS gf180mcu_fd_sc_mcu7t5v0__filltie
Xg_reg\[13\].g_bit\[1\].genblk1.g_l.genblk1.g_d.u_l _710_/D _427_/ZN input1/Z _553_/A1
+ VDD VDD VSS VSS gf180mcu_fd_sc_mcu7t5v0__latrnq_1
XFILLER_8_4 VDD VDD VSS VSS gf180mcu_fd_sc_mcu7t5v0__fill_1
X_514_ _514_/I _657_/D VDD VDD VSS VSS gf180mcu_fd_sc_mcu7t5v0__clkinv_1
XFILLER_9_212 VDD VDD VSS VSS gf180mcu_fd_sc_mcu7t5v0__fill_2
X_376_ _380_/C _376_/A2 _376_/B1 _376_/B2 _377_/A2 VDD VDD VSS VSS gf180mcu_fd_sc_mcu7t5v0__aoi22_1
X_445_ _656_/Q _657_/Q _519_/A2 VDD VDD VSS VSS gf180mcu_fd_sc_mcu7t5v0__nor2_1
XFILLER_24_32 VDD VDD VSS VSS gf180mcu_fd_sc_mcu7t5v0__fill_2
X_359_ _373_/B _312_/I _384_/A2 _376_/B2 VDD VDD VSS VSS gf180mcu_fd_sc_mcu7t5v0__nand3_1
X_428_ _428_/A1 _428_/A2 _428_/A3 _442_/A2 VDD VDD VSS VSS gf180mcu_fd_sc_mcu7t5v0__nand3_1
Xinput2 spk_in[0] input2/Z VDD VDD VSS VSS gf180mcu_fd_sc_mcu7t5v0__buf_1
Xg_reg\[12\].g_bit\[4\].genblk1.g_l.genblk1.g_d.u_l _713_/D _429_/ZN l_r1_b1/RN _642_/B
+ VDD VDD VSS VSS gf180mcu_fd_sc_mcu7t5v0__latrnq_1
XFILLER_21_66 VDD VDD VSS VSS gf180mcu_fd_sc_mcu7t5v0__fillcap_4
XFILLER_21_88 VDD VDD VSS VSS gf180mcu_fd_sc_mcu7t5v0__fillcap_4
XFILLER_24_100 VDD VDD VSS VSS gf180mcu_fd_sc_mcu7t5v0__fill_1
X_762_ spk_in[9] uio_out[1] VDD VDD VSS VSS gf180mcu_fd_sc_mcu7t5v0__buf_1
X_693_ _693_/D _693_/CLK _693_/Q VDD VDD VSS VSS gf180mcu_fd_sc_mcu7t5v0__dffq_1
XFILLER_23_4 VDD VDD VSS VSS gf180mcu_fd_sc_mcu7t5v0__fill_1
XTAP_TAPCELL_ROW_25_183 VDD VSS gf180mcu_fd_sc_mcu7t5v0__filltie
XFILLER_32_10 VDD VDD VSS VSS gf180mcu_fd_sc_mcu7t5v0__fill_1
XFILLER_37_280 VDD VDD VSS VSS gf180mcu_fd_sc_mcu7t5v0__fill_2
X_676_ _676_/D _677_/RN _698_/CLK _676_/Q VDD VDD VSS VSS gf180mcu_fd_sc_mcu7t5v0__dffrnq_1
XTAP_TAPCELL_ROW_10_123 VDD VSS gf180mcu_fd_sc_mcu7t5v0__filltie
X_392_ _385_/B _312_/I _392_/B _398_/A3 VDD VDD VSS VSS gf180mcu_fd_sc_mcu7t5v0__oai21_1
X_461_ _694_/Q _631_/C _479_/B VDD VDD VSS VSS gf180mcu_fd_sc_mcu7t5v0__nor2_1
X_530_ _694_/Q _622_/C _530_/Z VDD VDD VSS VSS gf180mcu_fd_sc_mcu7t5v0__and2_1
Xg_reg\[11\].g_bit\[7\].genblk1.g_l.genblk1.g_d.u_l _716_/D _431_/ZN input1/Z _326_/I
+ VDD VDD VSS VSS gf180mcu_fd_sc_mcu7t5v0__latrnq_1
XTAP_TAPCELL_ROW_33_215 VDD VSS gf180mcu_fd_sc_mcu7t5v0__filltie
X_659_ _659_/D _698_/RN _698_/CLK _659_/Q VDD VDD VSS VSS gf180mcu_fd_sc_mcu7t5v0__dffrnq_1
XFILLER_14_209 VDD VDD VSS VSS gf180mcu_fd_sc_mcu7t5v0__fill_2
XFILLER_13_220 VDD VDD VSS VSS gf180mcu_fd_sc_mcu7t5v0__fill_1
X_375_ _385_/B _406_/A2 _375_/B _376_/B1 VDD VDD VSS VSS gf180mcu_fd_sc_mcu7t5v0__aoi21_1
X_444_ _697_/Q _698_/Q _444_/Z VDD VDD VSS VSS gf180mcu_fd_sc_mcu7t5v0__or2_1
X_513_ _657_/Q _506_/B _508_/S _513_/B2 _514_/I VDD VDD VSS VSS gf180mcu_fd_sc_mcu7t5v0__aoi22_1
XFILLER_24_44 VDD VDD VSS VSS gf180mcu_fd_sc_mcu7t5v0__fill_1
XFILLER_24_66 VDD VDD VSS VSS gf180mcu_fd_sc_mcu7t5v0__fillcap_4
X_358_ _374_/B _385_/B _384_/A2 VDD VDD VSS VSS gf180mcu_fd_sc_mcu7t5v0__nor2_1
X_427_ _429_/A1 _441_/A2 _427_/ZN VDD VDD VSS VSS gf180mcu_fd_sc_mcu7t5v0__nor2_1
XPHY_EDGE_ROW_18_Right_18 VDD VSS gf180mcu_fd_sc_mcu7t5v0__endcap
XPHY_EDGE_ROW_27_Right_27 VDD VSS gf180mcu_fd_sc_mcu7t5v0__endcap
Xinput3 spk_in[14] input3/Z VDD VDD VSS VSS gf180mcu_fd_sc_mcu7t5v0__buf_1
XFILLER_19_88 VDD VDD VSS VSS gf180mcu_fd_sc_mcu7t5v0__fill_1
XPHY_EDGE_ROW_36_Right_36 VDD VSS gf180mcu_fd_sc_mcu7t5v0__endcap
XTAP_TAPCELL_ROW_28_192 VDD VSS gf180mcu_fd_sc_mcu7t5v0__filltie
XFILLER_21_56 VDD VDD VSS VSS gf180mcu_fd_sc_mcu7t5v0__fill_1
XFILLER_24_156 VDD VDD VSS VSS gf180mcu_fd_sc_mcu7t5v0__fill_1
X_761_ spk_in[8] uio_out[0] VDD VDD VSS VSS gf180mcu_fd_sc_mcu7t5v0__buf_1
XFILLER_15_101 VDD VDD VSS VSS gf180mcu_fd_sc_mcu7t5v0__fill_2
Xg_reg\[7\].g_bit\[1\].genblk1.g_l.genblk1.g_d.u_l _710_/D _435_/ZN load_slew33/Z
+ _385_/B VDD VDD VSS VSS gf180mcu_fd_sc_mcu7t5v0__latrnq_1
X_692_ _692_/D _692_/CLK _692_/Q VDD VDD VSS VSS gf180mcu_fd_sc_mcu7t5v0__dffq_1
Xl_r1_b0 _715_/D _439_/ZN l_r1_b1/RN r1_b0 VDD VDD VSS VSS gf180mcu_fd_sc_mcu7t5v0__latrnq_1
XFILLER_28_281 VDD VDD VSS VSS gf180mcu_fd_sc_mcu7t5v0__fill_1
XFILLER_32_33 VDD VDD VSS VSS gf180mcu_fd_sc_mcu7t5v0__fill_2
XPHY_EDGE_ROW_0_Right_0 VDD VSS gf180mcu_fd_sc_mcu7t5v0__endcap
X_675_ _675_/D _677_/RN _705_/CLK _675_/Q VDD VDD VSS VSS gf180mcu_fd_sc_mcu7t5v0__dffrnq_1
XFILLER_21_2 VDD VDD VSS VSS gf180mcu_fd_sc_mcu7t5v0__fill_2
XTAP_TAPCELL_ROW_13_132 VDD VSS gf180mcu_fd_sc_mcu7t5v0__filltie
XTAP_TAPCELL_ROW_36_224 VDD VSS gf180mcu_fd_sc_mcu7t5v0__filltie
X_391_ _375_/B _390_/Z _391_/Z VDD VDD VSS VSS gf180mcu_fd_sc_mcu7t5v0__or2_1
X_460_ _624_/C _525_/A2 _631_/C _696_/D VDD VDD VSS VSS gf180mcu_fd_sc_mcu7t5v0__aoi21_1
XFILLER_4_37 VDD VDD VSS VSS gf180mcu_fd_sc_mcu7t5v0__fill_2
X_589_ _644_/A1 _653_/C _589_/B _591_/A1 VDD VDD VSS VSS gf180mcu_fd_sc_mcu7t5v0__oai21_1
X_658_ _658_/D _698_/RN _698_/CLK _658_/Q VDD VDD VSS VSS gf180mcu_fd_sc_mcu7t5v0__dffrnq_1
XFILLER_13_24 VDD VDD VSS VSS gf180mcu_fd_sc_mcu7t5v0__fill_2
XPHY_EDGE_ROW_18_Left_56 VDD VSS gf180mcu_fd_sc_mcu7t5v0__endcap
XFILLER_9_214 VDD VDD VSS VSS gf180mcu_fd_sc_mcu7t5v0__fill_1
X_374_ _385_/B _406_/A2 _374_/B _376_/A2 VDD VDD VSS VSS gf180mcu_fd_sc_mcu7t5v0__oai21_1
X_443_ _697_/Q _698_/Q _600_/A2 VDD VDD VSS VSS gf180mcu_fd_sc_mcu7t5v0__nor2_1
X_512_ _600_/A2 _509_/Z _512_/A3 _512_/B _513_/B2 VDD VDD VSS VSS gf180mcu_fd_sc_mcu7t5v0__oai31_1
XFILLER_24_34 VDD VDD VSS VSS gf180mcu_fd_sc_mcu7t5v0__fill_1
X_357_ _311_/I _381_/A1 probe_en_c4 VDD VDD VSS VSS gf180mcu_fd_sc_mcu7t5v0__and2_1
X_426_ _717_/D _428_/A2 _428_/A3 _441_/A2 VDD VDD VSS VSS gf180mcu_fd_sc_mcu7t5v0__nand3_1
Xinput4 spk_in[15] input4/Z VDD VDD VSS VSS gf180mcu_fd_sc_mcu7t5v0__buf_1
Xclkbuf_2_3__f_clk_regs clkbuf_0_clk_regs/Z _705_/CLK VDD VDD VSS VSS gf180mcu_fd_sc_mcu7t5v0__clkbuf_4
XTAP_TAPCELL_ROW_28_193 VDD VSS gf180mcu_fd_sc_mcu7t5v0__filltie
X_409_ _719_/D _430_/A2 _438_/A1 VDD VDD VSS VSS gf180mcu_fd_sc_mcu7t5v0__nand2_1
XPHY_EDGE_ROW_6_Left_44 VDD VSS gf180mcu_fd_sc_mcu7t5v0__endcap
X_760_ probe_sub probe_sub_raw[0] VDD VDD VSS VSS gf180mcu_fd_sc_mcu7t5v0__buf_1
X_691_ _691_/D _693_/CLK _691_/Q VDD VDD VSS VSS gf180mcu_fd_sc_mcu7t5v0__dffq_1
Xg_reg\[10\].g_bit\[2\].genblk1.g_l.genblk1.g_d.u_l _711_/D _432_/ZN l_v0_c5/RN _340_/I
+ VDD VDD VSS VSS gf180mcu_fd_sc_mcu7t5v0__latrnq_1
XFILLER_16_24 VDD VDD VSS VSS gf180mcu_fd_sc_mcu7t5v0__fill_2
Xl_r1_b1 _716_/D _439_/ZN l_r1_b1/RN r1_b1 VDD VDD VSS VSS gf180mcu_fd_sc_mcu7t5v0__latrnq_1
Xg_reg\[23\].g_bit\[0\].genblk1.g_l.genblk1.g_d.u_l _709_/D _411_/ZN load_slew33/Z
+ _470_/S VDD VDD VSS VSS gf180mcu_fd_sc_mcu7t5v0__latrnq_1
X_674_ _674_/D _677_/RN _705_/CLK _674_/Q VDD VDD VSS VSS gf180mcu_fd_sc_mcu7t5v0__dffrnq_1
XFILLER_14_2 VDD VDD VSS VSS gf180mcu_fd_sc_mcu7t5v0__fill_2
XTAP_TAPCELL_ROW_13_133 VDD VSS gf180mcu_fd_sc_mcu7t5v0__filltie
XTAP_TAPCELL_ROW_36_225 VDD VSS gf180mcu_fd_sc_mcu7t5v0__filltie
X_390_ _306_/I _387_/Z _390_/Z VDD VDD VSS VSS gf180mcu_fd_sc_mcu7t5v0__xor2_1
Xg_reg\[14\].g_bit\[5\].genblk1.g_l.genblk1.g_d.u_l _714_/D _425_/ZN l_v0_c5/RN _581_/A2
+ VDD VDD VSS VSS gf180mcu_fd_sc_mcu7t5v0__latrnq_1
X_588_ _588_/A1 _643_/B1 _588_/B _588_/C _593_/B1 VDD VDD VSS VSS gf180mcu_fd_sc_mcu7t5v0__oai211_1
X_657_ _657_/D _698_/RN _698_/CLK _657_/Q VDD VDD VSS VSS gf180mcu_fd_sc_mcu7t5v0__dffrnq_1
XFILLER_22_244 VDD VDD VSS VSS gf180mcu_fd_sc_mcu7t5v0__fill_1
XFILLER_1_148 VDD VDD VSS VSS gf180mcu_fd_sc_mcu7t5v0__fill_2
XPHY_EDGE_ROW_35_Left_73 VDD VSS gf180mcu_fd_sc_mcu7t5v0__endcap
X_373_ _306_/I _312_/I _373_/B _380_/C VDD VDD VSS VSS gf180mcu_fd_sc_mcu7t5v0__aoi21_1
X_442_ _414_/Z _442_/A2 _442_/ZN VDD VDD VSS VSS gf180mcu_fd_sc_mcu7t5v0__nor2_1
X_511_ _657_/Q _698_/Q _511_/A3 _645_/B _512_/A3 VDD VDD VSS VSS gf180mcu_fd_sc_mcu7t5v0__nor4_1
X_709_ _709_/D _715_/CLK _710_/D VDD VDD VSS VSS gf180mcu_fd_sc_mcu7t5v0__dffq_1
XFILLER_6_207 VDD VDD VSS VSS gf180mcu_fd_sc_mcu7t5v0__fill_1
Xclkbuf_2_2__f_clk_regs clkbuf_0_clk_regs/Z _698_/CLK VDD VDD VSS VSS gf180mcu_fd_sc_mcu7t5v0__clkbuf_4
X_356_ _374_/B _407_/A1 _356_/A3 _381_/A1 VDD VDD VSS VSS gf180mcu_fd_sc_mcu7t5v0__nor3_1
X_425_ _429_/A1 _440_/A2 _425_/ZN VDD VDD VSS VSS gf180mcu_fd_sc_mcu7t5v0__nor2_1
Xu_lif.u_cg.u_icg_37 u_lif.u_cg.u_icg/TE VDD VDD VSS VSS gf180mcu_fd_sc_mcu7t5v0__tiel
Xinput5 spk_in[16] input5/Z VDD VDD VSS VSS gf180mcu_fd_sc_mcu7t5v0__buf_1
XFILLER_10_26 VDD VDD VSS VSS gf180mcu_fd_sc_mcu7t5v0__fill_1
Xg_reg\[6\].g_bit\[0\].genblk1.g_l.g_c.u_l _709_/D _436_/ZN l_r0_b4/RN cfg_out[0]
+ VDD VDD VSS VSS gf180mcu_fd_sc_mcu7t5v0__latrnq_1
XTAP_TAPCELL_ROW_28_194 VDD VSS gf180mcu_fd_sc_mcu7t5v0__filltie
X_408_ _717_/D _718_/D _416_/A1 VDD VDD VSS VSS gf180mcu_fd_sc_mcu7t5v0__nand2_1
XPHY_EDGE_ROW_22_Left_60 VDD VSS gf180mcu_fd_sc_mcu7t5v0__endcap
X_339_ _339_/I _507_/A1 VDD VDD VSS VSS gf180mcu_fd_sc_mcu7t5v0__clkinv_1
XFILLER_15_103 VDD VDD VSS VSS gf180mcu_fd_sc_mcu7t5v0__fill_1
XFILLER_23_191 VDD VDD VSS VSS gf180mcu_fd_sc_mcu7t5v0__fill_2
X_690_ _690_/D _692_/CLK _690_/Q VDD VDD VSS VSS gf180mcu_fd_sc_mcu7t5v0__dffq_1
XTAP_TAPCELL_ROW_7_110 VDD VSS gf180mcu_fd_sc_mcu7t5v0__filltie
Xl_r1_b2 _709_/D _438_/ZN l_v0_c5/RN r1_b2 VDD VDD VSS VSS gf180mcu_fd_sc_mcu7t5v0__latrnq_1
Xg_reg\[16\].g_bit\[0\].genblk1.g_l.g_c.u_l _709_/D _419_/ZN load_slew31/Z cfg_out[15]
+ VDD VDD VSS VSS gf180mcu_fd_sc_mcu7t5v0__latrnq_1
XFILLER_21_4 VDD VDD VSS VSS gf180mcu_fd_sc_mcu7t5v0__fill_1
XFILLER_7_198 VDD VDD VSS VSS gf180mcu_fd_sc_mcu7t5v0__fill_1
XTAP_TAPCELL_ROW_13_134 VDD VSS gf180mcu_fd_sc_mcu7t5v0__filltie
Xg_reg\[22\].g_bit\[1\].genblk1.g_l.g_c.u_l _710_/D _413_/ZN load_slew33/Z cfg_out[64]
+ VDD VDD VSS VSS gf180mcu_fd_sc_mcu7t5v0__latrnq_1
X_673_ _673_/D _677_/RN _705_/CLK _673_/Q VDD VDD VSS VSS gf180mcu_fd_sc_mcu7t5v0__dffrnq_1
XTAP_TAPCELL_ROW_36_226 VDD VSS gf180mcu_fd_sc_mcu7t5v0__filltie
X_587_ _644_/A1 _587_/A2 _653_/C _588_/C VDD VDD VSS VSS gf180mcu_fd_sc_mcu7t5v0__or3_1
X_725_ _725_/D _725_/RN _725_/CLK _725_/Q VDD VDD VSS VSS gf180mcu_fd_sc_mcu7t5v0__dffrnq_1
X_656_ _656_/D _698_/RN _698_/CLK _656_/Q VDD VDD VSS VSS gf180mcu_fd_sc_mcu7t5v0__dffrnq_1
Xg_reg\[9\].g_bit\[2\].genblk1.g_l.genblk1.g_d.u_l _711_/D _433_/ZN _707_/RN _322_/I
+ VDD VDD VSS VSS gf180mcu_fd_sc_mcu7t5v0__latrnq_1
Xclkbuf_2_1__f_clk_regs clkbuf_0_clk_regs/Z _724_/CLK VDD VDD VSS VSS gf180mcu_fd_sc_mcu7t5v0__clkbuf_4
X_372_ _372_/A1 _372_/A2 _380_/B VDD VDD VSS VSS gf180mcu_fd_sc_mcu7t5v0__nand2_1
X_441_ _414_/Z _441_/A2 _441_/ZN VDD VDD VSS VSS gf180mcu_fd_sc_mcu7t5v0__nor2_1
X_510_ _696_/Q _509_/Z _512_/B VDD VDD VSS VSS gf180mcu_fd_sc_mcu7t5v0__nand2_1
X_708_ _708_/D _715_/CLK _709_/D VDD VDD VSS VSS gf180mcu_fd_sc_mcu7t5v0__dffq_1
X_639_ _644_/A1 _639_/A2 _640_/A3 VDD VDD VSS VSS gf180mcu_fd_sc_mcu7t5v0__nor2_1
X_355_ _375_/B _371_/B _372_/A2 _356_/A3 VDD VDD VSS VSS gf180mcu_fd_sc_mcu7t5v0__nand3_1
X_424_ _428_/A1 _718_/D _428_/A3 _440_/A2 VDD VDD VSS VSS gf180mcu_fd_sc_mcu7t5v0__nand3_1
Xinput6 spk_in[17] input6/Z VDD VDD VSS VSS gf180mcu_fd_sc_mcu7t5v0__buf_1
XFILLER_27_156 VDD VDD VSS VSS gf180mcu_fd_sc_mcu7t5v0__fill_1
XFILLER_4_2 VDD VDD VSS VSS gf180mcu_fd_sc_mcu7t5v0__fillcap_4
XPHY_EDGE_ROW_14_Right_14 VDD VSS gf180mcu_fd_sc_mcu7t5v0__endcap
XPHY_EDGE_ROW_23_Right_23 VDD VSS gf180mcu_fd_sc_mcu7t5v0__endcap
XFILLER_37_2 VDD VDD VSS VSS gf180mcu_fd_sc_mcu7t5v0__fillcap_8
XPHY_EDGE_ROW_32_Right_32 VDD VSS gf180mcu_fd_sc_mcu7t5v0__endcap
XTAP_TAPCELL_ROW_28_195 VDD VSS gf180mcu_fd_sc_mcu7t5v0__filltie
X_338_ _670_/Q _578_/A1 VDD VDD VSS VSS gf180mcu_fd_sc_mcu7t5v0__clkinv_1
X_407_ _407_/A1 _312_/I _407_/A3 probe_sel_bay[2] VDD VDD VSS VSS gf180mcu_fd_sc_mcu7t5v0__nor3_1
Xg_reg\[8\].g_bit\[5\].genblk1.g_l.genblk1.g_d.u_l _714_/D _434_/ZN _707_/RN _368_/A2
+ VDD VDD VSS VSS gf180mcu_fd_sc_mcu7t5v0__latrnq_1
XFILLER_30_129 VDD VDD VSS VSS gf180mcu_fd_sc_mcu7t5v0__fill_2
Xinput20 ui_in[1] _708_/D VDD VDD VSS VSS gf180mcu_fd_sc_mcu7t5v0__buf_1
Xg_reg\[13\].g_bit\[0\].genblk1.g_l.genblk1.g_d.u_l _709_/D _427_/ZN input1/Z _548_/A1
+ VDD VDD VSS VSS gf180mcu_fd_sc_mcu7t5v0__latrnq_1
XFILLER_16_59 VDD VDD VSS VSS gf180mcu_fd_sc_mcu7t5v0__fill_2
XTAP_TAPCELL_ROW_22_168 VDD VSS gf180mcu_fd_sc_mcu7t5v0__filltie
Xl_r1_b3 _710_/D _438_/ZN l_v0_c5/RN r1_b3 VDD VDD VSS VSS gf180mcu_fd_sc_mcu7t5v0__latrnq_1
Xg_reg\[6\].g_bit\[5\].genblk1.g_l.g_c.u_l _714_/D _436_/ZN l_r0_b4/RN cfg_out[5]
+ VDD VDD VSS VSS gf180mcu_fd_sc_mcu7t5v0__latrnq_1
XTAP_TAPCELL_ROW_13_135 VDD VSS gf180mcu_fd_sc_mcu7t5v0__filltie
XTAP_TAPCELL_ROW_7_111 VDD VSS gf180mcu_fd_sc_mcu7t5v0__filltie
X_672_ _672_/D _677_/RN _705_/CLK _672_/Q VDD VDD VSS VSS gf180mcu_fd_sc_mcu7t5v0__dffrnq_1
XFILLER_14_4 VDD VDD VSS VSS gf180mcu_fd_sc_mcu7t5v0__fill_1
XPHY_EDGE_ROW_4_Right_4 VDD VSS gf180mcu_fd_sc_mcu7t5v0__endcap
XTAP_TAPCELL_ROW_36_227 VDD VSS gf180mcu_fd_sc_mcu7t5v0__filltie
Xclkbuf_2_0__f_clk_regs clkbuf_0_clk_regs/Z _725_/CLK VDD VDD VSS VSS gf180mcu_fd_sc_mcu7t5v0__clkbuf_4
X_724_ _724_/D _724_/RN _724_/CLK _724_/Q VDD VDD VSS VSS gf180mcu_fd_sc_mcu7t5v0__dffrnq_1
X_586_ _583_/Z _586_/A2 _659_/Q _586_/C _593_/A2 VDD VDD VSS VSS gf180mcu_fd_sc_mcu7t5v0__aoi211_1
Xg_reg\[17\].g_bit\[1\].genblk1.g_l.g_c.u_l _710_/D _418_/ZN load_slew31/Z cfg_out[24]
+ VDD VDD VSS VSS gf180mcu_fd_sc_mcu7t5v0__latrnq_1
X_655_ _655_/D _693_/CLK _655_/Q VDD VDD VSS VSS gf180mcu_fd_sc_mcu7t5v0__dffq_1
XFILLER_22_202 VDD VDD VSS VSS gf180mcu_fd_sc_mcu7t5v0__fill_2
X_371_ probe_sub_raw[1] probe_sub _371_/B _398_/A1 VDD VDD VSS VSS gf180mcu_fd_sc_mcu7t5v0__aoi21_1
X_440_ _414_/Z _440_/A2 _440_/ZN VDD VDD VSS VSS gf180mcu_fd_sc_mcu7t5v0__nor2_1
Xg_reg\[16\].g_bit\[5\].genblk1.g_l.g_c.u_l _714_/D _419_/ZN load_slew31/Z cfg_out[20]
+ VDD VDD VSS VSS gf180mcu_fd_sc_mcu7t5v0__latrnq_1
X_569_ _569_/A1 _577_/B _569_/B _668_/D VDD VDD VSS VSS gf180mcu_fd_sc_mcu7t5v0__aoi21_1
Xg_reg\[12\].g_bit\[3\].genblk1.g_l.genblk1.g_d.u_l _712_/D _429_/ZN l_r1_b1/RN _639_/A2
+ VDD VDD VSS VSS gf180mcu_fd_sc_mcu7t5v0__latrnq_1
X_707_ _707_/D _707_/RN _724_/CLK _707_/Q VDD VDD VSS VSS gf180mcu_fd_sc_mcu7t5v0__dffrnq_2
X_638_ _656_/Q _645_/B _638_/B _640_/A2 VDD VDD VSS VSS gf180mcu_fd_sc_mcu7t5v0__aoi21_1
XFILLER_5_72 VDD VDD VSS VSS gf180mcu_fd_sc_mcu7t5v0__fill_2
Xg_reg\[22\].g_bit\[6\].genblk1.g_l.g_c.u_l _715_/D _413_/ZN load_slew33/Z cfg_out[69]
+ VDD VDD VSS VSS gf180mcu_fd_sc_mcu7t5v0__latrnq_1
X_354_ probe_sub_raw[1] probe_sub _372_/A2 VDD VDD VSS VSS gf180mcu_fd_sc_mcu7t5v0__nand2_1
X_423_ _429_/A1 _439_/A2 _423_/ZN VDD VDD VSS VSS gf180mcu_fd_sc_mcu7t5v0__nor2_1
XTAP_TAPCELL_ROW_1_84 VDD VSS gf180mcu_fd_sc_mcu7t5v0__filltie
Xinput7 spk_in[18] input7/Z VDD VDD VSS VSS gf180mcu_fd_sc_mcu7t5v0__buf_1
Xl_i2_b0 _711_/D _441_/ZN l_r1_b1/RN i2_b0 VDD VDD VSS VSS gf180mcu_fd_sc_mcu7t5v0__latrnq_1
XFILLER_35_25 VDD VDD VSS VSS gf180mcu_fd_sc_mcu7t5v0__fill_1
X_337_ _668_/Q _569_/A1 VDD VDD VSS VSS gf180mcu_fd_sc_mcu7t5v0__clkinv_1
X_406_ _385_/B _406_/A2 _407_/A3 probe_sel_bay[1] VDD VDD VSS VSS gf180mcu_fd_sc_mcu7t5v0__nor3_1
XFILLER_21_27 VDD VDD VSS VSS gf180mcu_fd_sc_mcu7t5v0__fill_1
Xg_reg\[11\].g_bit\[6\].genblk1.g_l.genblk1.g_d.u_l _715_/D _431_/ZN load_slew33/Z
+ _327_/I VDD VDD VSS VSS gf180mcu_fd_sc_mcu7t5v0__latrnq_1
XFILLER_23_193 VDD VDD VSS VSS gf180mcu_fd_sc_mcu7t5v0__fill_1
XTAP_TAPCELL_ROW_16_144 VDD VSS gf180mcu_fd_sc_mcu7t5v0__filltie
XFILLER_32_37 VDD VDD VSS VSS gf180mcu_fd_sc_mcu7t5v0__fillcap_16
Xl_r1_b4 _711_/D _438_/ZN l_v0_c5/RN r1_b4 VDD VDD VSS VSS gf180mcu_fd_sc_mcu7t5v0__latrnq_1
Xinput21 ui_in[2] _317_/I VDD VDD VSS VSS gf180mcu_fd_sc_mcu7t5v0__buf_1
Xinput10 spk_in[20] _467_/I1 VDD VDD VSS VSS gf180mcu_fd_sc_mcu7t5v0__buf_1
XTAP_TAPCELL_ROW_22_169 VDD VSS gf180mcu_fd_sc_mcu7t5v0__filltie
X_671_ _671_/D _724_/RN _725_/CLK _671_/Q VDD VDD VSS VSS gf180mcu_fd_sc_mcu7t5v0__dffrnq_1
XFILLER_25_244 VDD VDD VSS VSS gf180mcu_fd_sc_mcu7t5v0__fill_2
XFILLER_31_236 VDD VDD VSS VSS gf180mcu_fd_sc_mcu7t5v0__fill_1
XFILLER_31_269 VDD VDD VSS VSS gf180mcu_fd_sc_mcu7t5v0__fill_2
X_585_ _590_/C _653_/C _585_/A3 _586_/A2 VDD VDD VSS VSS gf180mcu_fd_sc_mcu7t5v0__nor3_1
X_723_ _723_/D _725_/RN _724_/CLK _723_/Q VDD VDD VSS VSS gf180mcu_fd_sc_mcu7t5v0__dffrnq_1
X_654_ _654_/A1 _653_/B _654_/B1 _654_/B2 _680_/D VDD VDD VSS VSS gf180mcu_fd_sc_mcu7t5v0__aoi22_1
XFILLER_9_207 VDD VDD VSS VSS gf180mcu_fd_sc_mcu7t5v0__fill_2
X_370_ _370_/A1 _370_/A2 rt_out[3] VDD VDD VSS VSS gf180mcu_fd_sc_mcu7t5v0__and2_1
X_706_ _706_/D _707_/RN _724_/CLK _706_/Q VDD VDD VSS VSS gf180mcu_fd_sc_mcu7t5v0__dffrnq_1
X_637_ _657_/Q _645_/B _643_/B1 _637_/B2 _637_/C _641_/A1 VDD VDD VSS VSS gf180mcu_fd_sc_mcu7t5v0__aoi221_1
X_499_ _501_/A2 _501_/A3 _503_/A3 VDD VDD VSS VSS gf180mcu_fd_sc_mcu7t5v0__nand2_1
X_568_ _487_/B _631_/C _577_/B _568_/C _569_/B VDD VDD VSS VSS gf180mcu_fd_sc_mcu7t5v0__aoi211_1
Xg_reg\[18\].g_bit\[2\].genblk1.g_l.g_c.u_l _711_/D _417_/ZN load_slew31/Z cfg_out[33]
+ VDD VDD VSS VSS gf180mcu_fd_sc_mcu7t5v0__latrnq_1
X_353_ _353_/A1 bias_en ua0_int VDD VDD VSS VSS gf180mcu_fd_sc_mcu7t5v0__and2_1
X_422_ _717_/D _718_/D _428_/A3 _439_/A2 VDD VDD VSS VSS gf180mcu_fd_sc_mcu7t5v0__nand3_1
Xg_reg\[7\].g_bit\[0\].genblk1.g_l.genblk1.g_d.u_l _709_/D _435_/ZN load_slew33/Z
+ _312_/I VDD VDD VSS VSS gf180mcu_fd_sc_mcu7t5v0__latrnq_1
XTAP_TAPCELL_ROW_1_85 VDD VSS gf180mcu_fd_sc_mcu7t5v0__filltie
Xinput8 spk_in[19] input8/Z VDD VDD VSS VSS gf180mcu_fd_sc_mcu7t5v0__buf_1
Xl_i2_b1 _712_/D _441_/ZN l_r1_b1/RN i2_b1 VDD VDD VSS VSS gf180mcu_fd_sc_mcu7t5v0__latrnq_1
Xg_reg\[17\].g_bit\[6\].genblk1.g_l.g_c.u_l _715_/D _418_/ZN load_slew31/Z cfg_out[29]
+ VDD VDD VSS VSS gf180mcu_fd_sc_mcu7t5v0__latrnq_1
X_336_ _666_/Q _560_/A1 VDD VDD VSS VSS gf180mcu_fd_sc_mcu7t5v0__clkinv_1
X_405_ _385_/B _312_/I _407_/A3 probe_sel_bay[0] VDD VDD VSS VSS gf180mcu_fd_sc_mcu7t5v0__nor3_1
XFILLER_11_61 VDD VDD VSS VSS gf180mcu_fd_sc_mcu7t5v0__fill_1
XFILLER_11_94 VDD VDD VSS VSS gf180mcu_fd_sc_mcu7t5v0__fill_2
XFILLER_23_150 VDD VDD VSS VSS gf180mcu_fd_sc_mcu7t5v0__fill_2
XFILLER_14_172 VDD VDD VSS VSS gf180mcu_fd_sc_mcu7t5v0__fill_2
XPHY_EDGE_ROW_10_Left_48 VDD VSS gf180mcu_fd_sc_mcu7t5v0__endcap
XPHY_EDGE_ROW_26_Left_64 VDD VSS gf180mcu_fd_sc_mcu7t5v0__endcap
XTAP_TAPCELL_ROW_16_145 VDD VSS gf180mcu_fd_sc_mcu7t5v0__filltie
X_319_ _319_/I _590_/A2 VDD VDD VSS VSS gf180mcu_fd_sc_mcu7t5v0__clkinv_1
Xinput22 ui_in[3] _313_/I VDD VDD VSS VSS gf180mcu_fd_sc_mcu7t5v0__buf_1
Xinput11 spk_in[21] _468_/I1 VDD VDD VSS VSS gf180mcu_fd_sc_mcu7t5v0__buf_1
Xclkbuf_1_0__f_clk clkbuf_0_clk/Z clkbuf_1_0__f_clk/Z VDD VDD VSS VSS gf180mcu_fd_sc_mcu7t5v0__clkbuf_4
X_670_ _670_/D _725_/RN _725_/CLK _670_/Q VDD VDD VSS VSS gf180mcu_fd_sc_mcu7t5v0__dffrnq_1
XFILLER_22_71 VDD VDD VSS VSS gf180mcu_fd_sc_mcu7t5v0__fillcap_16
XTAP_TAPCELL_ROW_4_96 VDD VSS gf180mcu_fd_sc_mcu7t5v0__filltie
X_584_ _656_/Q _584_/A2 _585_/A3 VDD VDD VSS VSS gf180mcu_fd_sc_mcu7t5v0__nor2_1
X_722_ _722_/D _725_/RN _724_/CLK _723_/D VDD VDD VSS VSS gf180mcu_fd_sc_mcu7t5v0__dffrnq_1
X_653_ _654_/A1 _597_/Z _653_/B _653_/C _654_/B1 VDD VDD VSS VSS gf180mcu_fd_sc_mcu7t5v0__oai211_1
XTAP_TAPCELL_ROW_32_210 VDD VSS gf180mcu_fd_sc_mcu7t5v0__filltie
XPHY_EDGE_ROW_13_Left_51 VDD VSS gf180mcu_fd_sc_mcu7t5v0__endcap
X_498_ _498_/A1 _498_/A2 _641_/B _501_/A3 VDD VDD VSS VSS gf180mcu_fd_sc_mcu7t5v0__oai21_1
X_567_ _567_/A1 _567_/A2 _568_/C VDD VDD VSS VSS gf180mcu_fd_sc_mcu7t5v0__nor2_1
X_705_ _705_/D _707_/Q _705_/CLK _705_/Q VDD VDD VSS VSS gf180mcu_fd_sc_mcu7t5v0__dffrnq_1
X_636_ _656_/Q _645_/B _636_/B _637_/C VDD VDD VSS VSS gf180mcu_fd_sc_mcu7t5v0__aoi21_1
X_421_ _720_/Q _421_/A2 _428_/A3 VDD VDD VSS VSS gf180mcu_fd_sc_mcu7t5v0__nor2_1
XFILLER_5_222 VDD VDD VSS VSS gf180mcu_fd_sc_mcu7t5v0__fill_2
XTAP_TAPCELL_ROW_1_86 VDD VSS gf180mcu_fd_sc_mcu7t5v0__filltie
X_352_ ua0_s1 ua0_stim ua0_s0 VDD VDD VSS VSS gf180mcu_fd_sc_mcu7t5v0__nor2_1
Xinput9 spk_in[1] input9/Z VDD VDD VSS VSS gf180mcu_fd_sc_mcu7t5v0__buf_1
Xg_reg\[10\].g_bit\[1\].genblk1.g_l.genblk1.g_d.u_l _710_/D _432_/ZN l_v0_c5/RN _511_/A3
+ VDD VDD VSS VSS gf180mcu_fd_sc_mcu7t5v0__latrnq_1
X_619_ _674_/Q _452_/Z _675_/Q _620_/I VDD VDD VSS VSS gf180mcu_fd_sc_mcu7t5v0__oai21_1
Xl_i2_b2 _713_/D _441_/ZN l_r1_b1/RN i2_b2 VDD VDD VSS VSS gf180mcu_fd_sc_mcu7t5v0__latrnq_1
Xg_reg\[19\].g_bit\[3\].genblk1.g_l.g_c.u_l _712_/D _416_/ZN load_slew33/Z cfg_out[42]
+ VDD VDD VSS VSS gf180mcu_fd_sc_mcu7t5v0__latrnq_1
X_335_ _664_/Q _551_/A1 VDD VDD VSS VSS gf180mcu_fd_sc_mcu7t5v0__clkinv_1
X_404_ _311_/I _404_/A2 _404_/A3 _407_/A3 VDD VDD VSS VSS gf180mcu_fd_sc_mcu7t5v0__nand3_1
XFILLER_24_129 VDD VDD VSS VSS gf180mcu_fd_sc_mcu7t5v0__fill_1
XFILLER_32_162 VDD VDD VSS VSS gf180mcu_fd_sc_mcu7t5v0__fill_1
XPHY_EDGE_ROW_10_Right_10 VDD VSS gf180mcu_fd_sc_mcu7t5v0__endcap
Xg_reg\[18\].g_bit\[7\].genblk1.g_l.g_c.u_l _716_/D _417_/ZN load_slew33/Z cfg_out[38]
+ VDD VDD VSS VSS gf180mcu_fd_sc_mcu7t5v0__latrnq_1
Xg_reg\[14\].g_bit\[4\].genblk1.g_l.genblk1.g_d.u_l _713_/D _425_/ZN l_v0_c5/RN _582_/A1
+ VDD VDD VSS VSS gf180mcu_fd_sc_mcu7t5v0__latrnq_1
XFILLER_2_2 VDD VDD VSS VSS gf180mcu_fd_sc_mcu7t5v0__fill_1
XFILLER_35_2 VDD VDD VSS VSS gf180mcu_fd_sc_mcu7t5v0__fill_1
XTAP_TAPCELL_ROW_16_146 VDD VSS gf180mcu_fd_sc_mcu7t5v0__filltie
X_318_ _318_/I _589_/B VDD VDD VSS VSS gf180mcu_fd_sc_mcu7t5v0__clkinv_1
Xinput23 ui_in[4] _481_/A1 VDD VDD VSS VSS gf180mcu_fd_sc_mcu7t5v0__buf_1
Xinput12 spk_in[22] _469_/I1 VDD VDD VSS VSS gf180mcu_fd_sc_mcu7t5v0__buf_1
XFILLER_25_235 VDD VDD VSS VSS gf180mcu_fd_sc_mcu7t5v0__fill_2
X_583_ _644_/A1 _583_/A2 _653_/C _583_/Z VDD VDD VSS VSS gf180mcu_fd_sc_mcu7t5v0__or3_1
X_721_ _721_/D _725_/RN _724_/CLK _721_/Q VDD VDD VSS VSS gf180mcu_fd_sc_mcu7t5v0__dffrnq_1
X_652_ _648_/B _649_/Z _652_/A3 _652_/B _679_/D VDD VDD VSS VSS gf180mcu_fd_sc_mcu7t5v0__oai31_1
XFILLER_3_150 VDD VDD VSS VSS gf180mcu_fd_sc_mcu7t5v0__fill_1
XPHY_EDGE_ROW_8_Right_8 VDD VSS gf180mcu_fd_sc_mcu7t5v0__endcap
XTAP_TAPCELL_ROW_32_211 VDD VSS gf180mcu_fd_sc_mcu7t5v0__filltie
XTAP_TAPCELL_ROW_4_97 VDD VSS gf180mcu_fd_sc_mcu7t5v0__filltie
Xg_reg\[13\].g_bit\[7\].genblk1.g_l.genblk1.g_d.u_l _716_/D _427_/ZN l_v0_c5/RN _600_/A1
+ VDD VDD VSS VSS gf180mcu_fd_sc_mcu7t5v0__latrnq_1
XFILLER_9_209 VDD VDD VSS VSS gf180mcu_fd_sc_mcu7t5v0__fill_1
X_497_ _656_/Q _563_/A1 _588_/B _497_/C _498_/A2 VDD VDD VSS VSS gf180mcu_fd_sc_mcu7t5v0__aoi211_1
X_566_ _566_/A1 _444_/Z _622_/C _567_/A2 VDD VDD VSS VSS gf180mcu_fd_sc_mcu7t5v0__oai21_1
X_704_ _704_/D _707_/Q _724_/CLK _705_/D VDD VDD VSS VSS gf180mcu_fd_sc_mcu7t5v0__dffrnq_1
X_635_ _645_/B _653_/B _648_/B VDD VDD VSS VSS gf180mcu_fd_sc_mcu7t5v0__nand2_1
XFILLER_5_278 VDD VDD VSS VSS gf180mcu_fd_sc_mcu7t5v0__fill_2
XTAP_TAPCELL_ROW_1_87 VDD VSS gf180mcu_fd_sc_mcu7t5v0__filltie
X_351_ _351_/A1 _353_/A1 ua0_stim VDD VDD VSS VSS gf180mcu_fd_sc_mcu7t5v0__and2_1
X_420_ _719_/D _720_/D _429_/A1 VDD VDD VSS VSS gf180mcu_fd_sc_mcu7t5v0__nand2_1
X_549_ _549_/A1 _549_/A2 _550_/C VDD VDD VSS VSS gf180mcu_fd_sc_mcu7t5v0__nor2_1
Xl_i2_b3 _714_/D _441_/ZN l_r1_b1/RN i2_b3 VDD VDD VSS VSS gf180mcu_fd_sc_mcu7t5v0__latrnq_1
X_618_ _675_/Q _621_/B _623_/A1 VDD VDD VSS VSS gf180mcu_fd_sc_mcu7t5v0__nand2_1
XFILLER_25_72 VDD VDD VSS VSS gf180mcu_fd_sc_mcu7t5v0__fillcap_4
XFILLER_4_6 VDD VDD VSS VSS gf180mcu_fd_sc_mcu7t5v0__fill_1
X_334_ _695_/Q _462_/B VDD VDD VSS VSS gf180mcu_fd_sc_mcu7t5v0__clkinv_1
X_403_ _389_/I _403_/A2 probe_en_c[3] VDD VDD VSS VSS gf180mcu_fd_sc_mcu7t5v0__nor2_1
XFILLER_17_171 VDD VDD VSS VSS gf180mcu_fd_sc_mcu7t5v0__fill_1
XFILLER_23_152 VDD VDD VSS VSS gf180mcu_fd_sc_mcu7t5v0__fill_1
Xclkbuf_0_ui_in[0] ui_in[0] clkbuf_0_ui_in[0]/Z VDD VDD VSS VSS gf180mcu_fd_sc_mcu7t5v0__clkbuf_4
XFILLER_14_174 VDD VDD VSS VSS gf180mcu_fd_sc_mcu7t5v0__fill_1
XFILLER_14_185 VDD VDD VSS VSS gf180mcu_fd_sc_mcu7t5v0__fill_2
XTAP_TAPCELL_ROW_16_147 VDD VSS gf180mcu_fd_sc_mcu7t5v0__filltie
X_317_ _317_/I _421_/A2 VDD VDD VSS VSS gf180mcu_fd_sc_mcu7t5v0__clkinv_1
Xinput24 ui_in[5] _369_/A1 VDD VDD VSS VSS gf180mcu_fd_sc_mcu7t5v0__buf_1
Xinput13 spk_in[23] _470_/I1 VDD VDD VSS VSS gf180mcu_fd_sc_mcu7t5v0__buf_1
XFILLER_28_2 VDD VDD VSS VSS gf180mcu_fd_sc_mcu7t5v0__fill_2
Xg_reg\[9\].g_bit\[1\].genblk1.g_l.genblk1.g_d.u_l _710_/D _433_/ZN _707_/RN _482_/B
+ VDD VDD VSS VSS gf180mcu_fd_sc_mcu7t5v0__latrnq_1
XFILLER_22_95 VDD VDD VSS VSS gf180mcu_fd_sc_mcu7t5v0__fill_2
XFILLER_16_247 VDD VDD VSS VSS gf180mcu_fd_sc_mcu7t5v0__fill_1
XTAP_TAPCELL_ROW_35_220 VDD VSS gf180mcu_fd_sc_mcu7t5v0__filltie
X_582_ _582_/A1 _643_/B1 _582_/B _590_/C _593_/A1 VDD VDD VSS VSS gf180mcu_fd_sc_mcu7t5v0__oai211_1
X_720_ _720_/D _720_/CLK _720_/Q VDD VDD VSS VSS gf180mcu_fd_sc_mcu7t5v0__dffq_1
X_651_ _654_/A1 _597_/Z _652_/A3 VDD VDD VSS VSS gf180mcu_fd_sc_mcu7t5v0__nor2_1
XFILLER_33_94 VDD VDD VSS VSS gf180mcu_fd_sc_mcu7t5v0__fill_2
XTAP_TAPCELL_ROW_4_98 VDD VSS gf180mcu_fd_sc_mcu7t5v0__filltie
X_496_ _656_/Q _645_/B _496_/B _497_/C VDD VDD VSS VSS gf180mcu_fd_sc_mcu7t5v0__aoi21_1
X_565_ _669_/Q _600_/A2 _567_/A1 VDD VDD VSS VSS gf180mcu_fd_sc_mcu7t5v0__nor2_1
Xg_reg\[8\].g_bit\[4\].genblk1.g_l.genblk1.g_d.u_l _713_/D _434_/ZN _707_/RN _367_/A2
+ VDD VDD VSS VSS gf180mcu_fd_sc_mcu7t5v0__latrnq_1
X_703_ _703_/D _707_/Q _724_/CLK _703_/Q VDD VDD VSS VSS gf180mcu_fd_sc_mcu7t5v0__dffrnq_1
X_634_ _678_/Q _634_/I1 _634_/S _678_/D VDD VDD VSS VSS gf180mcu_fd_sc_mcu7t5v0__mux2_2
XFILLER_10_2 VDD VDD VSS VSS gf180mcu_fd_sc_mcu7t5v0__fill_2
X_350_ _351_/A1 _353_/A1 ua0_s1 VDD VDD VSS VSS gf180mcu_fd_sc_mcu7t5v0__nor2_1
X_479_ _679_/Q _680_/Q _479_/B _479_/C _480_/I VDD VDD VSS VSS gf180mcu_fd_sc_mcu7t5v0__oai211_1
X_548_ _548_/A1 _444_/Z _622_/C _549_/A2 VDD VDD VSS VSS gf180mcu_fd_sc_mcu7t5v0__oai21_1
Xl_i2_b4 _715_/D _441_/ZN l_r0_b4/RN i2_b4 VDD VDD VSS VSS gf180mcu_fd_sc_mcu7t5v0__latrnq_1
X_617_ _617_/A1 _617_/A2 _617_/B _674_/D VDD VDD VSS VSS gf180mcu_fd_sc_mcu7t5v0__oai21_1
XTAP_TAPCELL_ROW_19_156 VDD VSS gf180mcu_fd_sc_mcu7t5v0__filltie
X_333_ _333_/I _643_/B2 VDD VDD VSS VSS gf180mcu_fd_sc_mcu7t5v0__clkinv_1
X_402_ _377_/Z _402_/A2 _402_/B probe_rsel[3] VDD VDD VSS VSS gf180mcu_fd_sc_mcu7t5v0__aoi21_1
XFILLER_14_131 VDD VDD VSS VSS gf180mcu_fd_sc_mcu7t5v0__fill_1
X_316_ _720_/D _430_/A2 VDD VDD VSS VSS gf180mcu_fd_sc_mcu7t5v0__clkinv_1
Xinput25 ui_in[6] _370_/A1 VDD VDD VSS VSS gf180mcu_fd_sc_mcu7t5v0__buf_1
Xinput14 spk_in[2] _465_/I0 VDD VDD VSS VSS gf180mcu_fd_sc_mcu7t5v0__buf_1
Xg_reg\[7\].g_bit\[7\].genblk1.g_l.genblk1.g_d.u_l _716_/D _435_/ZN load_slew33/Z
+ _371_/B VDD VDD VSS VSS gf180mcu_fd_sc_mcu7t5v0__latrnq_1
XFILLER_20_145 VDD VDD VSS VSS gf180mcu_fd_sc_mcu7t5v0__fill_1
XFILLER_37_201 VDD VDD VSS VSS gf180mcu_fd_sc_mcu7t5v0__fill_2
XFILLER_37_256 VDD VDD VSS VSS gf180mcu_fd_sc_mcu7t5v0__fill_2
XFILLER_28_234 VDD VDD VSS VSS gf180mcu_fd_sc_mcu7t5v0__fill_2
Xg_reg\[12\].g_bit\[2\].genblk1.g_l.genblk1.g_d.u_l _711_/D _429_/ZN l_r1_b1/RN _638_/B
+ VDD VDD VSS VSS gf180mcu_fd_sc_mcu7t5v0__latrnq_1
XFILLER_19_212 VDD VDD VSS VSS gf180mcu_fd_sc_mcu7t5v0__fill_2
XFILLER_19_223 VDD VDD VSS VSS gf180mcu_fd_sc_mcu7t5v0__fill_2
XFILLER_25_237 VDD VDD VSS VSS gf180mcu_fd_sc_mcu7t5v0__fill_1
XTAP_TAPCELL_ROW_35_221 VDD VSS gf180mcu_fd_sc_mcu7t5v0__filltie
X_650_ _650_/A1 _650_/A2 _652_/B VDD VDD VSS VSS gf180mcu_fd_sc_mcu7t5v0__or2_1
XFILLER_24_281 VDD VDD VSS VSS gf180mcu_fd_sc_mcu7t5v0__fill_1
XFILLER_33_51 VDD VDD VSS VSS gf180mcu_fd_sc_mcu7t5v0__fill_2
XTAP_TAPCELL_ROW_4_99 VDD VSS gf180mcu_fd_sc_mcu7t5v0__filltie
X_581_ _644_/A1 _581_/A2 _653_/C _582_/B VDD VDD VSS VSS gf180mcu_fd_sc_mcu7t5v0__or3_1
X_495_ _657_/Q _645_/B _643_/B1 _554_/A1 _495_/C _498_/A1 VDD VDD VSS VSS gf180mcu_fd_sc_mcu7t5v0__aoi221_1
X_564_ _564_/I0 _667_/Q _577_/B _667_/D VDD VDD VSS VSS gf180mcu_fd_sc_mcu7t5v0__mux2_2
X_702_ _702_/D _707_/Q _483_/ZN _702_/Q VDD VDD VSS VSS gf180mcu_fd_sc_mcu7t5v0__dffrnq_1
X_633_ _482_/B _633_/A2 _633_/B _634_/I1 VDD VDD VSS VSS gf180mcu_fd_sc_mcu7t5v0__oai21_1
XPHY_EDGE_ROW_17_Left_55 VDD VSS gf180mcu_fd_sc_mcu7t5v0__endcap
Xg_reg\[11\].g_bit\[5\].genblk1.g_l.genblk1.g_d.u_l _714_/D _431_/ZN load_slew33/Z
+ _325_/I VDD VDD VSS VSS gf180mcu_fd_sc_mcu7t5v0__latrnq_1
XFILLER_36_107 VDD VDD VSS VSS gf180mcu_fd_sc_mcu7t5v0__fill_2
X_478_ _696_/Q _444_/Z _478_/Z VDD VDD VSS VSS gf180mcu_fd_sc_mcu7t5v0__or2_1
X_547_ _665_/Q _600_/A2 _549_/A1 VDD VDD VSS VSS gf180mcu_fd_sc_mcu7t5v0__nor2_1
X_616_ _694_/Q _616_/A2 _622_/C _617_/A2 VDD VDD VSS VSS gf180mcu_fd_sc_mcu7t5v0__oai21_1
Xclkbuf_0_clk_regs clkbuf_regs_0_clk/Z clkbuf_0_clk_regs/Z VDD VDD VSS VSS gf180mcu_fd_sc_mcu7t5v0__clkbuf_4
XFILLER_25_85 VDD VDD VSS VSS gf180mcu_fd_sc_mcu7t5v0__fill_1
XFILLER_26_173 VDD VDD VSS VSS gf180mcu_fd_sc_mcu7t5v0__fill_2
X_332_ _332_/I _637_/B2 VDD VDD VSS VSS gf180mcu_fd_sc_mcu7t5v0__clkinv_1
X_401_ _380_/B _389_/I _396_/B probe_en_c[2] VDD VDD VSS VSS gf180mcu_fd_sc_mcu7t5v0__nor3_1
XTAP_TAPCELL_ROW_19_157 VDD VSS gf180mcu_fd_sc_mcu7t5v0__filltie
XTAP_TAPCELL_ROW_27_190 VDD VSS gf180mcu_fd_sc_mcu7t5v0__filltie
XFILLER_37_235 VDD VDD VSS VSS gf180mcu_fd_sc_mcu7t5v0__fill_2
X_315_ _718_/D _428_/A2 VDD VDD VSS VSS gf180mcu_fd_sc_mcu7t5v0__clkinv_1
Xinput26 ui_in[7] _703_/D VDD VDD VSS VSS gf180mcu_fd_sc_mcu7t5v0__buf_1
Xinput15 spk_in[3] _466_/I0 VDD VDD VSS VSS gf180mcu_fd_sc_mcu7t5v0__buf_1
XFILLER_22_20 VDD VDD VSS VSS gf180mcu_fd_sc_mcu7t5v0__fill_1
Xg_reg\[22\].g_bit\[0\].genblk1.g_l.g_c.u_l _709_/D _413_/ZN load_slew33/Z cfg_out[63]
+ VDD VDD VSS VSS gf180mcu_fd_sc_mcu7t5v0__latrnq_1
Xg_reg\[15\].g_bit\[3\].genblk1.g_l.g_c.u_l _712_/D _423_/ZN load_slew31/Z cfg_out[10]
+ VDD VDD VSS VSS gf180mcu_fd_sc_mcu7t5v0__latrnq_1
XFILLER_0_2 VDD VDD VSS VSS gf180mcu_fd_sc_mcu7t5v0__fillcap_4
XPHY_EDGE_ROW_5_Left_43 VDD VSS gf180mcu_fd_sc_mcu7t5v0__endcap
XTAP_TAPCELL_ROW_12_130 VDD VSS gf180mcu_fd_sc_mcu7t5v0__filltie
XFILLER_33_2 VDD VDD VSS VSS gf180mcu_fd_sc_mcu7t5v0__fillcap_4
XTAP_TAPCELL_ROW_35_222 VDD VSS gf180mcu_fd_sc_mcu7t5v0__filltie
XPHY_EDGE_ROW_31_Left_69 VDD VSS gf180mcu_fd_sc_mcu7t5v0__endcap
X_580_ _676_/Q _627_/A2 _580_/Z VDD VDD VSS VSS gf180mcu_fd_sc_mcu7t5v0__xor2_1
XFILLER_0_178 VDD VDD VSS VSS gf180mcu_fd_sc_mcu7t5v0__fill_1
XPHY_EDGE_ROW_17_Right_17 VDD VSS gf180mcu_fd_sc_mcu7t5v0__endcap
XPHY_EDGE_ROW_26_Right_26 VDD VSS gf180mcu_fd_sc_mcu7t5v0__endcap
X_563_ _563_/A1 _622_/C _563_/B1 _563_/B2 _564_/I0 VDD VDD VSS VSS gf180mcu_fd_sc_mcu7t5v0__oai22_1
X_701_ _701_/D _707_/Q _705_/CLK _701_/Q VDD VDD VSS VSS gf180mcu_fd_sc_mcu7t5v0__dffrnq_1
X_632_ _632_/A1 _632_/A2 _632_/A3 _653_/B _632_/B2 _677_/D VDD VDD VSS VSS gf180mcu_fd_sc_mcu7t5v0__oai32_1
XFILLER_8_201 VDD VDD VSS VSS gf180mcu_fd_sc_mcu7t5v0__fill_1
XPHY_EDGE_ROW_35_Right_35 VDD VSS gf180mcu_fd_sc_mcu7t5v0__endcap
X_494_ _656_/Q _645_/B _494_/B _495_/C VDD VDD VSS VSS gf180mcu_fd_sc_mcu7t5v0__aoi21_1
XFILLER_14_98 VDD VDD VSS VSS gf180mcu_fd_sc_mcu7t5v0__fill_1
XPHY_EDGE_ROW_34_Left_72 VDD VSS gf180mcu_fd_sc_mcu7t5v0__endcap
X_477_ _697_/Q _698_/Q _696_/Q _479_/C VDD VDD VSS VSS gf180mcu_fd_sc_mcu7t5v0__nor3_1
X_546_ _546_/I _663_/D VDD VDD VSS VSS gf180mcu_fd_sc_mcu7t5v0__clkinv_1
X_615_ _674_/Q _452_/Z _610_/B _615_/B2 _617_/A1 VDD VDD VSS VSS gf180mcu_fd_sc_mcu7t5v0__aoi22_1
XFILLER_25_31 VDD VDD VSS VSS gf180mcu_fd_sc_mcu7t5v0__fillcap_16
X_331_ _680_/Q _654_/B2 VDD VDD VSS VSS gf180mcu_fd_sc_mcu7t5v0__clkinv_1
X_400_ _400_/A1 _402_/B probe_rsel[2] VDD VDD VSS VSS gf180mcu_fd_sc_mcu7t5v0__nor2_1
XTAP_TAPCELL_ROW_19_158 VDD VSS gf180mcu_fd_sc_mcu7t5v0__filltie
XTAP_TAPCELL_ROW_27_191 VDD VSS gf180mcu_fd_sc_mcu7t5v0__filltie
X_529_ _524_/C _528_/Z _529_/B _659_/D VDD VDD VSS VSS gf180mcu_fd_sc_mcu7t5v0__oai21_1
XFILLER_23_100 VDD VDD VSS VSS gf180mcu_fd_sc_mcu7t5v0__fill_1
Xg_reg\[6\].g_bit\[4\].genblk1.g_l.g_c.u_l _713_/D _436_/ZN l_r0_b4/RN cfg_out[4]
+ VDD VDD VSS VSS gf180mcu_fd_sc_mcu7t5v0__latrnq_1
XFILLER_37_203 VDD VDD VSS VSS gf180mcu_fd_sc_mcu7t5v0__fill_1
X_314_ _717_/D _428_/A1 VDD VDD VSS VSS gf180mcu_fd_sc_mcu7t5v0__clkinv_1
Xinput16 spk_in[4] _467_/I0 VDD VDD VSS VSS gf180mcu_fd_sc_mcu7t5v0__buf_1
XFILLER_20_103 VDD VDD VSS VSS gf180mcu_fd_sc_mcu7t5v0__fill_2
XFILLER_11_125 VDD VDD VSS VSS gf180mcu_fd_sc_mcu7t5v0__fill_2
XFILLER_22_87 VDD VDD VSS VSS gf180mcu_fd_sc_mcu7t5v0__fillcap_8
XTAP_TAPCELL_ROW_12_131 VDD VSS gf180mcu_fd_sc_mcu7t5v0__filltie
XTAP_TAPCELL_ROW_21_164 VDD VSS gf180mcu_fd_sc_mcu7t5v0__filltie
XTAP_TAPCELL_ROW_35_223 VDD VSS gf180mcu_fd_sc_mcu7t5v0__filltie
Xg_reg\[17\].g_bit\[0\].genblk1.g_l.g_c.u_l _709_/D _418_/ZN load_slew31/Z cfg_out[23]
+ VDD VDD VSS VSS gf180mcu_fd_sc_mcu7t5v0__latrnq_1
XFILLER_33_53 VDD VDD VSS VSS gf180mcu_fd_sc_mcu7t5v0__fill_1
Xg_reg\[10\].g_bit\[0\].genblk1.g_l.genblk1.g_d.u_l _709_/D _432_/ZN l_v0_c5/RN _339_/I
+ VDD VDD VSS VSS gf180mcu_fd_sc_mcu7t5v0__latrnq_1
XFILLER_30_242 VDD VDD VSS VSS gf180mcu_fd_sc_mcu7t5v0__fill_2
Xg_reg\[16\].g_bit\[4\].genblk1.g_l.g_c.u_l _713_/D _419_/ZN load_slew31/Z cfg_out[19]
+ VDD VDD VSS VSS gf180mcu_fd_sc_mcu7t5v0__latrnq_1
Xg_reg\[22\].g_bit\[5\].genblk1.g_l.g_c.u_l _714_/D _413_/ZN l_r0_b4/RN cfg_out[68]
+ VDD VDD VSS VSS gf180mcu_fd_sc_mcu7t5v0__latrnq_1
X_700_ _700_/D _707_/Q _724_/CLK _701_/D VDD VDD VSS VSS gf180mcu_fd_sc_mcu7t5v0__dffrnq_1
X_493_ _659_/Q _586_/C _641_/B VDD VDD VSS VSS gf180mcu_fd_sc_mcu7t5v0__nor2_1
X_562_ _562_/A1 _444_/Z _622_/C _563_/B2 VDD VDD VSS VSS gf180mcu_fd_sc_mcu7t5v0__oai21_1
X_631_ _696_/Q _631_/A2 _631_/B _631_/C _653_/B VDD VDD VSS VSS gf180mcu_fd_sc_mcu7t5v0__aoi211_1
Xg_reg\[14\].g_bit\[3\].genblk1.g_l.genblk1.g_d.u_l _712_/D _425_/ZN l_v0_c5/RN _319_/I
+ VDD VDD VSS VSS gf180mcu_fd_sc_mcu7t5v0__latrnq_1
XFILLER_30_32 VDD VDD VSS VSS gf180mcu_fd_sc_mcu7t5v0__fill_2
X_476_ _698_/Q _696_/Q _631_/B VDD VDD VSS VSS gf180mcu_fd_sc_mcu7t5v0__nor2_1
X_545_ _663_/Q _577_/B _545_/B1 _664_/Q _546_/I VDD VDD VSS VSS gf180mcu_fd_sc_mcu7t5v0__aoi22_1
X_614_ _694_/Q _674_/Q _615_/B2 VDD VDD VSS VSS gf180mcu_fd_sc_mcu7t5v0__nand2_1
XFILLER_25_76 VDD VDD VSS VSS gf180mcu_fd_sc_mcu7t5v0__fill_1
X_330_ _679_/Q _650_/A1 VDD VDD VSS VSS gf180mcu_fd_sc_mcu7t5v0__clkinv_1
XFILLER_17_142 VDD VDD VSS VSS gf180mcu_fd_sc_mcu7t5v0__fill_2
XTAP_TAPCELL_ROW_19_159 VDD VSS gf180mcu_fd_sc_mcu7t5v0__filltie
XTAP_TAPCELL_ROW_2_90 VDD VSS gf180mcu_fd_sc_mcu7t5v0__filltie
X_459_ _697_/Q _506_/A2 _525_/A2 VDD VDD VSS VSS gf180mcu_fd_sc_mcu7t5v0__nand2_1
X_528_ _508_/S _518_/Z _528_/A3 _528_/Z VDD VDD VSS VSS gf180mcu_fd_sc_mcu7t5v0__and3_1
XFILLER_23_167 VDD VDD VSS VSS gf180mcu_fd_sc_mcu7t5v0__fill_2
XFILLER_36_31 VDD VDD VSS VSS gf180mcu_fd_sc_mcu7t5v0__fillcap_4
X_313_ _313_/I _483_/A1 VDD VDD VSS VSS gf180mcu_fd_sc_mcu7t5v0__clkinv_1
Xinput17 spk_in[5] _468_/I0 VDD VDD VSS VSS gf180mcu_fd_sc_mcu7t5v0__buf_1
Xg_reg\[13\].g_bit\[6\].genblk1.g_l.genblk1.g_d.u_l _715_/D _427_/ZN input1/Z _575_/A1
+ VDD VDD VSS VSS gf180mcu_fd_sc_mcu7t5v0__latrnq_1
XFILLER_37_237 VDD VDD VSS VSS gf180mcu_fd_sc_mcu7t5v0__fill_1
XTAP_TAPCELL_ROW_15_140 VDD VSS gf180mcu_fd_sc_mcu7t5v0__filltie
XTAP_TAPCELL_ROW_7_108 VDD VSS gf180mcu_fd_sc_mcu7t5v0__filltie
XFILLER_36_281 VDD VDD VSS VSS gf180mcu_fd_sc_mcu7t5v0__fill_1
XTAP_TAPCELL_ROW_21_165 VDD VSS gf180mcu_fd_sc_mcu7t5v0__filltie
XFILLER_18_281 VDD VDD VSS VSS gf180mcu_fd_sc_mcu7t5v0__fill_1
XFILLER_6_163 VDD VDD VSS VSS gf180mcu_fd_sc_mcu7t5v0__fill_2
XPHY_EDGE_ROW_3_Right_3 VDD VSS gf180mcu_fd_sc_mcu7t5v0__endcap
X_492_ _492_/A1 _492_/A2 _647_/B _501_/A2 VDD VDD VSS VSS gf180mcu_fd_sc_mcu7t5v0__oai21_1
X_561_ _668_/Q _600_/A2 _563_/B1 VDD VDD VSS VSS gf180mcu_fd_sc_mcu7t5v0__nor2_1
Xg_reg\[18\].g_bit\[1\].genblk1.g_l.g_c.u_l _710_/D _417_/ZN load_slew31/Z cfg_out[32]
+ VDD VDD VSS VSS gf180mcu_fd_sc_mcu7t5v0__latrnq_1
X_630_ _698_/Q _622_/C _624_/C _632_/A3 VDD VDD VSS VSS gf180mcu_fd_sc_mcu7t5v0__nand3_1
Xneuron_ctrl cfg_out[11] VDD VDD VSS VSS gf180mcu_fd_sc_mcu7t5v0__tiel
Xg_reg\[17\].g_bit\[5\].genblk1.g_l.g_c.u_l _714_/D _418_/ZN load_slew31/Z cfg_out[28]
+ VDD VDD VSS VSS gf180mcu_fd_sc_mcu7t5v0__latrnq_1
X_613_ _674_/Q _621_/B _617_/B VDD VDD VSS VSS gf180mcu_fd_sc_mcu7t5v0__nand2_1
X_475_ _631_/C _454_/Z _633_/B _724_/D VDD VDD VSS VSS gf180mcu_fd_sc_mcu7t5v0__nor3_1
X_544_ _544_/I _662_/D VDD VDD VSS VSS gf180mcu_fd_sc_mcu7t5v0__clkinv_1
Xg_reg\[9\].g_bit\[0\].genblk1.g_l.genblk1.g_d.u_l _709_/D _433_/ZN _707_/RN _721_/D
+ VDD VDD VSS VSS gf180mcu_fd_sc_mcu7t5v0__latrnq_1
XFILLER_1_264 VDD VDD VSS VSS gf180mcu_fd_sc_mcu7t5v0__fill_2
XFILLER_2_37 VDD VDD VSS VSS gf180mcu_fd_sc_mcu7t5v0__fill_2
X_389_ _389_/I _396_/A2 VDD VDD VSS VSS gf180mcu_fd_sc_mcu7t5v0__clkinv_1
X_458_ _453_/Z _458_/A2 _458_/B _697_/D VDD VDD VSS VSS gf180mcu_fd_sc_mcu7t5v0__oai21_1
X_527_ _656_/Q _657_/Q _658_/Q _696_/Q _528_/A3 VDD VDD VSS VSS gf180mcu_fd_sc_mcu7t5v0__oai31_1
XFILLER_11_35 VDD VDD VSS VSS gf180mcu_fd_sc_mcu7t5v0__fill_2
XTAP_TAPCELL_ROW_2_91 VDD VSS gf180mcu_fd_sc_mcu7t5v0__filltie
X_312_ _312_/I _406_/A2 VDD VDD VSS VSS gf180mcu_fd_sc_mcu7t5v0__clkinv_1
Xinput18 spk_in[6] _469_/I0 VDD VDD VSS VSS gf180mcu_fd_sc_mcu7t5v0__buf_1
XTAP_TAPCELL_ROW_15_141 VDD VSS gf180mcu_fd_sc_mcu7t5v0__filltie
XTAP_TAPCELL_ROW_7_109 VDD VSS gf180mcu_fd_sc_mcu7t5v0__filltie
XTAP_TAPCELL_ROW_21_166 VDD VSS gf180mcu_fd_sc_mcu7t5v0__filltie
XPHY_EDGE_ROW_9_Left_47 VDD VSS gf180mcu_fd_sc_mcu7t5v0__endcap
Xl_r2_b0 _712_/D _438_/ZN l_v0_c5/RN r2_b0 VDD VDD VSS VSS gf180mcu_fd_sc_mcu7t5v0__latrnq_1
XFILLER_30_244 VDD VDD VSS VSS gf180mcu_fd_sc_mcu7t5v0__fill_1
XFILLER_21_244 VDD VDD VSS VSS gf180mcu_fd_sc_mcu7t5v0__fill_2
XFILLER_12_255 VDD VDD VSS VSS gf180mcu_fd_sc_mcu7t5v0__fill_2
X_491_ _524_/C _658_/Q _647_/B VDD VDD VSS VSS gf180mcu_fd_sc_mcu7t5v0__nor2_1
X_560_ _560_/A1 _577_/B _560_/B _666_/D VDD VDD VSS VSS gf180mcu_fd_sc_mcu7t5v0__aoi21_1
XPHY_EDGE_ROW_13_Right_13 VDD VSS gf180mcu_fd_sc_mcu7t5v0__endcap
XPHY_EDGE_ROW_22_Right_22 VDD VSS gf180mcu_fd_sc_mcu7t5v0__endcap
X_689_ _689_/D _692_/CLK _689_/Q VDD VDD VSS VSS gf180mcu_fd_sc_mcu7t5v0__dffq_1
XFILLER_30_34 VDD VDD VSS VSS gf180mcu_fd_sc_mcu7t5v0__fill_1
XFILLER_30_67 VDD VDD VSS VSS gf180mcu_fd_sc_mcu7t5v0__fill_2
XPHY_EDGE_ROW_31_Right_31 VDD VSS gf180mcu_fd_sc_mcu7t5v0__endcap
Xg_reg\[7\].g_bit\[6\].genblk1.g_l.genblk1.g_d.u_l _715_/D _435_/ZN load_slew33/Z
+ _311_/I VDD VDD VSS VSS gf180mcu_fd_sc_mcu7t5v0__latrnq_1
X_474_ _724_/Q _473_/Z _633_/B VDD VDD VSS VSS gf180mcu_fd_sc_mcu7t5v0__nor2_1
X_543_ _662_/Q _577_/B _545_/B1 _663_/Q _544_/I VDD VDD VSS VSS gf180mcu_fd_sc_mcu7t5v0__aoi22_1
Xg_reg\[19\].g_bit\[2\].genblk1.g_l.g_c.u_l _711_/D _416_/ZN load_slew33/Z cfg_out[41]
+ VDD VDD VSS VSS gf180mcu_fd_sc_mcu7t5v0__latrnq_1
X_612_ _612_/A1 _612_/A2 _612_/B _673_/D VDD VDD VSS VSS gf180mcu_fd_sc_mcu7t5v0__oai21_1
Xg_reg\[12\].g_bit\[1\].genblk1.g_l.genblk1.g_d.u_l _710_/D _429_/ZN l_r1_b1/RN _332_/I
+ VDD VDD VSS VSS gf180mcu_fd_sc_mcu7t5v0__latrnq_1
XFILLER_17_144 VDD VDD VSS VSS gf180mcu_fd_sc_mcu7t5v0__fill_1
X_526_ _508_/S _526_/A2 _529_/B VDD VDD VSS VSS gf180mcu_fd_sc_mcu7t5v0__nand2_1
Xg_reg\[18\].g_bit\[6\].genblk1.g_l.g_c.u_l _715_/D _417_/ZN load_slew33/Z cfg_out[37]
+ VDD VDD VSS VSS gf180mcu_fd_sc_mcu7t5v0__latrnq_1
X_388_ _404_/A2 _387_/Z _388_/B _389_/I VDD VDD VSS VSS gf180mcu_fd_sc_mcu7t5v0__aoi21_1
X_457_ _697_/Q _622_/C _516_/A2 _458_/B VDD VDD VSS VSS gf180mcu_fd_sc_mcu7t5v0__nand3_1
X_311_ _311_/I _394_/A1 VDD VDD VSS VSS gf180mcu_fd_sc_mcu7t5v0__clkinv_1
Xinput19 spk_in[7] _470_/I0 VDD VDD VSS VSS gf180mcu_fd_sc_mcu7t5v0__buf_1
XTAP_TAPCELL_ROW_15_142 VDD VSS gf180mcu_fd_sc_mcu7t5v0__filltie
X_509_ _644_/A1 _657_/Q _509_/Z VDD VDD VSS VSS gf180mcu_fd_sc_mcu7t5v0__xor2_1
XTAP_TAPCELL_ROW_21_167 VDD VSS gf180mcu_fd_sc_mcu7t5v0__filltie
XFILLER_33_6 VDD VDD VSS VSS gf180mcu_fd_sc_mcu7t5v0__fill_1
XFILLER_25_209 VDD VDD VSS VSS gf180mcu_fd_sc_mcu7t5v0__fill_1
XPHY_EDGE_ROW_25_Left_63 VDD VSS gf180mcu_fd_sc_mcu7t5v0__endcap
Xl_r2_b1 _713_/D _438_/ZN l_v0_c5/RN r2_b1 VDD VDD VSS VSS gf180mcu_fd_sc_mcu7t5v0__latrnq_1
Xg_reg\[11\].g_bit\[4\].genblk1.g_l.genblk1.g_d.u_l _713_/D _431_/ZN load_slew33/Z
+ _487_/B VDD VDD VSS VSS gf180mcu_fd_sc_mcu7t5v0__latrnq_1
XFILLER_21_212 VDD VDD VSS VSS gf180mcu_fd_sc_mcu7t5v0__fill_2
XFILLER_24_2 VDD VDD VSS VSS gf180mcu_fd_sc_mcu7t5v0__fill_2
XFILLER_28_34 VDD VDD VSS VSS gf180mcu_fd_sc_mcu7t5v0__fill_1
X_490_ _644_/A1 _490_/A2 _643_/B1 _490_/B2 _588_/B _492_/A2 VDD VDD VSS VSS gf180mcu_fd_sc_mcu7t5v0__aoi221_1
X_688_ _688_/D _692_/CLK _688_/Q VDD VDD VSS VSS gf180mcu_fd_sc_mcu7t5v0__dffq_1
XPHY_EDGE_ROW_12_Left_50 VDD VSS gf180mcu_fd_sc_mcu7t5v0__endcap
X_473_ _701_/D _701_/Q _473_/Z VDD VDD VSS VSS gf180mcu_fd_sc_mcu7t5v0__xor2_1
X_542_ _542_/I _661_/D VDD VDD VSS VSS gf180mcu_fd_sc_mcu7t5v0__clkinv_1
X_611_ _694_/Q _611_/A2 _622_/C _612_/A2 VDD VDD VSS VSS gf180mcu_fd_sc_mcu7t5v0__oai21_1
Xg_reg\[10\].g_bit\[7\].genblk1.g_l.genblk1.g_d.u_l _716_/D _432_/ZN input1/Z _622_/A2
+ VDD VDD VSS VSS gf180mcu_fd_sc_mcu7t5v0__latrnq_1
X_387_ _385_/B _312_/I _387_/Z VDD VDD VSS VSS gf180mcu_fd_sc_mcu7t5v0__xor2_1
X_456_ _453_/Z _458_/A2 _634_/S VDD VDD VSS VSS gf180mcu_fd_sc_mcu7t5v0__nor2_1
X_525_ _525_/A1 _525_/A2 _525_/B _526_/A2 VDD VDD VSS VSS gf180mcu_fd_sc_mcu7t5v0__oai21_1
Xclkbuf_1_1__f_ui_in[0] clkbuf_0_ui_in[0]/Z _715_/CLK VDD VDD VSS VSS gf180mcu_fd_sc_mcu7t5v0__clkbuf_4
XFILLER_11_26 VDD VDD VSS VSS gf180mcu_fd_sc_mcu7t5v0__fill_1
XFILLER_11_59 VDD VDD VSS VSS gf180mcu_fd_sc_mcu7t5v0__fill_2
X_310_ probe_sub probe_sub_b VDD VDD VSS VSS gf180mcu_fd_sc_mcu7t5v0__clkinv_1
XTAP_TAPCELL_ROW_15_143 VDD VSS gf180mcu_fd_sc_mcu7t5v0__filltie
XTAP_TAPCELL_ROW_24_176 VDD VSS gf180mcu_fd_sc_mcu7t5v0__filltie
X_439_ _414_/Z _439_/A2 _439_/ZN VDD VDD VSS VSS gf180mcu_fd_sc_mcu7t5v0__nor2_1
X_508_ _656_/Q _508_/I1 _508_/S _656_/D VDD VDD VSS VSS gf180mcu_fd_sc_mcu7t5v0__mux2_2
XFILLER_27_240 VDD VDD VSS VSS gf180mcu_fd_sc_mcu7t5v0__fill_1
XFILLER_17_69 VDD VDD VSS VSS gf180mcu_fd_sc_mcu7t5v0__fill_1
Xl_r2_b2 _714_/D _438_/ZN l_v0_c5/RN r2_b2 VDD VDD VSS VSS gf180mcu_fd_sc_mcu7t5v0__latrnq_1
XTAP_TAPCELL_ROW_32_208 VDD VSS gf180mcu_fd_sc_mcu7t5v0__filltie
XFILLER_18_90 VDD VDD VSS VSS gf180mcu_fd_sc_mcu7t5v0__fill_2
X_687_ _687_/D _692_/CLK _687_/Q VDD VDD VSS VSS gf180mcu_fd_sc_mcu7t5v0__dffq_1
XFILLER_14_37 VDD VDD VSS VSS gf180mcu_fd_sc_mcu7t5v0__fill_2
XPHY_EDGE_ROW_7_Right_7 VDD VSS gf180mcu_fd_sc_mcu7t5v0__endcap
X_472_ _720_/Q input4/Z _472_/S uio_out[7] VDD VDD VSS VSS gf180mcu_fd_sc_mcu7t5v0__mux2_2
X_541_ _661_/Q _577_/B _545_/B1 _662_/Q _542_/I VDD VDD VSS VSS gf180mcu_fd_sc_mcu7t5v0__aoi22_1
Xl_v0_c0 _709_/D _437_/ZN l_v0_c5/RN v0_c0 VDD VDD VSS VSS gf180mcu_fd_sc_mcu7t5v0__latrnq_1
Xclkbuf_1_0__f_ui_in[0] clkbuf_0_ui_in[0]/Z _720_/CLK VDD VDD VSS VSS gf180mcu_fd_sc_mcu7t5v0__clkbuf_4
X_610_ _673_/Q _672_/Q _610_/B _612_/A1 VDD VDD VSS VSS gf180mcu_fd_sc_mcu7t5v0__aoi21_1
XFILLER_25_47 VDD VDD VSS VSS gf180mcu_fd_sc_mcu7t5v0__fill_1
X_386_ _373_/B _386_/A2 _392_/B _388_/B VDD VDD VSS VSS gf180mcu_fd_sc_mcu7t5v0__aoi21_1
X_455_ _694_/Q _531_/A1 _705_/D _622_/C _458_/A2 VDD VDD VSS VSS gf180mcu_fd_sc_mcu7t5v0__nand4_1
X_524_ _697_/Q _698_/Q _524_/B _524_/C _525_/B VDD VDD VSS VSS gf180mcu_fd_sc_mcu7t5v0__oai211_1
Xu_lif.u_cg.u_icg clkbuf_1_0__f_clk/Z _448_/ZN u_lif.u_cg.u_icg/TE u_lif.u_cg.u_icg/Q
+ VDD VDD VSS VSS gf180mcu_fd_sc_mcu7t5v0__icgtp_1
XTAP_TAPCELL_ROW_18_152 VDD VSS gf180mcu_fd_sc_mcu7t5v0__filltie
XTAP_TAPCELL_ROW_24_177 VDD VSS gf180mcu_fd_sc_mcu7t5v0__filltie
XFILLER_3_72 VDD VDD VSS VSS gf180mcu_fd_sc_mcu7t5v0__fill_2
XFILLER_9_164 VDD VDD VSS VSS gf180mcu_fd_sc_mcu7t5v0__fill_1
X_369_ _369_/A1 _369_/A2 rt_out[2] VDD VDD VSS VSS gf180mcu_fd_sc_mcu7t5v0__and2_1
X_438_ _438_/A1 _442_/A2 _438_/ZN VDD VDD VSS VSS gf180mcu_fd_sc_mcu7t5v0__nor2_1
X_507_ _507_/A1 _525_/A2 _479_/C _656_/Q _508_/I1 VDD VDD VSS VSS gf180mcu_fd_sc_mcu7t5v0__oai22_1
XFILLER_18_252 VDD VDD VSS VSS gf180mcu_fd_sc_mcu7t5v0__fill_1
Xl_i0_b0 _709_/D _442_/ZN l_r0_b4/RN i0_b0 VDD VDD VSS VSS gf180mcu_fd_sc_mcu7t5v0__latrnq_1
Xg_reg\[14\].g_bit\[2\].genblk1.g_l.genblk1.g_d.u_l _711_/D _425_/ZN l_v0_c5/RN _318_/I
+ VDD VDD VSS VSS gf180mcu_fd_sc_mcu7t5v0__latrnq_1
XFILLER_3_148 VDD VDD VSS VSS gf180mcu_fd_sc_mcu7t5v0__fill_2
Xl_r2_b3 _715_/D _438_/ZN l_v0_c5/RN r2_b3 VDD VDD VSS VSS gf180mcu_fd_sc_mcu7t5v0__latrnq_1
XFILLER_30_247 VDD VDD VSS VSS gf180mcu_fd_sc_mcu7t5v0__fill_1
XTAP_TAPCELL_ROW_32_209 VDD VSS gf180mcu_fd_sc_mcu7t5v0__filltie
XFILLER_24_4 VDD VDD VSS VSS gf180mcu_fd_sc_mcu7t5v0__fill_1
XFILLER_20_280 VDD VDD VSS VSS gf180mcu_fd_sc_mcu7t5v0__fill_2
XFILLER_28_69 VDD VDD VSS VSS gf180mcu_fd_sc_mcu7t5v0__fill_2
X_686_ _686_/D _692_/CLK _686_/Q VDD VDD VSS VSS gf180mcu_fd_sc_mcu7t5v0__dffq_1
XFILLER_29_100 VDD VDD VSS VSS gf180mcu_fd_sc_mcu7t5v0__fill_1
XFILLER_30_37 VDD VDD VSS VSS gf180mcu_fd_sc_mcu7t5v0__fillcap_8
X_471_ _725_/Q input3/Z _472_/S uio_out[6] VDD VDD VSS VSS gf180mcu_fd_sc_mcu7t5v0__mux2_2
X_540_ _540_/I _660_/D VDD VDD VSS VSS gf180mcu_fd_sc_mcu7t5v0__clkinv_1
Xl_v0_c1 _710_/D _437_/ZN l_v0_c5/RN v0_c1 VDD VDD VSS VSS gf180mcu_fd_sc_mcu7t5v0__latrnq_1
Xg_reg\[13\].g_bit\[5\].genblk1.g_l.genblk1.g_d.u_l _714_/D _427_/ZN _707_/RN _571_/A1
+ VDD VDD VSS VSS gf180mcu_fd_sc_mcu7t5v0__latrnq_1
X_669_ _669_/D _725_/RN _725_/CLK _669_/Q VDD VDD VSS VSS gf180mcu_fd_sc_mcu7t5v0__dffrnq_1
XFILLER_26_103 VDD VDD VSS VSS gf180mcu_fd_sc_mcu7t5v0__fill_2
XFILLER_25_191 VDD VDD VSS VSS gf180mcu_fd_sc_mcu7t5v0__fill_2
X_385_ _306_/I _312_/I _385_/B _386_/A2 VDD VDD VSS VSS gf180mcu_fd_sc_mcu7t5v0__oai21_1
X_454_ _694_/Q _531_/A1 _705_/D _454_/Z VDD VDD VSS VSS gf180mcu_fd_sc_mcu7t5v0__and3_1
X_523_ _586_/C _508_/S _523_/B _658_/D VDD VDD VSS VSS gf180mcu_fd_sc_mcu7t5v0__oai21_1
XTAP_TAPCELL_ROW_18_153 VDD VSS gf180mcu_fd_sc_mcu7t5v0__filltie
Xl_i3_b0 _716_/D _441_/ZN l_r0_b4/RN i3_b0 VDD VDD VSS VSS gf180mcu_fd_sc_mcu7t5v0__latrnq_1
XFILLER_7_2 VDD VDD VSS VSS gf180mcu_fd_sc_mcu7t5v0__fill_2
XTAP_TAPCELL_ROW_24_178 VDD VSS gf180mcu_fd_sc_mcu7t5v0__filltie
X_368_ _481_/A1 _368_/A2 rt_out[1] VDD VDD VSS VSS gf180mcu_fd_sc_mcu7t5v0__and2_1
X_437_ _438_/A1 _441_/A2 _437_/ZN VDD VDD VSS VSS gf180mcu_fd_sc_mcu7t5v0__nor2_1
X_506_ _698_/Q _506_/A2 _506_/B _508_/S VDD VDD VSS VSS gf180mcu_fd_sc_mcu7t5v0__aoi21_1
Xg_reg\[15\].g_bit\[2\].genblk1.g_l.g_c.u_l _711_/D _423_/ZN load_slew31/Z cfg_out[9]
+ VDD VDD VSS VSS gf180mcu_fd_sc_mcu7t5v0__latrnq_1
XFILLER_22_49 VDD VDD VSS VSS gf180mcu_fd_sc_mcu7t5v0__fill_2
XPHY_EDGE_ROW_29_Right_29 VDD VSS gf180mcu_fd_sc_mcu7t5v0__endcap
XFILLER_33_212 VDD VDD VSS VSS gf180mcu_fd_sc_mcu7t5v0__fill_2
Xl_i0_b1 _710_/D _442_/ZN l_r0_b4/RN i0_b1 VDD VDD VSS VSS gf180mcu_fd_sc_mcu7t5v0__latrnq_1
Xl_r2_b4 _716_/D _438_/ZN l_v0_c5/RN r2_b4 VDD VDD VSS VSS gf180mcu_fd_sc_mcu7t5v0__latrnq_1
XPHY_EDGE_ROW_29_Left_67 VDD VSS gf180mcu_fd_sc_mcu7t5v0__endcap
XFILLER_28_26 VDD VDD VSS VSS gf180mcu_fd_sc_mcu7t5v0__fillcap_8
XFILLER_28_37 VDD VDD VSS VSS gf180mcu_fd_sc_mcu7t5v0__fillcap_32
XFILLER_18_92 VDD VDD VSS VSS gf180mcu_fd_sc_mcu7t5v0__fill_1
XFILLER_22_2 VDD VDD VSS VSS gf180mcu_fd_sc_mcu7t5v0__fill_2
XFILLER_7_263 VDD VDD VSS VSS gf180mcu_fd_sc_mcu7t5v0__fill_2
X_685_ _685_/D _692_/CLK _685_/Q VDD VDD VSS VSS gf180mcu_fd_sc_mcu7t5v0__dffq_1
XFILLER_29_123 VDD VDD VSS VSS gf180mcu_fd_sc_mcu7t5v0__fill_2
XFILLER_29_167 VDD VDD VSS VSS gf180mcu_fd_sc_mcu7t5v0__fill_2
Xl_v0_c2 _711_/D _437_/ZN l_v0_c5/RN v0_c2 VDD VDD VSS VSS gf180mcu_fd_sc_mcu7t5v0__latrnq_1
X_470_ _470_/I0 _470_/I1 _470_/S uo_out[7] VDD VDD VSS VSS gf180mcu_fd_sc_mcu7t5v0__mux2_2
X_599_ _622_/C _599_/A2 _600_/C VDD VDD VSS VSS gf180mcu_fd_sc_mcu7t5v0__nand2_1
Xneuron_ctrl_60 cfg_out[62] VDD VDD VSS VSS gf180mcu_fd_sc_mcu7t5v0__tiel
Xhold80 _692_/Q _691_/D VDD VDD VSS VSS gf180mcu_fd_sc_mcu7t5v0__dlyc_1
X_668_ _668_/D _725_/RN _725_/CLK _668_/Q VDD VDD VSS VSS gf180mcu_fd_sc_mcu7t5v0__dffrnq_1
XPHY_EDGE_ROW_16_Left_54 VDD VSS gf180mcu_fd_sc_mcu7t5v0__endcap
XFILLER_32_107 VDD VDD VSS VSS gf180mcu_fd_sc_mcu7t5v0__fill_2
X_384_ _373_/B _384_/A2 _392_/B VDD VDD VSS VSS gf180mcu_fd_sc_mcu7t5v0__nor2_1
X_453_ _673_/Q _672_/Q _674_/Q _675_/Q _453_/Z VDD VDD VSS VSS gf180mcu_fd_sc_mcu7t5v0__or4_1
X_522_ _508_/S _522_/A2 _523_/B VDD VDD VSS VSS gf180mcu_fd_sc_mcu7t5v0__nand2_1
Xg_reg\[8\].g_bit\[2\].genblk1.g_l.genblk1.g_d.u_l _711_/D _434_/ZN _707_/RN _472_/S
+ VDD VDD VSS VSS gf180mcu_fd_sc_mcu7t5v0__latrnq_1
Xclkbuf_0_u_lif.d_clk u_lif.u_cg.u_icg/Q clkbuf_0_u_lif.d_clk/Z VDD VDD VSS VSS gf180mcu_fd_sc_mcu7t5v0__clkbuf_4
XTAP_TAPCELL_ROW_18_154 VDD VSS gf180mcu_fd_sc_mcu7t5v0__filltie
Xl_i3_b1 _709_/D _440_/ZN l_r1_b1/RN i3_b1 VDD VDD VSS VSS gf180mcu_fd_sc_mcu7t5v0__latrnq_1
Xg_reg\[6\].g_bit\[3\].genblk1.g_l.g_c.u_l _712_/D _436_/ZN l_r0_b4/RN cfg_out[3]
+ VDD VDD VSS VSS gf180mcu_fd_sc_mcu7t5v0__latrnq_1
XFILLER_14_129 VDD VDD VSS VSS gf180mcu_fd_sc_mcu7t5v0__fill_2
XFILLER_36_37 VDD VDD VSS VSS gf180mcu_fd_sc_mcu7t5v0__fillcap_8
XPHY_EDGE_ROW_1_Left_39 VDD VSS gf180mcu_fd_sc_mcu7t5v0__endcap
XTAP_TAPCELL_ROW_24_179 VDD VSS gf180mcu_fd_sc_mcu7t5v0__filltie
X_367_ _313_/I _367_/A2 rt_out[0] VDD VDD VSS VSS gf180mcu_fd_sc_mcu7t5v0__and2_1
X_436_ _438_/A1 _440_/A2 _436_/ZN VDD VDD VSS VSS gf180mcu_fd_sc_mcu7t5v0__nor2_1
X_505_ _634_/S _479_/B _478_/Z _694_/Q _505_/C _506_/B VDD VDD VSS VSS gf180mcu_fd_sc_mcu7t5v0__oai221_1
XFILLER_18_243 VDD VDD VSS VSS gf180mcu_fd_sc_mcu7t5v0__fill_2
XFILLER_6_103 VDD VDD VSS VSS gf180mcu_fd_sc_mcu7t5v0__fill_2
XTAP_TAPCELL_ROW_20_160 VDD VSS gf180mcu_fd_sc_mcu7t5v0__filltie
XFILLER_33_279 VDD VDD VSS VSS gf180mcu_fd_sc_mcu7t5v0__fill_1
X_419_ _717_/D _718_/D _415_/Z _419_/ZN VDD VDD VSS VSS gf180mcu_fd_sc_mcu7t5v0__nor3_1
Xl_i0_b2 _711_/D _442_/ZN l_r0_b4/RN i0_b2 VDD VDD VSS VSS gf180mcu_fd_sc_mcu7t5v0__latrnq_1
Xg_reg\[16\].g_bit\[3\].genblk1.g_l.g_c.u_l _712_/D _419_/ZN load_slew31/Z cfg_out[18]
+ VDD VDD VSS VSS gf180mcu_fd_sc_mcu7t5v0__latrnq_1
XPHY_EDGE_ROW_4_Left_42 VDD VSS gf180mcu_fd_sc_mcu7t5v0__endcap
Xg_reg\[22\].g_bit\[4\].genblk1.g_l.g_c.u_l _713_/D _413_/ZN l_r0_b4/RN cfg_out[67]
+ VDD VDD VSS VSS gf180mcu_fd_sc_mcu7t5v0__latrnq_1
Xg_reg\[12\].g_bit\[0\].genblk1.g_l.genblk1.g_d.u_l _709_/D _429_/ZN l_r1_b1/RN _636_/B
+ VDD VDD VSS VSS gf180mcu_fd_sc_mcu7t5v0__latrnq_1
XPHY_EDGE_ROW_30_Left_68 VDD VSS gf180mcu_fd_sc_mcu7t5v0__endcap
X_684_ _684_/D _692_/CLK _684_/Q VDD VDD VSS VSS gf180mcu_fd_sc_mcu7t5v0__dffq_1
XFILLER_15_2 VDD VDD VSS VSS gf180mcu_fd_sc_mcu7t5v0__fill_1
XFILLER_30_28 VDD VDD VSS VSS gf180mcu_fd_sc_mcu7t5v0__fillcap_4
XFILLER_20_72 VDD VDD VSS VSS gf180mcu_fd_sc_mcu7t5v0__fill_2
Xl_v0_c3 _712_/D _437_/ZN l_v0_c5/RN v0_c3 VDD VDD VSS VSS gf180mcu_fd_sc_mcu7t5v0__latrnq_1
Xneuron_ctrl_50 cfg_out[52] VDD VDD VSS VSS gf180mcu_fd_sc_mcu7t5v0__tiel
Xhold81 _686_/Q _685_/D VDD VDD VSS VSS gf180mcu_fd_sc_mcu7t5v0__dlyc_1
Xhold70 _690_/Q _689_/D VDD VDD VSS VSS gf180mcu_fd_sc_mcu7t5v0__dlyc_1
X_598_ _697_/Q _660_/Q _599_/A2 VDD VDD VSS VSS gf180mcu_fd_sc_mcu7t5v0__nand2_1
X_667_ _667_/D _725_/RN _725_/CLK _667_/Q VDD VDD VSS VSS gf180mcu_fd_sc_mcu7t5v0__dffrnq_1
XFILLER_25_193 VDD VDD VSS VSS gf180mcu_fd_sc_mcu7t5v0__fill_1
XTAP_TAPCELL_ROW_27_188 VDD VSS gf180mcu_fd_sc_mcu7t5v0__filltie
X_383_ _404_/A3 _400_/A1 _382_/I probe_rsel[0] VDD VDD VSS VSS gf180mcu_fd_sc_mcu7t5v0__nor3_1
X_452_ _673_/Q _672_/Q _452_/Z VDD VDD VSS VSS gf180mcu_fd_sc_mcu7t5v0__or2_1
X_521_ _521_/A1 _525_/A2 _521_/B1 _518_/Z _521_/C _522_/A2 VDD VDD VSS VSS gf180mcu_fd_sc_mcu7t5v0__oai221_1
XPHY_EDGE_ROW_33_Left_71 VDD VSS gf180mcu_fd_sc_mcu7t5v0__endcap
XTAP_TAPCELL_ROW_18_155 VDD VSS gf180mcu_fd_sc_mcu7t5v0__filltie
Xl_i3_b2 _710_/D _440_/ZN l_r1_b1/RN i3_b2 VDD VDD VSS VSS gf180mcu_fd_sc_mcu7t5v0__latrnq_1
Xg_reg\[11\].g_bit\[3\].genblk1.g_l.genblk1.g_d.u_l _712_/D _431_/ZN load_slew33/Z
+ _324_/I VDD VDD VSS VSS gf180mcu_fd_sc_mcu7t5v0__latrnq_1
X_719_ _719_/D _720_/CLK _720_/D VDD VDD VSS VSS gf180mcu_fd_sc_mcu7t5v0__dffq_1
XFILLER_9_101 VDD VDD VSS VSS gf180mcu_fd_sc_mcu7t5v0__fill_2
X_366_ _373_/B _371_/B _366_/A3 probe_sel_adex VDD VDD VSS VSS gf180mcu_fd_sc_mcu7t5v0__nor3_1
X_435_ _438_/A1 _439_/A2 _435_/ZN VDD VDD VSS VSS gf180mcu_fd_sc_mcu7t5v0__nor2_1
X_504_ _697_/Q _503_/Z _504_/B _655_/D VDD VDD VSS VSS gf180mcu_fd_sc_mcu7t5v0__aoi21_1
XTAP_TAPCELL_ROW_6_104 VDD VSS gf180mcu_fd_sc_mcu7t5v0__filltie
XFILLER_10_199 VDD VDD VSS VSS gf180mcu_fd_sc_mcu7t5v0__fill_1
XTAP_TAPCELL_ROW_12_128 VDD VSS gf180mcu_fd_sc_mcu7t5v0__filltie
XTAP_TAPCELL_ROW_20_161 VDD VSS gf180mcu_fd_sc_mcu7t5v0__filltie
XFILLER_33_214 VDD VDD VSS VSS gf180mcu_fd_sc_mcu7t5v0__fill_1
XFILLER_37_70 VDD VDD VSS VSS gf180mcu_fd_sc_mcu7t5v0__fill_1
X_349_ _654_/A1 _631_/C _516_/A2 _695_/D VDD VDD VSS VSS gf180mcu_fd_sc_mcu7t5v0__nor3_1
X_418_ _428_/A1 _718_/D _415_/Z _418_/ZN VDD VDD VSS VSS gf180mcu_fd_sc_mcu7t5v0__nor3_1
Xl_i0_b3 _712_/D _442_/ZN l_r0_b4/RN i0_b3 VDD VDD VSS VSS gf180mcu_fd_sc_mcu7t5v0__latrnq_1
XFILLER_24_247 VDD VDD VSS VSS gf180mcu_fd_sc_mcu7t5v0__fill_2
XFILLER_23_72 VDD VDD VSS VSS gf180mcu_fd_sc_mcu7t5v0__fillcap_16
Xg_reg\[18\].g_bit\[0\].genblk1.g_l.g_c.u_l _709_/D _417_/ZN load_slew31/Z cfg_out[31]
+ VDD VDD VSS VSS gf180mcu_fd_sc_mcu7t5v0__latrnq_1
Xg_reg\[10\].g_bit\[6\].genblk1.g_l.genblk1.g_d.u_l _715_/D _432_/ZN input1/Z _616_/A2
+ VDD VDD VSS VSS gf180mcu_fd_sc_mcu7t5v0__latrnq_1
XFILLER_18_61 VDD VDD VSS VSS gf180mcu_fd_sc_mcu7t5v0__fill_2
XFILLER_18_83 VDD VDD VSS VSS gf180mcu_fd_sc_mcu7t5v0__fill_2
XFILLER_7_265 VDD VDD VSS VSS gf180mcu_fd_sc_mcu7t5v0__fill_1
Xg_reg\[17\].g_bit\[4\].genblk1.g_l.g_c.u_l _713_/D _418_/ZN load_slew31/Z cfg_out[27]
+ VDD VDD VSS VSS gf180mcu_fd_sc_mcu7t5v0__latrnq_1
X_683_ _683_/D _693_/CLK _683_/Q VDD VDD VSS VSS gf180mcu_fd_sc_mcu7t5v0__dffq_1
XFILLER_22_4 VDD VDD VSS VSS gf180mcu_fd_sc_mcu7t5v0__fill_1
XFILLER_20_51 VDD VDD VSS VSS gf180mcu_fd_sc_mcu7t5v0__fill_2
XFILLER_29_125 VDD VDD VSS VSS gf180mcu_fd_sc_mcu7t5v0__fill_1
Xl_v0_c4 _713_/D _437_/ZN l_v0_c5/RN v0_c4 VDD VDD VSS VSS gf180mcu_fd_sc_mcu7t5v0__latrnq_1
X_597_ _677_/Q _580_/Z _597_/A3 _597_/Z VDD VDD VSS VSS gf180mcu_fd_sc_mcu7t5v0__xor3_1
Xneuron_ctrl_40 cfg_out[14] VDD VDD VSS VSS gf180mcu_fd_sc_mcu7t5v0__tiel
Xneuron_ctrl_51 cfg_out[53] VDD VDD VSS VSS gf180mcu_fd_sc_mcu7t5v0__tiel
Xneuron_ctrl_62 uio_oe[0] VDD VDD VSS VSS gf180mcu_fd_sc_mcu7t5v0__tieh
Xhold82 _693_/Q _692_/D VDD VDD VSS VSS gf180mcu_fd_sc_mcu7t5v0__dlyc_1
Xhold71 _688_/Q _687_/D VDD VDD VSS VSS gf180mcu_fd_sc_mcu7t5v0__dlyc_1
X_666_ _666_/D _725_/RN _725_/CLK _666_/Q VDD VDD VSS VSS gf180mcu_fd_sc_mcu7t5v0__dffrnq_1
XFILLER_26_139 VDD VDD VSS VSS gf180mcu_fd_sc_mcu7t5v0__fill_2
XFILLER_34_172 VDD VDD VSS VSS gf180mcu_fd_sc_mcu7t5v0__fill_2
X_520_ _696_/Q _519_/Z _521_/C VDD VDD VSS VSS gf180mcu_fd_sc_mcu7t5v0__nand2_1
XFILLER_0_271 VDD VDD VSS VSS gf180mcu_fd_sc_mcu7t5v0__fill_1
XFILLER_32_109 VDD VDD VSS VSS gf180mcu_fd_sc_mcu7t5v0__fill_1
XTAP_TAPCELL_ROW_27_189 VDD VSS gf180mcu_fd_sc_mcu7t5v0__filltie
X_382_ _382_/I _402_/B VDD VDD VSS VSS gf180mcu_fd_sc_mcu7t5v0__clkinv_1
X_451_ _505_/C _451_/A2 _631_/C _698_/D VDD VDD VSS VSS gf180mcu_fd_sc_mcu7t5v0__aoi21_1
X_718_ _718_/D _720_/CLK _719_/D VDD VDD VSS VSS gf180mcu_fd_sc_mcu7t5v0__dffq_1
X_649_ _650_/A1 _650_/A2 _649_/Z VDD VDD VSS VSS gf180mcu_fd_sc_mcu7t5v0__and2_1
Xl_i3_b3 _711_/D _440_/ZN l_r0_b4/RN i3_b3 VDD VDD VSS VSS gf180mcu_fd_sc_mcu7t5v0__latrnq_1
X_365_ _375_/B _371_/B _366_/A3 probe_sel_d1 VDD VDD VSS VSS gf180mcu_fd_sc_mcu7t5v0__nor3_1
X_434_ _442_/A2 _430_/Z _434_/ZN VDD VDD VSS VSS gf180mcu_fd_sc_mcu7t5v0__nor2_1
X_503_ _629_/A1 _485_/I _503_/A3 _503_/Z VDD VDD VSS VSS gf180mcu_fd_sc_mcu7t5v0__xor3_1
XFILLER_27_212 VDD VDD VSS VSS gf180mcu_fd_sc_mcu7t5v0__fill_2
XTAP_TAPCELL_ROW_12_129 VDD VSS gf180mcu_fd_sc_mcu7t5v0__filltie
XTAP_TAPCELL_ROW_20_162 VDD VSS gf180mcu_fd_sc_mcu7t5v0__filltie
XTAP_TAPCELL_ROW_6_105 VDD VSS gf180mcu_fd_sc_mcu7t5v0__filltie
XFILLER_5_2 VDD VDD VSS VSS gf180mcu_fd_sc_mcu7t5v0__fill_2
XPHY_EDGE_ROW_16_Right_16 VDD VSS gf180mcu_fd_sc_mcu7t5v0__endcap
XPHY_EDGE_ROW_25_Right_25 VDD VSS gf180mcu_fd_sc_mcu7t5v0__endcap
X_348_ _656_/Q _590_/C _653_/C _516_/A2 VDD VDD VSS VSS gf180mcu_fd_sc_mcu7t5v0__nand3_1
X_417_ _417_/A1 _415_/Z _417_/ZN VDD VDD VSS VSS gf180mcu_fd_sc_mcu7t5v0__nor2_1
Xl_i0_b4 _713_/D _442_/ZN l_r0_b4/RN i0_b4 VDD VDD VSS VSS gf180mcu_fd_sc_mcu7t5v0__latrnq_1
XPHY_EDGE_ROW_34_Right_34 VDD VSS gf180mcu_fd_sc_mcu7t5v0__endcap
XFILLER_2_174 VDD VDD VSS VSS gf180mcu_fd_sc_mcu7t5v0__fill_1
X_682_ _682_/D _693_/CLK _682_/Q VDD VDD VSS VSS gf180mcu_fd_sc_mcu7t5v0__dffq_1
XPHY_EDGE_ROW_2_Right_2 VDD VSS gf180mcu_fd_sc_mcu7t5v0__endcap
Xl_v0_c5 _714_/D _437_/ZN l_v0_c5/RN v0_c5 VDD VDD VSS VSS gf180mcu_fd_sc_mcu7t5v0__latrnq_1
Xg_reg\[19\].g_bit\[1\].genblk1.g_l.g_c.u_l _710_/D _416_/ZN load_slew33/Z cfg_out[40]
+ VDD VDD VSS VSS gf180mcu_fd_sc_mcu7t5v0__latrnq_1
XFILLER_29_61 VDD VDD VSS VSS gf180mcu_fd_sc_mcu7t5v0__fill_1
X_596_ _580_/Z _632_/A1 _595_/Z _632_/A2 VDD VDD VSS VSS gf180mcu_fd_sc_mcu7t5v0__nor3_1
Xneuron_ctrl_41 cfg_out[43] VDD VDD VSS VSS gf180mcu_fd_sc_mcu7t5v0__tiel
Xneuron_ctrl_52 cfg_out[54] VDD VDD VSS VSS gf180mcu_fd_sc_mcu7t5v0__tiel
Xneuron_ctrl_63 uio_oe[1] VDD VDD VSS VSS gf180mcu_fd_sc_mcu7t5v0__tieh
Xhold83 _683_/Q _682_/D VDD VDD VSS VSS gf180mcu_fd_sc_mcu7t5v0__dlyc_1
Xhold72 _689_/Q _688_/D VDD VDD VSS VSS gf180mcu_fd_sc_mcu7t5v0__dlyc_1
Xg_reg\[18\].g_bit\[5\].genblk1.g_l.g_c.u_l _714_/D _417_/ZN load_slew33/Z cfg_out[36]
+ VDD VDD VSS VSS gf180mcu_fd_sc_mcu7t5v0__latrnq_1
X_665_ _665_/D _724_/RN _725_/CLK _665_/Q VDD VDD VSS VSS gf180mcu_fd_sc_mcu7t5v0__dffrnq_1
XTAP_TAPCELL_ROW_2_88 VDD VSS gf180mcu_fd_sc_mcu7t5v0__filltie
X_381_ _381_/A1 _381_/A2 _382_/I VDD VDD VSS VSS gf180mcu_fd_sc_mcu7t5v0__or2_1
X_450_ _698_/Q _516_/A2 _451_/A2 VDD VDD VSS VSS gf180mcu_fd_sc_mcu7t5v0__nand2_1
Xg_reg\[14\].g_bit\[1\].genblk1.g_l.genblk1.g_d.u_l _710_/D _425_/ZN l_v0_c5/RN _587_/A2
+ VDD VDD VSS VSS gf180mcu_fd_sc_mcu7t5v0__latrnq_1
X_579_ _681_/Q _485_/I _627_/A2 VDD VDD VSS VSS gf180mcu_fd_sc_mcu7t5v0__xnor2_1
Xl_i3_b4 _712_/D _440_/ZN l_r1_b1/RN i3_b4 VDD VDD VSS VSS gf180mcu_fd_sc_mcu7t5v0__latrnq_1
X_717_ _717_/D _720_/CLK _718_/D VDD VDD VSS VSS gf180mcu_fd_sc_mcu7t5v0__dffq_1
X_648_ _648_/A1 _648_/A2 _648_/B _650_/A2 VDD VDD VSS VSS gf180mcu_fd_sc_mcu7t5v0__aoi21_1
X_433_ _441_/A2 _430_/Z _433_/ZN VDD VDD VSS VSS gf180mcu_fd_sc_mcu7t5v0__nor2_1
X_502_ _696_/Q _655_/Q _697_/Q _504_/B VDD VDD VSS VSS gf180mcu_fd_sc_mcu7t5v0__aoi21_1
XFILLER_9_103 VDD VDD VSS VSS gf180mcu_fd_sc_mcu7t5v0__fill_1
X_364_ _311_/I _404_/A3 _366_/A3 VDD VDD VSS VSS gf180mcu_fd_sc_mcu7t5v0__nand2_1
XTAP_TAPCELL_ROW_37_230 VDD VSS gf180mcu_fd_sc_mcu7t5v0__filltie
XTAP_TAPCELL_ROW_6_106 VDD VSS gf180mcu_fd_sc_mcu7t5v0__filltie
XTAP_TAPCELL_ROW_20_163 VDD VSS gf180mcu_fd_sc_mcu7t5v0__filltie
X_347_ _644_/A1 _657_/Q _645_/B _506_/A2 VDD VDD VSS VSS gf180mcu_fd_sc_mcu7t5v0__nor3_1
X_416_ _416_/A1 _415_/Z _416_/ZN VDD VDD VSS VSS gf180mcu_fd_sc_mcu7t5v0__nor2_1
XFILLER_24_249 VDD VDD VSS VSS gf180mcu_fd_sc_mcu7t5v0__fill_1
XFILLER_23_260 VDD VDD VSS VSS gf180mcu_fd_sc_mcu7t5v0__fill_1
XFILLER_23_271 VDD VDD VSS VSS gf180mcu_fd_sc_mcu7t5v0__fill_1
XFILLER_23_96 VDD VDD VSS VSS gf180mcu_fd_sc_mcu7t5v0__fillcap_4
Xg_reg\[13\].g_bit\[4\].genblk1.g_l.genblk1.g_d.u_l _713_/D _427_/ZN _707_/RN _566_/A1
+ VDD VDD VSS VSS gf180mcu_fd_sc_mcu7t5v0__latrnq_1
XFILLER_9_54 VDD VDD VSS VSS gf180mcu_fd_sc_mcu7t5v0__fill_1
XFILLER_18_85 VDD VDD VSS VSS gf180mcu_fd_sc_mcu7t5v0__fill_1
XPHY_EDGE_ROW_8_Left_46 VDD VSS gf180mcu_fd_sc_mcu7t5v0__endcap
X_681_ _681_/D _693_/CLK _681_/Q VDD VDD VSS VSS gf180mcu_fd_sc_mcu7t5v0__dffq_1
XFILLER_7_212 VDD VDD VSS VSS gf180mcu_fd_sc_mcu7t5v0__fill_2
X_595_ _677_/Q _597_/A3 _595_/Z VDD VDD VSS VSS gf180mcu_fd_sc_mcu7t5v0__and2_1
Xneuron_ctrl_42 cfg_out[44] VDD VDD VSS VSS gf180mcu_fd_sc_mcu7t5v0__tiel
Xneuron_ctrl_53 cfg_out[55] VDD VDD VSS VSS gf180mcu_fd_sc_mcu7t5v0__tiel
Xneuron_ctrl_64 uio_oe[2] VDD VDD VSS VSS gf180mcu_fd_sc_mcu7t5v0__tieh
Xhold84 _703_/Q _704_/D VDD VDD VSS VSS gf180mcu_fd_sc_mcu7t5v0__dlyc_1
Xhold73 _721_/Q _722_/D VDD VDD VSS VSS gf180mcu_fd_sc_mcu7t5v0__dlyc_1
X_664_ _664_/D _724_/RN _724_/CLK _664_/Q VDD VDD VSS VSS gf180mcu_fd_sc_mcu7t5v0__dffrnq_1
XFILLER_19_182 VDD VDD VSS VSS gf180mcu_fd_sc_mcu7t5v0__fill_2
XFILLER_34_174 VDD VDD VSS VSS gf180mcu_fd_sc_mcu7t5v0__fill_1
XTAP_TAPCELL_ROW_2_89 VDD VSS gf180mcu_fd_sc_mcu7t5v0__filltie
X_380_ _373_/B _384_/A2 _380_/B _380_/C _381_/A2 VDD VDD VSS VSS gf180mcu_fd_sc_mcu7t5v0__aoi211_1
Xg_reg\[12\].g_bit\[7\].genblk1.g_l.genblk1.g_d.u_l _716_/D _429_/ZN l_r1_b1/RN _644_/A2
+ VDD VDD VSS VSS gf180mcu_fd_sc_mcu7t5v0__latrnq_1
XFILLER_0_240 VDD VDD VSS VSS gf180mcu_fd_sc_mcu7t5v0__fill_2
X_578_ _578_/A1 _577_/B _578_/B _670_/D VDD VDD VSS VSS gf180mcu_fd_sc_mcu7t5v0__aoi21_1
X_716_ _716_/D _720_/CLK _717_/D VDD VDD VSS VSS gf180mcu_fd_sc_mcu7t5v0__dffq_1
X_647_ _647_/A1 _647_/A2 _647_/B _648_/A2 VDD VDD VSS VSS gf180mcu_fd_sc_mcu7t5v0__oai21_1
.ends
