* NGSPICE file created from neuron_ctrl.ext - technology: gf180mcuD

* Black-box entry subcircuit for gf180mcu_fd_sc_mcu7t5v0__fill_2 abstract view
.subckt gf180mcu_fd_sc_mcu7t5v0__fill_2 VDD VNW VPW VSS
.ends

* Black-box entry subcircuit for gf180mcu_fd_sc_mcu7t5v0__filltie abstract view
.subckt gf180mcu_fd_sc_mcu7t5v0__filltie VDD VSS
.ends

* Black-box entry subcircuit for gf180mcu_fd_sc_mcu7t5v0__fill_1 abstract view
.subckt gf180mcu_fd_sc_mcu7t5v0__fill_1 VDD VNW VPW VSS
.ends

* Black-box entry subcircuit for gf180mcu_fd_sc_mcu7t5v0__fillcap_8 abstract view
.subckt gf180mcu_fd_sc_mcu7t5v0__fillcap_8 VDD VNW VPW VSS
.ends

* Black-box entry subcircuit for gf180mcu_fd_sc_mcu7t5v0__fillcap_4 abstract view
.subckt gf180mcu_fd_sc_mcu7t5v0__fillcap_4 VDD VNW VPW VSS
.ends

* Black-box entry subcircuit for gf180mcu_fd_sc_mcu7t5v0__and2_1 abstract view
.subckt gf180mcu_fd_sc_mcu7t5v0__and2_1 A1 A2 Z VDD VNW VPW VSS
.ends

* Black-box entry subcircuit for gf180mcu_fd_sc_mcu7t5v0__nor2_1 abstract view
.subckt gf180mcu_fd_sc_mcu7t5v0__nor2_1 A1 A2 ZN VDD VNW VPW VSS
.ends

* Black-box entry subcircuit for gf180mcu_fd_sc_mcu7t5v0__latrnq_1 abstract view
.subckt gf180mcu_fd_sc_mcu7t5v0__latrnq_1 D E RN Q VDD VNW VPW VSS
.ends

* Black-box entry subcircuit for gf180mcu_fd_sc_mcu7t5v0__clkbuf_4 abstract view
.subckt gf180mcu_fd_sc_mcu7t5v0__clkbuf_4 I Z VDD VNW VPW VSS
.ends

* Black-box entry subcircuit for gf180mcu_fd_sc_mcu7t5v0__endcap abstract view
.subckt gf180mcu_fd_sc_mcu7t5v0__endcap VDD VSS
.ends

* Black-box entry subcircuit for gf180mcu_fd_sc_mcu7t5v0__clkinv_1 abstract view
.subckt gf180mcu_fd_sc_mcu7t5v0__clkinv_1 I ZN VDD VNW VPW VSS
.ends

* Black-box entry subcircuit for gf180mcu_fd_sc_mcu7t5v0__nand3_1 abstract view
.subckt gf180mcu_fd_sc_mcu7t5v0__nand3_1 A1 A2 A3 ZN VDD VNW VPW VSS
.ends

* Black-box entry subcircuit for gf180mcu_fd_sc_mcu7t5v0__dlyc_1 abstract view
.subckt gf180mcu_fd_sc_mcu7t5v0__dlyc_1 I Z VDD VNW VPW VSS
.ends

* Black-box entry subcircuit for gf180mcu_fd_sc_mcu7t5v0__dffq_1 abstract view
.subckt gf180mcu_fd_sc_mcu7t5v0__dffq_1 D CLK Q VDD VNW VPW VSS
.ends

* Black-box entry subcircuit for gf180mcu_fd_sc_mcu7t5v0__oai22_1 abstract view
.subckt gf180mcu_fd_sc_mcu7t5v0__oai22_1 A1 A2 B1 B2 ZN VDD VNW VPW VSS
.ends

* Black-box entry subcircuit for gf180mcu_fd_sc_mcu7t5v0__nand2_1 abstract view
.subckt gf180mcu_fd_sc_mcu7t5v0__nand2_1 A1 A2 ZN VDD VNW VPW VSS
.ends

* Black-box entry subcircuit for gf180mcu_fd_sc_mcu7t5v0__oai211_1 abstract view
.subckt gf180mcu_fd_sc_mcu7t5v0__oai211_1 A1 A2 B C ZN VDD VNW VPW VSS
.ends

* Black-box entry subcircuit for gf180mcu_fd_sc_mcu7t5v0__tieh abstract view
.subckt gf180mcu_fd_sc_mcu7t5v0__tieh Z VDD VNW VPW VSS
.ends

* Black-box entry subcircuit for gf180mcu_fd_sc_mcu7t5v0__aoi21_1 abstract view
.subckt gf180mcu_fd_sc_mcu7t5v0__aoi21_1 A1 A2 B ZN VDD VNW VPW VSS
.ends

* Black-box entry subcircuit for gf180mcu_fd_sc_mcu7t5v0__oai21_1 abstract view
.subckt gf180mcu_fd_sc_mcu7t5v0__oai21_1 A1 A2 B ZN VDD VNW VPW VSS
.ends

* Black-box entry subcircuit for gf180mcu_fd_sc_mcu7t5v0__or2_1 abstract view
.subckt gf180mcu_fd_sc_mcu7t5v0__or2_1 A1 A2 Z VDD VNW VPW VSS
.ends

* Black-box entry subcircuit for gf180mcu_fd_sc_mcu7t5v0__fillcap_16 abstract view
.subckt gf180mcu_fd_sc_mcu7t5v0__fillcap_16 VDD VNW VPW VSS
.ends

* Black-box entry subcircuit for gf180mcu_fd_sc_mcu7t5v0__buf_1 abstract view
.subckt gf180mcu_fd_sc_mcu7t5v0__buf_1 I Z VDD VNW VPW VSS
.ends

* Black-box entry subcircuit for gf180mcu_fd_sc_mcu7t5v0__clkbuf_2 abstract view
.subckt gf180mcu_fd_sc_mcu7t5v0__clkbuf_2 I Z VDD VNW VPW VSS
.ends

* Black-box entry subcircuit for gf180mcu_fd_sc_mcu7t5v0__clkinv_8 abstract view
.subckt gf180mcu_fd_sc_mcu7t5v0__clkinv_8 I ZN VDD VNW VPW VSS
.ends

* Black-box entry subcircuit for gf180mcu_fd_sc_mcu7t5v0__mux2_2 abstract view
.subckt gf180mcu_fd_sc_mcu7t5v0__mux2_2 I0 I1 S Z VDD VNW VPW VSS
.ends

* Black-box entry subcircuit for gf180mcu_fd_sc_mcu7t5v0__inv_4 abstract view
.subckt gf180mcu_fd_sc_mcu7t5v0__inv_4 I ZN VDD VNW VPW VSS
.ends

* Black-box entry subcircuit for gf180mcu_fd_sc_mcu7t5v0__aoi22_1 abstract view
.subckt gf180mcu_fd_sc_mcu7t5v0__aoi22_1 A1 A2 B1 B2 ZN VDD VNW VPW VSS
.ends

* Black-box entry subcircuit for gf180mcu_fd_sc_mcu7t5v0__mux4_1 abstract view
.subckt gf180mcu_fd_sc_mcu7t5v0__mux4_1 I0 I1 I2 I3 S0 S1 Z VDD VNW VPW VSS
.ends

* Black-box entry subcircuit for gf180mcu_fd_sc_mcu7t5v0__clkinv_4 abstract view
.subckt gf180mcu_fd_sc_mcu7t5v0__clkinv_4 I ZN VDD VNW VPW VSS
.ends

* Black-box entry subcircuit for gf180mcu_fd_sc_mcu7t5v0__dffrnq_1 abstract view
.subckt gf180mcu_fd_sc_mcu7t5v0__dffrnq_1 D RN CLK Q VDD VNW VPW VSS
.ends

* Black-box entry subcircuit for gf180mcu_fd_sc_mcu7t5v0__nor3_1 abstract view
.subckt gf180mcu_fd_sc_mcu7t5v0__nor3_1 A1 A2 A3 ZN VDD VNW VPW VSS
.ends

* Black-box entry subcircuit for gf180mcu_fd_sc_mcu7t5v0__oai32_1 abstract view
.subckt gf180mcu_fd_sc_mcu7t5v0__oai32_1 A1 A2 A3 B1 B2 ZN VDD VNW VPW VSS
.ends

* Black-box entry subcircuit for gf180mcu_fd_sc_mcu7t5v0__oai31_1 abstract view
.subckt gf180mcu_fd_sc_mcu7t5v0__oai31_1 A1 A2 A3 B ZN VDD VNW VPW VSS
.ends

* Black-box entry subcircuit for gf180mcu_fd_sc_mcu7t5v0__xor2_1 abstract view
.subckt gf180mcu_fd_sc_mcu7t5v0__xor2_1 A1 A2 Z VDD VNW VPW VSS
.ends

* Black-box entry subcircuit for gf180mcu_fd_sc_mcu7t5v0__oai221_1 abstract view
.subckt gf180mcu_fd_sc_mcu7t5v0__oai221_1 A1 A2 B1 B2 C ZN VDD VNW VPW VSS
.ends

* Black-box entry subcircuit for gf180mcu_fd_sc_mcu7t5v0__aoi211_1 abstract view
.subckt gf180mcu_fd_sc_mcu7t5v0__aoi211_1 A1 A2 B C ZN VDD VNW VPW VSS
.ends

* Black-box entry subcircuit for gf180mcu_fd_sc_mcu7t5v0__buf_4 abstract view
.subckt gf180mcu_fd_sc_mcu7t5v0__buf_4 I Z VDD VNW VPW VSS
.ends

* Black-box entry subcircuit for gf180mcu_fd_sc_mcu7t5v0__nor4_2 abstract view
.subckt gf180mcu_fd_sc_mcu7t5v0__nor4_2 A1 A2 A3 A4 ZN VDD VNW VPW VSS
.ends

* Black-box entry subcircuit for gf180mcu_fd_sc_mcu7t5v0__and3_1 abstract view
.subckt gf180mcu_fd_sc_mcu7t5v0__and3_1 A1 A2 A3 Z VDD VNW VPW VSS
.ends

* Black-box entry subcircuit for gf180mcu_fd_sc_mcu7t5v0__buf_16 abstract view
.subckt gf180mcu_fd_sc_mcu7t5v0__buf_16 I Z VDD VNW VPW VSS
.ends

* Black-box entry subcircuit for gf180mcu_fd_sc_mcu7t5v0__tiel abstract view
.subckt gf180mcu_fd_sc_mcu7t5v0__tiel ZN VDD VNW VPW VSS
.ends

* Black-box entry subcircuit for gf180mcu_fd_sc_mcu7t5v0__buf_20 abstract view
.subckt gf180mcu_fd_sc_mcu7t5v0__buf_20 I Z VDD VNW VPW VSS
.ends

* Black-box entry subcircuit for gf180mcu_fd_sc_mcu7t5v0__or3_1 abstract view
.subckt gf180mcu_fd_sc_mcu7t5v0__or3_1 A1 A2 A3 Z VDD VNW VPW VSS
.ends

* Black-box entry subcircuit for gf180mcu_fd_sc_mcu7t5v0__xnor2_1 abstract view
.subckt gf180mcu_fd_sc_mcu7t5v0__xnor2_1 A1 A2 ZN VDD VNW VPW VSS
.ends

* Black-box entry subcircuit for gf180mcu_fd_sc_mcu7t5v0__nor4_1 abstract view
.subckt gf180mcu_fd_sc_mcu7t5v0__nor4_1 A1 A2 A3 A4 ZN VDD VNW VPW VSS
.ends

* Black-box entry subcircuit for gf180mcu_fd_sc_mcu7t5v0__and4_1 abstract view
.subckt gf180mcu_fd_sc_mcu7t5v0__and4_1 A1 A2 A3 A4 Z VDD VNW VPW VSS
.ends

* Black-box entry subcircuit for gf180mcu_fd_sc_mcu7t5v0__aoi221_1 abstract view
.subckt gf180mcu_fd_sc_mcu7t5v0__aoi221_1 A1 A2 B1 B2 C ZN VDD VNW VPW VSS
.ends

* Black-box entry subcircuit for gf180mcu_fd_sc_mcu7t5v0__xor3_1 abstract view
.subckt gf180mcu_fd_sc_mcu7t5v0__xor3_1 A1 A2 A3 Z VDD VNW VPW VSS
.ends

* Black-box entry subcircuit for gf180mcu_fd_sc_mcu7t5v0__icgtp_1 abstract view
.subckt gf180mcu_fd_sc_mcu7t5v0__icgtp_1 CLK E TE Q VDD VNW VPW VSS
.ends

* Black-box entry subcircuit for gf180mcu_fd_sc_mcu7t5v0__dffsnq_1 abstract view
.subckt gf180mcu_fd_sc_mcu7t5v0__dffsnq_1 D SETN CLK Q VDD VNW VPW VSS
.ends

* Black-box entry subcircuit for gf180mcu_fd_sc_mcu7t5v0__dffrnq_2 abstract view
.subckt gf180mcu_fd_sc_mcu7t5v0__dffrnq_2 D RN CLK Q VDD VNW VPW VSS
.ends

.subckt neuron_ctrl VDD VSS cfg_out[0] cfg_out[100] cfg_out[101] cfg_out[102] cfg_out[103]
+ cfg_out[104] cfg_out[105] cfg_out[106] cfg_out[107] cfg_out[108] cfg_out[109] cfg_out[10]
+ cfg_out[110] cfg_out[111] cfg_out[112] cfg_out[113] cfg_out[114] cfg_out[115] cfg_out[116]
+ cfg_out[117] cfg_out[118] cfg_out[119] cfg_out[11] cfg_out[120] cfg_out[121] cfg_out[122]
+ cfg_out[123] cfg_out[124] cfg_out[125] cfg_out[126] cfg_out[127] cfg_out[128] cfg_out[129]
+ cfg_out[12] cfg_out[130] cfg_out[131] cfg_out[132] cfg_out[133] cfg_out[134] cfg_out[135]
+ cfg_out[136] cfg_out[137] cfg_out[138] cfg_out[139] cfg_out[13] cfg_out[140] cfg_out[141]
+ cfg_out[14] cfg_out[15] cfg_out[16] cfg_out[17] cfg_out[18] cfg_out[19] cfg_out[1]
+ cfg_out[20] cfg_out[21] cfg_out[22] cfg_out[23] cfg_out[24] cfg_out[25] cfg_out[26]
+ cfg_out[27] cfg_out[28] cfg_out[29] cfg_out[2] cfg_out[30] cfg_out[31] cfg_out[32]
+ cfg_out[33] cfg_out[34] cfg_out[35] cfg_out[36] cfg_out[37] cfg_out[38] cfg_out[39]
+ cfg_out[3] cfg_out[40] cfg_out[41] cfg_out[42] cfg_out[43] cfg_out[44] cfg_out[45]
+ cfg_out[46] cfg_out[47] cfg_out[48] cfg_out[49] cfg_out[4] cfg_out[50] cfg_out[51]
+ cfg_out[52] cfg_out[53] cfg_out[54] cfg_out[55] cfg_out[56] cfg_out[57] cfg_out[58]
+ cfg_out[59] cfg_out[5] cfg_out[60] cfg_out[61] cfg_out[62] cfg_out[63] cfg_out[64]
+ cfg_out[65] cfg_out[66] cfg_out[67] cfg_out[68] cfg_out[69] cfg_out[6] cfg_out[70]
+ cfg_out[71] cfg_out[72] cfg_out[73] cfg_out[74] cfg_out[75] cfg_out[76] cfg_out[77]
+ cfg_out[78] cfg_out[79] cfg_out[7] cfg_out[80] cfg_out[81] cfg_out[82] cfg_out[83]
+ cfg_out[84] cfg_out[85] cfg_out[86] cfg_out[87] cfg_out[88] cfg_out[89] cfg_out[8]
+ cfg_out[90] cfg_out[91] cfg_out[92] cfg_out[93] cfg_out[94] cfg_out[95] cfg_out[96]
+ cfg_out[97] cfg_out[98] cfg_out[99] cfg_out[9] clk probe_sel_onehot[0] probe_sel_onehot[10]
+ probe_sel_onehot[11] probe_sel_onehot[12] probe_sel_onehot[13] probe_sel_onehot[14]
+ probe_sel_onehot[15] probe_sel_onehot[1] probe_sel_onehot[2] probe_sel_onehot[3]
+ probe_sel_onehot[4] probe_sel_onehot[5] probe_sel_onehot[6] probe_sel_onehot[7]
+ probe_sel_onehot[8] probe_sel_onehot[9] rst_n rt_out[0] rt_out[1] rt_out[2] rt_out[3]
+ sc_clk spk_in[0] spk_in[10] spk_in[11] spk_in[12] spk_in[13] spk_in[14] spk_in[15]
+ spk_in[1] spk_in[2] spk_in[3] spk_in[4] spk_in[5] spk_in[6] spk_in[7] spk_in[8]
+ spk_in[9] ui_in[0] ui_in[1] ui_in[2] ui_in[3] ui_in[4] ui_in[5] ui_in[6] ui_in[7]
+ uio_in[0] uio_in[1] uio_in[2] uio_in[3] uio_in[4] uio_in[5] uio_in[6] uio_in[7]
+ uio_oe[0] uio_oe[1] uio_oe[2] uio_oe[3] uio_oe[4] uio_oe[5] uio_oe[6] uio_oe[7]
+ uio_out[0] uio_out[1] uio_out[2] uio_out[3] uio_out[4] uio_out[5] uio_out[6] uio_out[7]
+ uo_out[0] uo_out[1] uo_out[2] uo_out[3] uo_out[4] uo_out[5] uo_out[6] uo_out[7]
XFILLER_22_177 VDD VDD VSS VSS gf180mcu_fd_sc_mcu7t5v0__fill_2
XTAP_TAPCELL_ROW_9_126 VDD VSS gf180mcu_fd_sc_mcu7t5v0__filltie
XFILLER_13_144 VDD VDD VSS VSS gf180mcu_fd_sc_mcu7t5v0__fill_1
XFILLER_26_63 VDD VDD VSS VSS gf180mcu_fd_sc_mcu7t5v0__fillcap_8
XFILLER_9_126 VDD VDD VSS VSS gf180mcu_fd_sc_mcu7t5v0__fillcap_4
XTAP_TAPCELL_ROW_23_183 VDD VSS gf180mcu_fd_sc_mcu7t5v0__filltie
X_363_ _363_/A1 _363_/A2 rt_out[3] VDD VDD VSS VSS gf180mcu_fd_sc_mcu7t5v0__and2_1
X_432_ _687_/Q _544_/A2 _435_/A2 VDD VDD VSS VSS gf180mcu_fd_sc_mcu7t5v0__nor2_1
X_501_ _602_/B _355_/Z _656_/C VDD VDD VSS VSS gf180mcu_fd_sc_mcu7t5v0__nor2_1
Xg_reg\[16\].g_bit\[2\].g_l.g_d.u_l _754_/D _406_/ZN input1/Z _570_/A1 VDD VDD VSS
+ VSS gf180mcu_fd_sc_mcu7t5v0__latrnq_1
Xclkbuf_3_6__f_clk_regs clkbuf_0_clk_regs/Z _748_/CLK VDD VDD VSS VSS gf180mcu_fd_sc_mcu7t5v0__clkbuf_4
XPHY_EDGE_ROW_19_Left_61 VDD VSS gf180mcu_fd_sc_mcu7t5v0__endcap
Xg_reg\[5\].g_bit\[7\].g_l.g_a.u_l _759_/D _423_/ZN load_slew18/Z cfg_out[47] VDD
+ VDD VSS VSS gf180mcu_fd_sc_mcu7t5v0__latrnq_1
Xg_reg\[2\].g_bit\[4\].g_l.g_a.u_l _756_/D _426_/ZN load_slew18/Z cfg_out[20] VDD
+ VDD VSS VSS gf180mcu_fd_sc_mcu7t5v0__latrnq_1
Xg_reg\[21\].g_bit\[5\].g_l.g_a.u_l _757_/D _399_/ZN _750_/RN cfg_out[107] VDD VDD
+ VSS VSS gf180mcu_fd_sc_mcu7t5v0__latrnq_1
XFILLER_6_107 VDD VDD VSS VSS gf180mcu_fd_sc_mcu7t5v0__fill_2
X_346_ _346_/I _470_/A1 VDD VDD VSS VSS gf180mcu_fd_sc_mcu7t5v0__clkinv_1
X_415_ _415_/A1 _415_/A2 _415_/A3 _428_/A2 VDD VDD VSS VSS gf180mcu_fd_sc_mcu7t5v0__nand3_1
Xg_reg\[11\].g_bit\[6\].g_l.g_d.u_l _758_/D _417_/ZN _750_/RN _362_/A2 VDD VDD VSS
+ VSS gf180mcu_fd_sc_mcu7t5v0__latrnq_1
XFILLER_23_42 VDD VDD VSS VSS gf180mcu_fd_sc_mcu7t5v0__fillcap_4
XPHY_EDGE_ROW_4_Left_46 VDD VSS gf180mcu_fd_sc_mcu7t5v0__endcap
XTAP_TAPCELL_ROW_40_248 VDD VSS gf180mcu_fd_sc_mcu7t5v0__filltie
XTAP_TAPCELL_ROW_31_215 VDD VSS gf180mcu_fd_sc_mcu7t5v0__filltie
X_329_ _329_/I _408_/A2 VDD VDD VSS VSS gf180mcu_fd_sc_mcu7t5v0__clkinv_1
X_680_ _730_/Q _480_/Z _681_/A3 VDD VDD VSS VSS gf180mcu_fd_sc_mcu7t5v0__nor2_1
X_594_ _698_/Q _615_/B _595_/B VDD VDD VSS VSS gf180mcu_fd_sc_mcu7t5v0__nor2_1
X_663_ _355_/Z _664_/A2 _661_/B _664_/B1 VDD VDD VSS VSS gf180mcu_fd_sc_mcu7t5v0__nand3_1
Xhold30 _711_/Q _710_/D VDD VDD VSS VSS gf180mcu_fd_sc_mcu7t5v0__dlyc_1
Xhold41 _713_/Q _712_/D VDD VDD VSS VSS gf180mcu_fd_sc_mcu7t5v0__dlyc_1
X_732_ _732_/D _736_/CLK _732_/Q VDD VDD VSS VSS gf180mcu_fd_sc_mcu7t5v0__dffq_1
Xclkbuf_3_5__f_clk_regs clkbuf_0_clk_regs/Z _736_/CLK VDD VDD VSS VSS gf180mcu_fd_sc_mcu7t5v0__clkbuf_4
XFILLER_0_296 VDD VDD VSS VSS gf180mcu_fd_sc_mcu7t5v0__fill_2
XFILLER_16_153 VDD VDD VSS VSS gf180mcu_fd_sc_mcu7t5v0__fill_1
XPHY_EDGE_ROW_33_Left_75 VDD VSS gf180mcu_fd_sc_mcu7t5v0__endcap
XTAP_TAPCELL_ROW_26_192 VDD VSS gf180mcu_fd_sc_mcu7t5v0__filltie
X_577_ _577_/A1 _577_/A2 _578_/B VDD VDD VSS VSS gf180mcu_fd_sc_mcu7t5v0__nor2_1
X_646_ _646_/A1 _664_/A2 _643_/Z _646_/B2 _705_/D VDD VDD VSS VSS gf180mcu_fd_sc_mcu7t5v0__oai22_1
X_715_ _715_/D _770_/CLK _715_/Q VDD VDD VSS VSS gf180mcu_fd_sc_mcu7t5v0__dffq_1
XTAP_TAPCELL_ROW_9_127 VDD VSS gf180mcu_fd_sc_mcu7t5v0__filltie
X_362_ input9/Z _362_/A2 rt_out[2] VDD VDD VSS VSS gf180mcu_fd_sc_mcu7t5v0__and2_1
X_431_ _656_/A1 _602_/B _541_/A1 _544_/A2 VDD VDD VSS VSS gf180mcu_fd_sc_mcu7t5v0__nand3_1
X_500_ _684_/Q _603_/B _655_/A2 VDD VDD VSS VSS gf180mcu_fd_sc_mcu7t5v0__nand2_1
X_629_ _737_/Q _629_/A2 _633_/C _629_/C _631_/A2 VDD VDD VSS VSS gf180mcu_fd_sc_mcu7t5v0__oai211_1
Xg_reg\[19\].g_bit\[2\].g_l.g_a.u_l _754_/D _403_/ZN _750_/RN cfg_out[88] VDD VDD
+ VSS VSS gf180mcu_fd_sc_mcu7t5v0__latrnq_1
Xg_reg\[9\].g_bit\[1\].g_l.g_a.u_l _753_/D _419_/ZN input1/Z cfg_out[70] VDD VDD VSS
+ VSS gf180mcu_fd_sc_mcu7t5v0__latrnq_1
XFILLER_41_240 VDD VDD VSS VSS gf180mcu_fd_sc_mcu7t5v0__fill_2
XPHY_EDGE_ROW_20_Left_62 VDD VSS gf180mcu_fd_sc_mcu7t5v0__endcap
XTAP_TAPCELL_ROW_11_132 VDD VSS gf180mcu_fd_sc_mcu7t5v0__filltie
XTAP_TAPCELL_ROW_34_224 VDD VSS gf180mcu_fd_sc_mcu7t5v0__filltie
X_345_ _708_/Q _664_/B2 VDD VDD VSS VSS gf180mcu_fd_sc_mcu7t5v0__clkinv_1
X_414_ _416_/A1 _427_/A2 _414_/ZN VDD VDD VSS VSS gf180mcu_fd_sc_mcu7t5v0__nor2_1
XFILLER_15_218 VDD VDD VSS VSS gf180mcu_fd_sc_mcu7t5v0__fill_1
XPHY_EDGE_ROW_12_Right_12 VDD VSS gf180mcu_fd_sc_mcu7t5v0__endcap
XPHY_EDGE_ROW_21_Right_21 VDD VSS gf180mcu_fd_sc_mcu7t5v0__endcap
XTAP_TAPCELL_ROW_40_249 VDD VSS gf180mcu_fd_sc_mcu7t5v0__filltie
Xg_reg\[15\].g_bit\[0\].g_l.g_d.u_l _752_/D _410_/ZN _750_/RN _651_/A1 VDD VDD VSS
+ VSS gf180mcu_fd_sc_mcu7t5v0__latrnq_1
XFILLER_0_36 VDD VDD VSS VSS gf180mcu_fd_sc_mcu7t5v0__fill_1
XFILLER_3_2 VDD VDD VSS VSS gf180mcu_fd_sc_mcu7t5v0__fill_1
XPHY_EDGE_ROW_30_Right_30 VDD VSS gf180mcu_fd_sc_mcu7t5v0__endcap
X_328_ _761_/D _415_/A2 VDD VDD VSS VSS gf180mcu_fd_sc_mcu7t5v0__clkinv_1
Xg_reg\[23\].g_bit\[6\].g_l.g_a.u_l _758_/D _396_/ZN _750_/RN cfg_out[124] VDD VDD
+ VSS VSS gf180mcu_fd_sc_mcu7t5v0__latrnq_1
Xg_reg\[20\].g_bit\[3\].g_l.g_a.u_l _755_/D _400_/ZN _750_/RN cfg_out[97] VDD VDD
+ VSS VSS gf180mcu_fd_sc_mcu7t5v0__latrnq_1
Xg_reg\[1\].g_bit\[2\].g_l.g_a.u_l _754_/D _427_/ZN load_slew18/Z cfg_out[10] VDD
+ VDD VSS VSS gf180mcu_fd_sc_mcu7t5v0__latrnq_1
XFILLER_36_2 VDD VDD VSS VSS gf180mcu_fd_sc_mcu7t5v0__fill_2
XTAP_TAPCELL_ROW_0_90 VDD VSS gf180mcu_fd_sc_mcu7t5v0__filltie
Xg_reg\[4\].g_bit\[5\].g_l.g_a.u_l _757_/D _424_/ZN load_slew18/Z cfg_out[37] VDD
+ VDD VSS VSS gf180mcu_fd_sc_mcu7t5v0__latrnq_1
XFILLER_11_298 VDD VDD VSS VSS gf180mcu_fd_sc_mcu7t5v0__fill_1
XFILLER_18_43 VDD VDD VSS VSS gf180mcu_fd_sc_mcu7t5v0__fill_2
XFILLER_18_98 VDD VDD VSS VSS gf180mcu_fd_sc_mcu7t5v0__fillcap_4
Xg_reg\[13\].g_bit\[7\].g_l.g_d.u_l _759_/D _414_/ZN input1/Z _633_/A2 VDD VDD VSS
+ VSS gf180mcu_fd_sc_mcu7t5v0__latrnq_1
X_662_ _662_/A1 _662_/A2 _662_/B1 _662_/B2 _707_/D VDD VDD VSS VSS gf180mcu_fd_sc_mcu7t5v0__oai22_1
Xhold31 _714_/Q _713_/D VDD VDD VSS VSS gf180mcu_fd_sc_mcu7t5v0__dlyc_1
Xhold42 _770_/Q _721_/D VDD VDD VSS VSS gf180mcu_fd_sc_mcu7t5v0__dlyc_1
Xneuron_ctrl_22 uio_oe[1] VDD VDD VSS VSS gf180mcu_fd_sc_mcu7t5v0__tieh
Xclkbuf_3_4__f_clk_regs clkbuf_0_clk_regs/Z _766_/CLK VDD VDD VSS VSS gf180mcu_fd_sc_mcu7t5v0__clkbuf_4
X_731_ _731_/D _736_/CLK _731_/Q VDD VDD VSS VSS gf180mcu_fd_sc_mcu7t5v0__dffq_1
XFILLER_13_4 VDD VDD VSS VSS gf180mcu_fd_sc_mcu7t5v0__fill_1
X_593_ _593_/A1 _613_/C _593_/B _595_/A2 VDD VDD VSS VSS gf180mcu_fd_sc_mcu7t5v0__aoi21_1
Xclkbuf_1_1__f_u_lif.d_clk clkbuf_0_u_lif.d_clk/Z _770_/CLK VDD VDD VSS VSS gf180mcu_fd_sc_mcu7t5v0__clkbuf_4
XFILLER_25_176 VDD VDD VSS VSS gf180mcu_fd_sc_mcu7t5v0__fill_2
XPHY_EDGE_ROW_6_Right_6 VDD VSS gf180mcu_fd_sc_mcu7t5v0__endcap
XFILLER_31_21 VDD VDD VSS VSS gf180mcu_fd_sc_mcu7t5v0__fill_1
XTAP_TAPCELL_ROW_26_193 VDD VSS gf180mcu_fd_sc_mcu7t5v0__filltie
X_576_ _576_/A1 _430_/Z _633_/C _577_/A2 VDD VDD VSS VSS gf180mcu_fd_sc_mcu7t5v0__oai21_1
X_645_ _741_/Q _645_/A2 _645_/A3 _646_/B2 VDD VDD VSS VSS gf180mcu_fd_sc_mcu7t5v0__nand3_1
X_714_ _714_/D _718_/CLK _714_/Q VDD VDD VSS VSS gf180mcu_fd_sc_mcu7t5v0__dffq_1
XFILLER_22_102 VDD VDD VSS VSS gf180mcu_fd_sc_mcu7t5v0__fill_2
X_361_ input8/Z _361_/A2 rt_out[1] VDD VDD VSS VSS gf180mcu_fd_sc_mcu7t5v0__and2_1
X_430_ _740_/Q _741_/Q _430_/Z VDD VDD VSS VSS gf180mcu_fd_sc_mcu7t5v0__or2_1
XFILLER_3_25 VDD VDD VSS VSS gf180mcu_fd_sc_mcu7t5v0__fill_1
X_559_ _693_/Q _613_/B2 _561_/A1 VDD VDD VSS VSS gf180mcu_fd_sc_mcu7t5v0__nor2_1
X_628_ _737_/Q _439_/Z _628_/A3 _629_/C VDD VDD VSS VSS gf180mcu_fd_sc_mcu7t5v0__nand3_1
XFILLER_12_34 VDD VDD VSS VSS gf180mcu_fd_sc_mcu7t5v0__fill_1
XFILLER_6_109 VDD VDD VSS VSS gf180mcu_fd_sc_mcu7t5v0__fill_1
XFILLER_5_164 VDD VDD VSS VSS gf180mcu_fd_sc_mcu7t5v0__fill_2
XTAP_TAPCELL_ROW_11_133 VDD VSS gf180mcu_fd_sc_mcu7t5v0__filltie
XTAP_TAPCELL_ROW_28_200 VDD VSS gf180mcu_fd_sc_mcu7t5v0__filltie
X_344_ _707_/Q _662_/A1 VDD VDD VSS VSS gf180mcu_fd_sc_mcu7t5v0__clkinv_1
X_413_ _760_/D _415_/A2 _415_/A3 _427_/A2 VDD VDD VSS VSS gf180mcu_fd_sc_mcu7t5v0__nand3_1
XTAP_TAPCELL_ROW_34_225 VDD VSS gf180mcu_fd_sc_mcu7t5v0__filltie
XFILLER_23_88 VDD VDD VSS VSS gf180mcu_fd_sc_mcu7t5v0__fill_2
Xg_reg\[18\].g_bit\[0\].g_l.g_a.u_l _752_/D _404_/ZN _750_/RN cfg_out[78] VDD VDD
+ VSS VSS gf180mcu_fd_sc_mcu7t5v0__latrnq_1
XFILLER_20_244 VDD VDD VSS VSS gf180mcu_fd_sc_mcu7t5v0__fill_1
XFILLER_29_2 VDD VDD VSS VSS gf180mcu_fd_sc_mcu7t5v0__fill_2
XFILLER_9_79 VDD VDD VSS VSS gf180mcu_fd_sc_mcu7t5v0__fill_2
XTAP_TAPCELL_ROW_0_91 VDD VSS gf180mcu_fd_sc_mcu7t5v0__filltie
X_327_ _760_/D _415_/A1 VDD VDD VSS VSS gf180mcu_fd_sc_mcu7t5v0__clkinv_1
Xclkbuf_3_3__f_clk_regs clkbuf_0_clk_regs/Z _767_/CLK VDD VDD VSS VSS gf180mcu_fd_sc_mcu7t5v0__clkbuf_4
XFILLER_18_33 VDD VDD VSS VSS gf180mcu_fd_sc_mcu7t5v0__fill_2
Xg_reg\[17\].g_bit\[1\].g_l.g_d.u_l _753_/D _405_/ZN _750_/RN _597_/A2 VDD VDD VSS
+ VSS gf180mcu_fd_sc_mcu7t5v0__latrnq_1
XFILLER_20_6 VDD VDD VSS VSS gf180mcu_fd_sc_mcu7t5v0__fill_1
XFILLER_29_43 VDD VDD VSS VSS gf180mcu_fd_sc_mcu7t5v0__fill_1
X_592_ _616_/A1 _430_/Z _592_/B _593_/B VDD VDD VSS VSS gf180mcu_fd_sc_mcu7t5v0__aoi21_1
X_661_ _707_/Q _661_/A2 _661_/B _662_/B1 VDD VDD VSS VSS gf180mcu_fd_sc_mcu7t5v0__oai21_1
Xhold32 _721_/Q _720_/D VDD VDD VSS VSS gf180mcu_fd_sc_mcu7t5v0__dlyc_1
Xhold43 _747_/Q _748_/D VDD VDD VSS VSS gf180mcu_fd_sc_mcu7t5v0__dlyc_1
Xneuron_ctrl_23 uio_oe[2] VDD VDD VSS VSS gf180mcu_fd_sc_mcu7t5v0__tieh
Xg_reg\[3\].g_bit\[3\].g_l.g_a.u_l _755_/D _425_/ZN load_slew18/Z cfg_out[27] VDD
+ VDD VSS VSS gf180mcu_fd_sc_mcu7t5v0__latrnq_1
Xg_reg\[25\].g_bit\[7\].g_l.g_a.u_l _759_/D _391_/ZN _750_/RN cfg_out[141] VDD VDD
+ VSS VSS gf180mcu_fd_sc_mcu7t5v0__latrnq_1
Xg_reg\[22\].g_bit\[4\].g_l.g_a.u_l _756_/D _398_/ZN _750_/RN cfg_out[114] VDD VDD
+ VSS VSS gf180mcu_fd_sc_mcu7t5v0__latrnq_1
Xg_reg\[0\].g_bit\[0\].g_l.g_a.u_l _752_/D _428_/ZN load_slew18/Z cfg_out[0] VDD VDD
+ VSS VSS gf180mcu_fd_sc_mcu7t5v0__latrnq_1
X_730_ _730_/D _736_/CLK _730_/Q VDD VDD VSS VSS gf180mcu_fd_sc_mcu7t5v0__dffq_1
XFILLER_0_298 VDD VDD VSS VSS gf180mcu_fd_sc_mcu7t5v0__fill_1
XFILLER_16_100 VDD VDD VSS VSS gf180mcu_fd_sc_mcu7t5v0__fill_1
XFILLER_25_199 VDD VDD VSS VSS gf180mcu_fd_sc_mcu7t5v0__fill_1
X_575_ _696_/Q _613_/B2 _577_/A1 VDD VDD VSS VSS gf180mcu_fd_sc_mcu7t5v0__nor2_1
X_644_ _646_/A1 _610_/Z _644_/B _645_/A3 VDD VDD VSS VSS gf180mcu_fd_sc_mcu7t5v0__aoi21_1
Xg_reg\[12\].g_bit\[5\].g_l.g_d.u_l _757_/D _416_/ZN _750_/RN _475_/B VDD VDD VSS
+ VSS gf180mcu_fd_sc_mcu7t5v0__latrnq_1
X_713_ _713_/D _718_/CLK _713_/Q VDD VDD VSS VSS gf180mcu_fd_sc_mcu7t5v0__dffq_1
XTAP_TAPCELL_ROW_26_194 VDD VSS gf180mcu_fd_sc_mcu7t5v0__filltie
X_360_ _323_/I _360_/A2 rt_out[0] VDD VDD VSS VSS gf180mcu_fd_sc_mcu7t5v0__and2_1
X_489_ _733_/Q _482_/Z _734_/Q _491_/A2 VDD VDD VSS VSS gf180mcu_fd_sc_mcu7t5v0__aoi21_1
X_558_ _558_/A1 _615_/B _558_/B1 _558_/B2 _691_/D VDD VDD VSS VSS gf180mcu_fd_sc_mcu7t5v0__oai22_1
X_627_ _701_/Q _700_/Q _702_/Q _628_/A3 VDD VDD VSS VSS gf180mcu_fd_sc_mcu7t5v0__oai21_1
XFILLER_37_32 VDD VDD VSS VSS gf180mcu_fd_sc_mcu7t5v0__fill_2
XFILLER_41_242 VDD VDD VSS VSS gf180mcu_fd_sc_mcu7t5v0__fill_1
XTAP_TAPCELL_ROW_11_134 VDD VSS gf180mcu_fd_sc_mcu7t5v0__filltie
XTAP_TAPCELL_ROW_28_201 VDD VSS gf180mcu_fd_sc_mcu7t5v0__filltie
XTAP_TAPCELL_ROW_5_110 VDD VSS gf180mcu_fd_sc_mcu7t5v0__filltie
X_343_ _737_/Q _552_/A1 VDD VDD VSS VSS gf180mcu_fd_sc_mcu7t5v0__clkinv_1
X_412_ _416_/A1 _426_/A2 _412_/ZN VDD VDD VSS VSS gf180mcu_fd_sc_mcu7t5v0__nor2_1
XTAP_TAPCELL_ROW_34_226 VDD VSS gf180mcu_fd_sc_mcu7t5v0__filltie
Xclkbuf_3_2__f_clk_regs clkbuf_0_clk_regs/Z _750_/CLK VDD VDD VSS VSS gf180mcu_fd_sc_mcu7t5v0__clkbuf_4
XFILLER_23_297 VDD VDD VSS VSS gf180mcu_fd_sc_mcu7t5v0__fill_2
XFILLER_23_34 VDD VDD VSS VSS gf180mcu_fd_sc_mcu7t5v0__fillcap_8
XFILLER_1_190 VDD VDD VSS VSS gf180mcu_fd_sc_mcu7t5v0__fillcap_16
XFILLER_36_4 VDD VDD VSS VSS gf180mcu_fd_sc_mcu7t5v0__fill_1
X_326_ _326_/I _369_/A3 VDD VDD VSS VSS gf180mcu_fd_sc_mcu7t5v0__clkinv_1
XFILLER_18_45 VDD VDD VSS VSS gf180mcu_fd_sc_mcu7t5v0__fill_1
XFILLER_20_267 VDD VDD VSS VSS gf180mcu_fd_sc_mcu7t5v0__fill_2
XFILLER_37_164 VDD VDD VSS VSS gf180mcu_fd_sc_mcu7t5v0__fill_1
XFILLER_41_2 VDD VDD VSS VSS gf180mcu_fd_sc_mcu7t5v0__fill_1
X_591_ _591_/A1 _430_/Z _633_/C _592_/B VDD VDD VSS VSS gf180mcu_fd_sc_mcu7t5v0__oai21_1
X_660_ _741_/Q _612_/Z _661_/B VDD VDD VSS VSS gf180mcu_fd_sc_mcu7t5v0__nand2_1
Xhold33 _720_/Q _719_/D VDD VDD VSS VSS gf180mcu_fd_sc_mcu7t5v0__dlyc_1
Xhold44 _716_/Q _715_/D VDD VDD VSS VSS gf180mcu_fd_sc_mcu7t5v0__dlyc_1
Xneuron_ctrl_24 uio_oe[3] VDD VDD VSS VSS gf180mcu_fd_sc_mcu7t5v0__tieh
X_789_ spk_in[1] uo_out[1] VDD VDD VSS VSS gf180mcu_fd_sc_mcu7t5v0__buf_1
XFILLER_25_178 VDD VDD VSS VSS gf180mcu_fd_sc_mcu7t5v0__fill_1
XFILLER_25_189 VDD VDD VSS VSS gf180mcu_fd_sc_mcu7t5v0__fill_2
X_712_ _712_/D _718_/CLK _712_/Q VDD VDD VSS VSS gf180mcu_fd_sc_mcu7t5v0__dffq_1
XTAP_TAPCELL_ROW_26_195 VDD VSS gf180mcu_fd_sc_mcu7t5v0__filltie
X_574_ _615_/B _574_/A2 _574_/B _694_/D VDD VDD VSS VSS gf180mcu_fd_sc_mcu7t5v0__aoi21_1
X_643_ _646_/A1 _643_/A2 _643_/Z VDD VDD VSS VSS gf180mcu_fd_sc_mcu7t5v0__and2_1
XFILLER_22_104 VDD VDD VSS VSS gf180mcu_fd_sc_mcu7t5v0__fill_1
XFILLER_26_34 VDD VDD VSS VSS gf180mcu_fd_sc_mcu7t5v0__fill_1
XPHY_EDGE_ROW_37_Left_79 VDD VSS gf180mcu_fd_sc_mcu7t5v0__endcap
Xg_reg\[2\].g_bit\[1\].g_l.g_a.u_l _753_/D _426_/ZN load_slew18/Z cfg_out[17] VDD
+ VDD VSS VSS gf180mcu_fd_sc_mcu7t5v0__latrnq_1
Xg_reg\[24\].g_bit\[5\].g_l.g_a.u_l _757_/D load_slew13/Z _750_/RN cfg_out[131] VDD
+ VDD VSS VSS gf180mcu_fd_sc_mcu7t5v0__latrnq_1
Xg_reg\[21\].g_bit\[2\].g_l.g_a.u_l _754_/D _399_/ZN _750_/RN cfg_out[104] VDD VDD
+ VSS VSS gf180mcu_fd_sc_mcu7t5v0__latrnq_1
X_488_ _488_/I _733_/D VDD VDD VSS VSS gf180mcu_fd_sc_mcu7t5v0__clkinv_1
X_557_ _557_/A1 _615_/B _558_/B1 _558_/A1 _690_/D VDD VDD VSS VSS gf180mcu_fd_sc_mcu7t5v0__oai22_1
X_626_ _634_/A1 _626_/A2 _626_/B _701_/D VDD VDD VSS VSS gf180mcu_fd_sc_mcu7t5v0__aoi21_1
Xg_reg\[5\].g_bit\[4\].g_l.g_a.u_l _756_/D _423_/ZN load_slew18/Z cfg_out[44] VDD
+ VDD VSS VSS gf180mcu_fd_sc_mcu7t5v0__latrnq_1
Xclkbuf_3_1__f_clk_regs clkbuf_0_clk_regs/Z _768_/CLK VDD VDD VSS VSS gf180mcu_fd_sc_mcu7t5v0__clkbuf_4
XFILLER_8_185 VDD VDD VSS VSS gf180mcu_fd_sc_mcu7t5v0__fill_2
XTAP_TAPCELL_ROW_11_135 VDD VSS gf180mcu_fd_sc_mcu7t5v0__filltie
XTAP_TAPCELL_ROW_20_168 VDD VSS gf180mcu_fd_sc_mcu7t5v0__filltie
XTAP_TAPCELL_ROW_28_202 VDD VSS gf180mcu_fd_sc_mcu7t5v0__filltie
XTAP_TAPCELL_ROW_5_111 VDD VSS gf180mcu_fd_sc_mcu7t5v0__filltie
X_342_ _747_/Q _449_/A1 VDD VDD VSS VSS gf180mcu_fd_sc_mcu7t5v0__clkinv_1
X_411_ _415_/A1 _761_/D _415_/A3 _426_/A2 VDD VDD VSS VSS gf180mcu_fd_sc_mcu7t5v0__nand3_1
Xg_reg\[14\].g_bit\[6\].g_l.g_d.u_l _758_/D _412_/ZN input1/Z _593_/A1 VDD VDD VSS
+ VSS gf180mcu_fd_sc_mcu7t5v0__latrnq_1
XTAP_TAPCELL_ROW_34_227 VDD VSS gf180mcu_fd_sc_mcu7t5v0__filltie
X_609_ _688_/Q _709_/Q _603_/B _638_/A2 VDD VDD VSS VSS gf180mcu_fd_sc_mcu7t5v0__nand3_1
XFILLER_23_46 VDD VDD VSS VSS gf180mcu_fd_sc_mcu7t5v0__fill_2
XFILLER_4_92 VDD VDD VSS VSS gf180mcu_fd_sc_mcu7t5v0__fillcap_4
XFILLER_29_4 VDD VDD VSS VSS gf180mcu_fd_sc_mcu7t5v0__fill_1
XPHY_EDGE_ROW_24_Left_66 VDD VSS gf180mcu_fd_sc_mcu7t5v0__endcap
X_325_ _781_/I _369_/A1 VDD VDD VSS VSS gf180mcu_fd_sc_mcu7t5v0__clkinv_1
XFILLER_1_2 VDD VDD VSS VSS gf180mcu_fd_sc_mcu7t5v0__fill_1
XFILLER_34_34 VDD VDD VSS VSS gf180mcu_fd_sc_mcu7t5v0__fill_1
Xload_slew12 load_slew13/Z load_slew12/Z VDD VDD VSS VSS gf180mcu_fd_sc_mcu7t5v0__clkbuf_2
Xclkload0 _769_/CLK clkload0/ZN VDD VDD VSS VSS gf180mcu_fd_sc_mcu7t5v0__clkinv_8
XFILLER_37_187 VDD VDD VSS VSS gf180mcu_fd_sc_mcu7t5v0__fill_1
X_590_ _697_/Q _590_/I1 _615_/B _697_/D VDD VDD VSS VSS gf180mcu_fd_sc_mcu7t5v0__mux2_2
Xhold34 _746_/Q _747_/D VDD VDD VSS VSS gf180mcu_fd_sc_mcu7t5v0__dlyc_1
Xhold45 _718_/Q _717_/D VDD VDD VSS VSS gf180mcu_fd_sc_mcu7t5v0__dlyc_1
Xneuron_ctrl_25 uio_oe[4] VDD VDD VSS VSS gf180mcu_fd_sc_mcu7t5v0__tieh
X_788_ _788_/I uo_out[0] VDD VDD VSS VSS gf180mcu_fd_sc_mcu7t5v0__buf_1
XPHY_EDGE_ROW_11_Left_53 VDD VSS gf180mcu_fd_sc_mcu7t5v0__endcap
XFILLER_16_168 VDD VDD VSS VSS gf180mcu_fd_sc_mcu7t5v0__fill_2
XFILLER_31_138 VDD VDD VSS VSS gf180mcu_fd_sc_mcu7t5v0__fill_2
XPHY_EDGE_ROW_19_Right_19 VDD VSS gf180mcu_fd_sc_mcu7t5v0__endcap
XPHY_EDGE_ROW_28_Right_28 VDD VSS gf180mcu_fd_sc_mcu7t5v0__endcap
X_573_ _694_/Q _615_/B _574_/B VDD VDD VSS VSS gf180mcu_fd_sc_mcu7t5v0__nor2_1
X_642_ _613_/C _642_/A2 _644_/B _638_/C _664_/A2 VDD VDD VSS VSS gf180mcu_fd_sc_mcu7t5v0__oai22_1
Xclkbuf_3_0__f_clk_regs clkbuf_0_clk_regs/Z _769_/CLK VDD VDD VSS VSS gf180mcu_fd_sc_mcu7t5v0__clkbuf_4
X_711_ _711_/D _718_/CLK _711_/Q VDD VDD VSS VSS gf180mcu_fd_sc_mcu7t5v0__dffq_1
XPHY_EDGE_ROW_37_Right_37 VDD VSS gf180mcu_fd_sc_mcu7t5v0__endcap
XTAP_TAPCELL_ROW_8_120 VDD VSS gf180mcu_fd_sc_mcu7t5v0__filltie
X_625_ _701_/Q _634_/A1 _626_/B VDD VDD VSS VSS gf180mcu_fd_sc_mcu7t5v0__nor2_1
XTAP_TAPCELL_ROW_14_144 VDD VSS gf180mcu_fd_sc_mcu7t5v0__filltie
XTAP_TAPCELL_ROW_37_236 VDD VSS gf180mcu_fd_sc_mcu7t5v0__filltie
X_487_ _733_/Q _482_/Z _487_/B _488_/I VDD VDD VSS VSS gf180mcu_fd_sc_mcu7t5v0__oai21_1
X_556_ _556_/A1 _615_/B _558_/B1 _557_/A1 _689_/D VDD VDD VSS VSS gf180mcu_fd_sc_mcu7t5v0__oai22_1
XFILLER_12_37 VDD VDD VSS VSS gf180mcu_fd_sc_mcu7t5v0__fill_2
XFILLER_37_34 VDD VDD VSS VSS gf180mcu_fd_sc_mcu7t5v0__fill_1
XTAP_TAPCELL_ROW_20_169 VDD VSS gf180mcu_fd_sc_mcu7t5v0__filltie
XTAP_TAPCELL_ROW_28_203 VDD VSS gf180mcu_fd_sc_mcu7t5v0__filltie
X_341_ _726_/Q _672_/A1 VDD VDD VSS VSS gf180mcu_fd_sc_mcu7t5v0__clkinv_1
X_410_ _416_/A1 _425_/A2 _410_/ZN VDD VDD VSS VSS gf180mcu_fd_sc_mcu7t5v0__nor2_1
XFILLER_17_230 VDD VDD VSS VSS gf180mcu_fd_sc_mcu7t5v0__fill_1
XFILLER_32_255 VDD VDD VSS VSS gf180mcu_fd_sc_mcu7t5v0__fill_2
X_539_ _539_/A1 _545_/A2 _539_/B _540_/A2 VDD VDD VSS VSS gf180mcu_fd_sc_mcu7t5v0__oai21_1
X_608_ _688_/Q _603_/B _709_/Q _638_/B VDD VDD VSS VSS gf180mcu_fd_sc_mcu7t5v0__aoi21_1
Xg_reg\[11\].g_bit\[0\].g_l.g_a.u_l _752_/D _417_/ZN input1/Z cfg_out[76] VDD VDD
+ VSS VSS gf180mcu_fd_sc_mcu7t5v0__latrnq_1
XFILLER_23_277 VDD VDD VSS VSS gf180mcu_fd_sc_mcu7t5v0__fill_2
Xg_reg\[4\].g_bit\[2\].g_l.g_a.u_l _754_/D _424_/ZN load_slew18/Z cfg_out[34] VDD
+ VDD VSS VSS gf180mcu_fd_sc_mcu7t5v0__latrnq_1
Xg_reg\[7\].g_bit\[5\].g_l.g_a.u_l _757_/D _421_/ZN input1/Z cfg_out[59] VDD VDD VSS
+ VSS gf180mcu_fd_sc_mcu7t5v0__latrnq_1
Xg_reg\[23\].g_bit\[3\].g_l.g_a.u_l _755_/D _396_/ZN _750_/RN cfg_out[121] VDD VDD
+ VSS VSS gf180mcu_fd_sc_mcu7t5v0__latrnq_1
Xg_reg\[20\].g_bit\[0\].g_l.g_a.u_l _752_/D _400_/ZN _750_/RN cfg_out[94] VDD VDD
+ VSS VSS gf180mcu_fd_sc_mcu7t5v0__latrnq_1
X_324_ _324_/I _378_/A1 VDD VDD VSS VSS gf180mcu_fd_sc_mcu7t5v0__clkinv_1
XFILLER_20_269 VDD VDD VSS VSS gf180mcu_fd_sc_mcu7t5v0__fill_1
Xg_reg\[13\].g_bit\[4\].g_l.g_d.u_l _756_/D _414_/ZN _750_/RN _619_/A2 VDD VDD VSS
+ VSS gf180mcu_fd_sc_mcu7t5v0__latrnq_1
Xg_reg\[10\].g_bit\[1\].g_l.g_d.u_l _753_/D _418_/ZN input1/Z _326_/I VDD VDD VSS
+ VSS gf180mcu_fd_sc_mcu7t5v0__latrnq_1
XPHY_EDGE_ROW_41_Left_83 VDD VSS gf180mcu_fd_sc_mcu7t5v0__endcap
Xload_slew13 _392_/ZN load_slew13/Z VDD VDD VSS VSS gf180mcu_fd_sc_mcu7t5v0__clkbuf_2
Xg_reg\[16\].g_bit\[7\].g_l.g_d.u_l _759_/D _406_/ZN input1/Z _613_/B1 VDD VDD VSS
+ VSS gf180mcu_fd_sc_mcu7t5v0__latrnq_1
Xclkload1 _768_/CLK clkload1/ZN VDD VDD VSS VSS gf180mcu_fd_sc_mcu7t5v0__inv_4
XFILLER_1_72 VDD VDD VSS VSS gf180mcu_fd_sc_mcu7t5v0__fill_2
XFILLER_27_2 VDD VDD VSS VSS gf180mcu_fd_sc_mcu7t5v0__fillcap_4
XFILLER_20_37 VDD VDD VSS VSS gf180mcu_fd_sc_mcu7t5v0__fillcap_16
XFILLER_28_177 VDD VDD VSS VSS gf180mcu_fd_sc_mcu7t5v0__fill_2
Xhold35 _710_/Q _709_/D VDD VDD VSS VSS gf180mcu_fd_sc_mcu7t5v0__dlyc_1
Xhold46 _717_/Q _716_/D VDD VDD VSS VSS gf180mcu_fd_sc_mcu7t5v0__dlyc_1
Xneuron_ctrl_26 uio_oe[5] VDD VDD VSS VSS gf180mcu_fd_sc_mcu7t5v0__tieh
XFILLER_3_298 VDD VDD VSS VSS gf180mcu_fd_sc_mcu7t5v0__fill_1
X_787_ spk_in[13] uio_out[5] VDD VDD VSS VSS gf180mcu_fd_sc_mcu7t5v0__buf_1
XFILLER_0_202 VDD VDD VSS VSS gf180mcu_fd_sc_mcu7t5v0__fill_2
X_572_ _572_/A1 _613_/C _572_/B _574_/A2 VDD VDD VSS VSS gf180mcu_fd_sc_mcu7t5v0__aoi21_1
X_641_ _633_/C _641_/A2 _644_/B VDD VDD VSS VSS gf180mcu_fd_sc_mcu7t5v0__nand2_1
X_710_ _710_/D _718_/CLK _710_/Q VDD VDD VSS VSS gf180mcu_fd_sc_mcu7t5v0__dffq_1
XFILLER_13_117 VDD VDD VSS VSS gf180mcu_fd_sc_mcu7t5v0__fill_1
XTAP_TAPCELL_ROW_8_121 VDD VSS gf180mcu_fd_sc_mcu7t5v0__filltie
XFILLER_12_183 VDD VDD VSS VSS gf180mcu_fd_sc_mcu7t5v0__fill_1
XTAP_TAPCELL_ROW_14_145 VDD VSS gf180mcu_fd_sc_mcu7t5v0__filltie
X_486_ _733_/Q _482_/Z _486_/B _487_/B VDD VDD VSS VSS gf180mcu_fd_sc_mcu7t5v0__aoi21_1
X_555_ _555_/A1 _615_/B _558_/B1 _556_/A1 _688_/D VDD VDD VSS VSS gf180mcu_fd_sc_mcu7t5v0__oai22_1
X_624_ _737_/Q _624_/A2 _633_/C _624_/C _626_/A2 VDD VDD VSS VSS gf180mcu_fd_sc_mcu7t5v0__oai211_1
XTAP_TAPCELL_ROW_37_237 VDD VSS gf180mcu_fd_sc_mcu7t5v0__filltie
X_340_ _723_/Q _462_/B2 VDD VDD VSS VSS gf180mcu_fd_sc_mcu7t5v0__clkinv_1
X_538_ _538_/A1 _445_/Z _538_/B1 _739_/Q _539_/B VDD VDD VSS VSS gf180mcu_fd_sc_mcu7t5v0__aoi22_1
X_607_ _607_/A1 _607_/A2 _607_/B _607_/C _643_/A2 VDD VDD VSS VSS gf180mcu_fd_sc_mcu7t5v0__oai211_1
XFILLER_23_212 VDD VDD VSS VSS gf180mcu_fd_sc_mcu7t5v0__fill_1
X_469_ _731_/Q _732_/Q _735_/Q _736_/Q _483_/A2 _467_/C _469_/Z VDD VDD VSS VSS gf180mcu_fd_sc_mcu7t5v0__mux4_1
X_323_ _323_/I _476_/A1 VDD VDD VSS VSS gf180mcu_fd_sc_mcu7t5v0__clkinv_1
XTAP_TAPCELL_ROW_0_84 VDD VSS gf180mcu_fd_sc_mcu7t5v0__filltie
XTAP_TAPCELL_ROW_30_210 VDD VSS gf180mcu_fd_sc_mcu7t5v0__filltie
Xclkload2 _750_/CLK clkload2/ZN VDD VDD VSS VSS gf180mcu_fd_sc_mcu7t5v0__clkinv_4
Xg_reg\[25\].g_bit\[4\].g_l.g_a.u_l _756_/D _391_/ZN _750_/RN cfg_out[138] VDD VDD
+ VSS VSS gf180mcu_fd_sc_mcu7t5v0__latrnq_1
Xg_reg\[22\].g_bit\[1\].g_l.g_a.u_l _753_/D _398_/ZN _750_/RN cfg_out[111] VDD VDD
+ VSS VSS gf180mcu_fd_sc_mcu7t5v0__latrnq_1
Xg_reg\[19\].g_bit\[7\].g_l.g_a.u_l _759_/D _403_/ZN _750_/RN cfg_out[93] VDD VDD
+ VSS VSS gf180mcu_fd_sc_mcu7t5v0__latrnq_1
Xg_reg\[6\].g_bit\[3\].g_l.g_a.u_l _755_/D _422_/ZN load_slew18/Z cfg_out[51] VDD
+ VDD VSS VSS gf180mcu_fd_sc_mcu7t5v0__latrnq_1
Xg_reg\[9\].g_bit\[6\].g_l.g_a.u_l _758_/D _419_/ZN input1/Z cfg_out[75] VDD VDD VSS
+ VSS gf180mcu_fd_sc_mcu7t5v0__latrnq_1
Xhold36 _749_/Q _750_/D VDD VDD VSS VSS gf180mcu_fd_sc_mcu7t5v0__dlyc_1
Xhold47 _765_/Q _766_/D VDD VDD VSS VSS gf180mcu_fd_sc_mcu7t5v0__dlyc_1
Xneuron_ctrl_27 uio_oe[6] VDD VDD VSS VSS gf180mcu_fd_sc_mcu7t5v0__tieh
Xg_reg\[3\].g_bit\[0\].g_l.g_a.u_l _752_/D _425_/ZN load_slew18/Z cfg_out[24] VDD
+ VDD VSS VSS gf180mcu_fd_sc_mcu7t5v0__latrnq_1
XFILLER_19_156 VDD VDD VSS VSS gf180mcu_fd_sc_mcu7t5v0__fill_1
X_786_ spk_in[12] uio_out[4] VDD VDD VSS VSS gf180mcu_fd_sc_mcu7t5v0__buf_1
XFILLER_25_137 VDD VDD VSS VSS gf180mcu_fd_sc_mcu7t5v0__fill_2
XFILLER_40_107 VDD VDD VSS VSS gf180mcu_fd_sc_mcu7t5v0__fill_1
Xg_reg\[15\].g_bit\[5\].g_l.g_d.u_l _757_/D _410_/ZN _750_/RN _655_/A1 VDD VDD VSS
+ VSS gf180mcu_fd_sc_mcu7t5v0__latrnq_1
Xg_reg\[12\].g_bit\[2\].g_l.g_d.u_l _754_/D _416_/ZN load_slew18/Z _467_/C VDD VDD
+ VSS VSS gf180mcu_fd_sc_mcu7t5v0__latrnq_1
XFILLER_0_236 VDD VDD VSS VSS gf180mcu_fd_sc_mcu7t5v0__fill_2
XPHY_EDGE_ROW_1_Right_1 VDD VSS gf180mcu_fd_sc_mcu7t5v0__endcap
X_571_ _571_/A1 _571_/A2 _572_/B VDD VDD VSS VSS gf180mcu_fd_sc_mcu7t5v0__nor2_1
X_640_ _640_/A1 _640_/A2 _640_/B1 _640_/B2 _704_/D VDD VDD VSS VSS gf180mcu_fd_sc_mcu7t5v0__aoi22_1
Xg_reg\[1\].g_bit\[7\].g_l.g_a.u_l _759_/D _427_/ZN load_slew18/Z cfg_out[15] VDD
+ VDD VSS VSS gf180mcu_fd_sc_mcu7t5v0__latrnq_1
XFILLER_11_6 VDD VDD VSS VSS gf180mcu_fd_sc_mcu7t5v0__fill_1
XFILLER_21_92 VDD VDD VSS VSS gf180mcu_fd_sc_mcu7t5v0__fill_1
XFILLER_7_50 VDD VDD VSS VSS gf180mcu_fd_sc_mcu7t5v0__fill_2
X_769_ _769_/D wire14/Z _769_/CLK sc_clk VDD VDD VSS VSS gf180mcu_fd_sc_mcu7t5v0__dffrnq_1
XFILLER_26_26 VDD VDD VSS VSS gf180mcu_fd_sc_mcu7t5v0__fillcap_8
XFILLER_26_37 VDD VDD VSS VSS gf180mcu_fd_sc_mcu7t5v0__fillcap_4
XFILLER_8_111 VDD VDD VSS VSS gf180mcu_fd_sc_mcu7t5v0__fill_2
XTAP_TAPCELL_ROW_14_146 VDD VSS gf180mcu_fd_sc_mcu7t5v0__filltie
XTAP_TAPCELL_ROW_8_122 VDD VSS gf180mcu_fd_sc_mcu7t5v0__filltie
X_485_ _482_/Z _486_/B _485_/A3 _732_/D VDD VDD VSS VSS gf180mcu_fd_sc_mcu7t5v0__nor3_1
X_554_ _633_/C _430_/Z _615_/B _558_/B1 VDD VDD VSS VSS gf180mcu_fd_sc_mcu7t5v0__nand3_1
X_623_ _737_/Q _622_/Z _624_/C VDD VDD VSS VSS gf180mcu_fd_sc_mcu7t5v0__nand2_1
XFILLER_12_39 VDD VDD VSS VSS gf180mcu_fd_sc_mcu7t5v0__fill_1
XTAP_TAPCELL_ROW_37_238 VDD VSS gf180mcu_fd_sc_mcu7t5v0__filltie
XFILLER_5_136 VDD VDD VSS VSS gf180mcu_fd_sc_mcu7t5v0__fillcap_4
XFILLER_32_257 VDD VDD VSS VSS gf180mcu_fd_sc_mcu7t5v0__fill_1
X_399_ _405_/A1 _395_/Z _399_/ZN VDD VDD VSS VSS gf180mcu_fd_sc_mcu7t5v0__nor2_1
X_468_ _346_/I _483_/A2 _467_/C _465_/Z _468_/B2 _473_/A3 VDD VDD VSS VSS gf180mcu_fd_sc_mcu7t5v0__oai32_1
X_537_ _544_/A2 _537_/A2 _538_/B1 VDD VDD VSS VSS gf180mcu_fd_sc_mcu7t5v0__nand2_1
X_606_ _655_/B _606_/A2 _606_/A3 _606_/B _607_/A2 VDD VDD VSS VSS gf180mcu_fd_sc_mcu7t5v0__oai31_1
XFILLER_14_235 VDD VDD VSS VSS gf180mcu_fd_sc_mcu7t5v0__fill_2
XFILLER_23_279 VDD VDD VSS VSS gf180mcu_fd_sc_mcu7t5v0__fill_1
X_322_ _741_/Q _638_/C VDD VDD VSS VSS gf180mcu_fd_sc_mcu7t5v0__clkinv_1
XFILLER_22_290 VDD VDD VSS VSS gf180mcu_fd_sc_mcu7t5v0__fill_1
XTAP_TAPCELL_ROW_0_85 VDD VSS gf180mcu_fd_sc_mcu7t5v0__filltie
XTAP_TAPCELL_ROW_30_211 VDD VSS gf180mcu_fd_sc_mcu7t5v0__filltie
Xclkload3 _767_/CLK clkload3/ZN VDD VDD VSS VSS gf180mcu_fd_sc_mcu7t5v0__clkinv_4
XFILLER_28_179 VDD VDD VSS VSS gf180mcu_fd_sc_mcu7t5v0__fill_1
XFILLER_3_278 VDD VDD VSS VSS gf180mcu_fd_sc_mcu7t5v0__fill_2
Xhold37 _764_/Q _765_/D VDD VDD VSS VSS gf180mcu_fd_sc_mcu7t5v0__dlyc_1
Xhold48 _743_/Q _744_/D VDD VDD VSS VSS gf180mcu_fd_sc_mcu7t5v0__dlyc_1
Xneuron_ctrl_28 uio_oe[7] VDD VDD VSS VSS gf180mcu_fd_sc_mcu7t5v0__tieh
XFILLER_32_2 VDD VDD VSS VSS gf180mcu_fd_sc_mcu7t5v0__fillcap_4
X_785_ spk_in[11] uio_out[3] VDD VDD VSS VSS gf180mcu_fd_sc_mcu7t5v0__buf_1
X_570_ _570_/A1 _430_/Z _633_/C _571_/A2 VDD VDD VSS VSS gf180mcu_fd_sc_mcu7t5v0__oai21_1
Xg_reg\[18\].g_bit\[5\].g_l.g_a.u_l _757_/D _404_/ZN _750_/RN cfg_out[83] VDD VDD
+ VSS VSS gf180mcu_fd_sc_mcu7t5v0__latrnq_1
Xg_reg\[5\].g_bit\[1\].g_l.g_a.u_l _753_/D _423_/ZN load_slew18/Z cfg_out[41] VDD
+ VDD VSS VSS gf180mcu_fd_sc_mcu7t5v0__latrnq_1
Xg_reg\[8\].g_bit\[4\].g_l.g_a.u_l _756_/D _420_/ZN input1/Z cfg_out[64] VDD VDD VSS
+ VSS gf180mcu_fd_sc_mcu7t5v0__latrnq_1
Xg_reg\[24\].g_bit\[2\].g_l.g_a.u_l _754_/D load_slew12/Z _750_/RN cfg_out[128] VDD
+ VDD VSS VSS gf180mcu_fd_sc_mcu7t5v0__latrnq_1
Xclkbuf_0_clk clk clkbuf_0_clk/Z VDD VDD VSS VSS gf180mcu_fd_sc_mcu7t5v0__clkbuf_4
X_768_ _768_/D _750_/Q _768_/CLK _768_/Q VDD VDD VSS VSS gf180mcu_fd_sc_mcu7t5v0__dffrnq_1
X_699_ _699_/D wire17/Z _748_/CLK _699_/Q VDD VDD VSS VSS gf180mcu_fd_sc_mcu7t5v0__dffrnq_1
XPHY_EDGE_ROW_15_Left_57 VDD VSS gf180mcu_fd_sc_mcu7t5v0__endcap
XPHY_EDGE_ROW_15_Right_15 VDD VSS gf180mcu_fd_sc_mcu7t5v0__endcap
XPHY_EDGE_ROW_24_Right_24 VDD VSS gf180mcu_fd_sc_mcu7t5v0__endcap
XFILLER_8_123 VDD VDD VSS VSS gf180mcu_fd_sc_mcu7t5v0__fill_2
XPHY_EDGE_ROW_33_Right_33 VDD VSS gf180mcu_fd_sc_mcu7t5v0__endcap
XTAP_TAPCELL_ROW_14_147 VDD VSS gf180mcu_fd_sc_mcu7t5v0__filltie
XTAP_TAPCELL_ROW_8_123 VDD VSS gf180mcu_fd_sc_mcu7t5v0__filltie
X_484_ _731_/Q _481_/Z _732_/Q _485_/A3 VDD VDD VSS VSS gf180mcu_fd_sc_mcu7t5v0__aoi21_1
X_553_ _613_/B2 _552_/Z _553_/B _615_/B VDD VDD VSS VSS gf180mcu_fd_sc_mcu7t5v0__aoi21_1
X_622_ _701_/Q _700_/Q _622_/Z VDD VDD VSS VSS gf180mcu_fd_sc_mcu7t5v0__xor2_1
XTAP_TAPCELL_ROW_37_239 VDD VSS gf180mcu_fd_sc_mcu7t5v0__filltie
Xg_reg\[17\].g_bit\[6\].g_l.g_d.u_l _758_/D _405_/ZN _750_/RN _603_/A2 VDD VDD VSS
+ VSS gf180mcu_fd_sc_mcu7t5v0__latrnq_1
Xg_reg\[14\].g_bit\[3\].g_l.g_d.u_l _755_/D _412_/ZN input1/Z _578_/A1 VDD VDD VSS
+ VSS gf180mcu_fd_sc_mcu7t5v0__latrnq_1
Xg_reg\[10\].g_bit\[6\].g_l.g_a.u_l _758_/D _418_/ZN input1/Z _781_/I VDD VDD VSS
+ VSS gf180mcu_fd_sc_mcu7t5v0__latrnq_1
XFILLER_41_236 VDD VDD VSS VSS gf180mcu_fd_sc_mcu7t5v0__fill_2
Xg_reg\[0\].g_bit\[5\].g_l.g_a.u_l _757_/D _428_/ZN load_slew18/Z cfg_out[5] VDD VDD
+ VSS VSS gf180mcu_fd_sc_mcu7t5v0__latrnq_1
XFILLER_4_41 VDD VDD VSS VSS gf180mcu_fd_sc_mcu7t5v0__fill_1
XFILLER_4_96 VDD VDD VSS VSS gf180mcu_fd_sc_mcu7t5v0__fill_2
X_398_ _395_/Z _404_/A1 _398_/ZN VDD VDD VSS VSS gf180mcu_fd_sc_mcu7t5v0__nor2_1
X_467_ _672_/A1 _346_/I _483_/A2 _467_/B2 _467_/C _468_/B2 VDD VDD VSS VSS gf180mcu_fd_sc_mcu7t5v0__oai221_1
X_536_ _684_/Q _685_/Q _686_/Q _537_/A2 VDD VDD VSS VSS gf180mcu_fd_sc_mcu7t5v0__oai21_1
X_605_ _605_/A1 _655_/A2 _656_/C _605_/C _607_/A1 VDD VDD VSS VSS gf180mcu_fd_sc_mcu7t5v0__aoi211_1
XPHY_EDGE_ROW_18_Left_60 VDD VSS gf180mcu_fd_sc_mcu7t5v0__endcap
XTAP_TAPCELL_ROW_33_220 VDD VSS gf180mcu_fd_sc_mcu7t5v0__filltie
XFILLER_14_269 VDD VDD VSS VSS gf180mcu_fd_sc_mcu7t5v0__fill_1
XTAP_TAPCELL_ROW_0_86 VDD VSS gf180mcu_fd_sc_mcu7t5v0__filltie
X_321_ _686_/Q _541_/A1 VDD VDD VSS VSS gf180mcu_fd_sc_mcu7t5v0__clkinv_1
XFILLER_9_240 VDD VDD VSS VSS gf180mcu_fd_sc_mcu7t5v0__fill_2
X_519_ _552_/A1 _639_/A1 _519_/B _635_/A2 VDD VDD VSS VSS gf180mcu_fd_sc_mcu7t5v0__aoi21_1
XPHY_EDGE_ROW_3_Left_45 VDD VSS gf180mcu_fd_sc_mcu7t5v0__endcap
Xload_slew16 wire17/Z wire15/I VDD VDD VSS VSS gf180mcu_fd_sc_mcu7t5v0__buf_4
Xclkload4 _766_/CLK clkload4/Z VDD VDD VSS VSS gf180mcu_fd_sc_mcu7t5v0__clkbuf_4
XFILLER_6_298 VDD VDD VSS VSS gf180mcu_fd_sc_mcu7t5v0__fill_1
XFILLER_29_27 VDD VDD VSS VSS gf180mcu_fd_sc_mcu7t5v0__fillcap_16
Xhold38 _712_/Q _711_/D VDD VDD VSS VSS gf180mcu_fd_sc_mcu7t5v0__dlyc_1
Xhold49 _761_/Q _762_/D VDD VDD VSS VSS gf180mcu_fd_sc_mcu7t5v0__dlyc_1
XFILLER_19_114 VDD VDD VSS VSS gf180mcu_fd_sc_mcu7t5v0__fillcap_4
Xclkbuf_regs_0_clk clk clkbuf_regs_0_clk/Z VDD VDD VSS VSS gf180mcu_fd_sc_mcu7t5v0__clkbuf_4
X_784_ spk_in[10] uio_out[2] VDD VDD VSS VSS gf180mcu_fd_sc_mcu7t5v0__buf_1
XFILLER_25_139 VDD VDD VSS VSS gf180mcu_fd_sc_mcu7t5v0__fill_1
XFILLER_25_2 VDD VDD VSS VSS gf180mcu_fd_sc_mcu7t5v0__fillcap_16
XFILLER_21_72 VDD VDD VSS VSS gf180mcu_fd_sc_mcu7t5v0__fillcap_16
X_767_ _767_/D wire17/Z _767_/CLK _767_/Q VDD VDD VSS VSS gf180mcu_fd_sc_mcu7t5v0__dffrnq_1
XFILLER_15_194 VDD VDD VSS VSS gf180mcu_fd_sc_mcu7t5v0__fill_1
XTAP_TAPCELL_ROW_17_156 VDD VSS gf180mcu_fd_sc_mcu7t5v0__filltie
X_698_ _698_/D wire14/Z _766_/CLK _698_/Q VDD VDD VSS VSS gf180mcu_fd_sc_mcu7t5v0__dffrnq_1
XFILLER_21_142 VDD VDD VSS VSS gf180mcu_fd_sc_mcu7t5v0__fill_2
XFILLER_8_102 VDD VDD VSS VSS gf180mcu_fd_sc_mcu7t5v0__fill_2
XPHY_EDGE_ROW_32_Left_74 VDD VSS gf180mcu_fd_sc_mcu7t5v0__endcap
X_483_ _346_/I _483_/A2 _467_/C _472_/B _486_/B VDD VDD VSS VSS gf180mcu_fd_sc_mcu7t5v0__nor4_2
X_552_ _552_/A1 _633_/C _552_/A3 _552_/Z VDD VDD VSS VSS gf180mcu_fd_sc_mcu7t5v0__and3_1
X_621_ _634_/A1 _621_/A2 _621_/B _700_/D VDD VDD VSS VSS gf180mcu_fd_sc_mcu7t5v0__aoi21_1
XFILLER_35_212 VDD VDD VSS VSS gf180mcu_fd_sc_mcu7t5v0__fill_1
XFILLER_26_267 VDD VDD VSS VSS gf180mcu_fd_sc_mcu7t5v0__fill_2
XFILLER_7_190 VDD VDD VSS VSS gf180mcu_fd_sc_mcu7t5v0__fill_2
Xg_reg\[23\].g_bit\[0\].g_l.g_a.u_l _752_/D _396_/ZN _750_/RN cfg_out[118] VDD VDD
+ VSS VSS gf180mcu_fd_sc_mcu7t5v0__latrnq_1
X_397_ _415_/A1 _761_/D _404_/A1 VDD VDD VSS VSS gf180mcu_fd_sc_mcu7t5v0__nand2_1
X_466_ _727_/Q _470_/A1 _467_/B2 VDD VDD VSS VSS gf180mcu_fd_sc_mcu7t5v0__nor2_1
X_535_ _543_/B1 _542_/A2 _545_/A2 VDD VDD VSS VSS gf180mcu_fd_sc_mcu7t5v0__nand2_1
X_604_ _604_/A1 _604_/A2 _604_/B1 _604_/B2 _604_/C _607_/C VDD VDD VSS VSS gf180mcu_fd_sc_mcu7t5v0__oai221_1
Xg_reg\[7\].g_bit\[2\].g_l.g_a.u_l _754_/D _421_/ZN input1/Z cfg_out[56] VDD VDD VSS
+ VSS gf180mcu_fd_sc_mcu7t5v0__latrnq_1
XTAP_TAPCELL_ROW_33_221 VDD VSS gf180mcu_fd_sc_mcu7t5v0__filltie
XTAP_TAPCELL_ROW_0_87 VDD VSS gf180mcu_fd_sc_mcu7t5v0__filltie
X_320_ _687_/Q _598_/A1 VDD VDD VSS VSS gf180mcu_fd_sc_mcu7t5v0__clkinv_1
Xg_reg\[16\].g_bit\[4\].g_l.g_d.u_l _756_/D _406_/ZN load_slew18/Z _582_/A1 VDD VDD
+ VSS VSS gf180mcu_fd_sc_mcu7t5v0__latrnq_1
Xg_reg\[13\].g_bit\[1\].g_l.g_d.u_l _753_/D _414_/ZN _750_/RN _528_/A3 VDD VDD VSS
+ VSS gf180mcu_fd_sc_mcu7t5v0__latrnq_1
X_449_ _449_/A1 _748_/Q _737_/Q _450_/A3 VDD VDD VSS VSS gf180mcu_fd_sc_mcu7t5v0__oai21_1
X_518_ _740_/Q _517_/Z _518_/B _770_/D VDD VDD VSS VSS gf180mcu_fd_sc_mcu7t5v0__aoi21_1
Xg_reg\[21\].g_bit\[7\].g_l.g_a.u_l _759_/D _399_/ZN _750_/RN cfg_out[109] VDD VDD
+ VSS VSS gf180mcu_fd_sc_mcu7t5v0__latrnq_1
XFILLER_11_207 VDD VDD VSS VSS gf180mcu_fd_sc_mcu7t5v0__fill_2
Xg_reg\[2\].g_bit\[6\].g_l.g_a.u_l _758_/D _426_/ZN load_slew18/Z cfg_out[22] VDD
+ VDD VSS VSS gf180mcu_fd_sc_mcu7t5v0__latrnq_1
Xclkload5 _748_/CLK clkload5/ZN VDD VDD VSS VSS gf180mcu_fd_sc_mcu7t5v0__inv_4
XFILLER_24_72 VDD VDD VSS VSS gf180mcu_fd_sc_mcu7t5v0__fillcap_4
XFILLER_6_222 VDD VDD VSS VSS gf180mcu_fd_sc_mcu7t5v0__fill_1
Xhold39 _715_/Q _714_/D VDD VDD VSS VSS gf180mcu_fd_sc_mcu7t5v0__dlyc_1
X_783_ spk_in[9] uio_out[1] VDD VDD VSS VSS gf180mcu_fd_sc_mcu7t5v0__buf_1
XFILLER_0_228 VDD VDD VSS VSS gf180mcu_fd_sc_mcu7t5v0__fillcap_8
XFILLER_18_2 VDD VDD VSS VSS gf180mcu_fd_sc_mcu7t5v0__fill_2
XFILLER_2_291 VDD VDD VSS VSS gf180mcu_fd_sc_mcu7t5v0__fillcap_8
XFILLER_33_173 VDD VDD VSS VSS gf180mcu_fd_sc_mcu7t5v0__fill_2
XFILLER_16_129 VDD VDD VSS VSS gf180mcu_fd_sc_mcu7t5v0__fill_2
XFILLER_15_184 VDD VDD VSS VSS gf180mcu_fd_sc_mcu7t5v0__fill_2
XTAP_TAPCELL_ROW_17_157 VDD VSS gf180mcu_fd_sc_mcu7t5v0__filltie
XTAP_TAPCELL_ROW_25_190 VDD VSS gf180mcu_fd_sc_mcu7t5v0__filltie
X_766_ _766_/D wire14/Z _766_/CLK _766_/Q VDD VDD VSS VSS gf180mcu_fd_sc_mcu7t5v0__dffrnq_1
X_697_ _697_/D wire14/Z _766_/CLK _697_/Q VDD VDD VSS VSS gf180mcu_fd_sc_mcu7t5v0__dffrnq_1
XFILLER_21_132 VDD VDD VSS VSS gf180mcu_fd_sc_mcu7t5v0__fill_2
XPHY_EDGE_ROW_5_Right_5 VDD VSS gf180mcu_fd_sc_mcu7t5v0__endcap
X_551_ _551_/A1 _551_/A2 _551_/B _553_/B VDD VDD VSS VSS gf180mcu_fd_sc_mcu7t5v0__oai21_1
X_620_ _700_/Q _634_/A1 _621_/B VDD VDD VSS VSS gf180mcu_fd_sc_mcu7t5v0__nor2_1
XFILLER_16_73 VDD VDD VSS VSS gf180mcu_fd_sc_mcu7t5v0__fill_2
X_482_ _731_/Q _732_/Q _481_/Z _482_/Z VDD VDD VSS VSS gf180mcu_fd_sc_mcu7t5v0__and3_1
X_749_ _749_/D _750_/RN _750_/CLK _749_/Q VDD VDD VSS VSS gf180mcu_fd_sc_mcu7t5v0__dffrnq_1
XFILLER_17_268 VDD VDD VSS VSS gf180mcu_fd_sc_mcu7t5v0__fill_2
XFILLER_27_72 VDD VDD VSS VSS gf180mcu_fd_sc_mcu7t5v0__fill_2
XTAP_TAPCELL_ROW_10_130 VDD VSS gf180mcu_fd_sc_mcu7t5v0__filltie
X_396_ _403_/A1 _395_/Z _396_/ZN VDD VDD VSS VSS gf180mcu_fd_sc_mcu7t5v0__nor2_1
X_465_ _728_/Q _346_/I _483_/A2 _465_/Z VDD VDD VSS VSS gf180mcu_fd_sc_mcu7t5v0__and3_1
X_534_ _684_/Q _685_/Q _686_/Q _542_/A2 VDD VDD VSS VSS gf180mcu_fd_sc_mcu7t5v0__nand3_1
X_603_ _684_/Q _603_/A2 _603_/B _685_/Q _604_/B1 VDD VDD VSS VSS gf180mcu_fd_sc_mcu7t5v0__oai211_1
XFILLER_4_98 VDD VDD VSS VSS gf180mcu_fd_sc_mcu7t5v0__fill_1
XTAP_TAPCELL_ROW_33_222 VDD VSS gf180mcu_fd_sc_mcu7t5v0__filltie
XFILLER_13_85 VDD VDD VSS VSS gf180mcu_fd_sc_mcu7t5v0__fill_2
XFILLER_1_142 VDD VDD VSS VSS gf180mcu_fd_sc_mcu7t5v0__fillcap_4
XFILLER_38_82 VDD VDD VSS VSS gf180mcu_fd_sc_mcu7t5v0__fill_1
XFILLER_9_242 VDD VDD VSS VSS gf180mcu_fd_sc_mcu7t5v0__fill_1
XTAP_TAPCELL_ROW_0_88 VDD VSS gf180mcu_fd_sc_mcu7t5v0__filltie
X_379_ _365_/Z _378_/Z probe_sel_onehot[8] VDD VDD VSS VSS gf180mcu_fd_sc_mcu7t5v0__nor2_1
X_448_ _552_/A1 _547_/A1 _448_/Z VDD VDD VSS VSS gf180mcu_fd_sc_mcu7t5v0__or2_1
X_517_ _704_/Q _517_/A2 _517_/Z VDD VDD VSS VSS gf180mcu_fd_sc_mcu7t5v0__xor2_1
Xg_reg\[19\].g_bit\[4\].g_l.g_a.u_l _756_/D _403_/ZN _750_/RN cfg_out[90] VDD VDD
+ VSS VSS gf180mcu_fd_sc_mcu7t5v0__latrnq_1
Xg_reg\[6\].g_bit\[0\].g_l.g_a.u_l _752_/D _422_/ZN load_slew18/Z cfg_out[48] VDD
+ VDD VSS VSS gf180mcu_fd_sc_mcu7t5v0__latrnq_1
Xg_reg\[9\].g_bit\[3\].g_l.g_a.u_l _755_/D _419_/ZN input1/Z cfg_out[72] VDD VDD VSS
+ VSS gf180mcu_fd_sc_mcu7t5v0__latrnq_1
Xload_slew18 input1/Z load_slew18/Z VDD VDD VSS VSS gf180mcu_fd_sc_mcu7t5v0__buf_16
Xg_reg\[25\].g_bit\[1\].g_l.g_a.u_l _753_/D _391_/ZN _750_/RN cfg_out[135] VDD VDD
+ VSS VSS gf180mcu_fd_sc_mcu7t5v0__latrnq_1
Xclkload6 _703_/CLK clkload6/ZN VDD VDD VSS VSS gf180mcu_fd_sc_mcu7t5v0__clkinv_4
XFILLER_10_230 VDD VDD VSS VSS gf180mcu_fd_sc_mcu7t5v0__fill_1
XFILLER_41_9 VDD VDD VSS VSS gf180mcu_fd_sc_mcu7t5v0__fill_2
Xhold29 _742_/Q _743_/D VDD VDD VSS VSS gf180mcu_fd_sc_mcu7t5v0__dlyc_1
Xu_lif.u_cg.u_icg_20 u_lif.u_cg.u_icg/TE VDD VDD VSS VSS gf180mcu_fd_sc_mcu7t5v0__tiel
XFILLER_27_182 VDD VDD VSS VSS gf180mcu_fd_sc_mcu7t5v0__fill_1
XFILLER_35_94 VDD VDD VSS VSS gf180mcu_fd_sc_mcu7t5v0__fill_1
Xg_reg\[15\].g_bit\[2\].g_l.g_d.u_l _754_/D _410_/ZN input1/Z _652_/B2 VDD VDD VSS
+ VSS gf180mcu_fd_sc_mcu7t5v0__latrnq_1
X_782_ spk_in[8] uio_out[0] VDD VDD VSS VSS gf180mcu_fd_sc_mcu7t5v0__buf_1
Xg_reg\[4\].g_bit\[7\].g_l.g_a.u_l _759_/D _424_/ZN load_slew18/Z cfg_out[39] VDD
+ VDD VSS VSS gf180mcu_fd_sc_mcu7t5v0__latrnq_1
Xg_reg\[20\].g_bit\[5\].g_l.g_a.u_l _757_/D _400_/ZN _750_/RN cfg_out[99] VDD VDD
+ VSS VSS gf180mcu_fd_sc_mcu7t5v0__latrnq_1
Xg_reg\[1\].g_bit\[4\].g_l.g_a.u_l _756_/D _427_/ZN load_slew18/Z cfg_out[12] VDD
+ VDD VSS VSS gf180mcu_fd_sc_mcu7t5v0__latrnq_1
XFILLER_30_2 VDD VDD VSS VSS gf180mcu_fd_sc_mcu7t5v0__fill_2
XTAP_TAPCELL_ROW_17_158 VDD VSS gf180mcu_fd_sc_mcu7t5v0__filltie
XTAP_TAPCELL_ROW_25_191 VDD VSS gf180mcu_fd_sc_mcu7t5v0__filltie
X_765_ _765_/D wire14/Z _769_/CLK _765_/Q VDD VDD VSS VSS gf180mcu_fd_sc_mcu7t5v0__dffrnq_1
X_696_ _696_/D wire14/Z _766_/CLK _696_/Q VDD VDD VSS VSS gf180mcu_fd_sc_mcu7t5v0__dffrnq_1
XFILLER_8_104 VDD VDD VSS VSS gf180mcu_fd_sc_mcu7t5v0__fill_1
XPHY_EDGE_ROW_11_Right_11 VDD VSS gf180mcu_fd_sc_mcu7t5v0__endcap
XPHY_EDGE_ROW_20_Right_20 VDD VSS gf180mcu_fd_sc_mcu7t5v0__endcap
X_481_ _730_/Q _480_/Z _481_/Z VDD VDD VSS VSS gf180mcu_fd_sc_mcu7t5v0__and2_1
X_550_ _739_/Q _355_/Z _551_/A2 VDD VDD VSS VSS gf180mcu_fd_sc_mcu7t5v0__nor2_1
XFILLER_26_269 VDD VDD VSS VSS gf180mcu_fd_sc_mcu7t5v0__fill_1
X_748_ _748_/D wire15/I _748_/CLK _748_/Q VDD VDD VSS VSS gf180mcu_fd_sc_mcu7t5v0__dffrnq_1
X_679_ _480_/Z _486_/B _679_/A3 _729_/D VDD VDD VSS VSS gf180mcu_fd_sc_mcu7t5v0__nor3_1
X_464_ _464_/A1 _464_/A2 _464_/Z VDD VDD VSS VSS gf180mcu_fd_sc_mcu7t5v0__and2_1
X_533_ _638_/C _533_/A2 _543_/B1 VDD VDD VSS VSS gf180mcu_fd_sc_mcu7t5v0__nand2_1
X_602_ _656_/A1 _602_/A2 _355_/Z _602_/B _604_/A2 VDD VDD VSS VSS gf180mcu_fd_sc_mcu7t5v0__oai31_1
XTAP_TAPCELL_ROW_10_131 VDD VSS gf180mcu_fd_sc_mcu7t5v0__filltie
XTAP_TAPCELL_ROW_33_223 VDD VSS gf180mcu_fd_sc_mcu7t5v0__filltie
X_395_ _402_/A1 _424_/A1 _395_/Z VDD VDD VSS VSS gf180mcu_fd_sc_mcu7t5v0__or2_1
Xclkbuf_1_0__f_u_lif.d_clk clkbuf_0_u_lif.d_clk/Z _718_/CLK VDD VDD VSS VSS gf180mcu_fd_sc_mcu7t5v0__clkbuf_4
XFILLER_8_2 VDD VDD VSS VSS gf180mcu_fd_sc_mcu7t5v0__fillcap_4
XFILLER_9_298 VDD VDD VSS VSS gf180mcu_fd_sc_mcu7t5v0__fill_1
XTAP_TAPCELL_ROW_0_89 VDD VSS gf180mcu_fd_sc_mcu7t5v0__filltie
X_378_ _378_/A1 _383_/A2 _378_/Z VDD VDD VSS VSS gf180mcu_fd_sc_mcu7t5v0__or2_1
X_447_ _641_/A2 _447_/A2 _613_/C _739_/D VDD VDD VSS VSS gf180mcu_fd_sc_mcu7t5v0__aoi21_1
X_516_ _636_/A2 _515_/Z _517_/A2 VDD VDD VSS VSS gf180mcu_fd_sc_mcu7t5v0__nand2_1
XFILLER_11_209 VDD VDD VSS VSS gf180mcu_fd_sc_mcu7t5v0__fill_1
Xclkload7 _770_/CLK clkload7/Z VDD VDD VSS VSS gf180mcu_fd_sc_mcu7t5v0__clkbuf_4
Xload_slew19 input1/Z _750_/RN VDD VDD VSS VSS gf180mcu_fd_sc_mcu7t5v0__buf_20
XFILLER_28_139 VDD VDD VSS VSS gf180mcu_fd_sc_mcu7t5v0__fill_2
XPHY_EDGE_ROW_7_Left_49 VDD VSS gf180mcu_fd_sc_mcu7t5v0__endcap
X_781_ _781_/I cfg_out[68] VDD VDD VSS VSS gf180mcu_fd_sc_mcu7t5v0__buf_1
XFILLER_18_4 VDD VDD VSS VSS gf180mcu_fd_sc_mcu7t5v0__fill_1
XFILLER_33_175 VDD VDD VSS VSS gf180mcu_fd_sc_mcu7t5v0__fill_1
Xg_reg\[18\].g_bit\[2\].g_l.g_a.u_l _754_/D _404_/ZN _750_/RN cfg_out[80] VDD VDD
+ VSS VSS gf180mcu_fd_sc_mcu7t5v0__latrnq_1
Xg_reg\[8\].g_bit\[1\].g_l.g_a.u_l _753_/D _420_/ZN input1/Z cfg_out[61] VDD VDD VSS
+ VSS gf180mcu_fd_sc_mcu7t5v0__latrnq_1
XFILLER_15_142 VDD VDD VSS VSS gf180mcu_fd_sc_mcu7t5v0__fillcap_4
XTAP_TAPCELL_ROW_17_159 VDD VSS gf180mcu_fd_sc_mcu7t5v0__filltie
X_764_ _764_/D wire14/Z _769_/CLK _764_/Q VDD VDD VSS VSS gf180mcu_fd_sc_mcu7t5v0__dffrnq_1
X_695_ _695_/D wire14/Z _766_/CLK _695_/Q VDD VDD VSS VSS gf180mcu_fd_sc_mcu7t5v0__dffrnq_1
XFILLER_21_134 VDD VDD VSS VSS gf180mcu_fd_sc_mcu7t5v0__fill_1
Xg_reg\[17\].g_bit\[3\].g_l.g_d.u_l _755_/D _405_/ZN _750_/RN _601_/A2 VDD VDD VSS
+ VSS gf180mcu_fd_sc_mcu7t5v0__latrnq_1
Xg_reg\[14\].g_bit\[0\].g_l.g_d.u_l _752_/D _412_/ZN input1/Z _562_/A1 VDD VDD VSS
+ VSS gf180mcu_fd_sc_mcu7t5v0__latrnq_1
XFILLER_16_75 VDD VDD VSS VSS gf180mcu_fd_sc_mcu7t5v0__fill_1
XFILLER_29_212 VDD VDD VSS VSS gf180mcu_fd_sc_mcu7t5v0__fill_1
X_480_ _728_/Q _729_/Q _479_/Z _480_/Z VDD VDD VSS VSS gf180mcu_fd_sc_mcu7t5v0__and3_1
Xg_reg\[22\].g_bit\[6\].g_l.g_a.u_l _758_/D _398_/ZN _750_/RN cfg_out[116] VDD VDD
+ VSS VSS gf180mcu_fd_sc_mcu7t5v0__latrnq_1
Xg_reg\[0\].g_bit\[2\].g_l.g_a.u_l _754_/D _428_/ZN load_slew18/Z cfg_out[2] VDD VDD
+ VSS VSS gf180mcu_fd_sc_mcu7t5v0__latrnq_1
XTAP_TAPCELL_ROW_13_140 VDD VSS gf180mcu_fd_sc_mcu7t5v0__filltie
XTAP_TAPCELL_ROW_5_108 VDD VSS gf180mcu_fd_sc_mcu7t5v0__filltie
X_678_ _728_/Q _479_/Z _729_/Q _679_/A3 VDD VDD VSS VSS gf180mcu_fd_sc_mcu7t5v0__aoi21_1
Xg_reg\[3\].g_bit\[5\].g_l.g_a.u_l _757_/D _425_/ZN load_slew18/Z cfg_out[29] VDD
+ VDD VSS VSS gf180mcu_fd_sc_mcu7t5v0__latrnq_1
X_747_ _747_/D wire15/I _767_/CLK _747_/Q VDD VDD VSS VSS gf180mcu_fd_sc_mcu7t5v0__dffrnq_1
XPHY_EDGE_ROW_36_Left_78 VDD VSS gf180mcu_fd_sc_mcu7t5v0__endcap
XTAP_TAPCELL_ROW_36_232 VDD VSS gf180mcu_fd_sc_mcu7t5v0__filltie
X_601_ _656_/A1 _601_/A2 _606_/A3 VDD VDD VSS VSS gf180mcu_fd_sc_mcu7t5v0__nor2_1
X_394_ _401_/A1 _761_/Q _424_/A1 VDD VDD VSS VSS gf180mcu_fd_sc_mcu7t5v0__nand2_1
X_463_ _725_/Q _346_/I _483_/A2 _467_/C _463_/B2 _464_/A2 VDD VDD VSS VSS gf180mcu_fd_sc_mcu7t5v0__oai32_1
X_532_ _684_/Q _685_/Q _686_/Q _539_/A1 VDD VDD VSS VSS gf180mcu_fd_sc_mcu7t5v0__aoi21_1
XFILLER_13_87 VDD VDD VSS VSS gf180mcu_fd_sc_mcu7t5v0__fill_1
XFILLER_9_255 VDD VDD VSS VSS gf180mcu_fd_sc_mcu7t5v0__fill_2
X_377_ _387_/A1 _377_/A2 probe_sel_onehot[7] VDD VDD VSS VSS gf180mcu_fd_sc_mcu7t5v0__nor2_1
X_446_ _740_/Q _521_/A2 _447_/A2 VDD VDD VSS VSS gf180mcu_fd_sc_mcu7t5v0__nand2_1
X_515_ _514_/B _515_/A2 _515_/A3 _515_/Z VDD VDD VSS VSS gf180mcu_fd_sc_mcu7t5v0__or3_1
Xclkload8 _763_/CLK clkload8/Z VDD VDD VSS VSS gf180mcu_fd_sc_mcu7t5v0__clkbuf_2
XFILLER_10_243 VDD VDD VSS VSS gf180mcu_fd_sc_mcu7t5v0__fill_2
XFILLER_6_247 VDD VDD VSS VSS gf180mcu_fd_sc_mcu7t5v0__fillcap_4
XPHY_EDGE_ROW_23_Left_65 VDD VSS gf180mcu_fd_sc_mcu7t5v0__endcap
XPHY_EDGE_ROW_39_Left_81 VDD VSS gf180mcu_fd_sc_mcu7t5v0__endcap
X_429_ _740_/Q _741_/Q _613_/B2 VDD VDD VSS VSS gf180mcu_fd_sc_mcu7t5v0__nor2_1
XFILLER_3_206 VDD VDD VSS VSS gf180mcu_fd_sc_mcu7t5v0__fillcap_4
Xinput1 rst_n input1/Z VDD VDD VSS VSS gf180mcu_fd_sc_mcu7t5v0__buf_4
X_763_ _763_/D _763_/CLK _763_/Q VDD VDD VSS VSS gf180mcu_fd_sc_mcu7t5v0__dffq_1
X_694_ _694_/D wire14/Z _766_/CLK _694_/Q VDD VDD VSS VSS gf180mcu_fd_sc_mcu7t5v0__dffrnq_1
XFILLER_16_2 VDD VDD VSS VSS gf180mcu_fd_sc_mcu7t5v0__fill_1
XFILLER_30_4 VDD VDD VSS VSS gf180mcu_fd_sc_mcu7t5v0__fill_1
XFILLER_16_98 VDD VDD VSS VSS gf180mcu_fd_sc_mcu7t5v0__fill_2
XPHY_EDGE_ROW_10_Left_52 VDD VSS gf180mcu_fd_sc_mcu7t5v0__endcap
XPHY_EDGE_ROW_9_Right_9 VDD VSS gf180mcu_fd_sc_mcu7t5v0__endcap
XTAP_TAPCELL_ROW_13_141 VDD VSS gf180mcu_fd_sc_mcu7t5v0__filltie
X_677_ _486_/B _677_/A2 _728_/D VDD VDD VSS VSS gf180mcu_fd_sc_mcu7t5v0__nor2_1
X_746_ _746_/D wire15/I _767_/CLK _746_/Q VDD VDD VSS VSS gf180mcu_fd_sc_mcu7t5v0__dffrnq_1
XTAP_TAPCELL_ROW_36_233 VDD VSS gf180mcu_fd_sc_mcu7t5v0__filltie
XTAP_TAPCELL_ROW_5_109 VDD VSS gf180mcu_fd_sc_mcu7t5v0__filltie
XFILLER_27_64 VDD VDD VSS VSS gf180mcu_fd_sc_mcu7t5v0__fill_1
X_393_ _760_/D _761_/D _403_/A1 VDD VDD VSS VSS gf180mcu_fd_sc_mcu7t5v0__nand2_1
X_462_ _666_/A1 _346_/I _483_/A2 _462_/B2 _463_/B2 VDD VDD VSS VSS gf180mcu_fd_sc_mcu7t5v0__oai22_1
X_531_ _531_/I _685_/D VDD VDD VSS VSS gf180mcu_fd_sc_mcu7t5v0__clkinv_1
X_600_ _684_/Q _603_/B _600_/B _606_/A2 VDD VDD VSS VSS gf180mcu_fd_sc_mcu7t5v0__aoi21_1
Xg_reg\[16\].g_bit\[1\].g_l.g_d.u_l _753_/D _406_/ZN input1/Z _566_/A1 VDD VDD VSS
+ VSS gf180mcu_fd_sc_mcu7t5v0__latrnq_1
X_729_ _729_/D _736_/CLK _729_/Q VDD VDD VSS VSS gf180mcu_fd_sc_mcu7t5v0__dffq_1
XFILLER_22_285 VDD VDD VSS VSS gf180mcu_fd_sc_mcu7t5v0__fill_1
X_514_ _515_/A2 _515_/A3 _514_/B _636_/A2 VDD VDD VSS VSS gf180mcu_fd_sc_mcu7t5v0__oai21_1
Xg_reg\[5\].g_bit\[6\].g_l.g_a.u_l _758_/D _423_/ZN load_slew18/Z cfg_out[46] VDD
+ VDD VSS VSS gf180mcu_fd_sc_mcu7t5v0__latrnq_1
Xg_reg\[2\].g_bit\[3\].g_l.g_a.u_l _755_/D _426_/ZN load_slew18/Z cfg_out[19] VDD
+ VDD VSS VSS gf180mcu_fd_sc_mcu7t5v0__latrnq_1
Xg_reg\[24\].g_bit\[7\].g_l.g_a.u_l _759_/D load_slew13/Z _750_/RN cfg_out[133] VDD
+ VDD VSS VSS gf180mcu_fd_sc_mcu7t5v0__latrnq_1
Xg_reg\[21\].g_bit\[4\].g_l.g_a.u_l _756_/D _399_/ZN _750_/RN cfg_out[106] VDD VDD
+ VSS VSS gf180mcu_fd_sc_mcu7t5v0__latrnq_1
X_376_ _369_/Z _377_/A2 probe_sel_onehot[6] VDD VDD VSS VSS gf180mcu_fd_sc_mcu7t5v0__nor2_1
X_445_ _740_/Q _521_/A2 _445_/Z VDD VDD VSS VSS gf180mcu_fd_sc_mcu7t5v0__and2_1
XFILLER_24_76 VDD VDD VSS VSS gf180mcu_fd_sc_mcu7t5v0__fill_1
Xg_reg\[11\].g_bit\[5\].g_l.g_d.u_l _757_/D _417_/ZN _750_/RN _361_/A2 VDD VDD VSS
+ VSS gf180mcu_fd_sc_mcu7t5v0__latrnq_1
XFILLER_1_25 VDD VDD VSS VSS gf180mcu_fd_sc_mcu7t5v0__fill_1
X_359_ _638_/C _613_/C _438_/A2 _738_/D VDD VDD VSS VSS gf180mcu_fd_sc_mcu7t5v0__nor3_1
X_428_ _428_/A1 _428_/A2 _428_/ZN VDD VDD VSS VSS gf180mcu_fd_sc_mcu7t5v0__nor2_1
XFILLER_36_174 VDD VDD VSS VSS gf180mcu_fd_sc_mcu7t5v0__fill_1
Xinput2 spk_in[0] _788_/I VDD VDD VSS VSS gf180mcu_fd_sc_mcu7t5v0__buf_1
XPHY_EDGE_ROW_40_Left_82 VDD VSS gf180mcu_fd_sc_mcu7t5v0__endcap
XFILLER_18_185 VDD VDD VSS VSS gf180mcu_fd_sc_mcu7t5v0__fill_2
XFILLER_21_88 VDD VDD VSS VSS gf180mcu_fd_sc_mcu7t5v0__fillcap_4
X_762_ _762_/D _763_/CLK _762_/Q VDD VDD VSS VSS gf180mcu_fd_sc_mcu7t5v0__dffq_1
X_693_ _693_/D wire14/Z _766_/CLK _693_/Q VDD VDD VSS VSS gf180mcu_fd_sc_mcu7t5v0__dffrnq_1
XFILLER_38_269 VDD VDD VSS VSS gf180mcu_fd_sc_mcu7t5v0__fill_1
XFILLER_8_107 VDD VDD VSS VSS gf180mcu_fd_sc_mcu7t5v0__fillcap_4
XFILLER_32_43 VDD VDD VSS VSS gf180mcu_fd_sc_mcu7t5v0__fill_1
XTAP_TAPCELL_ROW_13_142 VDD VSS gf180mcu_fd_sc_mcu7t5v0__filltie
X_676_ _728_/Q _479_/Z _677_/A2 VDD VDD VSS VSS gf180mcu_fd_sc_mcu7t5v0__xnor2_1
X_745_ _745_/D wire17/Z _476_/ZN _745_/Q VDD VDD VSS VSS gf180mcu_fd_sc_mcu7t5v0__dffrnq_1
XTAP_TAPCELL_ROW_36_234 VDD VSS gf180mcu_fd_sc_mcu7t5v0__filltie
XFILLER_4_187 VDD VDD VSS VSS gf180mcu_fd_sc_mcu7t5v0__fillcap_4
X_392_ _760_/D _761_/D _402_/A1 _420_/A1 _392_/ZN VDD VDD VSS VSS gf180mcu_fd_sc_mcu7t5v0__nor4_1
X_461_ _724_/Q _346_/I _483_/A2 _464_/A1 VDD VDD VSS VSS gf180mcu_fd_sc_mcu7t5v0__nand3_1
X_530_ _685_/Q _521_/B _522_/I _530_/B2 _531_/I VDD VDD VSS VSS gf180mcu_fd_sc_mcu7t5v0__aoi22_1
X_659_ _662_/B2 _661_/A2 _662_/A2 VDD VDD VSS VSS gf180mcu_fd_sc_mcu7t5v0__nor2_1
X_728_ _728_/D _736_/CLK _728_/Q VDD VDD VSS VSS gf180mcu_fd_sc_mcu7t5v0__dffq_1
XFILLER_13_67 VDD VDD VSS VSS gf180mcu_fd_sc_mcu7t5v0__fill_2
Xg_reg\[19\].g_bit\[1\].g_l.g_a.u_l _753_/D _403_/ZN _750_/RN cfg_out[87] VDD VDD
+ VSS VSS gf180mcu_fd_sc_mcu7t5v0__latrnq_1
XFILLER_9_257 VDD VDD VSS VSS gf180mcu_fd_sc_mcu7t5v0__fill_1
X_375_ _385_/A1 _377_/A2 probe_sel_onehot[5] VDD VDD VSS VSS gf180mcu_fd_sc_mcu7t5v0__nor2_1
X_444_ _613_/C _533_/A2 _648_/S _740_/D VDD VDD VSS VSS gf180mcu_fd_sc_mcu7t5v0__oai21_1
X_513_ _513_/A1 _513_/A2 _606_/B _515_/A3 VDD VDD VSS VSS gf180mcu_fd_sc_mcu7t5v0__aoi21_1
Xg_reg\[9\].g_bit\[0\].g_l.g_a.u_l _752_/D _419_/ZN input1/Z cfg_out[69] VDD VDD VSS
+ VSS gf180mcu_fd_sc_mcu7t5v0__latrnq_1
XFILLER_24_99 VDD VDD VSS VSS gf180mcu_fd_sc_mcu7t5v0__fill_1
XFILLER_6_2 VDD VDD VSS VSS gf180mcu_fd_sc_mcu7t5v0__fill_2
X_358_ _684_/Q _602_/B _355_/Z _438_/A2 VDD VDD VSS VSS gf180mcu_fd_sc_mcu7t5v0__nand3_1
X_427_ _428_/A1 _427_/A2 _427_/ZN VDD VDD VSS VSS gf180mcu_fd_sc_mcu7t5v0__nor2_1
XFILLER_39_2 VDD VDD VSS VSS gf180mcu_fd_sc_mcu7t5v0__fill_2
XPHY_EDGE_ROW_18_Right_18 VDD VSS gf180mcu_fd_sc_mcu7t5v0__endcap
XPHY_EDGE_ROW_27_Right_27 VDD VSS gf180mcu_fd_sc_mcu7t5v0__endcap
Xinput3 spk_in[14] input3/Z VDD VDD VSS VSS gf180mcu_fd_sc_mcu7t5v0__buf_1
Xg_reg\[23\].g_bit\[5\].g_l.g_a.u_l _757_/D _396_/ZN _750_/RN cfg_out[123] VDD VDD
+ VSS VSS gf180mcu_fd_sc_mcu7t5v0__latrnq_1
Xg_reg\[20\].g_bit\[2\].g_l.g_a.u_l _754_/D _400_/ZN _750_/RN cfg_out[96] VDD VDD
+ VSS VSS gf180mcu_fd_sc_mcu7t5v0__latrnq_1
XPHY_EDGE_ROW_36_Right_36 VDD VSS gf180mcu_fd_sc_mcu7t5v0__endcap
Xg_reg\[4\].g_bit\[4\].g_l.g_a.u_l _756_/D _424_/ZN load_slew18/Z cfg_out[36] VDD
+ VDD VSS VSS gf180mcu_fd_sc_mcu7t5v0__latrnq_1
Xg_reg\[1\].g_bit\[1\].g_l.g_a.u_l _753_/D _427_/ZN load_slew18/Z cfg_out[9] VDD VDD
+ VSS VSS gf180mcu_fd_sc_mcu7t5v0__latrnq_1
Xg_reg\[13\].g_bit\[6\].g_l.g_d.u_l _758_/D _414_/ZN input1/Z _629_/A2 VDD VDD VSS
+ VSS gf180mcu_fd_sc_mcu7t5v0__latrnq_1
Xg_reg\[10\].g_bit\[3\].g_l.g_d.u_l _755_/D _418_/ZN _750_/RN _324_/I VDD VDD VSS
+ VSS gf180mcu_fd_sc_mcu7t5v0__latrnq_1
X_761_ _761_/D _763_/CLK _761_/Q VDD VDD VSS VSS gf180mcu_fd_sc_mcu7t5v0__dffq_1
X_692_ _692_/D wire14/Z _748_/CLK _692_/Q VDD VDD VSS VSS gf180mcu_fd_sc_mcu7t5v0__dffrnq_1
XFILLER_21_115 VDD VDD VSS VSS gf180mcu_fd_sc_mcu7t5v0__fill_1
XFILLER_8_119 VDD VDD VSS VSS gf180mcu_fd_sc_mcu7t5v0__fillcap_4
XPHY_EDGE_ROW_0_Right_0 VDD VSS gf180mcu_fd_sc_mcu7t5v0__endcap
XTAP_TAPCELL_ROW_22_176 VDD VSS gf180mcu_fd_sc_mcu7t5v0__filltie
X_675_ _479_/Z _486_/B _675_/A3 _727_/D VDD VDD VSS VSS gf180mcu_fd_sc_mcu7t5v0__nor3_1
X_744_ _744_/D wire17/Z _767_/CLK _744_/Q VDD VDD VSS VSS gf180mcu_fd_sc_mcu7t5v0__dffrnq_1
XFILLER_21_2 VDD VDD VSS VSS gf180mcu_fd_sc_mcu7t5v0__fill_2
XTAP_TAPCELL_ROW_13_143 VDD VSS gf180mcu_fd_sc_mcu7t5v0__filltie
XTAP_TAPCELL_ROW_36_235 VDD VSS gf180mcu_fd_sc_mcu7t5v0__filltie
X_391_ _405_/A1 _402_/A1 _420_/A1 _391_/ZN VDD VDD VSS VSS gf180mcu_fd_sc_mcu7t5v0__nor3_1
X_460_ _737_/Q _613_/C _458_/Z _552_/A3 _768_/D VDD VDD VSS VSS gf180mcu_fd_sc_mcu7t5v0__nor4_1
XFILLER_31_298 VDD VDD VSS VSS gf180mcu_fd_sc_mcu7t5v0__fill_1
XFILLER_4_177 VDD VDD VSS VSS gf180mcu_fd_sc_mcu7t5v0__fillcap_4
XFILLER_4_37 VDD VDD VSS VSS gf180mcu_fd_sc_mcu7t5v0__fillcap_4
X_589_ _589_/A1 _633_/C _589_/B1 _589_/B2 _590_/I1 VDD VDD VSS VSS gf180mcu_fd_sc_mcu7t5v0__oai22_1
X_658_ _604_/C _658_/A2 _658_/B _661_/A2 VDD VDD VSS VSS gf180mcu_fd_sc_mcu7t5v0__aoi21_1
X_727_ _727_/D _736_/CLK _727_/Q VDD VDD VSS VSS gf180mcu_fd_sc_mcu7t5v0__dffq_1
XFILLER_13_298 VDD VDD VSS VSS gf180mcu_fd_sc_mcu7t5v0__fill_1
XTAP_TAPCELL_ROW_30_208 VDD VSS gf180mcu_fd_sc_mcu7t5v0__filltie
X_374_ _365_/Z _377_/A2 probe_sel_onehot[4] VDD VDD VSS VSS gf180mcu_fd_sc_mcu7t5v0__nor2_1
X_443_ _633_/C _547_/A1 _456_/A2 _648_/S VDD VDD VSS VSS gf180mcu_fd_sc_mcu7t5v0__nand3_1
X_512_ _656_/A1 _578_/A1 _656_/B1 _572_/A1 _656_/C _513_/A2 VDD VDD VSS VSS gf180mcu_fd_sc_mcu7t5v0__oai221_1
XFILLER_24_45 VDD VDD VSS VSS gf180mcu_fd_sc_mcu7t5v0__fillcap_4
XFILLER_40_66 VDD VDD VSS VSS gf180mcu_fd_sc_mcu7t5v0__fill_2
XFILLER_5_294 VDD VDD VSS VSS gf180mcu_fd_sc_mcu7t5v0__fillcap_4
XTAP_TAPCELL_ROW_1_92 VDD VSS gf180mcu_fd_sc_mcu7t5v0__filltie
X_357_ _656_/A1 _685_/Q _603_/B _521_/A2 VDD VDD VSS VSS gf180mcu_fd_sc_mcu7t5v0__nor3_1
X_426_ _428_/A1 _426_/A2 _426_/ZN VDD VDD VSS VSS gf180mcu_fd_sc_mcu7t5v0__nor2_1
Xinput4 spk_in[15] input4/Z VDD VDD VSS VSS gf180mcu_fd_sc_mcu7t5v0__buf_1
XFILLER_27_121 VDD VDD VSS VSS gf180mcu_fd_sc_mcu7t5v0__fill_2
XFILLER_18_187 VDD VDD VSS VSS gf180mcu_fd_sc_mcu7t5v0__fill_1
XPHY_EDGE_ROW_27_Left_69 VDD VSS gf180mcu_fd_sc_mcu7t5v0__endcap
X_409_ _760_/D _761_/D _415_/A3 _425_/A2 VDD VDD VSS VSS gf180mcu_fd_sc_mcu7t5v0__nand3_1
Xg_reg\[17\].g_bit\[0\].g_l.g_d.u_l _752_/D _405_/ZN _750_/RN _332_/I VDD VDD VSS
+ VSS gf180mcu_fd_sc_mcu7t5v0__latrnq_1
X_760_ _760_/D _763_/CLK _761_/D VDD VDD VSS VSS gf180mcu_fd_sc_mcu7t5v0__dffq_1
X_691_ _691_/D wire15/Z _703_/CLK _691_/Q VDD VDD VSS VSS gf180mcu_fd_sc_mcu7t5v0__dffrnq_1
XTAP_TAPCELL_ROW_16_152 VDD VSS gf180mcu_fd_sc_mcu7t5v0__filltie
Xg_reg\[6\].g_bit\[5\].g_l.g_a.u_l _757_/D _422_/ZN load_slew18/Z cfg_out[53] VDD
+ VDD VSS VSS gf180mcu_fd_sc_mcu7t5v0__latrnq_1
Xg_reg\[3\].g_bit\[2\].g_l.g_a.u_l _754_/D _425_/ZN load_slew18/Z cfg_out[26] VDD
+ VDD VSS VSS gf180mcu_fd_sc_mcu7t5v0__latrnq_1
Xg_reg\[25\].g_bit\[6\].g_l.g_a.u_l _758_/D _391_/ZN _750_/RN cfg_out[140] VDD VDD
+ VSS VSS gf180mcu_fd_sc_mcu7t5v0__latrnq_1
Xg_reg\[22\].g_bit\[3\].g_l.g_a.u_l _755_/D _398_/ZN _750_/RN cfg_out[113] VDD VDD
+ VSS VSS gf180mcu_fd_sc_mcu7t5v0__latrnq_1
XFILLER_32_34 VDD VDD VSS VSS gf180mcu_fd_sc_mcu7t5v0__fill_1
XTAP_TAPCELL_ROW_22_177 VDD VSS gf180mcu_fd_sc_mcu7t5v0__filltie
XTAP_TAPCELL_ROW_39_244 VDD VSS gf180mcu_fd_sc_mcu7t5v0__filltie
X_674_ _726_/Q _478_/Z _727_/Q _675_/A3 VDD VDD VSS VSS gf180mcu_fd_sc_mcu7t5v0__aoi21_1
X_743_ _743_/D wire17/Z _750_/CLK _743_/Q VDD VDD VSS VSS gf180mcu_fd_sc_mcu7t5v0__dffrnq_1
XFILLER_14_2 VDD VDD VSS VSS gf180mcu_fd_sc_mcu7t5v0__fill_2
XFILLER_7_142 VDD VDD VSS VSS gf180mcu_fd_sc_mcu7t5v0__fillcap_8
XPHY_EDGE_ROW_14_Left_56 VDD VSS gf180mcu_fd_sc_mcu7t5v0__endcap
X_390_ _762_/Q _401_/A2 _420_/A1 VDD VDD VSS VSS gf180mcu_fd_sc_mcu7t5v0__nand2_1
Xg_reg\[15\].g_bit\[7\].g_l.g_d.u_l _759_/D _410_/ZN input1/Z _656_/A2 VDD VDD VSS
+ VSS gf180mcu_fd_sc_mcu7t5v0__latrnq_1
Xg_reg\[12\].g_bit\[4\].g_l.g_d.u_l _756_/D _416_/ZN input1/Z _764_/D VDD VDD VSS
+ VSS gf180mcu_fd_sc_mcu7t5v0__latrnq_1
X_588_ _588_/A1 _430_/Z _633_/C _589_/B2 VDD VDD VSS VSS gf180mcu_fd_sc_mcu7t5v0__oai21_1
X_657_ _657_/A1 _657_/A2 _657_/B _658_/B VDD VDD VSS VSS gf180mcu_fd_sc_mcu7t5v0__aoi21_1
X_726_ _726_/D _736_/CLK _726_/Q VDD VDD VSS VSS gf180mcu_fd_sc_mcu7t5v0__dffq_1
XFILLER_13_69 VDD VDD VSS VSS gf180mcu_fd_sc_mcu7t5v0__fill_1
XTAP_TAPCELL_ROW_30_209 VDD VSS gf180mcu_fd_sc_mcu7t5v0__filltie
X_373_ _378_/A1 _383_/A2 _377_/A2 VDD VDD VSS VSS gf180mcu_fd_sc_mcu7t5v0__nand2_1
X_442_ _552_/A1 _441_/Z _456_/A2 VDD VDD VSS VSS gf180mcu_fd_sc_mcu7t5v0__nor2_1
X_511_ _562_/A1 _656_/B1 _655_/B _511_/C _513_/A1 VDD VDD VSS VSS gf180mcu_fd_sc_mcu7t5v0__oai211_1
X_709_ _709_/D _718_/CLK _709_/Q VDD VDD VSS VSS gf180mcu_fd_sc_mcu7t5v0__dffq_1
XFILLER_10_247 VDD VDD VSS VSS gf180mcu_fd_sc_mcu7t5v0__fill_1
XFILLER_6_4 VDD VDD VSS VSS gf180mcu_fd_sc_mcu7t5v0__fill_1
XFILLER_39_4 VDD VDD VSS VSS gf180mcu_fd_sc_mcu7t5v0__fill_1
XTAP_TAPCELL_ROW_1_93 VDD VSS gf180mcu_fd_sc_mcu7t5v0__filltie
X_356_ _687_/Q _686_/Q _603_/B VDD VDD VSS VSS gf180mcu_fd_sc_mcu7t5v0__nand2_1
X_425_ _428_/A1 _425_/A2 _425_/ZN VDD VDD VSS VSS gf180mcu_fd_sc_mcu7t5v0__nor2_1
Xinput5 ui_in[1] _751_/D VDD VDD VSS VSS gf180mcu_fd_sc_mcu7t5v0__buf_1
XFILLER_19_68 VDD VDD VSS VSS gf180mcu_fd_sc_mcu7t5v0__fill_2
XFILLER_18_133 VDD VDD VSS VSS gf180mcu_fd_sc_mcu7t5v0__fill_1
XFILLER_2_243 VDD VDD VSS VSS gf180mcu_fd_sc_mcu7t5v0__fill_2
XPHY_EDGE_ROW_2_Left_44 VDD VSS gf180mcu_fd_sc_mcu7t5v0__endcap
X_408_ _763_/Q _408_/A2 _415_/A3 VDD VDD VSS VSS gf180mcu_fd_sc_mcu7t5v0__nor2_1
X_339_ _722_/Q _666_/A1 VDD VDD VSS VSS gf180mcu_fd_sc_mcu7t5v0__clkinv_1
XFILLER_7_27 VDD VDD VSS VSS gf180mcu_fd_sc_mcu7t5v0__fill_1
X_690_ _690_/D wire15/Z _703_/CLK _690_/Q VDD VDD VSS VSS gf180mcu_fd_sc_mcu7t5v0__dffrnq_1
XTAP_TAPCELL_ROW_16_153 VDD VSS gf180mcu_fd_sc_mcu7t5v0__filltie
XFILLER_16_25 VDD VDD VSS VSS gf180mcu_fd_sc_mcu7t5v0__fillcap_4
XTAP_TAPCELL_ROW_22_178 VDD VSS gf180mcu_fd_sc_mcu7t5v0__filltie
XTAP_TAPCELL_ROW_39_245 VDD VSS gf180mcu_fd_sc_mcu7t5v0__filltie
XFILLER_11_172 VDD VDD VSS VSS gf180mcu_fd_sc_mcu7t5v0__fill_1
XFILLER_35_209 VDD VDD VSS VSS gf180mcu_fd_sc_mcu7t5v0__fill_1
X_673_ _486_/B _672_/Z _726_/D VDD VDD VSS VSS gf180mcu_fd_sc_mcu7t5v0__nor2_1
X_742_ _745_/Q wire17/Z _767_/CLK _742_/Q VDD VDD VSS VSS gf180mcu_fd_sc_mcu7t5v0__dffrnq_1
XPHY_EDGE_ROW_31_Left_73 VDD VSS gf180mcu_fd_sc_mcu7t5v0__endcap
X_587_ _698_/Q _613_/B2 _589_/B1 VDD VDD VSS VSS gf180mcu_fd_sc_mcu7t5v0__nor2_1
X_656_ _656_/A1 _656_/A2 _656_/B1 _656_/B2 _656_/C _657_/A2 VDD VDD VSS VSS gf180mcu_fd_sc_mcu7t5v0__oai221_1
Xg_reg\[21\].g_bit\[1\].g_l.g_a.u_l _753_/D _399_/ZN _750_/RN cfg_out[103] VDD VDD
+ VSS VSS gf180mcu_fd_sc_mcu7t5v0__latrnq_1
Xg_reg\[18\].g_bit\[7\].g_l.g_a.u_l _759_/D _404_/ZN _750_/RN cfg_out[85] VDD VDD
+ VSS VSS gf180mcu_fd_sc_mcu7t5v0__latrnq_1
X_725_ _725_/D _736_/CLK _725_/Q VDD VDD VSS VSS gf180mcu_fd_sc_mcu7t5v0__dffq_1
XFILLER_22_201 VDD VDD VSS VSS gf180mcu_fd_sc_mcu7t5v0__fill_1
Xg_reg\[5\].g_bit\[3\].g_l.g_a.u_l _755_/D _423_/ZN load_slew18/Z cfg_out[43] VDD
+ VDD VSS VSS gf180mcu_fd_sc_mcu7t5v0__latrnq_1
Xg_reg\[2\].g_bit\[0\].g_l.g_a.u_l _752_/D _426_/ZN load_slew18/Z cfg_out[16] VDD
+ VDD VSS VSS gf180mcu_fd_sc_mcu7t5v0__latrnq_1
Xg_reg\[24\].g_bit\[4\].g_l.g_a.u_l _756_/D load_slew12/Z _750_/RN cfg_out[130] VDD
+ VDD VSS VSS gf180mcu_fd_sc_mcu7t5v0__latrnq_1
XFILLER_13_234 VDD VDD VSS VSS gf180mcu_fd_sc_mcu7t5v0__fill_2
X_372_ _364_/Z _387_/A1 probe_sel_onehot[3] VDD VDD VSS VSS gf180mcu_fd_sc_mcu7t5v0__nor2_1
X_441_ _449_/A1 _748_/Q _441_/Z VDD VDD VSS VSS gf180mcu_fd_sc_mcu7t5v0__or2_1
X_510_ _684_/Q _567_/A1 _603_/B _511_/C VDD VDD VSS VSS gf180mcu_fd_sc_mcu7t5v0__nand3_1
X_639_ _639_/A1 _640_/A2 _639_/A3 _640_/B2 VDD VDD VSS VSS gf180mcu_fd_sc_mcu7t5v0__nor3_1
Xg_reg\[14\].g_bit\[5\].g_l.g_d.u_l _757_/D _412_/ZN input1/Z _338_/I VDD VDD VSS
+ VSS gf180mcu_fd_sc_mcu7t5v0__latrnq_1
Xg_reg\[11\].g_bit\[2\].g_l.g_d.u_l _754_/D _417_/ZN _750_/RN _453_/S VDD VDD VSS
+ VSS gf180mcu_fd_sc_mcu7t5v0__latrnq_1
X_708_ _708_/D wire15/Z _768_/CLK _708_/Q VDD VDD VSS VSS gf180mcu_fd_sc_mcu7t5v0__dffrnq_1
XFILLER_39_142 VDD VDD VSS VSS gf180mcu_fd_sc_mcu7t5v0__fill_2
XFILLER_40_68 VDD VDD VSS VSS gf180mcu_fd_sc_mcu7t5v0__fill_1
XTAP_TAPCELL_ROW_1_94 VDD VSS gf180mcu_fd_sc_mcu7t5v0__filltie
X_355_ _687_/Q _686_/Q _355_/Z VDD VDD VSS VSS gf180mcu_fd_sc_mcu7t5v0__and2_1
X_424_ _424_/A1 _428_/A2 _424_/ZN VDD VDD VSS VSS gf180mcu_fd_sc_mcu7t5v0__nor2_1
Xg_reg\[0\].g_bit\[7\].g_l.g_a.u_l _759_/D _428_/ZN load_slew18/Z cfg_out[7] VDD VDD
+ VSS VSS gf180mcu_fd_sc_mcu7t5v0__latrnq_1
Xinput6 ui_in[2] _329_/I VDD VDD VSS VSS gf180mcu_fd_sc_mcu7t5v0__buf_1
XFILLER_4_2 VDD VDD VSS VSS gf180mcu_fd_sc_mcu7t5v0__fill_1
XPHY_EDGE_ROW_14_Right_14 VDD VSS gf180mcu_fd_sc_mcu7t5v0__endcap
XPHY_EDGE_ROW_23_Right_23 VDD VSS gf180mcu_fd_sc_mcu7t5v0__endcap
XFILLER_37_2 VDD VDD VSS VSS gf180mcu_fd_sc_mcu7t5v0__fill_2
XPHY_EDGE_ROW_32_Right_32 VDD VSS gf180mcu_fd_sc_mcu7t5v0__endcap
XPHY_EDGE_ROW_41_Right_41 VDD VSS gf180mcu_fd_sc_mcu7t5v0__endcap
X_338_ _338_/I _589_/A1 VDD VDD VSS VSS gf180mcu_fd_sc_mcu7t5v0__clkinv_1
X_407_ _762_/Q _761_/Q _416_/A1 VDD VDD VSS VSS gf180mcu_fd_sc_mcu7t5v0__nand2_1
XFILLER_23_8 VDD VDD VSS VSS gf180mcu_fd_sc_mcu7t5v0__fillcap_4
XTAP_TAPCELL_ROW_16_154 VDD VSS gf180mcu_fd_sc_mcu7t5v0__filltie
XFILLER_12_107 VDD VDD VSS VSS gf180mcu_fd_sc_mcu7t5v0__fill_1
XFILLER_20_162 VDD VDD VSS VSS gf180mcu_fd_sc_mcu7t5v0__fill_2
XTAP_TAPCELL_ROW_22_179 VDD VSS gf180mcu_fd_sc_mcu7t5v0__filltie
XTAP_TAPCELL_ROW_39_246 VDD VSS gf180mcu_fd_sc_mcu7t5v0__filltie
X_672_ _672_/A1 _478_/Z _672_/Z VDD VDD VSS VSS gf180mcu_fd_sc_mcu7t5v0__xor2_1
X_741_ _741_/D wire17/Z _768_/CLK _741_/Q VDD VDD VSS VSS gf180mcu_fd_sc_mcu7t5v0__dffrnq_1
XPHY_EDGE_ROW_4_Right_4 VDD VSS gf180mcu_fd_sc_mcu7t5v0__endcap
XFILLER_25_298 VDD VDD VSS VSS gf180mcu_fd_sc_mcu7t5v0__fill_1
X_724_ _724_/D _736_/CLK _724_/Q VDD VDD VSS VSS gf180mcu_fd_sc_mcu7t5v0__dffq_1
XTAP_TAPCELL_ROW_41_252 VDD VSS gf180mcu_fd_sc_mcu7t5v0__filltie
X_586_ _615_/B _586_/A2 _586_/B _696_/D VDD VDD VSS VSS gf180mcu_fd_sc_mcu7t5v0__aoi21_1
X_655_ _655_/A1 _655_/A2 _655_/B _655_/C _657_/A1 VDD VDD VSS VSS gf180mcu_fd_sc_mcu7t5v0__oai211_1
XFILLER_13_27 VDD VDD VSS VSS gf180mcu_fd_sc_mcu7t5v0__fill_2
X_371_ _781_/I _371_/A2 _326_/I _387_/A1 VDD VDD VSS VSS gf180mcu_fd_sc_mcu7t5v0__nand3_1
X_440_ _701_/Q _700_/Q _702_/Q _703_/Q _547_/A1 VDD VDD VSS VSS gf180mcu_fd_sc_mcu7t5v0__nor4_1
XFILLER_0_194 VDD VDD VSS VSS gf180mcu_fd_sc_mcu7t5v0__fillcap_8
X_569_ _695_/Q _613_/B2 _571_/A1 VDD VDD VSS VSS gf180mcu_fd_sc_mcu7t5v0__nor2_1
X_638_ _640_/A1 _638_/A2 _638_/B _638_/C _639_/A3 VDD VDD VSS VSS gf180mcu_fd_sc_mcu7t5v0__aoi211_1
X_707_ _707_/D wire15/Z _768_/CLK _707_/Q VDD VDD VSS VSS gf180mcu_fd_sc_mcu7t5v0__dffrnq_1
XFILLER_24_37 VDD VDD VSS VSS gf180mcu_fd_sc_mcu7t5v0__fillcap_8
XFILLER_39_187 VDD VDD VSS VSS gf180mcu_fd_sc_mcu7t5v0__fill_1
XFILLER_5_72 VDD VDD VSS VSS gf180mcu_fd_sc_mcu7t5v0__fill_2
X_354_ _766_/Q _765_/Q _613_/C VDD VDD VSS VSS gf180mcu_fd_sc_mcu7t5v0__nand2_1
X_423_ _424_/A1 _427_/A2 _423_/ZN VDD VDD VSS VSS gf180mcu_fd_sc_mcu7t5v0__nor2_1
Xg_reg\[4\].g_bit\[1\].g_l.g_a.u_l _753_/D _424_/ZN load_slew18/Z cfg_out[33] VDD
+ VDD VSS VSS gf180mcu_fd_sc_mcu7t5v0__latrnq_1
Xg_reg\[7\].g_bit\[4\].g_l.g_a.u_l _756_/D _421_/ZN input1/Z cfg_out[58] VDD VDD VSS
+ VSS gf180mcu_fd_sc_mcu7t5v0__latrnq_1
Xg_reg\[23\].g_bit\[2\].g_l.g_a.u_l _754_/D _396_/ZN _750_/RN cfg_out[120] VDD VDD
+ VSS VSS gf180mcu_fd_sc_mcu7t5v0__latrnq_1
XTAP_TAPCELL_ROW_1_95 VDD VSS gf180mcu_fd_sc_mcu7t5v0__filltie
Xinput7 ui_in[3] _323_/I VDD VDD VSS VSS gf180mcu_fd_sc_mcu7t5v0__buf_1
XFILLER_18_102 VDD VDD VSS VSS gf180mcu_fd_sc_mcu7t5v0__fill_2
X_337_ _337_/I _567_/A1 VDD VDD VSS VSS gf180mcu_fd_sc_mcu7t5v0__clkinv_1
X_406_ _760_/D _761_/D _402_/Z _406_/ZN VDD VDD VSS VSS gf180mcu_fd_sc_mcu7t5v0__nor3_1
Xg_reg\[16\].g_bit\[6\].g_l.g_d.u_l _758_/D _406_/ZN input1/Z _591_/A1 VDD VDD VSS
+ VSS gf180mcu_fd_sc_mcu7t5v0__latrnq_1
Xg_reg\[13\].g_bit\[3\].g_l.g_d.u_l _755_/D _414_/ZN _750_/RN _543_/A1 VDD VDD VSS
+ VSS gf180mcu_fd_sc_mcu7t5v0__latrnq_1
Xg_reg\[10\].g_bit\[0\].g_l.g_d.u_l _752_/D _418_/ZN input1/Z _371_/A2 VDD VDD VSS
+ VSS gf180mcu_fd_sc_mcu7t5v0__latrnq_1
XTAP_TAPCELL_ROW_16_155 VDD VSS gf180mcu_fd_sc_mcu7t5v0__filltie
XTAP_TAPCELL_ROW_25_188 VDD VSS gf180mcu_fd_sc_mcu7t5v0__filltie
XTAP_TAPCELL_ROW_39_247 VDD VSS gf180mcu_fd_sc_mcu7t5v0__filltie
Xinput10 ui_in[6] _363_/A1 VDD VDD VSS VSS gf180mcu_fd_sc_mcu7t5v0__buf_1
XFILLER_7_134 VDD VDD VSS VSS gf180mcu_fd_sc_mcu7t5v0__fillcap_4
X_671_ _478_/Z _486_/B _671_/A3 _725_/D VDD VDD VSS VSS gf180mcu_fd_sc_mcu7t5v0__nor3_1
X_740_ _740_/D wire15/Z _767_/CLK _740_/Q VDD VDD VSS VSS gf180mcu_fd_sc_mcu7t5v0__dffrnq_1
XFILLER_8_61 VDD VDD VSS VSS gf180mcu_fd_sc_mcu7t5v0__fill_1
XTAP_TAPCELL_ROW_10_128 VDD VSS gf180mcu_fd_sc_mcu7t5v0__filltie
XTAP_TAPCELL_ROW_4_104 VDD VSS gf180mcu_fd_sc_mcu7t5v0__filltie
XTAP_TAPCELL_ROW_41_253 VDD VSS gf180mcu_fd_sc_mcu7t5v0__filltie
X_585_ _696_/Q _615_/B _586_/B VDD VDD VSS VSS gf180mcu_fd_sc_mcu7t5v0__nor2_1
X_654_ _654_/A1 _656_/B1 _655_/C VDD VDD VSS VSS gf180mcu_fd_sc_mcu7t5v0__or2_1
X_723_ _723_/D _766_/CLK _723_/Q VDD VDD VSS VSS gf180mcu_fd_sc_mcu7t5v0__dffq_1
XFILLER_12_2 VDD VDD VSS VSS gf180mcu_fd_sc_mcu7t5v0__fillcap_4
X_370_ _364_/Z _369_/Z probe_sel_onehot[2] VDD VDD VSS VSS gf180mcu_fd_sc_mcu7t5v0__nor2_1
X_637_ _740_/Q _515_/Z _637_/A3 _640_/B1 VDD VDD VSS VSS gf180mcu_fd_sc_mcu7t5v0__nand3_1
X_706_ _706_/D _750_/Q _750_/CLK _706_/Q VDD VDD VSS VSS gf180mcu_fd_sc_mcu7t5v0__dffrnq_1
XFILLER_24_27 VDD VDD VSS VSS gf180mcu_fd_sc_mcu7t5v0__fillcap_8
XFILLER_24_49 VDD VDD VSS VSS gf180mcu_fd_sc_mcu7t5v0__fill_1
XFILLER_39_144 VDD VDD VSS VSS gf180mcu_fd_sc_mcu7t5v0__fill_1
X_499_ _656_/A1 _355_/Z _656_/B1 VDD VDD VSS VSS gf180mcu_fd_sc_mcu7t5v0__nor2_1
X_568_ _693_/Q _568_/I1 _615_/B _693_/D VDD VDD VSS VSS gf180mcu_fd_sc_mcu7t5v0__mux2_2
X_353_ _766_/Q _765_/Q _633_/C VDD VDD VSS VSS gf180mcu_fd_sc_mcu7t5v0__and2_1
X_422_ _424_/A1 _426_/A2 _422_/ZN VDD VDD VSS VSS gf180mcu_fd_sc_mcu7t5v0__nor2_1
XFILLER_5_298 VDD VDD VSS VSS gf180mcu_fd_sc_mcu7t5v0__fill_1
Xinput8 ui_in[4] input8/Z VDD VDD VSS VSS gf180mcu_fd_sc_mcu7t5v0__buf_1
XFILLER_19_16 VDD VDD VSS VSS gf180mcu_fd_sc_mcu7t5v0__fill_2
X_336_ _336_/I _647_/A2 VDD VDD VSS VSS gf180mcu_fd_sc_mcu7t5v0__clkinv_1
X_405_ _405_/A1 _402_/Z _405_/ZN VDD VDD VSS VSS gf180mcu_fd_sc_mcu7t5v0__nor2_1
XFILLER_24_117 VDD VDD VSS VSS gf180mcu_fd_sc_mcu7t5v0__fill_2
XTAP_TAPCELL_ROW_19_164 VDD VSS gf180mcu_fd_sc_mcu7t5v0__filltie
Xg_reg\[19\].g_bit\[6\].g_l.g_a.u_l _758_/D _403_/ZN _750_/RN cfg_out[92] VDD VDD
+ VSS VSS gf180mcu_fd_sc_mcu7t5v0__latrnq_1
XPHY_EDGE_ROW_6_Left_48 VDD VSS gf180mcu_fd_sc_mcu7t5v0__endcap
XTAP_TAPCELL_ROW_25_189 VDD VSS gf180mcu_fd_sc_mcu7t5v0__filltie
Xg_reg\[6\].g_bit\[2\].g_l.g_a.u_l _754_/D _422_/ZN load_slew18/Z cfg_out[50] VDD
+ VDD VSS VSS gf180mcu_fd_sc_mcu7t5v0__latrnq_1
Xg_reg\[9\].g_bit\[5\].g_l.g_a.u_l _757_/D _419_/ZN input1/Z cfg_out[74] VDD VDD VSS
+ VSS gf180mcu_fd_sc_mcu7t5v0__latrnq_1
Xg_reg\[25\].g_bit\[3\].g_l.g_a.u_l _755_/D _391_/ZN _750_/RN cfg_out[137] VDD VDD
+ VSS VSS gf180mcu_fd_sc_mcu7t5v0__latrnq_1
Xg_reg\[22\].g_bit\[0\].g_l.g_a.u_l _752_/D _398_/ZN _750_/RN cfg_out[110] VDD VDD
+ VSS VSS gf180mcu_fd_sc_mcu7t5v0__latrnq_1
X_319_ _685_/Q _602_/B VDD VDD VSS VSS gf180mcu_fd_sc_mcu7t5v0__clkinv_1
Xinput11 ui_in[7] _746_/D VDD VDD VSS VSS gf180mcu_fd_sc_mcu7t5v0__buf_1
Xclkbuf_1_0__f_clk clkbuf_0_clk/Z clkbuf_1_0__f_clk/Z VDD VDD VSS VSS gf180mcu_fd_sc_mcu7t5v0__clkbuf_4
XFILLER_20_164 VDD VDD VSS VSS gf180mcu_fd_sc_mcu7t5v0__fill_1
X_670_ _725_/Q _477_/Z _671_/A3 VDD VDD VSS VSS gf180mcu_fd_sc_mcu7t5v0__nor2_1
Xg_reg\[15\].g_bit\[4\].g_l.g_d.u_l _756_/D _410_/ZN _750_/RN _654_/A1 VDD VDD VSS
+ VSS gf180mcu_fd_sc_mcu7t5v0__latrnq_1
Xg_reg\[12\].g_bit\[1\].g_l.g_d.u_l _753_/D _416_/ZN load_slew18/Z _346_/I VDD VDD
+ VSS VSS gf180mcu_fd_sc_mcu7t5v0__latrnq_1
Xg_reg\[20\].g_bit\[7\].g_l.g_a.u_l _759_/D _400_/ZN _750_/RN cfg_out[101] VDD VDD
+ VSS VSS gf180mcu_fd_sc_mcu7t5v0__latrnq_1
XFILLER_25_212 VDD VDD VSS VSS gf180mcu_fd_sc_mcu7t5v0__fill_2
XTAP_TAPCELL_ROW_10_129 VDD VSS gf180mcu_fd_sc_mcu7t5v0__filltie
XTAP_TAPCELL_ROW_4_105 VDD VSS gf180mcu_fd_sc_mcu7t5v0__filltie
Xg_reg\[1\].g_bit\[6\].g_l.g_a.u_l _758_/D _427_/ZN load_slew18/Z cfg_out[14] VDD
+ VDD VSS VSS gf180mcu_fd_sc_mcu7t5v0__latrnq_1
XPHY_EDGE_ROW_9_Left_51 VDD VSS gf180mcu_fd_sc_mcu7t5v0__endcap
XTAP_TAPCELL_ROW_41_254 VDD VSS gf180mcu_fd_sc_mcu7t5v0__filltie
X_584_ _584_/A1 _613_/C _584_/B _586_/A2 VDD VDD VSS VSS gf180mcu_fd_sc_mcu7t5v0__aoi21_1
X_653_ _653_/A1 _653_/A2 _653_/B _658_/A2 VDD VDD VSS VSS gf180mcu_fd_sc_mcu7t5v0__oai21_1
X_722_ _722_/D _766_/CLK _722_/Q VDD VDD VSS VSS gf180mcu_fd_sc_mcu7t5v0__dffq_1
XFILLER_13_29 VDD VDD VSS VSS gf180mcu_fd_sc_mcu7t5v0__fill_1
XFILLER_38_37 VDD VDD VSS VSS gf180mcu_fd_sc_mcu7t5v0__fill_2
XPHY_EDGE_ROW_35_Left_77 VDD VSS gf180mcu_fd_sc_mcu7t5v0__endcap
X_498_ _688_/Q _603_/B _514_/B VDD VDD VSS VSS gf180mcu_fd_sc_mcu7t5v0__nand2_1
X_567_ _567_/A1 _633_/C _567_/B1 _567_/B2 _568_/I1 VDD VDD VSS VSS gf180mcu_fd_sc_mcu7t5v0__oai22_1
X_636_ _640_/A1 _636_/A2 _637_/A3 VDD VDD VSS VSS gf180mcu_fd_sc_mcu7t5v0__nand2_1
X_705_ _705_/D wire17/Z _769_/CLK _705_/Q VDD VDD VSS VSS gf180mcu_fd_sc_mcu7t5v0__dffrnq_1
X_421_ _424_/A1 _425_/A2 _421_/ZN VDD VDD VSS VSS gf180mcu_fd_sc_mcu7t5v0__nor2_1
XFILLER_36_115 VDD VDD VSS VSS gf180mcu_fd_sc_mcu7t5v0__fill_1
X_352_ _745_/Q _745_/D VDD VDD VSS VSS gf180mcu_fd_sc_mcu7t5v0__clkinv_1
X_619_ _737_/Q _619_/A2 _633_/C _619_/C _621_/A2 VDD VDD VSS VSS gf180mcu_fd_sc_mcu7t5v0__oai211_1
Xinput9 ui_in[5] input9/Z VDD VDD VSS VSS gf180mcu_fd_sc_mcu7t5v0__buf_1
XFILLER_18_104 VDD VDD VSS VSS gf180mcu_fd_sc_mcu7t5v0__fill_1
XFILLER_41_70 VDD VDD VSS VSS gf180mcu_fd_sc_mcu7t5v0__fill_2
XPHY_EDGE_ROW_38_Left_80 VDD VSS gf180mcu_fd_sc_mcu7t5v0__endcap
X_335_ _704_/Q _640_/A1 VDD VDD VSS VSS gf180mcu_fd_sc_mcu7t5v0__clkinv_1
X_404_ _404_/A1 _402_/Z _404_/ZN VDD VDD VSS VSS gf180mcu_fd_sc_mcu7t5v0__nor2_1
XPHY_EDGE_ROW_10_Right_10 VDD VSS gf180mcu_fd_sc_mcu7t5v0__endcap
XPHY_EDGE_ROW_22_Left_64 VDD VSS gf180mcu_fd_sc_mcu7t5v0__endcap
XTAP_TAPCELL_ROW_19_165 VDD VSS gf180mcu_fd_sc_mcu7t5v0__filltie
XFILLER_2_2 VDD VDD VSS VSS gf180mcu_fd_sc_mcu7t5v0__fill_2
XFILLER_14_173 VDD VDD VSS VSS gf180mcu_fd_sc_mcu7t5v0__fill_2
XFILLER_35_2 VDD VDD VSS VSS gf180mcu_fd_sc_mcu7t5v0__fill_2
X_318_ _684_/Q _656_/A1 VDD VDD VSS VSS gf180mcu_fd_sc_mcu7t5v0__clkinv_1
XFILLER_19_298 VDD VDD VSS VSS gf180mcu_fd_sc_mcu7t5v0__fill_1
XFILLER_28_298 VDD VDD VSS VSS gf180mcu_fd_sc_mcu7t5v0__fill_1
Xg_reg\[18\].g_bit\[4\].g_l.g_a.u_l _756_/D _404_/ZN _750_/RN cfg_out[82] VDD VDD
+ VSS VSS gf180mcu_fd_sc_mcu7t5v0__latrnq_1
XTAP_TAPCELL_ROW_35_230 VDD VSS gf180mcu_fd_sc_mcu7t5v0__filltie
XTAP_TAPCELL_ROW_4_106 VDD VSS gf180mcu_fd_sc_mcu7t5v0__filltie
Xg_reg\[5\].g_bit\[0\].g_l.g_a.u_l _752_/D _423_/ZN load_slew18/Z cfg_out[40] VDD
+ VDD VSS VSS gf180mcu_fd_sc_mcu7t5v0__latrnq_1
Xg_reg\[24\].g_bit\[1\].g_l.g_a.u_l _753_/D _392_/ZN _750_/RN cfg_out[127] VDD VDD
+ VSS VSS gf180mcu_fd_sc_mcu7t5v0__latrnq_1
XTAP_TAPCELL_ROW_41_255 VDD VSS gf180mcu_fd_sc_mcu7t5v0__filltie
X_583_ _583_/A1 _583_/A2 _584_/B VDD VDD VSS VSS gf180mcu_fd_sc_mcu7t5v0__nor2_1
X_652_ _656_/A1 _652_/A2 _656_/B1 _652_/B2 _656_/C _653_/B VDD VDD VSS VSS gf180mcu_fd_sc_mcu7t5v0__oai221_1
Xg_reg\[8\].g_bit\[3\].g_l.g_a.u_l _755_/D _420_/ZN input1/Z cfg_out[63] VDD VDD VSS
+ VSS gf180mcu_fd_sc_mcu7t5v0__latrnq_1
X_721_ _721_/D _770_/CLK _721_/Q VDD VDD VSS VSS gf180mcu_fd_sc_mcu7t5v0__dffq_1
XPHY_EDGE_ROW_8_Right_8 VDD VSS gf180mcu_fd_sc_mcu7t5v0__endcap
XPHY_EDGE_ROW_39_Right_39 VDD VSS gf180mcu_fd_sc_mcu7t5v0__endcap
Xg_reg\[17\].g_bit\[5\].g_l.g_d.u_l _757_/D _405_/ZN _750_/RN _602_/A2 VDD VDD VSS
+ VSS gf180mcu_fd_sc_mcu7t5v0__latrnq_1
Xg_reg\[14\].g_bit\[2\].g_l.g_d.u_l _754_/D _412_/ZN input1/Z _572_/A1 VDD VDD VSS
+ VSS gf180mcu_fd_sc_mcu7t5v0__latrnq_1
Xg_reg\[10\].g_bit\[5\].g_l.g_a.u_l _757_/D _418_/ZN input1/Z cfg_out[67] VDD VDD
+ VSS VSS gf180mcu_fd_sc_mcu7t5v0__latrnq_1
X_497_ _739_/Q _770_/Q _740_/Q _518_/B VDD VDD VSS VSS gf180mcu_fd_sc_mcu7t5v0__aoi21_1
X_566_ _566_/A1 _430_/Z _633_/C _567_/B2 VDD VDD VSS VSS gf180mcu_fd_sc_mcu7t5v0__oai21_1
X_635_ _641_/A2 _635_/A2 _640_/A2 VDD VDD VSS VSS gf180mcu_fd_sc_mcu7t5v0__nand2_1
Xg_reg\[3\].g_bit\[7\].g_l.g_a.u_l _759_/D _425_/ZN load_slew18/Z cfg_out[31] VDD
+ VDD VSS VSS gf180mcu_fd_sc_mcu7t5v0__latrnq_1
Xg_reg\[0\].g_bit\[4\].g_l.g_a.u_l _756_/D _428_/ZN load_slew18/Z cfg_out[4] VDD VDD
+ VSS VSS gf180mcu_fd_sc_mcu7t5v0__latrnq_1
X_704_ _704_/D wire15/Z _748_/CLK _704_/Q VDD VDD VSS VSS gf180mcu_fd_sc_mcu7t5v0__dffrnq_1
XFILLER_30_94 VDD VDD VSS VSS gf180mcu_fd_sc_mcu7t5v0__fill_1
X_351_ _699_/Q _616_/A1 VDD VDD VSS VSS gf180mcu_fd_sc_mcu7t5v0__clkinv_1
X_420_ _420_/A1 _428_/A2 _420_/ZN VDD VDD VSS VSS gf180mcu_fd_sc_mcu7t5v0__nor2_1
X_549_ _551_/B _551_/A1 _617_/A1 VDD VDD VSS VSS gf180mcu_fd_sc_mcu7t5v0__nand2_1
X_618_ _700_/Q _737_/Q _619_/C VDD VDD VSS VSS gf180mcu_fd_sc_mcu7t5v0__nand2_1
XFILLER_25_72 VDD VDD VSS VSS gf180mcu_fd_sc_mcu7t5v0__fillcap_4
X_334_ _688_/Q _555_/A1 VDD VDD VSS VSS gf180mcu_fd_sc_mcu7t5v0__clkinv_1
X_403_ _403_/A1 _402_/Z _403_/ZN VDD VDD VSS VSS gf180mcu_fd_sc_mcu7t5v0__nor2_1
XFILLER_2_10 VDD VDD VSS VSS gf180mcu_fd_sc_mcu7t5v0__fill_2
XTAP_TAPCELL_ROW_19_166 VDD VSS gf180mcu_fd_sc_mcu7t5v0__filltie
Xclkbuf_0_ui_in[0] ui_in[0] clkbuf_0_ui_in[0]/Z VDD VDD VSS VSS gf180mcu_fd_sc_mcu7t5v0__clkbuf_4
XFILLER_28_2 VDD VDD VSS VSS gf180mcu_fd_sc_mcu7t5v0__fill_2
XTAP_TAPCELL_ROW_21_172 VDD VSS gf180mcu_fd_sc_mcu7t5v0__filltie
XFILLER_27_18 VDD VDD VSS VSS gf180mcu_fd_sc_mcu7t5v0__fill_2
XFILLER_34_269 VDD VDD VSS VSS gf180mcu_fd_sc_mcu7t5v0__fill_1
XTAP_TAPCELL_ROW_4_107 VDD VSS gf180mcu_fd_sc_mcu7t5v0__filltie
XFILLER_4_129 VDD VDD VSS VSS gf180mcu_fd_sc_mcu7t5v0__fill_2
XTAP_TAPCELL_ROW_35_231 VDD VSS gf180mcu_fd_sc_mcu7t5v0__filltie
X_582_ _582_/A1 _430_/Z _633_/C _583_/A2 VDD VDD VSS VSS gf180mcu_fd_sc_mcu7t5v0__oai21_1
X_651_ _651_/A1 _656_/B1 _655_/B _653_/A2 VDD VDD VSS VSS gf180mcu_fd_sc_mcu7t5v0__oai21_1
X_720_ _720_/D _770_/CLK _720_/Q VDD VDD VSS VSS gf180mcu_fd_sc_mcu7t5v0__dffq_1
XFILLER_33_72 VDD VDD VSS VSS gf180mcu_fd_sc_mcu7t5v0__fill_2
XTAP_TAPCELL_ROW_41_256 VDD VSS gf180mcu_fd_sc_mcu7t5v0__filltie
XFILLER_38_39 VDD VDD VSS VSS gf180mcu_fd_sc_mcu7t5v0__fill_1
X_496_ _486_/B _496_/A2 _736_/D VDD VDD VSS VSS gf180mcu_fd_sc_mcu7t5v0__nor2_1
X_565_ _694_/Q _613_/B2 _567_/B1 VDD VDD VSS VSS gf180mcu_fd_sc_mcu7t5v0__nor2_1
X_634_ _634_/A1 _634_/A2 _634_/B _703_/D VDD VDD VSS VSS gf180mcu_fd_sc_mcu7t5v0__aoi21_1
X_703_ _703_/D wire15/I _703_/CLK _703_/Q VDD VDD VSS VSS gf180mcu_fd_sc_mcu7t5v0__dffrnq_1
XFILLER_39_103 VDD VDD VSS VSS gf180mcu_fd_sc_mcu7t5v0__fill_2
Xg_reg\[7\].g_bit\[1\].g_l.g_a.u_l _753_/D _421_/ZN input1/Z cfg_out[55] VDD VDD VSS
+ VSS gf180mcu_fd_sc_mcu7t5v0__latrnq_1
XFILLER_5_279 VDD VDD VSS VSS gf180mcu_fd_sc_mcu7t5v0__fill_1
X_350_ _692_/Q _558_/B2 VDD VDD VSS VSS gf180mcu_fd_sc_mcu7t5v0__clkinv_1
X_479_ _726_/Q _727_/Q _478_/Z _479_/Z VDD VDD VSS VSS gf180mcu_fd_sc_mcu7t5v0__and3_1
X_548_ _633_/C _458_/Z _551_/A1 VDD VDD VSS VSS gf180mcu_fd_sc_mcu7t5v0__nand2_1
X_617_ _617_/A1 _552_/Z _634_/A1 VDD VDD VSS VSS gf180mcu_fd_sc_mcu7t5v0__nor2_1
Xg_reg\[16\].g_bit\[3\].g_l.g_d.u_l _755_/D _406_/ZN input1/Z _576_/A1 VDD VDD VSS
+ VSS gf180mcu_fd_sc_mcu7t5v0__latrnq_1
Xg_reg\[13\].g_bit\[0\].g_l.g_d.u_l _752_/D _414_/ZN _750_/RN _524_/A1 VDD VDD VSS
+ VSS gf180mcu_fd_sc_mcu7t5v0__latrnq_1
Xg_reg\[21\].g_bit\[6\].g_l.g_a.u_l _758_/D _399_/ZN _750_/RN cfg_out[108] VDD VDD
+ VSS VSS gf180mcu_fd_sc_mcu7t5v0__latrnq_1
XFILLER_1_282 VDD VDD VSS VSS gf180mcu_fd_sc_mcu7t5v0__fillcap_16
XTAP_TAPCELL_ROW_19_167 VDD VSS gf180mcu_fd_sc_mcu7t5v0__filltie
X_333_ _705_/Q _646_/A1 VDD VDD VSS VSS gf180mcu_fd_sc_mcu7t5v0__clkinv_1
X_402_ _402_/A1 _428_/A1 _402_/Z VDD VDD VSS VSS gf180mcu_fd_sc_mcu7t5v0__or2_1
Xg_reg\[2\].g_bit\[5\].g_l.g_a.u_l _757_/D _426_/ZN load_slew18/Z cfg_out[21] VDD
+ VDD VSS VSS gf180mcu_fd_sc_mcu7t5v0__latrnq_1
Xg_reg\[11\].g_bit\[7\].g_l.g_d.u_l _759_/D _417_/ZN _750_/RN _363_/A2 VDD VDD VSS
+ VSS gf180mcu_fd_sc_mcu7t5v0__latrnq_1
XFILLER_37_212 VDD VDD VSS VSS gf180mcu_fd_sc_mcu7t5v0__fill_2
XFILLER_9_190 VDD VDD VSS VSS gf180mcu_fd_sc_mcu7t5v0__fill_2
XFILLER_7_138 VDD VDD VSS VSS gf180mcu_fd_sc_mcu7t5v0__fill_2
XTAP_TAPCELL_ROW_21_173 VDD VSS gf180mcu_fd_sc_mcu7t5v0__filltie
XTAP_TAPCELL_ROW_38_240 VDD VSS gf180mcu_fd_sc_mcu7t5v0__filltie
XTAP_TAPCELL_ROW_7_116 VDD VSS gf180mcu_fd_sc_mcu7t5v0__filltie
XFILLER_40_2 VDD VDD VSS VSS gf180mcu_fd_sc_mcu7t5v0__fill_1
X_650_ _650_/A1 _655_/A2 _653_/A1 VDD VDD VSS VSS gf180mcu_fd_sc_mcu7t5v0__nor2_1
XFILLER_16_215 VDD VDD VSS VSS gf180mcu_fd_sc_mcu7t5v0__fill_1
XTAP_TAPCELL_ROW_41_257 VDD VSS gf180mcu_fd_sc_mcu7t5v0__filltie
X_581_ _697_/Q _613_/B2 _583_/A1 VDD VDD VSS VSS gf180mcu_fd_sc_mcu7t5v0__nor2_1
X_495_ _736_/Q _493_/Z _496_/A2 VDD VDD VSS VSS gf180mcu_fd_sc_mcu7t5v0__xnor2_1
X_564_ _615_/B _564_/A2 _564_/B _692_/D VDD VDD VSS VSS gf180mcu_fd_sc_mcu7t5v0__aoi21_1
X_633_ _737_/Q _633_/A2 _439_/Z _448_/Z _633_/C _634_/A2 VDD VDD VSS VSS gf180mcu_fd_sc_mcu7t5v0__oai221_1
X_702_ _702_/D wire15/I _703_/CLK _702_/Q VDD VDD VSS VSS gf180mcu_fd_sc_mcu7t5v0__dffrnq_1
X_478_ _722_/Q _723_/Q _724_/Q _725_/Q _478_/Z VDD VDD VSS VSS gf180mcu_fd_sc_mcu7t5v0__and4_1
X_547_ _547_/A1 _441_/Z _737_/Q _633_/C _551_/B VDD VDD VSS VSS gf180mcu_fd_sc_mcu7t5v0__oai211_1
X_616_ _616_/A1 _615_/B _616_/B _699_/D VDD VDD VSS VSS gf180mcu_fd_sc_mcu7t5v0__oai21_1
Xg_reg\[19\].g_bit\[3\].g_l.g_a.u_l _755_/D _403_/ZN _750_/RN cfg_out[89] VDD VDD
+ VSS VSS gf180mcu_fd_sc_mcu7t5v0__latrnq_1
Xclkbuf_0_clk_regs clkbuf_regs_0_clk/Z clkbuf_0_clk_regs/Z VDD VDD VSS VSS gf180mcu_fd_sc_mcu7t5v0__clkbuf_4
XFILLER_18_129 VDD VDD VSS VSS gf180mcu_fd_sc_mcu7t5v0__fillcap_4
XFILLER_2_12 VDD VDD VSS VSS gf180mcu_fd_sc_mcu7t5v0__fill_1
X_332_ _332_/I _605_/A1 VDD VDD VSS VSS gf180mcu_fd_sc_mcu7t5v0__clkinv_1
X_401_ _401_/A1 _401_/A2 _428_/A1 VDD VDD VSS VSS gf180mcu_fd_sc_mcu7t5v0__nand2_1
Xg_reg\[25\].g_bit\[0\].g_l.g_a.u_l _752_/D _391_/ZN _750_/RN cfg_out[134] VDD VDD
+ VSS VSS gf180mcu_fd_sc_mcu7t5v0__latrnq_1
Xg_reg\[9\].g_bit\[2\].g_l.g_a.u_l _754_/D _419_/ZN input1/Z cfg_out[71] VDD VDD VSS
+ VSS gf180mcu_fd_sc_mcu7t5v0__latrnq_1
XFILLER_28_4 VDD VDD VSS VSS gf180mcu_fd_sc_mcu7t5v0__fill_1
XPHY_EDGE_ROW_26_Left_68 VDD VSS gf180mcu_fd_sc_mcu7t5v0__endcap
Xg_reg\[15\].g_bit\[1\].g_l.g_d.u_l _753_/D _410_/ZN _750_/RN _650_/A1 VDD VDD VSS
+ VSS gf180mcu_fd_sc_mcu7t5v0__latrnq_1
XFILLER_11_135 VDD VDD VSS VSS gf180mcu_fd_sc_mcu7t5v0__fillcap_4
XFILLER_22_75 VDD VDD VSS VSS gf180mcu_fd_sc_mcu7t5v0__fillcap_4
XTAP_TAPCELL_ROW_21_174 VDD VSS gf180mcu_fd_sc_mcu7t5v0__filltie
XTAP_TAPCELL_ROW_38_241 VDD VSS gf180mcu_fd_sc_mcu7t5v0__filltie
XTAP_TAPCELL_ROW_7_117 VDD VSS gf180mcu_fd_sc_mcu7t5v0__filltie
Xg_reg\[4\].g_bit\[6\].g_l.g_a.u_l _758_/D _424_/ZN load_slew18/Z cfg_out[38] VDD
+ VDD VSS VSS gf180mcu_fd_sc_mcu7t5v0__latrnq_1
Xg_reg\[23\].g_bit\[7\].g_l.g_a.u_l _759_/D _396_/ZN _750_/RN cfg_out[125] VDD VDD
+ VSS VSS gf180mcu_fd_sc_mcu7t5v0__latrnq_1
Xg_reg\[20\].g_bit\[4\].g_l.g_a.u_l _756_/D _400_/ZN _750_/RN cfg_out[98] VDD VDD
+ VSS VSS gf180mcu_fd_sc_mcu7t5v0__latrnq_1
Xg_reg\[1\].g_bit\[3\].g_l.g_a.u_l _755_/D _427_/ZN load_slew18/Z cfg_out[11] VDD
+ VDD VSS VSS gf180mcu_fd_sc_mcu7t5v0__latrnq_1
XFILLER_0_2 VDD VDD VSS VSS gf180mcu_fd_sc_mcu7t5v0__fillcap_4
XFILLER_6_183 VDD VDD VSS VSS gf180mcu_fd_sc_mcu7t5v0__fillcap_4
X_795_ spk_in[7] uo_out[7] VDD VDD VSS VSS gf180mcu_fd_sc_mcu7t5v0__buf_1
XFILLER_33_2 VDD VDD VSS VSS gf180mcu_fd_sc_mcu7t5v0__fill_2
XFILLER_33_41 VDD VDD VSS VSS gf180mcu_fd_sc_mcu7t5v0__fill_1
XFILLER_3_142 VDD VDD VSS VSS gf180mcu_fd_sc_mcu7t5v0__fillcap_16
XTAP_TAPCELL_ROW_41_258 VDD VSS gf180mcu_fd_sc_mcu7t5v0__filltie
X_580_ _615_/B _580_/A2 _580_/B _695_/D VDD VDD VSS VSS gf180mcu_fd_sc_mcu7t5v0__aoi21_1
XPHY_EDGE_ROW_13_Left_55 VDD VSS gf180mcu_fd_sc_mcu7t5v0__endcap
XPHY_EDGE_ROW_29_Left_71 VDD VSS gf180mcu_fd_sc_mcu7t5v0__endcap
XFILLER_0_112 VDD VDD VSS VSS gf180mcu_fd_sc_mcu7t5v0__fill_2
XFILLER_21_296 VDD VDD VSS VSS gf180mcu_fd_sc_mcu7t5v0__fill_2
XPHY_EDGE_ROW_17_Right_17 VDD VSS gf180mcu_fd_sc_mcu7t5v0__endcap
XPHY_EDGE_ROW_26_Right_26 VDD VSS gf180mcu_fd_sc_mcu7t5v0__endcap
X_563_ _692_/Q _615_/B _564_/B VDD VDD VSS VSS gf180mcu_fd_sc_mcu7t5v0__nor2_1
X_632_ _448_/Z _634_/A1 _703_/Q _634_/B VDD VDD VSS VSS gf180mcu_fd_sc_mcu7t5v0__aoi21_1
X_701_ _701_/D wire15/I _703_/CLK _701_/Q VDD VDD VSS VSS gf180mcu_fd_sc_mcu7t5v0__dffrnq_1
XFILLER_39_105 VDD VDD VSS VSS gf180mcu_fd_sc_mcu7t5v0__fill_1
XPHY_EDGE_ROW_35_Right_35 VDD VSS gf180mcu_fd_sc_mcu7t5v0__endcap
X_494_ _486_/B _494_/A2 _493_/Z _735_/D VDD VDD VSS VSS gf180mcu_fd_sc_mcu7t5v0__nor3_1
X_477_ _722_/Q _723_/Q _724_/Q _477_/Z VDD VDD VSS VSS gf180mcu_fd_sc_mcu7t5v0__and3_1
X_546_ _546_/A1 _546_/A2 _545_/Z _598_/A1 _687_/D VDD VDD VSS VSS gf180mcu_fd_sc_mcu7t5v0__oai22_1
X_615_ _615_/A1 _633_/C _615_/B _615_/C _616_/B VDD VDD VSS VSS gf180mcu_fd_sc_mcu7t5v0__oai211_1
X_331_ _761_/Q _401_/A2 VDD VDD VSS VSS gf180mcu_fd_sc_mcu7t5v0__clkinv_1
X_400_ _760_/D _761_/D _395_/Z _400_/ZN VDD VDD VSS VSS gf180mcu_fd_sc_mcu7t5v0__nor3_1
X_529_ _613_/B2 _526_/Z _529_/A3 _529_/B _530_/B2 VDD VDD VSS VSS gf180mcu_fd_sc_mcu7t5v0__oai31_1
XFILLER_37_214 VDD VDD VSS VSS gf180mcu_fd_sc_mcu7t5v0__fill_1
XPHY_EDGE_ROW_1_Left_43 VDD VSS gf180mcu_fd_sc_mcu7t5v0__endcap
XFILLER_28_214 VDD VDD VSS VSS gf180mcu_fd_sc_mcu7t5v0__fill_2
XTAP_TAPCELL_ROW_15_150 VDD VSS gf180mcu_fd_sc_mcu7t5v0__filltie
XTAP_TAPCELL_ROW_38_242 VDD VSS gf180mcu_fd_sc_mcu7t5v0__filltie
XTAP_TAPCELL_ROW_7_118 VDD VSS gf180mcu_fd_sc_mcu7t5v0__filltie
Xg_reg\[18\].g_bit\[1\].g_l.g_a.u_l _753_/D _404_/ZN _750_/RN cfg_out[79] VDD VDD
+ VSS VSS gf180mcu_fd_sc_mcu7t5v0__latrnq_1
XTAP_TAPCELL_ROW_21_175 VDD VSS gf180mcu_fd_sc_mcu7t5v0__filltie
Xg_reg\[8\].g_bit\[0\].g_l.g_a.u_l _752_/D _420_/ZN input1/Z cfg_out[60] VDD VDD VSS
+ VSS gf180mcu_fd_sc_mcu7t5v0__latrnq_1
X_794_ spk_in[6] uo_out[6] VDD VDD VSS VSS gf180mcu_fd_sc_mcu7t5v0__buf_1
XFILLER_26_2 VDD VDD VSS VSS gf180mcu_fd_sc_mcu7t5v0__fill_2
XFILLER_17_98 VDD VDD VSS VSS gf180mcu_fd_sc_mcu7t5v0__fill_2
XTAP_TAPCELL_ROW_41_259 VDD VSS gf180mcu_fd_sc_mcu7t5v0__filltie
Xg_reg\[17\].g_bit\[2\].g_l.g_d.u_l _754_/D _405_/ZN _750_/RN _600_/B VDD VDD VSS
+ VSS gf180mcu_fd_sc_mcu7t5v0__latrnq_1
XFILLER_0_168 VDD VDD VSS VSS gf180mcu_fd_sc_mcu7t5v0__fill_2
Xg_reg\[3\].g_bit\[4\].g_l.g_a.u_l _756_/D _425_/ZN load_slew18/Z cfg_out[28] VDD
+ VDD VSS VSS gf180mcu_fd_sc_mcu7t5v0__latrnq_1
Xg_reg\[22\].g_bit\[5\].g_l.g_a.u_l _757_/D _398_/ZN _750_/RN cfg_out[115] VDD VDD
+ VSS VSS gf180mcu_fd_sc_mcu7t5v0__latrnq_1
Xg_reg\[0\].g_bit\[1\].g_l.g_a.u_l _753_/D _428_/ZN load_slew18/Z cfg_out[1] VDD VDD
+ VSS VSS gf180mcu_fd_sc_mcu7t5v0__latrnq_1
X_700_ _700_/D wire15/I _748_/CLK _700_/Q VDD VDD VSS VSS gf180mcu_fd_sc_mcu7t5v0__dffrnq_1
XPHY_EDGE_ROW_30_Left_72 VDD VSS gf180mcu_fd_sc_mcu7t5v0__endcap
X_493_ _733_/Q _734_/Q _735_/Q _482_/Z _493_/Z VDD VDD VSS VSS gf180mcu_fd_sc_mcu7t5v0__and4_1
X_562_ _562_/A1 _613_/C _562_/B _564_/A2 VDD VDD VSS VSS gf180mcu_fd_sc_mcu7t5v0__aoi21_1
X_631_ _634_/A1 _631_/A2 _631_/B _702_/D VDD VDD VSS VSS gf180mcu_fd_sc_mcu7t5v0__aoi21_1
Xg_reg\[12\].g_bit\[6\].g_l.g_d.u_l _758_/D _416_/ZN _750_/RN _336_/I VDD VDD VSS
+ VSS gf180mcu_fd_sc_mcu7t5v0__latrnq_1
XFILLER_14_77 VDD VDD VSS VSS gf180mcu_fd_sc_mcu7t5v0__fill_2
X_476_ _476_/A1 _475_/B _336_/I _476_/B1 _476_/B2 _476_/ZN VDD VDD VSS VSS gf180mcu_fd_sc_mcu7t5v0__oai32_1
X_545_ _522_/I _545_/A2 _545_/A3 _545_/Z VDD VDD VSS VSS gf180mcu_fd_sc_mcu7t5v0__and3_1
X_614_ _638_/C _612_/Z _614_/B _615_/C VDD VDD VSS VSS gf180mcu_fd_sc_mcu7t5v0__oai21_1
XFILLER_35_142 VDD VDD VSS VSS gf180mcu_fd_sc_mcu7t5v0__fill_1
XFILLER_25_76 VDD VDD VSS VSS gf180mcu_fd_sc_mcu7t5v0__fill_2
X_330_ _762_/Q _401_/A1 VDD VDD VSS VSS gf180mcu_fd_sc_mcu7t5v0__clkinv_1
XFILLER_17_142 VDD VDD VSS VSS gf180mcu_fd_sc_mcu7t5v0__fill_1
X_459_ _707_/Q _708_/Q _552_/A3 VDD VDD VSS VSS gf180mcu_fd_sc_mcu7t5v0__nor2_1
X_528_ _685_/Q _741_/Q _528_/A3 _603_/B _529_/A3 VDD VDD VSS VSS gf180mcu_fd_sc_mcu7t5v0__nor4_1
XFILLER_23_156 VDD VDD VSS VSS gf180mcu_fd_sc_mcu7t5v0__fill_2
XTAP_TAPCELL_ROW_24_184 VDD VSS gf180mcu_fd_sc_mcu7t5v0__filltie
XTAP_TAPCELL_ROW_15_151 VDD VSS gf180mcu_fd_sc_mcu7t5v0__filltie
XTAP_TAPCELL_ROW_38_243 VDD VSS gf180mcu_fd_sc_mcu7t5v0__filltie
XTAP_TAPCELL_ROW_7_119 VDD VSS gf180mcu_fd_sc_mcu7t5v0__filltie
X_793_ spk_in[5] uo_out[5] VDD VDD VSS VSS gf180mcu_fd_sc_mcu7t5v0__buf_1
XFILLER_19_2 VDD VDD VSS VSS gf180mcu_fd_sc_mcu7t5v0__fill_2
XTAP_TAPCELL_ROW_3_100 VDD VSS gf180mcu_fd_sc_mcu7t5v0__filltie
XFILLER_30_298 VDD VDD VSS VSS gf180mcu_fd_sc_mcu7t5v0__fill_1
XTAP_TAPCELL_ROW_32_216 VDD VSS gf180mcu_fd_sc_mcu7t5v0__filltie
XFILLER_21_298 VDD VDD VSS VSS gf180mcu_fd_sc_mcu7t5v0__fill_1
XPHY_EDGE_ROW_3_Right_3 VDD VSS gf180mcu_fd_sc_mcu7t5v0__endcap
XFILLER_8_247 VDD VDD VSS VSS gf180mcu_fd_sc_mcu7t5v0__fill_1
X_492_ _735_/Q _490_/Z _494_/A2 VDD VDD VSS VSS gf180mcu_fd_sc_mcu7t5v0__nor2_1
X_561_ _561_/A1 _561_/A2 _562_/B VDD VDD VSS VSS gf180mcu_fd_sc_mcu7t5v0__nor2_1
X_630_ _702_/Q _634_/A1 _631_/B VDD VDD VSS VSS gf180mcu_fd_sc_mcu7t5v0__nor2_1
Xneuron_ctrl uio_oe[0] VDD VDD VSS VSS gf180mcu_fd_sc_mcu7t5v0__tieh
X_759_ _759_/D _763_/CLK _760_/D VDD VDD VSS VSS gf180mcu_fd_sc_mcu7t5v0__dffq_1
XFILLER_30_33 VDD VDD VSS VSS gf180mcu_fd_sc_mcu7t5v0__fill_2
X_613_ _740_/Q _688_/Q _613_/B1 _613_/B2 _613_/C _614_/B VDD VDD VSS VSS gf180mcu_fd_sc_mcu7t5v0__aoi221_1
Xg_reg\[16\].g_bit\[0\].g_l.g_d.u_l _752_/D _406_/ZN load_slew18/Z _560_/A1 VDD VDD
+ VSS VSS gf180mcu_fd_sc_mcu7t5v0__latrnq_1
X_475_ input8/Z _336_/I _475_/B _476_/B2 VDD VDD VSS VSS gf180mcu_fd_sc_mcu7t5v0__oai21_1
X_544_ _739_/Q _544_/A2 _545_/A3 VDD VDD VSS VSS gf180mcu_fd_sc_mcu7t5v0__nand2_1
Xg_reg\[5\].g_bit\[5\].g_l.g_a.u_l _757_/D _423_/ZN load_slew18/Z cfg_out[45] VDD
+ VDD VSS VSS gf180mcu_fd_sc_mcu7t5v0__latrnq_1
Xg_reg\[2\].g_bit\[2\].g_l.g_a.u_l _754_/D _426_/ZN load_slew18/Z cfg_out[18] VDD
+ VDD VSS VSS gf180mcu_fd_sc_mcu7t5v0__latrnq_1
Xg_reg\[24\].g_bit\[6\].g_l.g_a.u_l _758_/D load_slew13/Z _750_/RN cfg_out[132] VDD
+ VDD VSS VSS gf180mcu_fd_sc_mcu7t5v0__latrnq_1
Xg_reg\[21\].g_bit\[3\].g_l.g_a.u_l _755_/D _399_/ZN _750_/RN cfg_out[105] VDD VDD
+ VSS VSS gf180mcu_fd_sc_mcu7t5v0__latrnq_1
XFILLER_25_22 VDD VDD VSS VSS gf180mcu_fd_sc_mcu7t5v0__fill_1
XFILLER_2_37 VDD VDD VSS VSS gf180mcu_fd_sc_mcu7t5v0__fill_2
XFILLER_41_65 VDD VDD VSS VSS gf180mcu_fd_sc_mcu7t5v0__fill_2
X_389_ _763_/Q _329_/I _402_/A1 VDD VDD VSS VSS gf180mcu_fd_sc_mcu7t5v0__nand2_1
X_458_ _739_/Q _430_/Z _458_/Z VDD VDD VSS VSS gf180mcu_fd_sc_mcu7t5v0__or2_1
X_527_ _739_/Q _526_/Z _529_/B VDD VDD VSS VSS gf180mcu_fd_sc_mcu7t5v0__nand2_1
XFILLER_11_13 VDD VDD VSS VSS gf180mcu_fd_sc_mcu7t5v0__fill_2
XTAP_TAPCELL_ROW_18_160 VDD VSS gf180mcu_fd_sc_mcu7t5v0__filltie
Xg_reg\[14\].g_bit\[7\].g_l.g_d.u_l _759_/D _412_/ZN input1/Z _615_/A1 VDD VDD VSS
+ VSS gf180mcu_fd_sc_mcu7t5v0__latrnq_1
Xg_reg\[11\].g_bit\[4\].g_l.g_d.u_l _756_/D _417_/ZN _750_/RN _360_/A2 VDD VDD VSS
+ VSS gf180mcu_fd_sc_mcu7t5v0__latrnq_1
XTAP_TAPCELL_ROW_24_185 VDD VSS gf180mcu_fd_sc_mcu7t5v0__filltie
XFILLER_11_127 VDD VDD VSS VSS gf180mcu_fd_sc_mcu7t5v0__fillcap_8
XFILLER_19_227 VDD VDD VSS VSS gf180mcu_fd_sc_mcu7t5v0__fill_1
X_792_ spk_in[4] uo_out[4] VDD VDD VSS VSS gf180mcu_fd_sc_mcu7t5v0__buf_1
XFILLER_33_296 VDD VDD VSS VSS gf180mcu_fd_sc_mcu7t5v0__fill_2
XTAP_TAPCELL_ROW_3_101 VDD VSS gf180mcu_fd_sc_mcu7t5v0__filltie
XTAP_TAPCELL_ROW_32_217 VDD VSS gf180mcu_fd_sc_mcu7t5v0__filltie
XFILLER_21_277 VDD VDD VSS VSS gf180mcu_fd_sc_mcu7t5v0__fill_2
XFILLER_30_277 VDD VDD VSS VSS gf180mcu_fd_sc_mcu7t5v0__fill_1
XFILLER_31_2 VDD VDD VSS VSS gf180mcu_fd_sc_mcu7t5v0__fillcap_4
XTAP_TAPCELL_ROW_40_250 VDD VSS gf180mcu_fd_sc_mcu7t5v0__filltie
XFILLER_0_104 VDD VDD VSS VSS gf180mcu_fd_sc_mcu7t5v0__fillcap_8
X_491_ _486_/B _491_/A2 _490_/Z _734_/D VDD VDD VSS VSS gf180mcu_fd_sc_mcu7t5v0__nor3_1
X_560_ _560_/A1 _430_/Z _633_/C _561_/A2 VDD VDD VSS VSS gf180mcu_fd_sc_mcu7t5v0__oai21_1
XPHY_EDGE_ROW_13_Right_13 VDD VSS gf180mcu_fd_sc_mcu7t5v0__endcap
XPHY_EDGE_ROW_17_Left_59 VDD VSS gf180mcu_fd_sc_mcu7t5v0__endcap
XPHY_EDGE_ROW_22_Right_22 VDD VSS gf180mcu_fd_sc_mcu7t5v0__endcap
X_758_ _758_/D _763_/CLK _759_/D VDD VDD VSS VSS gf180mcu_fd_sc_mcu7t5v0__dffq_1
X_689_ _689_/D wire15/Z _703_/CLK _689_/Q VDD VDD VSS VSS gf180mcu_fd_sc_mcu7t5v0__dffrnq_1
XFILLER_14_79 VDD VDD VSS VSS gf180mcu_fd_sc_mcu7t5v0__fill_1
XPHY_EDGE_ROW_31_Right_31 VDD VSS gf180mcu_fd_sc_mcu7t5v0__endcap
XPHY_EDGE_ROW_40_Right_40 VDD VSS gf180mcu_fd_sc_mcu7t5v0__endcap
X_474_ _647_/A2 _788_/I _476_/B1 VDD VDD VSS VSS gf180mcu_fd_sc_mcu7t5v0__nor2_1
X_543_ _543_/A1 _445_/Z _543_/B1 _543_/B2 _546_/A2 VDD VDD VSS VSS gf180mcu_fd_sc_mcu7t5v0__aoi22_1
X_612_ _646_/A1 _643_/A2 _610_/Z _612_/Z VDD VDD VSS VSS gf180mcu_fd_sc_mcu7t5v0__xor3_1
Xg_reg\[19\].g_bit\[0\].g_l.g_a.u_l _752_/D _403_/ZN _750_/RN cfg_out[86] VDD VDD
+ VSS VSS gf180mcu_fd_sc_mcu7t5v0__latrnq_1
XFILLER_17_100 VDD VDD VSS VSS gf180mcu_fd_sc_mcu7t5v0__fill_1
XFILLER_1_298 VDD VDD VSS VSS gf180mcu_fd_sc_mcu7t5v0__fill_1
XFILLER_25_67 VDD VDD VSS VSS gf180mcu_fd_sc_mcu7t5v0__fill_2
XFILLER_41_11 VDD VDD VSS VSS gf180mcu_fd_sc_mcu7t5v0__fill_1
X_526_ _656_/A1 _685_/Q _526_/Z VDD VDD VSS VSS gf180mcu_fd_sc_mcu7t5v0__xor2_1
XTAP_TAPCELL_ROW_18_161 VDD VSS gf180mcu_fd_sc_mcu7t5v0__filltie
X_388_ _760_/D _415_/A2 _405_/A1 VDD VDD VSS VSS gf180mcu_fd_sc_mcu7t5v0__nand2_1
X_457_ _739_/Q _430_/Z _639_/A1 VDD VDD VSS VSS gf180mcu_fd_sc_mcu7t5v0__nor2_1
XFILLER_36_33 VDD VDD VSS VSS gf180mcu_fd_sc_mcu7t5v0__fill_2
XTAP_TAPCELL_ROW_24_186 VDD VSS gf180mcu_fd_sc_mcu7t5v0__filltie
Xg_reg\[11\].g_bit\[1\].g_l.g_a.u_l _753_/D _417_/ZN input1/Z cfg_out[77] VDD VDD
+ VSS VSS gf180mcu_fd_sc_mcu7t5v0__latrnq_1
X_509_ _598_/A1 _686_/Q _606_/B VDD VDD VSS VSS gf180mcu_fd_sc_mcu7t5v0__nand2_1
Xg_reg\[4\].g_bit\[3\].g_l.g_a.u_l _755_/D _424_/ZN load_slew18/Z cfg_out[35] VDD
+ VDD VSS VSS gf180mcu_fd_sc_mcu7t5v0__latrnq_1
Xg_reg\[23\].g_bit\[4\].g_l.g_a.u_l _756_/D _396_/ZN _750_/RN cfg_out[122] VDD VDD
+ VSS VSS gf180mcu_fd_sc_mcu7t5v0__latrnq_1
Xg_reg\[20\].g_bit\[1\].g_l.g_a.u_l _753_/D _400_/ZN _750_/RN cfg_out[95] VDD VDD
+ VSS VSS gf180mcu_fd_sc_mcu7t5v0__latrnq_1
Xg_reg\[1\].g_bit\[0\].g_l.g_a.u_l _752_/D _427_/ZN load_slew18/Z cfg_out[8] VDD VDD
+ VSS VSS gf180mcu_fd_sc_mcu7t5v0__latrnq_1
XFILLER_11_139 VDD VDD VSS VSS gf180mcu_fd_sc_mcu7t5v0__fill_1
XFILLER_22_79 VDD VDD VSS VSS gf180mcu_fd_sc_mcu7t5v0__fill_1
XPHY_EDGE_ROW_5_Left_47 VDD VSS gf180mcu_fd_sc_mcu7t5v0__endcap
XFILLER_8_59 VDD VDD VSS VSS gf180mcu_fd_sc_mcu7t5v0__fill_2
Xg_reg\[13\].g_bit\[5\].g_l.g_d.u_l _757_/D _414_/ZN _750_/RN _624_/A2 VDD VDD VSS
+ VSS gf180mcu_fd_sc_mcu7t5v0__latrnq_1
Xg_reg\[10\].g_bit\[2\].g_l.g_d.u_l _754_/D _418_/ZN _750_/RN _383_/A2 VDD VDD VSS
+ VSS gf180mcu_fd_sc_mcu7t5v0__latrnq_1
X_791_ spk_in[3] uo_out[3] VDD VDD VSS VSS gf180mcu_fd_sc_mcu7t5v0__buf_1
XTAP_TAPCELL_ROW_3_102 VDD VSS gf180mcu_fd_sc_mcu7t5v0__filltie
XFILLER_21_212 VDD VDD VSS VSS gf180mcu_fd_sc_mcu7t5v0__fill_2
XFILLER_24_2 VDD VDD VSS VSS gf180mcu_fd_sc_mcu7t5v0__fill_2
XTAP_TAPCELL_ROW_32_218 VDD VSS gf180mcu_fd_sc_mcu7t5v0__filltie
XTAP_TAPCELL_ROW_40_251 VDD VSS gf180mcu_fd_sc_mcu7t5v0__filltie
XFILLER_0_138 VDD VDD VSS VSS gf180mcu_fd_sc_mcu7t5v0__fillcap_8
XFILLER_28_45 VDD VDD VSS VSS gf180mcu_fd_sc_mcu7t5v0__fillcap_4
X_490_ _733_/Q _734_/Q _482_/Z _490_/Z VDD VDD VSS VSS gf180mcu_fd_sc_mcu7t5v0__and3_1
XPHY_EDGE_ROW_8_Left_50 VDD VSS gf180mcu_fd_sc_mcu7t5v0__endcap
X_757_ _757_/D _757_/CLK _758_/D VDD VDD VSS VSS gf180mcu_fd_sc_mcu7t5v0__dffq_1
X_688_ _688_/D wire15/Z _703_/CLK _688_/Q VDD VDD VSS VSS gf180mcu_fd_sc_mcu7t5v0__dffrnq_1
XFILLER_39_11 VDD VDD VSS VSS gf180mcu_fd_sc_mcu7t5v0__fill_1
XPHY_EDGE_ROW_34_Left_76 VDD VSS gf180mcu_fd_sc_mcu7t5v0__endcap
X_473_ _472_/B _464_/Z _473_/A3 _473_/B1 _473_/B2 _769_/D VDD VDD VSS VSS gf180mcu_fd_sc_mcu7t5v0__oai32_1
X_542_ _687_/Q _542_/A2 _543_/B2 VDD VDD VSS VSS gf180mcu_fd_sc_mcu7t5v0__nor2_1
X_611_ _643_/A2 _610_/Z _645_/A2 VDD VDD VSS VSS gf180mcu_fd_sc_mcu7t5v0__nand2_1
XFILLER_41_104 VDD VDD VSS VSS gf180mcu_fd_sc_mcu7t5v0__fill_2
XFILLER_41_67 VDD VDD VSS VSS gf180mcu_fd_sc_mcu7t5v0__fill_1
X_387_ _387_/A1 _387_/A2 probe_sel_onehot[15] VDD VDD VSS VSS gf180mcu_fd_sc_mcu7t5v0__nor2_1
X_456_ _613_/C _456_/A2 _647_/B _767_/D VDD VDD VSS VSS gf180mcu_fd_sc_mcu7t5v0__nor3_1
X_525_ _522_/I _525_/A2 _525_/B _684_/D VDD VDD VSS VSS gf180mcu_fd_sc_mcu7t5v0__aoi21_1
Xclkbuf_1_1__f_ui_in[0] clkbuf_0_ui_in[0]/Z _757_/CLK VDD VDD VSS VSS gf180mcu_fd_sc_mcu7t5v0__clkbuf_4
XFILLER_11_59 VDD VDD VSS VSS gf180mcu_fd_sc_mcu7t5v0__fillcap_4
XTAP_TAPCELL_ROW_18_162 VDD VSS gf180mcu_fd_sc_mcu7t5v0__filltie
XFILLER_20_107 VDD VDD VSS VSS gf180mcu_fd_sc_mcu7t5v0__fill_1
XFILLER_9_130 VDD VDD VSS VSS gf180mcu_fd_sc_mcu7t5v0__fill_2
XTAP_TAPCELL_ROW_24_187 VDD VSS gf180mcu_fd_sc_mcu7t5v0__filltie
X_439_ _701_/Q _700_/Q _702_/Q _439_/Z VDD VDD VSS VSS gf180mcu_fd_sc_mcu7t5v0__or3_1
X_508_ _687_/Q _541_/A1 _604_/C VDD VDD VSS VSS gf180mcu_fd_sc_mcu7t5v0__nor2_1
XPHY_EDGE_ROW_21_Left_63 VDD VSS gf180mcu_fd_sc_mcu7t5v0__endcap
X_790_ spk_in[2] uo_out[2] VDD VDD VSS VSS gf180mcu_fd_sc_mcu7t5v0__buf_1
XFILLER_33_298 VDD VDD VSS VSS gf180mcu_fd_sc_mcu7t5v0__fill_1
XFILLER_24_254 VDD VDD VSS VSS gf180mcu_fd_sc_mcu7t5v0__fill_2
XFILLER_3_158 VDD VDD VSS VSS gf180mcu_fd_sc_mcu7t5v0__fillcap_4
XTAP_TAPCELL_ROW_3_103 VDD VSS gf180mcu_fd_sc_mcu7t5v0__filltie
Xg_reg\[3\].g_bit\[1\].g_l.g_a.u_l _753_/D _425_/ZN load_slew18/Z cfg_out[25] VDD
+ VDD VSS VSS gf180mcu_fd_sc_mcu7t5v0__latrnq_1
Xg_reg\[25\].g_bit\[5\].g_l.g_a.u_l _757_/D _391_/ZN _750_/RN cfg_out[139] VDD VDD
+ VSS VSS gf180mcu_fd_sc_mcu7t5v0__latrnq_1
Xg_reg\[22\].g_bit\[2\].g_l.g_a.u_l _754_/D _398_/ZN _750_/RN cfg_out[112] VDD VDD
+ VSS VSS gf180mcu_fd_sc_mcu7t5v0__latrnq_1
XFILLER_15_298 VDD VDD VSS VSS gf180mcu_fd_sc_mcu7t5v0__fill_1
XFILLER_17_2 VDD VDD VSS VSS gf180mcu_fd_sc_mcu7t5v0__fill_2
XTAP_TAPCELL_ROW_32_219 VDD VSS gf180mcu_fd_sc_mcu7t5v0__filltie
Xg_reg\[6\].g_bit\[4\].g_l.g_a.u_l _756_/D _422_/ZN load_slew18/Z cfg_out[52] VDD
+ VDD VSS VSS gf180mcu_fd_sc_mcu7t5v0__latrnq_1
XFILLER_21_279 VDD VDD VSS VSS gf180mcu_fd_sc_mcu7t5v0__fill_1
Xg_reg\[15\].g_bit\[6\].g_l.g_d.u_l _758_/D _410_/ZN input1/Z _656_/B2 VDD VDD VSS
+ VSS gf180mcu_fd_sc_mcu7t5v0__latrnq_1
Xg_reg\[12\].g_bit\[3\].g_l.g_d.u_l _755_/D _416_/ZN load_slew18/Z _472_/B VDD VDD
+ VSS VSS gf180mcu_fd_sc_mcu7t5v0__latrnq_1
X_756_ _756_/D _757_/CLK _757_/D VDD VDD VSS VSS gf180mcu_fd_sc_mcu7t5v0__dffq_1
X_687_ _687_/D _750_/Q _750_/CLK _687_/Q VDD VDD VSS VSS gf180mcu_fd_sc_mcu7t5v0__dffrnq_1
XFILLER_14_26 VDD VDD VSS VSS gf180mcu_fd_sc_mcu7t5v0__fill_2
XFILLER_7_250 VDD VDD VSS VSS gf180mcu_fd_sc_mcu7t5v0__fill_1
XPHY_EDGE_ROW_7_Right_7 VDD VSS gf180mcu_fd_sc_mcu7t5v0__endcap
X_472_ _346_/I _471_/Z _472_/B _473_/B2 VDD VDD VSS VSS gf180mcu_fd_sc_mcu7t5v0__oai21_1
X_541_ _541_/A1 _522_/I _541_/B _686_/D VDD VDD VSS VSS gf180mcu_fd_sc_mcu7t5v0__oai21_1
X_610_ _709_/Q _704_/Q _514_/B _610_/Z VDD VDD VSS VSS gf180mcu_fd_sc_mcu7t5v0__xor3_1
Xclkbuf_1_0__f_ui_in[0] clkbuf_0_ui_in[0]/Z _763_/CLK VDD VDD VSS VSS gf180mcu_fd_sc_mcu7t5v0__clkbuf_4
X_739_ _739_/D wire15/Z _768_/CLK _739_/Q VDD VDD VSS VSS gf180mcu_fd_sc_mcu7t5v0__dffrnq_1
XFILLER_25_69 VDD VDD VSS VSS gf180mcu_fd_sc_mcu7t5v0__fill_1
XFILLER_41_138 VDD VDD VSS VSS gf180mcu_fd_sc_mcu7t5v0__fill_1
XFILLER_17_135 VDD VDD VSS VSS gf180mcu_fd_sc_mcu7t5v0__fillcap_4
XFILLER_1_278 VDD VDD VSS VSS gf180mcu_fd_sc_mcu7t5v0__fill_2
XTAP_TAPCELL_ROW_27_196 VDD VSS gf180mcu_fd_sc_mcu7t5v0__filltie
X_386_ _369_/Z _387_/A2 probe_sel_onehot[14] VDD VDD VSS VSS gf180mcu_fd_sc_mcu7t5v0__nor2_1
X_455_ _767_/Q _454_/Z _647_/B VDD VDD VSS VSS gf180mcu_fd_sc_mcu7t5v0__nor2_1
X_524_ _524_/A1 _445_/Z _458_/Z _656_/A1 _525_/A2 VDD VDD VSS VSS gf180mcu_fd_sc_mcu7t5v0__aoi22_1
Xu_lif.u_cg.u_icg clkbuf_1_0__f_clk/Z _434_/ZN u_lif.u_cg.u_icg/TE u_lif.u_cg.u_icg/Q
+ VDD VDD VSS VSS gf180mcu_fd_sc_mcu7t5v0__icgtp_1
XFILLER_31_193 VDD VDD VSS VSS gf180mcu_fd_sc_mcu7t5v0__fill_1
XTAP_TAPCELL_ROW_18_163 VDD VSS gf180mcu_fd_sc_mcu7t5v0__filltie
XFILLER_13_193 VDD VDD VSS VSS gf180mcu_fd_sc_mcu7t5v0__fill_2
XFILLER_3_94 VDD VDD VSS VSS gf180mcu_fd_sc_mcu7t5v0__fill_2
XFILLER_9_142 VDD VDD VSS VSS gf180mcu_fd_sc_mcu7t5v0__fill_1
X_369_ _369_/A1 _371_/A2 _369_/A3 _369_/Z VDD VDD VSS VSS gf180mcu_fd_sc_mcu7t5v0__or3_1
X_438_ _740_/Q _438_/A2 _533_/A2 VDD VDD VSS VSS gf180mcu_fd_sc_mcu7t5v0__nand2_1
X_507_ _507_/A1 _507_/A2 _657_/B _515_/A2 VDD VDD VSS VSS gf180mcu_fd_sc_mcu7t5v0__aoi21_1
XFILLER_22_59 VDD VDD VSS VSS gf180mcu_fd_sc_mcu7t5v0__fillcap_16
XFILLER_8_28 VDD VDD VSS VSS gf180mcu_fd_sc_mcu7t5v0__fill_1
XTAP_TAPCELL_ROW_12_136 VDD VSS gf180mcu_fd_sc_mcu7t5v0__filltie
XTAP_TAPCELL_ROW_6_112 VDD VSS gf180mcu_fd_sc_mcu7t5v0__filltie
XTAP_TAPCELL_ROW_35_228 VDD VSS gf180mcu_fd_sc_mcu7t5v0__filltie
XFILLER_30_225 VDD VDD VSS VSS gf180mcu_fd_sc_mcu7t5v0__fill_2
XFILLER_30_247 VDD VDD VSS VSS gf180mcu_fd_sc_mcu7t5v0__fill_1
XFILLER_21_214 VDD VDD VSS VSS gf180mcu_fd_sc_mcu7t5v0__fill_1
XFILLER_24_4 VDD VDD VSS VSS gf180mcu_fd_sc_mcu7t5v0__fill_1
XFILLER_12_214 VDD VDD VSS VSS gf180mcu_fd_sc_mcu7t5v0__fill_2
X_755_ _755_/D _757_/CLK _756_/D VDD VDD VSS VSS gf180mcu_fd_sc_mcu7t5v0__dffq_1
XFILLER_7_295 VDD VDD VSS VSS gf180mcu_fd_sc_mcu7t5v0__fillcap_4
Xg_reg\[18\].g_bit\[6\].g_l.g_a.u_l _758_/D _404_/ZN _750_/RN cfg_out[84] VDD VDD
+ VSS VSS gf180mcu_fd_sc_mcu7t5v0__latrnq_1
X_686_ _686_/D _750_/Q _750_/CLK _686_/Q VDD VDD VSS VSS gf180mcu_fd_sc_mcu7t5v0__dffrnq_1
XFILLER_29_166 VDD VDD VSS VSS gf180mcu_fd_sc_mcu7t5v0__fill_1
XFILLER_30_37 VDD VDD VSS VSS gf180mcu_fd_sc_mcu7t5v0__fill_1
X_471_ _729_/Q _730_/Q _733_/Q _734_/Q _483_/A2 _467_/C _471_/Z VDD VDD VSS VSS gf180mcu_fd_sc_mcu7t5v0__mux4_1
X_540_ _522_/I _540_/A2 _541_/B VDD VDD VSS VSS gf180mcu_fd_sc_mcu7t5v0__nand2_1
Xg_reg\[5\].g_bit\[2\].g_l.g_a.u_l _754_/D _423_/ZN load_slew18/Z cfg_out[42] VDD
+ VDD VSS VSS gf180mcu_fd_sc_mcu7t5v0__latrnq_1
Xg_reg\[8\].g_bit\[5\].g_l.g_a.u_l _757_/D _420_/ZN input1/Z cfg_out[65] VDD VDD VSS
+ VSS gf180mcu_fd_sc_mcu7t5v0__latrnq_1
Xg_reg\[24\].g_bit\[3\].g_l.g_a.u_l _755_/D load_slew12/Z _750_/RN cfg_out[129] VDD
+ VDD VSS VSS gf180mcu_fd_sc_mcu7t5v0__latrnq_1
Xg_reg\[21\].g_bit\[0\].g_l.g_a.u_l _752_/D _399_/ZN _750_/RN cfg_out[102] VDD VDD
+ VSS VSS gf180mcu_fd_sc_mcu7t5v0__latrnq_1
XFILLER_4_298 VDD VDD VSS VSS gf180mcu_fd_sc_mcu7t5v0__fill_1
X_669_ _477_/Z _486_/B _669_/A3 _724_/D VDD VDD VSS VSS gf180mcu_fd_sc_mcu7t5v0__nor3_1
X_738_ _738_/D wire15/Z _767_/CLK _738_/Q VDD VDD VSS VSS gf180mcu_fd_sc_mcu7t5v0__dffrnq_1
Xg_reg\[14\].g_bit\[4\].g_l.g_d.u_l _756_/D _412_/ZN input1/Z _584_/A1 VDD VDD VSS
+ VSS gf180mcu_fd_sc_mcu7t5v0__latrnq_1
XTAP_TAPCELL_ROW_27_197 VDD VSS gf180mcu_fd_sc_mcu7t5v0__filltie
X_385_ _385_/A1 _387_/A2 probe_sel_onehot[13] VDD VDD VSS VSS gf180mcu_fd_sc_mcu7t5v0__nor2_1
X_454_ _743_/Q _744_/Q _454_/Z VDD VDD VSS VSS gf180mcu_fd_sc_mcu7t5v0__xor2_1
X_523_ _684_/Q _522_/I _525_/B VDD VDD VSS VSS gf180mcu_fd_sc_mcu7t5v0__nor2_1
Xg_reg\[17\].g_bit\[7\].g_l.g_d.u_l _759_/D _405_/ZN _750_/RN _599_/A2 VDD VDD VSS
+ VSS gf180mcu_fd_sc_mcu7t5v0__latrnq_1
Xg_reg\[0\].g_bit\[6\].g_l.g_a.u_l _758_/D _428_/ZN load_slew18/Z cfg_out[6] VDD VDD
+ VSS VSS gf180mcu_fd_sc_mcu7t5v0__latrnq_1
XFILLER_7_2 VDD VDD VSS VSS gf180mcu_fd_sc_mcu7t5v0__fill_2
XFILLER_13_161 VDD VDD VSS VSS gf180mcu_fd_sc_mcu7t5v0__fillcap_4
X_368_ _364_/Z _385_/A1 probe_sel_onehot[1] VDD VDD VSS VSS gf180mcu_fd_sc_mcu7t5v0__nor2_1
X_437_ _642_/A2 _437_/A2 _613_/C _741_/D VDD VDD VSS VSS gf180mcu_fd_sc_mcu7t5v0__aoi21_1
X_506_ _687_/Q _541_/A1 _657_/B VDD VDD VSS VSS gf180mcu_fd_sc_mcu7t5v0__nand2_1
XFILLER_19_209 VDD VDD VSS VSS gf180mcu_fd_sc_mcu7t5v0__fill_1
XFILLER_22_27 VDD VDD VSS VSS gf180mcu_fd_sc_mcu7t5v0__fillcap_8
XPHY_EDGE_ROW_29_Right_29 VDD VSS gf180mcu_fd_sc_mcu7t5v0__endcap
XTAP_TAPCELL_ROW_29_204 VDD VSS gf180mcu_fd_sc_mcu7t5v0__filltie
XTAP_TAPCELL_ROW_6_113 VDD VSS gf180mcu_fd_sc_mcu7t5v0__filltie
XFILLER_33_278 VDD VDD VSS VSS gf180mcu_fd_sc_mcu7t5v0__fill_2
XPHY_EDGE_ROW_38_Right_38 VDD VSS gf180mcu_fd_sc_mcu7t5v0__endcap
XTAP_TAPCELL_ROW_12_137 VDD VSS gf180mcu_fd_sc_mcu7t5v0__filltie
XTAP_TAPCELL_ROW_20_170 VDD VSS gf180mcu_fd_sc_mcu7t5v0__filltie
XTAP_TAPCELL_ROW_35_229 VDD VSS gf180mcu_fd_sc_mcu7t5v0__filltie
XFILLER_31_6 VDD VDD VSS VSS gf180mcu_fd_sc_mcu7t5v0__fill_1
XFILLER_28_37 VDD VDD VSS VSS gf180mcu_fd_sc_mcu7t5v0__fillcap_8
XFILLER_22_2 VDD VDD VSS VSS gf180mcu_fd_sc_mcu7t5v0__fill_2
X_754_ _754_/D _757_/CLK _755_/D VDD VDD VSS VSS gf180mcu_fd_sc_mcu7t5v0__dffq_1
X_685_ _685_/D wire17/Z _768_/CLK _685_/Q VDD VDD VSS VSS gf180mcu_fd_sc_mcu7t5v0__dffrnq_1
XFILLER_14_28 VDD VDD VSS VSS gf180mcu_fd_sc_mcu7t5v0__fill_1
XFILLER_35_137 VDD VDD VSS VSS gf180mcu_fd_sc_mcu7t5v0__fill_2
X_470_ _470_/A1 _469_/Z _473_/B1 VDD VDD VSS VSS gf180mcu_fd_sc_mcu7t5v0__nor2_1
X_599_ _656_/A1 _599_/A2 _355_/Z _604_/B2 VDD VDD VSS VSS gf180mcu_fd_sc_mcu7t5v0__nor3_1
X_668_ _722_/Q _723_/Q _724_/Q _669_/A3 VDD VDD VSS VSS gf180mcu_fd_sc_mcu7t5v0__aoi21_1
X_737_ _737_/D wire15/Z _748_/CLK _737_/Q VDD VDD VSS VSS gf180mcu_fd_sc_mcu7t5v0__dffsnq_1
XFILLER_6_95 VDD VDD VSS VSS gf180mcu_fd_sc_mcu7t5v0__fillcap_4
XTAP_TAPCELL_ROW_27_198 VDD VSS gf180mcu_fd_sc_mcu7t5v0__filltie
X_384_ _365_/Z _387_/A2 probe_sel_onehot[12] VDD VDD VSS VSS gf180mcu_fd_sc_mcu7t5v0__nor2_1
X_453_ _763_/Q input4/Z _453_/S uio_out[7] VDD VDD VSS VSS gf180mcu_fd_sc_mcu7t5v0__mux2_2
X_522_ _522_/I _546_/A1 VDD VDD VSS VSS gf180mcu_fd_sc_mcu7t5v0__clkinv_1
Xclkbuf_0_u_lif.d_clk u_lif.u_cg.u_icg/Q clkbuf_0_u_lif.d_clk/Z VDD VDD VSS VSS gf180mcu_fd_sc_mcu7t5v0__clkbuf_4
XFILLER_16_170 VDD VDD VSS VSS gf180mcu_fd_sc_mcu7t5v0__fill_1
XTAP_TAPCELL_ROW_2_96 VDD VSS gf180mcu_fd_sc_mcu7t5v0__filltie
Xg_reg\[23\].g_bit\[1\].g_l.g_a.u_l _753_/D _396_/ZN _750_/RN cfg_out[119] VDD VDD
+ VSS VSS gf180mcu_fd_sc_mcu7t5v0__latrnq_1
XFILLER_36_37 VDD VDD VSS VSS gf180mcu_fd_sc_mcu7t5v0__fill_1
Xg_reg\[4\].g_bit\[0\].g_l.g_a.u_l _752_/D _424_/ZN load_slew18/Z cfg_out[32] VDD
+ VDD VSS VSS gf180mcu_fd_sc_mcu7t5v0__latrnq_1
Xg_reg\[7\].g_bit\[3\].g_l.g_a.u_l _755_/D _421_/ZN input1/Z cfg_out[57] VDD VDD VSS
+ VSS gf180mcu_fd_sc_mcu7t5v0__latrnq_1
XFILLER_13_195 VDD VDD VSS VSS gf180mcu_fd_sc_mcu7t5v0__fill_1
X_367_ _781_/I _371_/A2 _369_/A3 _385_/A1 VDD VDD VSS VSS gf180mcu_fd_sc_mcu7t5v0__nand3_1
X_436_ _741_/Q _438_/A2 _437_/A2 VDD VDD VSS VSS gf180mcu_fd_sc_mcu7t5v0__nand2_1
X_505_ _656_/A1 _615_/A1 _656_/B1 _593_/A1 _656_/C _507_/A2 VDD VDD VSS VSS gf180mcu_fd_sc_mcu7t5v0__oai221_1
XTAP_TAPCELL_ROW_29_205 VDD VSS gf180mcu_fd_sc_mcu7t5v0__filltie
XTAP_TAPCELL_ROW_6_114 VDD VSS gf180mcu_fd_sc_mcu7t5v0__filltie
Xwire14 wire17/Z wire14/Z VDD VDD VSS VSS gf180mcu_fd_sc_mcu7t5v0__buf_4
Xg_reg\[16\].g_bit\[5\].g_l.g_d.u_l _757_/D _406_/ZN load_slew18/Z _588_/A1 VDD VDD
+ VSS VSS gf180mcu_fd_sc_mcu7t5v0__latrnq_1
Xg_reg\[13\].g_bit\[2\].g_l.g_d.u_l _754_/D _414_/ZN _750_/RN _538_/A1 VDD VDD VSS
+ VSS gf180mcu_fd_sc_mcu7t5v0__latrnq_1
XFILLER_18_265 VDD VDD VSS VSS gf180mcu_fd_sc_mcu7t5v0__fill_1
XPHY_EDGE_ROW_25_Left_67 VDD VSS gf180mcu_fd_sc_mcu7t5v0__endcap
XTAP_TAPCELL_ROW_12_138 VDD VSS gf180mcu_fd_sc_mcu7t5v0__filltie
XTAP_TAPCELL_ROW_20_171 VDD VSS gf180mcu_fd_sc_mcu7t5v0__filltie
Xg_reg\[2\].g_bit\[7\].g_l.g_a.u_l _759_/D _426_/ZN load_slew18/Z cfg_out[23] VDD
+ VDD VSS VSS gf180mcu_fd_sc_mcu7t5v0__latrnq_1
X_419_ _420_/A1 _427_/A2 _419_/ZN VDD VDD VSS VSS gf180mcu_fd_sc_mcu7t5v0__nor2_1
XFILLER_30_227 VDD VDD VSS VSS gf180mcu_fd_sc_mcu7t5v0__fill_1
X_770_ _770_/D _770_/CLK _770_/Q VDD VDD VSS VSS gf180mcu_fd_sc_mcu7t5v0__dffq_1
XFILLER_12_216 VDD VDD VSS VSS gf180mcu_fd_sc_mcu7t5v0__fill_1
XFILLER_28_27 VDD VDD VSS VSS gf180mcu_fd_sc_mcu7t5v0__fillcap_8
XFILLER_7_220 VDD VDD VSS VSS gf180mcu_fd_sc_mcu7t5v0__fill_1
X_753_ _753_/D _757_/CLK _754_/D VDD VDD VSS VSS gf180mcu_fd_sc_mcu7t5v0__dffq_1
X_684_ _684_/D _750_/Q _750_/CLK _684_/Q VDD VDD VSS VSS gf180mcu_fd_sc_mcu7t5v0__dffrnq_1
XFILLER_15_2 VDD VDD VSS VSS gf180mcu_fd_sc_mcu7t5v0__fill_2
XPHY_EDGE_ROW_12_Left_54 VDD VSS gf180mcu_fd_sc_mcu7t5v0__endcap
XPHY_EDGE_ROW_28_Left_70 VDD VSS gf180mcu_fd_sc_mcu7t5v0__endcap
X_736_ _736_/D _736_/CLK _736_/Q VDD VDD VSS VSS gf180mcu_fd_sc_mcu7t5v0__dffq_1
XFILLER_26_127 VDD VDD VSS VSS gf180mcu_fd_sc_mcu7t5v0__fill_2
X_598_ _598_/A1 _706_/Q _607_/B VDD VDD VSS VSS gf180mcu_fd_sc_mcu7t5v0__and2_1
X_667_ _486_/B _666_/Z _723_/D VDD VDD VSS VSS gf180mcu_fd_sc_mcu7t5v0__nor2_1
XTAP_TAPCELL_ROW_27_199 VDD VSS gf180mcu_fd_sc_mcu7t5v0__filltie
X_383_ _324_/I _383_/A2 _387_/A2 VDD VDD VSS VSS gf180mcu_fd_sc_mcu7t5v0__nand2_1
X_452_ _768_/Q input3/Z _453_/S uio_out[6] VDD VDD VSS VSS gf180mcu_fd_sc_mcu7t5v0__mux2_2
X_521_ _741_/Q _521_/A2 _521_/B _522_/I VDD VDD VSS VSS gf180mcu_fd_sc_mcu7t5v0__aoi21_1
XFILLER_0_270 VDD VDD VSS VSS gf180mcu_fd_sc_mcu7t5v0__fill_2
XTAP_TAPCELL_ROW_2_97 VDD VSS gf180mcu_fd_sc_mcu7t5v0__filltie
X_719_ _719_/D _770_/CLK _719_/Q VDD VDD VSS VSS gf180mcu_fd_sc_mcu7t5v0__dffq_1
XFILLER_26_71 VDD VDD VSS VSS gf180mcu_fd_sc_mcu7t5v0__fill_2
XFILLER_7_4 VDD VDD VSS VSS gf180mcu_fd_sc_mcu7t5v0__fill_1
XTAP_TAPCELL_ROW_23_180 VDD VSS gf180mcu_fd_sc_mcu7t5v0__filltie
X_366_ _364_/Z _365_/Z probe_sel_onehot[0] VDD VDD VSS VSS gf180mcu_fd_sc_mcu7t5v0__nor2_1
X_435_ _739_/Q _435_/A2 _642_/A2 VDD VDD VSS VSS gf180mcu_fd_sc_mcu7t5v0__nand2_1
X_504_ _584_/A1 _656_/B1 _655_/B _504_/C _507_/A1 VDD VDD VSS VSS gf180mcu_fd_sc_mcu7t5v0__oai211_1
XFILLER_36_211 VDD VDD VSS VSS gf180mcu_fd_sc_mcu7t5v0__fill_1
XTAP_TAPCELL_ROW_6_115 VDD VSS gf180mcu_fd_sc_mcu7t5v0__filltie
Xwire15 wire15/I wire15/Z VDD VDD VSS VSS gf180mcu_fd_sc_mcu7t5v0__buf_4
XFILLER_10_177 VDD VDD VSS VSS gf180mcu_fd_sc_mcu7t5v0__fill_1
XFILLER_10_199 VDD VDD VSS VSS gf180mcu_fd_sc_mcu7t5v0__fill_2
XPHY_EDGE_ROW_0_Left_42 VDD VSS gf180mcu_fd_sc_mcu7t5v0__endcap
XTAP_TAPCELL_ROW_12_139 VDD VSS gf180mcu_fd_sc_mcu7t5v0__filltie
XTAP_TAPCELL_ROW_29_206 VDD VSS gf180mcu_fd_sc_mcu7t5v0__filltie
Xg_reg\[19\].g_bit\[5\].g_l.g_a.u_l _757_/D _403_/ZN _750_/RN cfg_out[91] VDD VDD
+ VSS VSS gf180mcu_fd_sc_mcu7t5v0__latrnq_1
XFILLER_18_244 VDD VDD VSS VSS gf180mcu_fd_sc_mcu7t5v0__fill_1
X_349_ _691_/Q _558_/A1 VDD VDD VSS VSS gf180mcu_fd_sc_mcu7t5v0__clkinv_1
X_418_ _420_/A1 _426_/A2 _418_/ZN VDD VDD VSS VSS gf180mcu_fd_sc_mcu7t5v0__nor2_1
Xg_reg\[6\].g_bit\[1\].g_l.g_a.u_l _753_/D _422_/ZN load_slew18/Z cfg_out[49] VDD
+ VDD VSS VSS gf180mcu_fd_sc_mcu7t5v0__latrnq_1
Xg_reg\[9\].g_bit\[4\].g_l.g_a.u_l _756_/D _419_/ZN input1/Z cfg_out[73] VDD VDD VSS
+ VSS gf180mcu_fd_sc_mcu7t5v0__latrnq_1
Xg_reg\[25\].g_bit\[2\].g_l.g_a.u_l _754_/D _391_/ZN _750_/RN cfg_out[136] VDD VDD
+ VSS VSS gf180mcu_fd_sc_mcu7t5v0__latrnq_1
XFILLER_0_43 VDD VDD VSS VSS gf180mcu_fd_sc_mcu7t5v0__fill_2
XFILLER_0_76 VDD VDD VSS VSS gf180mcu_fd_sc_mcu7t5v0__fillcap_4
XFILLER_23_291 VDD VDD VSS VSS gf180mcu_fd_sc_mcu7t5v0__fill_1
XFILLER_23_72 VDD VDD VSS VSS gf180mcu_fd_sc_mcu7t5v0__fillcap_16
XFILLER_2_173 VDD VDD VSS VSS gf180mcu_fd_sc_mcu7t5v0__fill_2
Xg_reg\[15\].g_bit\[3\].g_l.g_d.u_l _755_/D _410_/ZN input1/Z _652_/A2 VDD VDD VSS
+ VSS gf180mcu_fd_sc_mcu7t5v0__latrnq_1
Xg_reg\[12\].g_bit\[0\].g_l.g_d.u_l _752_/D _416_/ZN load_slew18/Z _483_/A2 VDD VDD
+ VSS VSS gf180mcu_fd_sc_mcu7t5v0__latrnq_1
XTAP_TAPCELL_ROW_31_212 VDD VSS gf180mcu_fd_sc_mcu7t5v0__filltie
Xg_reg\[20\].g_bit\[6\].g_l.g_a.u_l _758_/D _400_/ZN _750_/RN cfg_out[100] VDD VDD
+ VSS VSS gf180mcu_fd_sc_mcu7t5v0__latrnq_1
Xg_reg\[1\].g_bit\[5\].g_l.g_a.u_l _757_/D _427_/ZN load_slew18/Z cfg_out[13] VDD
+ VDD VSS VSS gf180mcu_fd_sc_mcu7t5v0__latrnq_1
X_752_ _752_/D _757_/CLK _753_/D VDD VDD VSS VSS gf180mcu_fd_sc_mcu7t5v0__dffq_1
X_683_ _486_/B _683_/A2 _731_/D VDD VDD VSS VSS gf180mcu_fd_sc_mcu7t5v0__nor2_1
XFILLER_22_4 VDD VDD VSS VSS gf180mcu_fd_sc_mcu7t5v0__fill_1
XFILLER_4_213 VDD VDD VSS VSS gf180mcu_fd_sc_mcu7t5v0__fill_2
XFILLER_35_139 VDD VDD VSS VSS gf180mcu_fd_sc_mcu7t5v0__fill_1
X_597_ _656_/A1 _597_/A2 _355_/Z _605_/C VDD VDD VSS VSS gf180mcu_fd_sc_mcu7t5v0__nor3_1
X_666_ _666_/A1 _723_/Q _666_/Z VDD VDD VSS VSS gf180mcu_fd_sc_mcu7t5v0__xor2_1
X_735_ _735_/D _766_/CLK _735_/Q VDD VDD VSS VSS gf180mcu_fd_sc_mcu7t5v0__dffq_1
XFILLER_25_18 VDD VDD VSS VSS gf180mcu_fd_sc_mcu7t5v0__fillcap_4
X_520_ _642_/A2 _635_/A2 _521_/B VDD VDD VSS VSS gf180mcu_fd_sc_mcu7t5v0__nand2_1
XFILLER_17_139 VDD VDD VSS VSS gf180mcu_fd_sc_mcu7t5v0__fill_1
XTAP_TAPCELL_ROW_2_98 VDD VSS gf180mcu_fd_sc_mcu7t5v0__filltie
X_382_ _387_/A1 _378_/Z probe_sel_onehot[11] VDD VDD VSS VSS gf180mcu_fd_sc_mcu7t5v0__nor2_1
X_451_ _738_/Q _519_/B _737_/D VDD VDD VSS VSS gf180mcu_fd_sc_mcu7t5v0__or2_1
X_649_ _603_/B _664_/A2 _662_/B2 VDD VDD VSS VSS gf180mcu_fd_sc_mcu7t5v0__nand2_1
X_718_ _718_/D _718_/CLK _718_/Q VDD VDD VSS VSS gf180mcu_fd_sc_mcu7t5v0__dffq_1
XFILLER_13_142 VDD VDD VSS VSS gf180mcu_fd_sc_mcu7t5v0__fill_2
XFILLER_22_153 VDD VDD VSS VSS gf180mcu_fd_sc_mcu7t5v0__fill_1
XTAP_TAPCELL_ROW_15_148 VDD VSS gf180mcu_fd_sc_mcu7t5v0__filltie
XTAP_TAPCELL_ROW_23_181 VDD VSS gf180mcu_fd_sc_mcu7t5v0__filltie
XTAP_TAPCELL_ROW_9_124 VDD VSS gf180mcu_fd_sc_mcu7t5v0__filltie
X_365_ _369_/A1 _371_/A2 _326_/I _365_/Z VDD VDD VSS VSS gf180mcu_fd_sc_mcu7t5v0__or3_1
X_434_ _613_/B2 _641_/A2 _434_/ZN VDD VDD VSS VSS gf180mcu_fd_sc_mcu7t5v0__nand2_1
X_503_ _684_/Q _589_/A1 _603_/B _504_/C VDD VDD VSS VSS gf180mcu_fd_sc_mcu7t5v0__nand3_1
XFILLER_10_123 VDD VDD VSS VSS gf180mcu_fd_sc_mcu7t5v0__fill_1
XTAP_TAPCELL_ROW_29_207 VDD VSS gf180mcu_fd_sc_mcu7t5v0__filltie
XFILLER_38_2 VDD VDD VSS VSS gf180mcu_fd_sc_mcu7t5v0__fill_1
XFILLER_5_2 VDD VDD VSS VSS gf180mcu_fd_sc_mcu7t5v0__fill_2
XPHY_EDGE_ROW_16_Right_16 VDD VSS gf180mcu_fd_sc_mcu7t5v0__endcap
XPHY_EDGE_ROW_25_Right_25 VDD VSS gf180mcu_fd_sc_mcu7t5v0__endcap
X_348_ _690_/Q _557_/A1 VDD VDD VSS VSS gf180mcu_fd_sc_mcu7t5v0__clkinv_1
X_417_ _420_/A1 _425_/A2 _417_/ZN VDD VDD VSS VSS gf180mcu_fd_sc_mcu7t5v0__nor2_1
XPHY_EDGE_ROW_34_Right_34 VDD VSS gf180mcu_fd_sc_mcu7t5v0__endcap
XTAP_TAPCELL_ROW_31_213 VDD VSS gf180mcu_fd_sc_mcu7t5v0__filltie
Xg_reg\[24\].g_bit\[0\].g_l.g_a.u_l _752_/D load_slew12/Z _750_/RN cfg_out[126] VDD
+ VDD VSS VSS gf180mcu_fd_sc_mcu7t5v0__latrnq_1
Xg_reg\[18\].g_bit\[3\].g_l.g_a.u_l _755_/D _404_/ZN _750_/RN cfg_out[81] VDD VDD
+ VSS VSS gf180mcu_fd_sc_mcu7t5v0__latrnq_1
X_751_ _751_/D _757_/CLK _752_/D VDD VDD VSS VSS gf180mcu_fd_sc_mcu7t5v0__dffq_1
X_682_ _731_/Q _481_/Z _683_/A2 VDD VDD VSS VSS gf180mcu_fd_sc_mcu7t5v0__xnor2_1
Xg_reg\[8\].g_bit\[2\].g_l.g_a.u_l _754_/D _420_/ZN input1/Z cfg_out[62] VDD VDD VSS
+ VSS gf180mcu_fd_sc_mcu7t5v0__latrnq_1
XPHY_EDGE_ROW_2_Right_2 VDD VSS gf180mcu_fd_sc_mcu7t5v0__endcap
XFILLER_4_247 VDD VDD VSS VSS gf180mcu_fd_sc_mcu7t5v0__fill_1
X_596_ _684_/Q _603_/B _596_/B _604_/A1 VDD VDD VSS VSS gf180mcu_fd_sc_mcu7t5v0__aoi21_1
X_665_ _722_/Q _486_/B _722_/D VDD VDD VSS VSS gf180mcu_fd_sc_mcu7t5v0__nor2_1
Xhold50 _762_/Q _763_/D VDD VDD VSS VSS gf180mcu_fd_sc_mcu7t5v0__dlyc_1
Xg_reg\[17\].g_bit\[4\].g_l.g_d.u_l _756_/D _405_/ZN _750_/RN _596_/B VDD VDD VSS
+ VSS gf180mcu_fd_sc_mcu7t5v0__latrnq_1
Xg_reg\[14\].g_bit\[1\].g_l.g_d.u_l _753_/D _412_/ZN input1/Z _337_/I VDD VDD VSS
+ VSS gf180mcu_fd_sc_mcu7t5v0__latrnq_1
Xg_reg\[10\].g_bit\[4\].g_l.g_a.u_l _756_/D _418_/ZN input1/Z cfg_out[66] VDD VDD
+ VSS VSS gf180mcu_fd_sc_mcu7t5v0__latrnq_1
X_734_ _734_/D _736_/CLK _734_/Q VDD VDD VSS VSS gf180mcu_fd_sc_mcu7t5v0__dffq_1
XFILLER_1_206 VDD VDD VSS VSS gf180mcu_fd_sc_mcu7t5v0__fillcap_4
XFILLER_20_2 VDD VDD VSS VSS gf180mcu_fd_sc_mcu7t5v0__fillcap_4
XFILLER_26_107 VDD VDD VSS VSS gf180mcu_fd_sc_mcu7t5v0__fill_1
Xg_reg\[3\].g_bit\[6\].g_l.g_a.u_l _758_/D _425_/ZN load_slew18/Z cfg_out[30] VDD
+ VDD VSS VSS gf180mcu_fd_sc_mcu7t5v0__latrnq_1
Xg_reg\[22\].g_bit\[7\].g_l.g_a.u_l _759_/D _398_/ZN _750_/RN cfg_out[117] VDD VDD
+ VSS VSS gf180mcu_fd_sc_mcu7t5v0__latrnq_1
Xg_reg\[0\].g_bit\[3\].g_l.g_a.u_l _755_/D _428_/ZN load_slew18/Z cfg_out[3] VDD VDD
+ VSS VSS gf180mcu_fd_sc_mcu7t5v0__latrnq_1
XTAP_TAPCELL_ROW_2_99 VDD VSS gf180mcu_fd_sc_mcu7t5v0__filltie
X_381_ _369_/Z _378_/Z probe_sel_onehot[10] VDD VDD VSS VSS gf180mcu_fd_sc_mcu7t5v0__nor2_1
X_450_ _633_/C _448_/Z _450_/A3 _519_/B VDD VDD VSS VSS gf180mcu_fd_sc_mcu7t5v0__nand3_1
XFILLER_39_298 VDD VDD VSS VSS gf180mcu_fd_sc_mcu7t5v0__fill_1
X_579_ _695_/Q _615_/B _580_/B VDD VDD VSS VSS gf180mcu_fd_sc_mcu7t5v0__nor2_1
X_648_ _648_/I0 _706_/Q _648_/S _706_/D VDD VDD VSS VSS gf180mcu_fd_sc_mcu7t5v0__mux2_2
X_717_ _717_/D _770_/CLK _717_/Q VDD VDD VSS VSS gf180mcu_fd_sc_mcu7t5v0__dffq_1
XTAP_TAPCELL_ROW_9_125 VDD VSS gf180mcu_fd_sc_mcu7t5v0__filltie
X_433_ _687_/Q _544_/A2 _739_/Q _641_/A2 VDD VDD VSS VSS gf180mcu_fd_sc_mcu7t5v0__oai21_1
X_502_ _685_/Q _603_/B _655_/B VDD VDD VSS VSS gf180mcu_fd_sc_mcu7t5v0__nand2_1
XTAP_TAPCELL_ROW_15_149 VDD VSS gf180mcu_fd_sc_mcu7t5v0__filltie
XTAP_TAPCELL_ROW_23_182 VDD VSS gf180mcu_fd_sc_mcu7t5v0__filltie
X_364_ _324_/I _383_/A2 _364_/Z VDD VDD VSS VSS gf180mcu_fd_sc_mcu7t5v0__or2_1
Xwire17 _750_/Q wire17/Z VDD VDD VSS VSS gf180mcu_fd_sc_mcu7t5v0__buf_4
XFILLER_27_279 VDD VDD VSS VSS gf180mcu_fd_sc_mcu7t5v0__fill_1
XFILLER_37_72 VDD VDD VSS VSS gf180mcu_fd_sc_mcu7t5v0__fill_1
X_347_ _689_/Q _556_/A1 VDD VDD VSS VSS gf180mcu_fd_sc_mcu7t5v0__clkinv_1
X_416_ _416_/A1 _428_/A2 _416_/ZN VDD VDD VSS VSS gf180mcu_fd_sc_mcu7t5v0__nor2_1
Xclkbuf_3_7__f_clk_regs clkbuf_0_clk_regs/Z _703_/CLK VDD VDD VSS VSS gf180mcu_fd_sc_mcu7t5v0__clkbuf_4
XFILLER_0_45 VDD VDD VSS VSS gf180mcu_fd_sc_mcu7t5v0__fill_1
XFILLER_9_87 VDD VDD VSS VSS gf180mcu_fd_sc_mcu7t5v0__fill_1
XTAP_TAPCELL_ROW_31_214 VDD VSS gf180mcu_fd_sc_mcu7t5v0__filltie
X_750_ _750_/D _750_/RN _750_/CLK _750_/Q VDD VDD VSS VSS gf180mcu_fd_sc_mcu7t5v0__dffrnq_2
X_749__21 _749_/D VDD VDD VSS VSS gf180mcu_fd_sc_mcu7t5v0__tieh
X_681_ _481_/Z _486_/B _681_/A3 _730_/D VDD VDD VSS VSS gf180mcu_fd_sc_mcu7t5v0__nor3_1
XFILLER_20_75 VDD VDD VSS VSS gf180mcu_fd_sc_mcu7t5v0__fillcap_8
X_595_ _615_/B _595_/A2 _595_/B _698_/D VDD VDD VSS VSS gf180mcu_fd_sc_mcu7t5v0__aoi21_1
X_664_ _638_/C _664_/A2 _664_/B1 _664_/B2 _708_/D VDD VDD VSS VSS gf180mcu_fd_sc_mcu7t5v0__aoi22_1
Xhold40 _719_/Q _718_/D VDD VDD VSS VSS gf180mcu_fd_sc_mcu7t5v0__dlyc_1
X_733_ _733_/D _736_/CLK _733_/Q VDD VDD VSS VSS gf180mcu_fd_sc_mcu7t5v0__dffq_1
XFILLER_13_2 VDD VDD VSS VSS gf180mcu_fd_sc_mcu7t5v0__fill_2
XFILLER_34_174 VDD VDD VSS VSS gf180mcu_fd_sc_mcu7t5v0__fill_1
XPHY_EDGE_ROW_16_Left_58 VDD VSS gf180mcu_fd_sc_mcu7t5v0__endcap
XFILLER_15_86 VDD VDD VSS VSS gf180mcu_fd_sc_mcu7t5v0__fill_2
X_380_ _385_/A1 _378_/Z probe_sel_onehot[9] VDD VDD VSS VSS gf180mcu_fd_sc_mcu7t5v0__nor2_1
Xg_reg\[7\].g_bit\[0\].g_l.g_a.u_l _752_/D _421_/ZN input1/Z cfg_out[54] VDD VDD VSS
+ VSS gf180mcu_fd_sc_mcu7t5v0__latrnq_1
XFILLER_0_262 VDD VDD VSS VSS gf180mcu_fd_sc_mcu7t5v0__fillcap_8
X_578_ _578_/A1 _613_/C _578_/B _580_/A2 VDD VDD VSS VSS gf180mcu_fd_sc_mcu7t5v0__aoi21_1
X_647_ _475_/B _647_/A2 _647_/B _648_/I0 VDD VDD VSS VSS gf180mcu_fd_sc_mcu7t5v0__oai21_1
X_716_ _716_/D _718_/CLK _716_/Q VDD VDD VSS VSS gf180mcu_fd_sc_mcu7t5v0__dffq_1
.ends
