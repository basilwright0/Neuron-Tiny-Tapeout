* trim_tau4: per-column leak-tau trim for the P slots (TE strip below the array; drives the aux column
* line, which in slot_ah_p is the gate of the leak OTA tail AND of the gap-trim ladder, in place of vbn_leak).
* Rev B (2026-11-20): referenced to vbn_leak / vss directly (B1 rev C exports no trim_ref_n / vg node).
* Self-contained (no bias_trim.spice dependency).
*
*   I_tail(P) = I_tail(S) * (8 + c)/16  (c = 0..15: 0.50x .. 1.44x, 1.00x at c = 8)
*   vbn_leak: B1's leak line, the gate of the rx_n4 master (4 x nfet 2/4 diodes on vss) that also biases every
*             S/H/F slot's leak tail (2/4). The trim mirrors it with L = 4 nfets on vss, i.e. the same device
*             type and length as the master and the tails:
*     XB0, XB1 (4/4 each, always on)   = 8 LSB
*     XU3a, XU3b (4/4 each, bit 3)      = 8 LSB,  XU2 4/4 (bit 2) = 4 LSB,  XU1 2/4 (bit 1) = 2 LSB,  XU0 1/4 (bit 0) = 1 LSB
*     -> I_d = (8 + c) * I(1/4) ~ (8 + c)/2 * I_tail(S).  SOURCE switches XS0..3 (0.5/0.5, unit source -> vss) on
*     c0..c3: an off branch is a two-high stack (its unit source floats up and cuts the unit off), so the
*     off-state leakage is far below that of a drain switch at Vds ~2.7 V (ff/85 C, pA-level codes).
*   XPD0..3 (4 x pfet 1/2 diode) : XPM (pfet 1/2, W trimmed) = 4 : 1, into the aux diode XNDa + XNDb (2 x 2/4 on vss,
*   each identical to the slot tail XMT), so I_tail(P) = I_d / 8 = (8 + c)/16 * I_tail(S).
*   XPM is narrowed to 0.83 um to cancel the systematic gain (~+17 % at W = 1) from the drain-voltage differences
*   (units at ~2.9 V vs the master diode at ~0.4 V, XPM at ~3 V vs XPD at ~0.4 V).
*   The gap trim in the P slot rides on aux too, so its mV/step does not change with the tau code.
*
* Ports: aux vbn_leak c0 c1 c2 c3 vdd vss
.subckt trim_tau4 aux vbn_leak c0 c1 c2 c3 vdd vss
XB0  d   vbn_leak vss vss nfet_03v3 W=4u L=4u
XB1  d   vbn_leak vss vss nfet_03v3 W=4u L=4u
XU0  d   vbn_leak s0 vss nfet_03v3 W=1u L=4u
XS0  s0  c0 vss vss nfet_03v3 W=0.5u L=0.5u
XU1  d   vbn_leak s1 vss nfet_03v3 W=2u L=4u
XS1  s1  c1 vss vss nfet_03v3 W=0.5u L=0.5u
XU2  d   vbn_leak s2 vss nfet_03v3 W=4u L=4u
XS2  s2  c2 vss vss nfet_03v3 W=0.5u L=0.5u
XU3a d   vbn_leak s3 vss nfet_03v3 W=4u L=4u
XU3b d   vbn_leak s3 vss nfet_03v3 W=4u L=4u
XS3  s3  c3 vss vss nfet_03v3 W=0.5u L=0.5u
XPD0 d   d   vdd vdd pfet_03v3 W=1u L=2u
XPD1 d   d   vdd vdd pfet_03v3 W=1u L=2u
XPD2 d   d   vdd vdd pfet_03v3 W=1u L=2u
XPD3 d   d   vdd vdd pfet_03v3 W=1u L=2u
XPM  aux d   vdd vdd pfet_03v3 W=0.83u L=2u
XNDa aux aux vss vss nfet_03v3 W=2u L=4u
XNDb aux aux vss vss nfet_03v3 W=2u L=4u
.ends trim_tau4
