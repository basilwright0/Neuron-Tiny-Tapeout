* bias_rangegen: two Bult-Geelen MOS R-2R ladders + range diodes (block B1)
* n-ladder (gates at vgln) halves the in_n current 19 times; shunts at nodes
* 3,6,..,18 feed 8-unit pfet diodes (drain-boosted by a source follower) -> p gate
* lines vgp0..5 (source vsp).  p-ladder (gates at vglp) does the same for in_p ->
* nfet diodes + followers -> vgn0..5 (source vsn).
* Diode current D_r = I_in/16/8^r ; idac LSB = D_r/8 = I_in/128/8^r.
* Ports:
*  in_n in_p        : ladder inputs (from bias_master)
*  vgn0..vgn5       : n gate lines (ranges 0..5, x8 steps), referenced to vsn
*  vgp0..vgp5       : p gate lines, referenced to vsp
*  vsn vsp          : shifted-source rails (from bias_rails)
*  vgln vglp        : ladder gate biases (from bias_rails)
*  vdd vss
.subckt bias_rangegen in_n in_p vgn0 vgn1 vgn2 vgn3 vgn4 vgn5 vgp0 vgp1 vgp2 vgp3 vgp4 vgp5 vsn vsp vgln vglp vdd vss
XnnSH0 vdd vgln in_n vss nfet_03v3 W=2u L=2u ad=1.2p as=1.2p pd=5.2u ps=5.2u
XnnSE0_0 nn1 vgln in_n vss nfet_03v3 W=2u L=2u ad=1.2p as=1.2p pd=5.2u ps=5.2u
XnnSE0_1 nn1 vgln in_n vss nfet_03v3 W=2u L=2u ad=1.2p as=1.2p pd=5.2u ps=5.2u
XnnSH1 vdd vgln nn1 vss nfet_03v3 W=2u L=2u ad=1.2p as=1.2p pd=5.2u ps=5.2u
XnnSE1_0 nn2 vgln nn1 vss nfet_03v3 W=2u L=2u ad=1.2p as=1.2p pd=5.2u ps=5.2u
XnnSE1_1 nn2 vgln nn1 vss nfet_03v3 W=2u L=2u ad=1.2p as=1.2p pd=5.2u ps=5.2u
XnnSH2 vdd vgln nn2 vss nfet_03v3 W=2u L=2u ad=1.2p as=1.2p pd=5.2u ps=5.2u
XnnSE2_0 nn3 vgln nn2 vss nfet_03v3 W=2u L=2u ad=1.2p as=1.2p pd=5.2u ps=5.2u
XnnSE2_1 nn3 vgln nn2 vss nfet_03v3 W=2u L=2u ad=1.2p as=1.2p pd=5.2u ps=5.2u
XnnSH3 xp0 vgln nn3 vss nfet_03v3 W=2u L=2u ad=1.2p as=1.2p pd=5.2u ps=5.2u
XnnSE3_0 nn4 vgln nn3 vss nfet_03v3 W=2u L=2u ad=1.2p as=1.2p pd=5.2u ps=5.2u
XnnSE3_1 nn4 vgln nn3 vss nfet_03v3 W=2u L=2u ad=1.2p as=1.2p pd=5.2u ps=5.2u
XnnSH4 vdd vgln nn4 vss nfet_03v3 W=2u L=2u ad=1.2p as=1.2p pd=5.2u ps=5.2u
XnnSE4_0 nn5 vgln nn4 vss nfet_03v3 W=2u L=2u ad=1.2p as=1.2p pd=5.2u ps=5.2u
XnnSE4_1 nn5 vgln nn4 vss nfet_03v3 W=2u L=2u ad=1.2p as=1.2p pd=5.2u ps=5.2u
XnnSH5 vdd vgln nn5 vss nfet_03v3 W=2u L=2u ad=1.2p as=1.2p pd=5.2u ps=5.2u
XnnSE5_0 nn6 vgln nn5 vss nfet_03v3 W=2u L=2u ad=1.2p as=1.2p pd=5.2u ps=5.2u
XnnSE5_1 nn6 vgln nn5 vss nfet_03v3 W=2u L=2u ad=1.2p as=1.2p pd=5.2u ps=5.2u
XnnSH6 xp1 vgln nn6 vss nfet_03v3 W=2u L=2u ad=1.2p as=1.2p pd=5.2u ps=5.2u
XnnSE6_0 nn7 vgln nn6 vss nfet_03v3 W=2u L=2u ad=1.2p as=1.2p pd=5.2u ps=5.2u
XnnSE6_1 nn7 vgln nn6 vss nfet_03v3 W=2u L=2u ad=1.2p as=1.2p pd=5.2u ps=5.2u
XnnSH7 vdd vgln nn7 vss nfet_03v3 W=2u L=2u ad=1.2p as=1.2p pd=5.2u ps=5.2u
XnnSE7_0 nn8 vgln nn7 vss nfet_03v3 W=2u L=2u ad=1.2p as=1.2p pd=5.2u ps=5.2u
XnnSE7_1 nn8 vgln nn7 vss nfet_03v3 W=2u L=2u ad=1.2p as=1.2p pd=5.2u ps=5.2u
XnnSH8 vdd vgln nn8 vss nfet_03v3 W=2u L=2u ad=1.2p as=1.2p pd=5.2u ps=5.2u
XnnSE8_0 nn9 vgln nn8 vss nfet_03v3 W=2u L=2u ad=1.2p as=1.2p pd=5.2u ps=5.2u
XnnSE8_1 nn9 vgln nn8 vss nfet_03v3 W=2u L=2u ad=1.2p as=1.2p pd=5.2u ps=5.2u
XnnSH9 xp2 vgln nn9 vss nfet_03v3 W=2u L=2u ad=1.2p as=1.2p pd=5.2u ps=5.2u
XnnSE9_0 nn10 vgln nn9 vss nfet_03v3 W=2u L=2u ad=1.2p as=1.2p pd=5.2u ps=5.2u
XnnSE9_1 nn10 vgln nn9 vss nfet_03v3 W=2u L=2u ad=1.2p as=1.2p pd=5.2u ps=5.2u
XnnSH10 vdd vgln nn10 vss nfet_03v3 W=2u L=2u ad=1.2p as=1.2p pd=5.2u ps=5.2u
XnnSE10_0 nn11 vgln nn10 vss nfet_03v3 W=2u L=2u ad=1.2p as=1.2p pd=5.2u ps=5.2u
XnnSE10_1 nn11 vgln nn10 vss nfet_03v3 W=2u L=2u ad=1.2p as=1.2p pd=5.2u ps=5.2u
XnnSH11 vdd vgln nn11 vss nfet_03v3 W=2u L=2u ad=1.2p as=1.2p pd=5.2u ps=5.2u
XnnSE11_0 nn12 vgln nn11 vss nfet_03v3 W=2u L=2u ad=1.2p as=1.2p pd=5.2u ps=5.2u
XnnSE11_1 nn12 vgln nn11 vss nfet_03v3 W=2u L=2u ad=1.2p as=1.2p pd=5.2u ps=5.2u
XnnSH12 xp3 vgln nn12 vss nfet_03v3 W=2u L=2u ad=1.2p as=1.2p pd=5.2u ps=5.2u
XnnSE12_0 nn13 vgln nn12 vss nfet_03v3 W=2u L=2u ad=1.2p as=1.2p pd=5.2u ps=5.2u
XnnSE12_1 nn13 vgln nn12 vss nfet_03v3 W=2u L=2u ad=1.2p as=1.2p pd=5.2u ps=5.2u
XnnSH13 vdd vgln nn13 vss nfet_03v3 W=2u L=2u ad=1.2p as=1.2p pd=5.2u ps=5.2u
XnnSE13_0 nn14 vgln nn13 vss nfet_03v3 W=2u L=2u ad=1.2p as=1.2p pd=5.2u ps=5.2u
XnnSE13_1 nn14 vgln nn13 vss nfet_03v3 W=2u L=2u ad=1.2p as=1.2p pd=5.2u ps=5.2u
XnnSH14 vdd vgln nn14 vss nfet_03v3 W=2u L=2u ad=1.2p as=1.2p pd=5.2u ps=5.2u
XnnSE14_0 nn15 vgln nn14 vss nfet_03v3 W=2u L=2u ad=1.2p as=1.2p pd=5.2u ps=5.2u
XnnSE14_1 nn15 vgln nn14 vss nfet_03v3 W=2u L=2u ad=1.2p as=1.2p pd=5.2u ps=5.2u
XnnSH15 xp4 vgln nn15 vss nfet_03v3 W=2u L=2u ad=1.2p as=1.2p pd=5.2u ps=5.2u
XnnSE15_0 nn16 vgln nn15 vss nfet_03v3 W=2u L=2u ad=1.2p as=1.2p pd=5.2u ps=5.2u
XnnSE15_1 nn16 vgln nn15 vss nfet_03v3 W=2u L=2u ad=1.2p as=1.2p pd=5.2u ps=5.2u
XnnSH16 vdd vgln nn16 vss nfet_03v3 W=2u L=2u ad=1.2p as=1.2p pd=5.2u ps=5.2u
XnnSE16_0 nn17 vgln nn16 vss nfet_03v3 W=2u L=2u ad=1.2p as=1.2p pd=5.2u ps=5.2u
XnnSE16_1 nn17 vgln nn16 vss nfet_03v3 W=2u L=2u ad=1.2p as=1.2p pd=5.2u ps=5.2u
XnnSH17 vdd vgln nn17 vss nfet_03v3 W=2u L=2u ad=1.2p as=1.2p pd=5.2u ps=5.2u
XnnSE17_0 nn18 vgln nn17 vss nfet_03v3 W=2u L=2u ad=1.2p as=1.2p pd=5.2u ps=5.2u
XnnSE17_1 nn18 vgln nn17 vss nfet_03v3 W=2u L=2u ad=1.2p as=1.2p pd=5.2u ps=5.2u
XnnSH18 xp5 vgln nn18 vss nfet_03v3 W=2u L=2u ad=1.2p as=1.2p pd=5.2u ps=5.2u
XnnTERM vdd vgln nn18 vss nfet_03v3 W=2u L=2u ad=1.2p as=1.2p pd=5.2u ps=5.2u
XnpSH0 vss vglp in_p vdd pfet_03v3 W=2u L=2u ad=1.2p as=1.2p pd=5.2u ps=5.2u
XnpSE0_0 np1 vglp in_p vdd pfet_03v3 W=2u L=2u ad=1.2p as=1.2p pd=5.2u ps=5.2u
XnpSE0_1 np1 vglp in_p vdd pfet_03v3 W=2u L=2u ad=1.2p as=1.2p pd=5.2u ps=5.2u
XnpSH1 vss vglp np1 vdd pfet_03v3 W=2u L=2u ad=1.2p as=1.2p pd=5.2u ps=5.2u
XnpSE1_0 np2 vglp np1 vdd pfet_03v3 W=2u L=2u ad=1.2p as=1.2p pd=5.2u ps=5.2u
XnpSE1_1 np2 vglp np1 vdd pfet_03v3 W=2u L=2u ad=1.2p as=1.2p pd=5.2u ps=5.2u
XnpSH2 vss vglp np2 vdd pfet_03v3 W=2u L=2u ad=1.2p as=1.2p pd=5.2u ps=5.2u
XnpSE2_0 np3 vglp np2 vdd pfet_03v3 W=2u L=2u ad=1.2p as=1.2p pd=5.2u ps=5.2u
XnpSE2_1 np3 vglp np2 vdd pfet_03v3 W=2u L=2u ad=1.2p as=1.2p pd=5.2u ps=5.2u
XnpSH3 xn0 vglp np3 vdd pfet_03v3 W=2u L=2u ad=1.2p as=1.2p pd=5.2u ps=5.2u
XnpSE3_0 np4 vglp np3 vdd pfet_03v3 W=2u L=2u ad=1.2p as=1.2p pd=5.2u ps=5.2u
XnpSE3_1 np4 vglp np3 vdd pfet_03v3 W=2u L=2u ad=1.2p as=1.2p pd=5.2u ps=5.2u
XnpSH4 vss vglp np4 vdd pfet_03v3 W=2u L=2u ad=1.2p as=1.2p pd=5.2u ps=5.2u
XnpSE4_0 np5 vglp np4 vdd pfet_03v3 W=2u L=2u ad=1.2p as=1.2p pd=5.2u ps=5.2u
XnpSE4_1 np5 vglp np4 vdd pfet_03v3 W=2u L=2u ad=1.2p as=1.2p pd=5.2u ps=5.2u
XnpSH5 vss vglp np5 vdd pfet_03v3 W=2u L=2u ad=1.2p as=1.2p pd=5.2u ps=5.2u
XnpSE5_0 np6 vglp np5 vdd pfet_03v3 W=2u L=2u ad=1.2p as=1.2p pd=5.2u ps=5.2u
XnpSE5_1 np6 vglp np5 vdd pfet_03v3 W=2u L=2u ad=1.2p as=1.2p pd=5.2u ps=5.2u
XnpSH6 xn1 vglp np6 vdd pfet_03v3 W=2u L=2u ad=1.2p as=1.2p pd=5.2u ps=5.2u
XnpSE6_0 np7 vglp np6 vdd pfet_03v3 W=2u L=2u ad=1.2p as=1.2p pd=5.2u ps=5.2u
XnpSE6_1 np7 vglp np6 vdd pfet_03v3 W=2u L=2u ad=1.2p as=1.2p pd=5.2u ps=5.2u
XnpSH7 vss vglp np7 vdd pfet_03v3 W=2u L=2u ad=1.2p as=1.2p pd=5.2u ps=5.2u
XnpSE7_0 np8 vglp np7 vdd pfet_03v3 W=2u L=2u ad=1.2p as=1.2p pd=5.2u ps=5.2u
XnpSE7_1 np8 vglp np7 vdd pfet_03v3 W=2u L=2u ad=1.2p as=1.2p pd=5.2u ps=5.2u
XnpSH8 vss vglp np8 vdd pfet_03v3 W=2u L=2u ad=1.2p as=1.2p pd=5.2u ps=5.2u
XnpSE8_0 np9 vglp np8 vdd pfet_03v3 W=2u L=2u ad=1.2p as=1.2p pd=5.2u ps=5.2u
XnpSE8_1 np9 vglp np8 vdd pfet_03v3 W=2u L=2u ad=1.2p as=1.2p pd=5.2u ps=5.2u
XnpSH9 xn2 vglp np9 vdd pfet_03v3 W=2u L=2u ad=1.2p as=1.2p pd=5.2u ps=5.2u
XnpSE9_0 np10 vglp np9 vdd pfet_03v3 W=2u L=2u ad=1.2p as=1.2p pd=5.2u ps=5.2u
XnpSE9_1 np10 vglp np9 vdd pfet_03v3 W=2u L=2u ad=1.2p as=1.2p pd=5.2u ps=5.2u
XnpSH10 vss vglp np10 vdd pfet_03v3 W=2u L=2u ad=1.2p as=1.2p pd=5.2u ps=5.2u
XnpSE10_0 np11 vglp np10 vdd pfet_03v3 W=2u L=2u ad=1.2p as=1.2p pd=5.2u ps=5.2u
XnpSE10_1 np11 vglp np10 vdd pfet_03v3 W=2u L=2u ad=1.2p as=1.2p pd=5.2u ps=5.2u
XnpSH11 vss vglp np11 vdd pfet_03v3 W=2u L=2u ad=1.2p as=1.2p pd=5.2u ps=5.2u
XnpSE11_0 np12 vglp np11 vdd pfet_03v3 W=2u L=2u ad=1.2p as=1.2p pd=5.2u ps=5.2u
XnpSE11_1 np12 vglp np11 vdd pfet_03v3 W=2u L=2u ad=1.2p as=1.2p pd=5.2u ps=5.2u
XnpSH12 xn3 vglp np12 vdd pfet_03v3 W=2u L=2u ad=1.2p as=1.2p pd=5.2u ps=5.2u
XnpSE12_0 np13 vglp np12 vdd pfet_03v3 W=2u L=2u ad=1.2p as=1.2p pd=5.2u ps=5.2u
XnpSE12_1 np13 vglp np12 vdd pfet_03v3 W=2u L=2u ad=1.2p as=1.2p pd=5.2u ps=5.2u
XnpSH13 vss vglp np13 vdd pfet_03v3 W=2u L=2u ad=1.2p as=1.2p pd=5.2u ps=5.2u
XnpSE13_0 np14 vglp np13 vdd pfet_03v3 W=2u L=2u ad=1.2p as=1.2p pd=5.2u ps=5.2u
XnpSE13_1 np14 vglp np13 vdd pfet_03v3 W=2u L=2u ad=1.2p as=1.2p pd=5.2u ps=5.2u
XnpSH14 vss vglp np14 vdd pfet_03v3 W=2u L=2u ad=1.2p as=1.2p pd=5.2u ps=5.2u
XnpSE14_0 np15 vglp np14 vdd pfet_03v3 W=2u L=2u ad=1.2p as=1.2p pd=5.2u ps=5.2u
XnpSE14_1 np15 vglp np14 vdd pfet_03v3 W=2u L=2u ad=1.2p as=1.2p pd=5.2u ps=5.2u
XnpSH15 xn4 vglp np15 vdd pfet_03v3 W=2u L=2u ad=1.2p as=1.2p pd=5.2u ps=5.2u
XnpSE15_0 np16 vglp np15 vdd pfet_03v3 W=2u L=2u ad=1.2p as=1.2p pd=5.2u ps=5.2u
XnpSE15_1 np16 vglp np15 vdd pfet_03v3 W=2u L=2u ad=1.2p as=1.2p pd=5.2u ps=5.2u
XnpSH16 vss vglp np16 vdd pfet_03v3 W=2u L=2u ad=1.2p as=1.2p pd=5.2u ps=5.2u
XnpSE16_0 np17 vglp np16 vdd pfet_03v3 W=2u L=2u ad=1.2p as=1.2p pd=5.2u ps=5.2u
XnpSE16_1 np17 vglp np16 vdd pfet_03v3 W=2u L=2u ad=1.2p as=1.2p pd=5.2u ps=5.2u
XnpSH17 vss vglp np17 vdd pfet_03v3 W=2u L=2u ad=1.2p as=1.2p pd=5.2u ps=5.2u
XnpSE17_0 np18 vglp np17 vdd pfet_03v3 W=2u L=2u ad=1.2p as=1.2p pd=5.2u ps=5.2u
XnpSE17_1 np18 vglp np17 vdd pfet_03v3 W=2u L=2u ad=1.2p as=1.2p pd=5.2u ps=5.2u
XnpSH18 xn5 vglp np18 vdd pfet_03v3 W=2u L=2u ad=1.2p as=1.2p pd=5.2u ps=5.2u
XnpTERM vss vglp np18 vdd pfet_03v3 W=2u L=2u ad=1.2p as=1.2p pd=5.2u ps=5.2u
XDP0_0 xp0 vgp0 vsp vdd pfet_03v3 W=2u L=2u ad=1.2p as=1.2p pd=5.2u ps=5.2u
XDN0_0 xn0 vgn0 vsn vss nfet_03v3 W=2u L=2u ad=1.2p as=1.2p pd=5.2u ps=5.2u
XDP0_1 xp0 vgp0 vsp vdd pfet_03v3 W=2u L=2u ad=1.2p as=1.2p pd=5.2u ps=5.2u
XDN0_1 xn0 vgn0 vsn vss nfet_03v3 W=2u L=2u ad=1.2p as=1.2p pd=5.2u ps=5.2u
XDP0_2 xp0 vgp0 vsp vdd pfet_03v3 W=2u L=2u ad=1.2p as=1.2p pd=5.2u ps=5.2u
XDN0_2 xn0 vgn0 vsn vss nfet_03v3 W=2u L=2u ad=1.2p as=1.2p pd=5.2u ps=5.2u
XDP0_3 xp0 vgp0 vsp vdd pfet_03v3 W=2u L=2u ad=1.2p as=1.2p pd=5.2u ps=5.2u
XDN0_3 xn0 vgn0 vsn vss nfet_03v3 W=2u L=2u ad=1.2p as=1.2p pd=5.2u ps=5.2u
XDP0_4 xp0 vgp0 vsp vdd pfet_03v3 W=2u L=2u ad=1.2p as=1.2p pd=5.2u ps=5.2u
XDN0_4 xn0 vgn0 vsn vss nfet_03v3 W=2u L=2u ad=1.2p as=1.2p pd=5.2u ps=5.2u
XDP0_5 xp0 vgp0 vsp vdd pfet_03v3 W=2u L=2u ad=1.2p as=1.2p pd=5.2u ps=5.2u
XDN0_5 xn0 vgn0 vsn vss nfet_03v3 W=2u L=2u ad=1.2p as=1.2p pd=5.2u ps=5.2u
XDP0_6 xp0 vgp0 vsp vdd pfet_03v3 W=2u L=2u ad=1.2p as=1.2p pd=5.2u ps=5.2u
XDN0_6 xn0 vgn0 vsn vss nfet_03v3 W=2u L=2u ad=1.2p as=1.2p pd=5.2u ps=5.2u
XDP0_7 xp0 vgp0 vsp vdd pfet_03v3 W=2u L=2u ad=1.2p as=1.2p pd=5.2u ps=5.2u
XDN0_7 xn0 vgn0 vsn vss nfet_03v3 W=2u L=2u ad=1.2p as=1.2p pd=5.2u ps=5.2u
XFN0 vdd xn0 vgn0 vss nfet_03v3 W=2u L=1u ad=1.2p as=1.2p pd=5.2u ps=5.2u
XBN0 vgn0 vgn4 vss vss nfet_03v3 W=2u L=2u ad=1.2p as=1.2p pd=5.2u ps=5.2u
XFP0 vss xp0 vgp0 vgp0 pfet_03v3 W=2u L=1u ad=1.2p as=1.2p pd=5.2u ps=5.2u
XBP0 vgp0 vgp4 vdd vdd pfet_03v3 W=2u L=2u ad=1.2p as=1.2p pd=5.2u ps=5.2u
XDP1_0 xp1 vgp1 vsp vdd pfet_03v3 W=2u L=2u ad=1.2p as=1.2p pd=5.2u ps=5.2u
XDN1_0 xn1 vgn1 vsn vss nfet_03v3 W=2u L=2u ad=1.2p as=1.2p pd=5.2u ps=5.2u
XDP1_1 xp1 vgp1 vsp vdd pfet_03v3 W=2u L=2u ad=1.2p as=1.2p pd=5.2u ps=5.2u
XDN1_1 xn1 vgn1 vsn vss nfet_03v3 W=2u L=2u ad=1.2p as=1.2p pd=5.2u ps=5.2u
XDP1_2 xp1 vgp1 vsp vdd pfet_03v3 W=2u L=2u ad=1.2p as=1.2p pd=5.2u ps=5.2u
XDN1_2 xn1 vgn1 vsn vss nfet_03v3 W=2u L=2u ad=1.2p as=1.2p pd=5.2u ps=5.2u
XDP1_3 xp1 vgp1 vsp vdd pfet_03v3 W=2u L=2u ad=1.2p as=1.2p pd=5.2u ps=5.2u
XDN1_3 xn1 vgn1 vsn vss nfet_03v3 W=2u L=2u ad=1.2p as=1.2p pd=5.2u ps=5.2u
XDP1_4 xp1 vgp1 vsp vdd pfet_03v3 W=2u L=2u ad=1.2p as=1.2p pd=5.2u ps=5.2u
XDN1_4 xn1 vgn1 vsn vss nfet_03v3 W=2u L=2u ad=1.2p as=1.2p pd=5.2u ps=5.2u
XDP1_5 xp1 vgp1 vsp vdd pfet_03v3 W=2u L=2u ad=1.2p as=1.2p pd=5.2u ps=5.2u
XDN1_5 xn1 vgn1 vsn vss nfet_03v3 W=2u L=2u ad=1.2p as=1.2p pd=5.2u ps=5.2u
XDP1_6 xp1 vgp1 vsp vdd pfet_03v3 W=2u L=2u ad=1.2p as=1.2p pd=5.2u ps=5.2u
XDN1_6 xn1 vgn1 vsn vss nfet_03v3 W=2u L=2u ad=1.2p as=1.2p pd=5.2u ps=5.2u
XDP1_7 xp1 vgp1 vsp vdd pfet_03v3 W=2u L=2u ad=1.2p as=1.2p pd=5.2u ps=5.2u
XDN1_7 xn1 vgn1 vsn vss nfet_03v3 W=2u L=2u ad=1.2p as=1.2p pd=5.2u ps=5.2u
XFN1 vdd xn1 vgn1 vss nfet_03v3 W=2u L=1u ad=1.2p as=1.2p pd=5.2u ps=5.2u
XBN1 vgn1 vgn4 vss vss nfet_03v3 W=2u L=2u ad=1.2p as=1.2p pd=5.2u ps=5.2u
XFP1 vss xp1 vgp1 vgp1 pfet_03v3 W=2u L=1u ad=1.2p as=1.2p pd=5.2u ps=5.2u
XBP1 vgp1 vgp4 vdd vdd pfet_03v3 W=2u L=2u ad=1.2p as=1.2p pd=5.2u ps=5.2u
XDP2_0 xp2 vgp2 vsp vdd pfet_03v3 W=2u L=2u ad=1.2p as=1.2p pd=5.2u ps=5.2u
XDN2_0 xn2 vgn2 vsn vss nfet_03v3 W=2u L=2u ad=1.2p as=1.2p pd=5.2u ps=5.2u
XDP2_1 xp2 vgp2 vsp vdd pfet_03v3 W=2u L=2u ad=1.2p as=1.2p pd=5.2u ps=5.2u
XDN2_1 xn2 vgn2 vsn vss nfet_03v3 W=2u L=2u ad=1.2p as=1.2p pd=5.2u ps=5.2u
XDP2_2 xp2 vgp2 vsp vdd pfet_03v3 W=2u L=2u ad=1.2p as=1.2p pd=5.2u ps=5.2u
XDN2_2 xn2 vgn2 vsn vss nfet_03v3 W=2u L=2u ad=1.2p as=1.2p pd=5.2u ps=5.2u
XDP2_3 xp2 vgp2 vsp vdd pfet_03v3 W=2u L=2u ad=1.2p as=1.2p pd=5.2u ps=5.2u
XDN2_3 xn2 vgn2 vsn vss nfet_03v3 W=2u L=2u ad=1.2p as=1.2p pd=5.2u ps=5.2u
XDP2_4 xp2 vgp2 vsp vdd pfet_03v3 W=2u L=2u ad=1.2p as=1.2p pd=5.2u ps=5.2u
XDN2_4 xn2 vgn2 vsn vss nfet_03v3 W=2u L=2u ad=1.2p as=1.2p pd=5.2u ps=5.2u
XDP2_5 xp2 vgp2 vsp vdd pfet_03v3 W=2u L=2u ad=1.2p as=1.2p pd=5.2u ps=5.2u
XDN2_5 xn2 vgn2 vsn vss nfet_03v3 W=2u L=2u ad=1.2p as=1.2p pd=5.2u ps=5.2u
XDP2_6 xp2 vgp2 vsp vdd pfet_03v3 W=2u L=2u ad=1.2p as=1.2p pd=5.2u ps=5.2u
XDN2_6 xn2 vgn2 vsn vss nfet_03v3 W=2u L=2u ad=1.2p as=1.2p pd=5.2u ps=5.2u
XDP2_7 xp2 vgp2 vsp vdd pfet_03v3 W=2u L=2u ad=1.2p as=1.2p pd=5.2u ps=5.2u
XDN2_7 xn2 vgn2 vsn vss nfet_03v3 W=2u L=2u ad=1.2p as=1.2p pd=5.2u ps=5.2u
XFN2 vdd xn2 vgn2 vss nfet_03v3 W=2u L=1u ad=1.2p as=1.2p pd=5.2u ps=5.2u
XBN2 vgn2 vgn4 vss vss nfet_03v3 W=2u L=2u ad=1.2p as=1.2p pd=5.2u ps=5.2u
XFP2 vss xp2 vgp2 vgp2 pfet_03v3 W=2u L=1u ad=1.2p as=1.2p pd=5.2u ps=5.2u
XBP2 vgp2 vgp4 vdd vdd pfet_03v3 W=2u L=2u ad=1.2p as=1.2p pd=5.2u ps=5.2u
XDP3_0 xp3 vgp3 vsp vdd pfet_03v3 W=2u L=2u ad=1.2p as=1.2p pd=5.2u ps=5.2u
XDN3_0 xn3 vgn3 vsn vss nfet_03v3 W=2u L=2u ad=1.2p as=1.2p pd=5.2u ps=5.2u
XDP3_1 xp3 vgp3 vsp vdd pfet_03v3 W=2u L=2u ad=1.2p as=1.2p pd=5.2u ps=5.2u
XDN3_1 xn3 vgn3 vsn vss nfet_03v3 W=2u L=2u ad=1.2p as=1.2p pd=5.2u ps=5.2u
XDP3_2 xp3 vgp3 vsp vdd pfet_03v3 W=2u L=2u ad=1.2p as=1.2p pd=5.2u ps=5.2u
XDN3_2 xn3 vgn3 vsn vss nfet_03v3 W=2u L=2u ad=1.2p as=1.2p pd=5.2u ps=5.2u
XDP3_3 xp3 vgp3 vsp vdd pfet_03v3 W=2u L=2u ad=1.2p as=1.2p pd=5.2u ps=5.2u
XDN3_3 xn3 vgn3 vsn vss nfet_03v3 W=2u L=2u ad=1.2p as=1.2p pd=5.2u ps=5.2u
XDP3_4 xp3 vgp3 vsp vdd pfet_03v3 W=2u L=2u ad=1.2p as=1.2p pd=5.2u ps=5.2u
XDN3_4 xn3 vgn3 vsn vss nfet_03v3 W=2u L=2u ad=1.2p as=1.2p pd=5.2u ps=5.2u
XDP3_5 xp3 vgp3 vsp vdd pfet_03v3 W=2u L=2u ad=1.2p as=1.2p pd=5.2u ps=5.2u
XDN3_5 xn3 vgn3 vsn vss nfet_03v3 W=2u L=2u ad=1.2p as=1.2p pd=5.2u ps=5.2u
XDP3_6 xp3 vgp3 vsp vdd pfet_03v3 W=2u L=2u ad=1.2p as=1.2p pd=5.2u ps=5.2u
XDN3_6 xn3 vgn3 vsn vss nfet_03v3 W=2u L=2u ad=1.2p as=1.2p pd=5.2u ps=5.2u
XDP3_7 xp3 vgp3 vsp vdd pfet_03v3 W=2u L=2u ad=1.2p as=1.2p pd=5.2u ps=5.2u
XDN3_7 xn3 vgn3 vsn vss nfet_03v3 W=2u L=2u ad=1.2p as=1.2p pd=5.2u ps=5.2u
XFN3 vdd xn3 vgn3 vss nfet_03v3 W=2u L=1u ad=1.2p as=1.2p pd=5.2u ps=5.2u
XBN3 vgn3 vgn4 vss vss nfet_03v3 W=2u L=2u ad=1.2p as=1.2p pd=5.2u ps=5.2u
XFP3 vss xp3 vgp3 vgp3 pfet_03v3 W=2u L=1u ad=1.2p as=1.2p pd=5.2u ps=5.2u
XBP3 vgp3 vgp4 vdd vdd pfet_03v3 W=2u L=2u ad=1.2p as=1.2p pd=5.2u ps=5.2u
XDP4_0 xp4 vgp4 vsp vdd pfet_03v3 W=2u L=2u ad=1.2p as=1.2p pd=5.2u ps=5.2u
XDN4_0 xn4 vgn4 vsn vss nfet_03v3 W=2u L=2u ad=1.2p as=1.2p pd=5.2u ps=5.2u
XDP4_1 xp4 vgp4 vsp vdd pfet_03v3 W=2u L=2u ad=1.2p as=1.2p pd=5.2u ps=5.2u
XDN4_1 xn4 vgn4 vsn vss nfet_03v3 W=2u L=2u ad=1.2p as=1.2p pd=5.2u ps=5.2u
XDP4_2 xp4 vgp4 vsp vdd pfet_03v3 W=2u L=2u ad=1.2p as=1.2p pd=5.2u ps=5.2u
XDN4_2 xn4 vgn4 vsn vss nfet_03v3 W=2u L=2u ad=1.2p as=1.2p pd=5.2u ps=5.2u
XDP4_3 xp4 vgp4 vsp vdd pfet_03v3 W=2u L=2u ad=1.2p as=1.2p pd=5.2u ps=5.2u
XDN4_3 xn4 vgn4 vsn vss nfet_03v3 W=2u L=2u ad=1.2p as=1.2p pd=5.2u ps=5.2u
XDP4_4 xp4 vgp4 vsp vdd pfet_03v3 W=2u L=2u ad=1.2p as=1.2p pd=5.2u ps=5.2u
XDN4_4 xn4 vgn4 vsn vss nfet_03v3 W=2u L=2u ad=1.2p as=1.2p pd=5.2u ps=5.2u
XDP4_5 xp4 vgp4 vsp vdd pfet_03v3 W=2u L=2u ad=1.2p as=1.2p pd=5.2u ps=5.2u
XDN4_5 xn4 vgn4 vsn vss nfet_03v3 W=2u L=2u ad=1.2p as=1.2p pd=5.2u ps=5.2u
XDP4_6 xp4 vgp4 vsp vdd pfet_03v3 W=2u L=2u ad=1.2p as=1.2p pd=5.2u ps=5.2u
XDN4_6 xn4 vgn4 vsn vss nfet_03v3 W=2u L=2u ad=1.2p as=1.2p pd=5.2u ps=5.2u
XDP4_7 xp4 vgp4 vsp vdd pfet_03v3 W=2u L=2u ad=1.2p as=1.2p pd=5.2u ps=5.2u
XDN4_7 xn4 vgn4 vsn vss nfet_03v3 W=2u L=2u ad=1.2p as=1.2p pd=5.2u ps=5.2u
XFN4 vdd xn4 vgn4 vss nfet_03v3 W=2u L=1u ad=1.2p as=1.2p pd=5.2u ps=5.2u
XBN4 vgn4 vgn4 vss vss nfet_03v3 W=2u L=2u ad=1.2p as=1.2p pd=5.2u ps=5.2u
XFP4 vss xp4 vgp4 vgp4 pfet_03v3 W=2u L=1u ad=1.2p as=1.2p pd=5.2u ps=5.2u
XBP4 vgp4 vgp4 vdd vdd pfet_03v3 W=2u L=2u ad=1.2p as=1.2p pd=5.2u ps=5.2u
XDP5_0 xp5 vgp5 vsp vdd pfet_03v3 W=2u L=2u ad=1.2p as=1.2p pd=5.2u ps=5.2u
XDN5_0 xn5 vgn5 vsn vss nfet_03v3 W=2u L=2u ad=1.2p as=1.2p pd=5.2u ps=5.2u
XDP5_1 xp5 vgp5 vsp vdd pfet_03v3 W=2u L=2u ad=1.2p as=1.2p pd=5.2u ps=5.2u
XDN5_1 xn5 vgn5 vsn vss nfet_03v3 W=2u L=2u ad=1.2p as=1.2p pd=5.2u ps=5.2u
XDP5_2 xp5 vgp5 vsp vdd pfet_03v3 W=2u L=2u ad=1.2p as=1.2p pd=5.2u ps=5.2u
XDN5_2 xn5 vgn5 vsn vss nfet_03v3 W=2u L=2u ad=1.2p as=1.2p pd=5.2u ps=5.2u
XDP5_3 xp5 vgp5 vsp vdd pfet_03v3 W=2u L=2u ad=1.2p as=1.2p pd=5.2u ps=5.2u
XDN5_3 xn5 vgn5 vsn vss nfet_03v3 W=2u L=2u ad=1.2p as=1.2p pd=5.2u ps=5.2u
XDP5_4 xp5 vgp5 vsp vdd pfet_03v3 W=2u L=2u ad=1.2p as=1.2p pd=5.2u ps=5.2u
XDN5_4 xn5 vgn5 vsn vss nfet_03v3 W=2u L=2u ad=1.2p as=1.2p pd=5.2u ps=5.2u
XDP5_5 xp5 vgp5 vsp vdd pfet_03v3 W=2u L=2u ad=1.2p as=1.2p pd=5.2u ps=5.2u
XDN5_5 xn5 vgn5 vsn vss nfet_03v3 W=2u L=2u ad=1.2p as=1.2p pd=5.2u ps=5.2u
XDP5_6 xp5 vgp5 vsp vdd pfet_03v3 W=2u L=2u ad=1.2p as=1.2p pd=5.2u ps=5.2u
XDN5_6 xn5 vgn5 vsn vss nfet_03v3 W=2u L=2u ad=1.2p as=1.2p pd=5.2u ps=5.2u
XDP5_7 xp5 vgp5 vsp vdd pfet_03v3 W=2u L=2u ad=1.2p as=1.2p pd=5.2u ps=5.2u
XDN5_7 xn5 vgn5 vsn vss nfet_03v3 W=2u L=2u ad=1.2p as=1.2p pd=5.2u ps=5.2u
XFN5 vdd xn5 vgn5 vss nfet_03v3 W=2u L=1u ad=1.2p as=1.2p pd=5.2u ps=5.2u
XBN5 vgn5 vgn4 vss vss nfet_03v3 W=2u L=2u ad=1.2p as=1.2p pd=5.2u ps=5.2u
XFP5 vss xp5 vgp5 vgp5 pfet_03v3 W=2u L=1u ad=1.2p as=1.2p pd=5.2u ps=5.2u
XBP5 vgp5 vgp4 vdd vdd pfet_03v3 W=2u L=2u ad=1.2p as=1.2p pd=5.2u ps=5.2u
.ends bias_rangegen
