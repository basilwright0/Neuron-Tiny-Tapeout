* bias_master: ua[0] master reference input stage (block B1), rev C
* I_nd (current in the 16-unit master diode nd) sets the speed: S = 100 * I_nd / 1 uA
* (S = 10 ... 1000 <-> I_nd = 0.1 ... 10 uA).  Ratioed to I_nd:
*   in_n   sinks   I_nd/16  (n-ladder input)        in_p  sources I_nd/16 (p-ladder input)
*   vbp_st sinks   I_nd/16  from the rx_p05 receiver (detector starve line, fixed ratio)
* UA0 modes (decoded one-hot by the control macro from UA0_MODE / BIAS_EN, see regmap):
*   s0     ua[0] -> nd directly          (mode 0 EXT/1: I_nd = Iref;  mode 3 INT_MON: pad reads V(nd))
*   s1     ua[0] -> nx, 16:1 pre-mirror  (mode 1 EXT/16: I_nd = Iref/16)
*   stim   ua[0] <-> ua0_stim (transmission gate; mode 2 STIM)
*   intref internal reference: the ~1 uA current iint from bias_vi (V-to-I, ua[0]-independent)
*          is switched into nd (modes 2, 3) -> I_nd ~1 uA, S ~100
*   en     BIAS_EN: 0 pulls nd to vss (all ladder currents 0) and en_b turns the strings off
* Secondary ESD: ua[0] -> 1 kOhm ppolyf_u_1k (W=4 um, 1 square) -> clamp diodes to vdd
*   (diode_pd2nw_03v3) and vss (diode_nd2ps_03v3) on the inner node 'pin'; the pad switches see 'pin'.
.subckt bias_master pad in_n in_p vbp_st ua0_stim iint s0 s1 stim intref en en_b vdd vss
XRS pad pin vss ppolyf_u_1k r_width=4u r_length=3.97u
DDP pin vdd diode_pd2nw_03v3 area=10p pj=22u
DDN vss pin diode_nd2ps_03v3 area=10p pj=22u
XIENp en_b en vdd vdd pfet_03v3 W=1u L=0.28u ad=0.6p as=0.6p pd=3.2u ps=3.2u
XIENn en_b en vss vss nfet_03v3 W=0.5u L=0.28u ad=0.3p as=0.3p pd=2.2u ps=2.2u
XISTp stim_b stim vdd vdd pfet_03v3 W=1u L=0.28u ad=0.6p as=0.6p pd=3.2u ps=3.2u
XISTn stim_b stim vss vss nfet_03v3 W=0.5u L=0.28u ad=0.3p as=0.3p pd=2.2u ps=2.2u
XIIRp intref_b intref vdd vdd pfet_03v3 W=1u L=0.28u ad=0.6p as=0.6p pd=3.2u ps=3.2u
XIIRn intref_b intref vss vss nfet_03v3 W=0.5u L=0.28u ad=0.3p as=0.3p pd=2.2u ps=2.2u
XS0 nd s0 pin vss nfet_03v3 W=4u L=0.5u ad=2.4p as=2.4p pd=9.2u ps=9.2u
XS1 nx s1 pin vss nfet_03v3 W=8u L=0.5u ad=4.8p as=4.8p pd=17.2u ps=17.2u
XSTN ua0_stim stim pin vss nfet_03v3 W=2u L=0.5u ad=1.2p as=1.2p pd=5.2u ps=5.2u
XSTP ua0_stim stim_b pin vdd pfet_03v3 W=4u L=0.5u ad=2.4p as=2.4p pd=9.2u ps=9.2u
XSWI nd intref_b iint vdd pfet_03v3 W=2u L=0.5u ad=1.2p as=1.2p pd=5.2u ps=5.2u
XDX0 nx nx vss vss nfet_03v3 W=2u L=2u ad=1.2p as=1.2p pd=5.2u ps=5.2u
XDX1 nx nx vss vss nfet_03v3 W=2u L=2u ad=1.2p as=1.2p pd=5.2u ps=5.2u
XDX2 nx nx vss vss nfet_03v3 W=2u L=2u ad=1.2p as=1.2p pd=5.2u ps=5.2u
XDX3 nx nx vss vss nfet_03v3 W=2u L=2u ad=1.2p as=1.2p pd=5.2u ps=5.2u
XDX4 nx nx vss vss nfet_03v3 W=2u L=2u ad=1.2p as=1.2p pd=5.2u ps=5.2u
XDX5 nx nx vss vss nfet_03v3 W=2u L=2u ad=1.2p as=1.2p pd=5.2u ps=5.2u
XDX6 nx nx vss vss nfet_03v3 W=2u L=2u ad=1.2p as=1.2p pd=5.2u ps=5.2u
XDX7 nx nx vss vss nfet_03v3 W=2u L=2u ad=1.2p as=1.2p pd=5.2u ps=5.2u
XDX8 nx nx vss vss nfet_03v3 W=2u L=2u ad=1.2p as=1.2p pd=5.2u ps=5.2u
XDX9 nx nx vss vss nfet_03v3 W=2u L=2u ad=1.2p as=1.2p pd=5.2u ps=5.2u
XDX10 nx nx vss vss nfet_03v3 W=2u L=2u ad=1.2p as=1.2p pd=5.2u ps=5.2u
XDX11 nx nx vss vss nfet_03v3 W=2u L=2u ad=1.2p as=1.2p pd=5.2u ps=5.2u
XDX12 nx nx vss vss nfet_03v3 W=2u L=2u ad=1.2p as=1.2p pd=5.2u ps=5.2u
XDX13 nx nx vss vss nfet_03v3 W=2u L=2u ad=1.2p as=1.2p pd=5.2u ps=5.2u
XDX14 nx nx vss vss nfet_03v3 W=2u L=2u ad=1.2p as=1.2p pd=5.2u ps=5.2u
XDX15 nx nx vss vss nfet_03v3 W=2u L=2u ad=1.2p as=1.2p pd=5.2u ps=5.2u
XOX px nx vss vss nfet_03v3 W=2u L=2u ad=1.2p as=1.2p pd=5.2u ps=5.2u
XPX0 px px vdd vdd pfet_03v3 W=2u L=2u ad=1.2p as=1.2p pd=5.2u ps=5.2u
XQX0 nd px vdd vdd pfet_03v3 W=2u L=2u ad=1.2p as=1.2p pd=5.2u ps=5.2u
XPX1 px px vdd vdd pfet_03v3 W=2u L=2u ad=1.2p as=1.2p pd=5.2u ps=5.2u
XQX1 nd px vdd vdd pfet_03v3 W=2u L=2u ad=1.2p as=1.2p pd=5.2u ps=5.2u
XD0 nd nd vss vss nfet_03v3 W=2u L=2u ad=1.2p as=1.2p pd=5.2u ps=5.2u
XD1 nd nd vss vss nfet_03v3 W=2u L=2u ad=1.2p as=1.2p pd=5.2u ps=5.2u
XD2 nd nd vss vss nfet_03v3 W=2u L=2u ad=1.2p as=1.2p pd=5.2u ps=5.2u
XD3 nd nd vss vss nfet_03v3 W=2u L=2u ad=1.2p as=1.2p pd=5.2u ps=5.2u
XD4 nd nd vss vss nfet_03v3 W=2u L=2u ad=1.2p as=1.2p pd=5.2u ps=5.2u
XD5 nd nd vss vss nfet_03v3 W=2u L=2u ad=1.2p as=1.2p pd=5.2u ps=5.2u
XD6 nd nd vss vss nfet_03v3 W=2u L=2u ad=1.2p as=1.2p pd=5.2u ps=5.2u
XD7 nd nd vss vss nfet_03v3 W=2u L=2u ad=1.2p as=1.2p pd=5.2u ps=5.2u
XD8 nd nd vss vss nfet_03v3 W=2u L=2u ad=1.2p as=1.2p pd=5.2u ps=5.2u
XD9 nd nd vss vss nfet_03v3 W=2u L=2u ad=1.2p as=1.2p pd=5.2u ps=5.2u
XD10 nd nd vss vss nfet_03v3 W=2u L=2u ad=1.2p as=1.2p pd=5.2u ps=5.2u
XD11 nd nd vss vss nfet_03v3 W=2u L=2u ad=1.2p as=1.2p pd=5.2u ps=5.2u
XD12 nd nd vss vss nfet_03v3 W=2u L=2u ad=1.2p as=1.2p pd=5.2u ps=5.2u
XD13 nd nd vss vss nfet_03v3 W=2u L=2u ad=1.2p as=1.2p pd=5.2u ps=5.2u
XD14 nd nd vss vss nfet_03v3 W=2u L=2u ad=1.2p as=1.2p pd=5.2u ps=5.2u
XD15 nd nd vss vss nfet_03v3 W=2u L=2u ad=1.2p as=1.2p pd=5.2u ps=5.2u
XPDN nd en_b vss vss nfet_03v3 W=4u L=0.5u ad=2.4p as=2.4p pd=9.2u ps=9.2u
XON in_n nd vss vss nfet_03v3 W=2u L=2u ad=1.2p as=1.2p pd=5.2u ps=5.2u
XOP pd nd vss vss nfet_03v3 W=2u L=2u ad=1.2p as=1.2p pd=5.2u ps=5.2u
XOS vbp_st nd vss vss nfet_03v3 W=2u L=2u ad=1.2p as=1.2p pd=5.2u ps=5.2u
XPD0 pd pd vdd vdd pfet_03v3 W=2u L=2u ad=1.2p as=1.2p pd=5.2u ps=5.2u
XPO0 in_p pd vdd vdd pfet_03v3 W=2u L=2u ad=1.2p as=1.2p pd=5.2u ps=5.2u
XPD1 pd pd vdd vdd pfet_03v3 W=2u L=2u ad=1.2p as=1.2p pd=5.2u ps=5.2u
XPO1 in_p pd vdd vdd pfet_03v3 W=2u L=2u ad=1.2p as=1.2p pd=5.2u ps=5.2u
.ends bias_master
