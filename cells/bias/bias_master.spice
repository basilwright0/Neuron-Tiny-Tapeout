* bias_master: ua[0] master reference input stage (block B1)
* Ports:
*  iref_pad : from ua[0]; external current Iref (1-100 uA) flows INTO this pin
*  in_n     : sink output  I = Iref*m/16 (drawn out of the n-ladder input node)
*  in_p     : source output I = Iref*m/16 (pushed into the p-ladder input node)
*  m0..m3   : ratio code m = m0+2*m1+4*m2+8*m3 (0..15), 3.3 V logic
*  vdd vss  : 3.3 V / 0 V
* Series ppolyf_u_1k 2 kOhm between pad and diode (secondary ESD / isolation);
* the TT pad ring supplies the primary ESD clamp.  Diode = 16 x (4/2) nfet.
.subckt bias_master iref_pad in_n in_p m0 m1 m2 m3 vdd vss
XRS iref_pad nd vss ppolyf_u_1k r_width=2u r_length=4u
XD0 nd nd vss vss nfet_03v3 W=4u L=2u ad=2.4p as=2.4p pd=9.2u ps=9.2u
XD1 nd nd vss vss nfet_03v3 W=4u L=2u ad=2.4p as=2.4p pd=9.2u ps=9.2u
XD2 nd nd vss vss nfet_03v3 W=4u L=2u ad=2.4p as=2.4p pd=9.2u ps=9.2u
XD3 nd nd vss vss nfet_03v3 W=4u L=2u ad=2.4p as=2.4p pd=9.2u ps=9.2u
XD4 nd nd vss vss nfet_03v3 W=4u L=2u ad=2.4p as=2.4p pd=9.2u ps=9.2u
XD5 nd nd vss vss nfet_03v3 W=4u L=2u ad=2.4p as=2.4p pd=9.2u ps=9.2u
XD6 nd nd vss vss nfet_03v3 W=4u L=2u ad=2.4p as=2.4p pd=9.2u ps=9.2u
XD7 nd nd vss vss nfet_03v3 W=4u L=2u ad=2.4p as=2.4p pd=9.2u ps=9.2u
XD8 nd nd vss vss nfet_03v3 W=4u L=2u ad=2.4p as=2.4p pd=9.2u ps=9.2u
XD9 nd nd vss vss nfet_03v3 W=4u L=2u ad=2.4p as=2.4p pd=9.2u ps=9.2u
XD10 nd nd vss vss nfet_03v3 W=4u L=2u ad=2.4p as=2.4p pd=9.2u ps=9.2u
XD11 nd nd vss vss nfet_03v3 W=4u L=2u ad=2.4p as=2.4p pd=9.2u ps=9.2u
XD12 nd nd vss vss nfet_03v3 W=4u L=2u ad=2.4p as=2.4p pd=9.2u ps=9.2u
XD13 nd nd vss vss nfet_03v3 W=4u L=2u ad=2.4p as=2.4p pd=9.2u ps=9.2u
XD14 nd nd vss vss nfet_03v3 W=4u L=2u ad=2.4p as=2.4p pd=9.2u ps=9.2u
XD15 nd nd vss vss nfet_03v3 W=4u L=2u ad=2.4p as=2.4p pd=9.2u ps=9.2u
XOa0_0 xa0 nd vss vss nfet_03v3 W=4u L=2u ad=2.4p as=2.4p pd=9.2u ps=9.2u
XSa0 in_n m0 xa0 vss nfet_03v3 W=2u L=0.5u ad=1.2p as=1.2p pd=5.2u ps=5.2u
XOa1_0 xa1 nd vss vss nfet_03v3 W=4u L=2u ad=2.4p as=2.4p pd=9.2u ps=9.2u
XOa1_1 xa1 nd vss vss nfet_03v3 W=4u L=2u ad=2.4p as=2.4p pd=9.2u ps=9.2u
XSa1 in_n m1 xa1 vss nfet_03v3 W=2u L=0.5u ad=1.2p as=1.2p pd=5.2u ps=5.2u
XOa2_0 xa2 nd vss vss nfet_03v3 W=4u L=2u ad=2.4p as=2.4p pd=9.2u ps=9.2u
XOa2_1 xa2 nd vss vss nfet_03v3 W=4u L=2u ad=2.4p as=2.4p pd=9.2u ps=9.2u
XOa2_2 xa2 nd vss vss nfet_03v3 W=4u L=2u ad=2.4p as=2.4p pd=9.2u ps=9.2u
XOa2_3 xa2 nd vss vss nfet_03v3 W=4u L=2u ad=2.4p as=2.4p pd=9.2u ps=9.2u
XSa2 in_n m2 xa2 vss nfet_03v3 W=2u L=0.5u ad=1.2p as=1.2p pd=5.2u ps=5.2u
XOa3_0 xa3 nd vss vss nfet_03v3 W=4u L=2u ad=2.4p as=2.4p pd=9.2u ps=9.2u
XOa3_1 xa3 nd vss vss nfet_03v3 W=4u L=2u ad=2.4p as=2.4p pd=9.2u ps=9.2u
XOa3_2 xa3 nd vss vss nfet_03v3 W=4u L=2u ad=2.4p as=2.4p pd=9.2u ps=9.2u
XOa3_3 xa3 nd vss vss nfet_03v3 W=4u L=2u ad=2.4p as=2.4p pd=9.2u ps=9.2u
XOa3_4 xa3 nd vss vss nfet_03v3 W=4u L=2u ad=2.4p as=2.4p pd=9.2u ps=9.2u
XOa3_5 xa3 nd vss vss nfet_03v3 W=4u L=2u ad=2.4p as=2.4p pd=9.2u ps=9.2u
XOa3_6 xa3 nd vss vss nfet_03v3 W=4u L=2u ad=2.4p as=2.4p pd=9.2u ps=9.2u
XOa3_7 xa3 nd vss vss nfet_03v3 W=4u L=2u ad=2.4p as=2.4p pd=9.2u ps=9.2u
XSa3 in_n m3 xa3 vss nfet_03v3 W=2u L=0.5u ad=1.2p as=1.2p pd=5.2u ps=5.2u
XOb0_0 xb0 nd vss vss nfet_03v3 W=4u L=2u ad=2.4p as=2.4p pd=9.2u ps=9.2u
XSb0 pd m0 xb0 vss nfet_03v3 W=2u L=0.5u ad=1.2p as=1.2p pd=5.2u ps=5.2u
XOb1_0 xb1 nd vss vss nfet_03v3 W=4u L=2u ad=2.4p as=2.4p pd=9.2u ps=9.2u
XOb1_1 xb1 nd vss vss nfet_03v3 W=4u L=2u ad=2.4p as=2.4p pd=9.2u ps=9.2u
XSb1 pd m1 xb1 vss nfet_03v3 W=2u L=0.5u ad=1.2p as=1.2p pd=5.2u ps=5.2u
XOb2_0 xb2 nd vss vss nfet_03v3 W=4u L=2u ad=2.4p as=2.4p pd=9.2u ps=9.2u
XOb2_1 xb2 nd vss vss nfet_03v3 W=4u L=2u ad=2.4p as=2.4p pd=9.2u ps=9.2u
XOb2_2 xb2 nd vss vss nfet_03v3 W=4u L=2u ad=2.4p as=2.4p pd=9.2u ps=9.2u
XOb2_3 xb2 nd vss vss nfet_03v3 W=4u L=2u ad=2.4p as=2.4p pd=9.2u ps=9.2u
XSb2 pd m2 xb2 vss nfet_03v3 W=2u L=0.5u ad=1.2p as=1.2p pd=5.2u ps=5.2u
XOb3_0 xb3 nd vss vss nfet_03v3 W=4u L=2u ad=2.4p as=2.4p pd=9.2u ps=9.2u
XOb3_1 xb3 nd vss vss nfet_03v3 W=4u L=2u ad=2.4p as=2.4p pd=9.2u ps=9.2u
XOb3_2 xb3 nd vss vss nfet_03v3 W=4u L=2u ad=2.4p as=2.4p pd=9.2u ps=9.2u
XOb3_3 xb3 nd vss vss nfet_03v3 W=4u L=2u ad=2.4p as=2.4p pd=9.2u ps=9.2u
XOb3_4 xb3 nd vss vss nfet_03v3 W=4u L=2u ad=2.4p as=2.4p pd=9.2u ps=9.2u
XOb3_5 xb3 nd vss vss nfet_03v3 W=4u L=2u ad=2.4p as=2.4p pd=9.2u ps=9.2u
XOb3_6 xb3 nd vss vss nfet_03v3 W=4u L=2u ad=2.4p as=2.4p pd=9.2u ps=9.2u
XOb3_7 xb3 nd vss vss nfet_03v3 W=4u L=2u ad=2.4p as=2.4p pd=9.2u ps=9.2u
XSb3 pd m3 xb3 vss nfet_03v3 W=2u L=0.5u ad=1.2p as=1.2p pd=5.2u ps=5.2u
XPD0 pd pd vdd vdd pfet_03v3 W=4u L=2u ad=2.4p as=2.4p pd=9.2u ps=9.2u
XPO0 in_p pd vdd vdd pfet_03v3 W=4u L=2u ad=2.4p as=2.4p pd=9.2u ps=9.2u
XPD1 pd pd vdd vdd pfet_03v3 W=4u L=2u ad=2.4p as=2.4p pd=9.2u ps=9.2u
XPO1 in_p pd vdd vdd pfet_03v3 W=4u L=2u ad=2.4p as=2.4p pd=9.2u ps=9.2u
XPD2 pd pd vdd vdd pfet_03v3 W=4u L=2u ad=2.4p as=2.4p pd=9.2u ps=9.2u
XPO2 in_p pd vdd vdd pfet_03v3 W=4u L=2u ad=2.4p as=2.4p pd=9.2u ps=9.2u
XPD3 pd pd vdd vdd pfet_03v3 W=4u L=2u ad=2.4p as=2.4p pd=9.2u ps=9.2u
XPO3 in_p pd vdd vdd pfet_03v3 W=4u L=2u ad=2.4p as=2.4p pd=9.2u ps=9.2u
XPD4 pd pd vdd vdd pfet_03v3 W=4u L=2u ad=2.4p as=2.4p pd=9.2u ps=9.2u
XPO4 in_p pd vdd vdd pfet_03v3 W=4u L=2u ad=2.4p as=2.4p pd=9.2u ps=9.2u
XPD5 pd pd vdd vdd pfet_03v3 W=4u L=2u ad=2.4p as=2.4p pd=9.2u ps=9.2u
XPO5 in_p pd vdd vdd pfet_03v3 W=4u L=2u ad=2.4p as=2.4p pd=9.2u ps=9.2u
XPD6 pd pd vdd vdd pfet_03v3 W=4u L=2u ad=2.4p as=2.4p pd=9.2u ps=9.2u
XPO6 in_p pd vdd vdd pfet_03v3 W=4u L=2u ad=2.4p as=2.4p pd=9.2u ps=9.2u
XPD7 pd pd vdd vdd pfet_03v3 W=4u L=2u ad=2.4p as=2.4p pd=9.2u ps=9.2u
XPO7 in_p pd vdd vdd pfet_03v3 W=4u L=2u ad=2.4p as=2.4p pd=9.2u ps=9.2u
.ends bias_master
