* bias_rails: shifted-source rails and ladder gate biases (block B1)
* ppolyf_u_3k string, 10 uA (330 kOhm, 110 squares at W=1 um), ratiometric to VDD.
* vsn ~0.3 V, vsp ~VDD-0.3 V, vgln ~1.8 V (n-ladder gates), vglp ~1.2 V (p-ladder gates).
* 1 pF MOS decaps (MIM needs Metal5, forbidden on TT GF): pfet gate cap vsn->vdd (strong inversion),
* nfet gate cap vsp->vss (strong inversion). ~4 fF/um^2 -> 15.8x15.8 um each.
* Ports: vsn vsp vgln vglp vdd vss
.subckt bias_rails vsn vsp vgln vglp vdd vss
XR0 vdd vsp vss ppolyf_u_3k r_width=1u r_length=9.814u
XR1 vsp vgln vss ppolyf_u_3k r_width=1u r_length=39.814u
XR2 vgln vglp vss ppolyf_u_3k r_width=1u r_length=19.814u
XR3 vglp vsn vss ppolyf_u_3k r_width=1u r_length=29.814u
XR4 vsn vss vss ppolyf_u_3k r_width=1u r_length=9.814u
XC1 vdd vsn vdd vdd pfet_03v3 W=15.8u L=15.8u
XC2 vss vsp vss vss nfet_03v3 W=15.8u L=15.8u
.ends bias_rails
