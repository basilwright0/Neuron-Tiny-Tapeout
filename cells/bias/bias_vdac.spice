* vref_string64: shared ratiometric poly string (ppolyf_u_3k, W=1 um, 3.3 uA)
*   t_k = VDD*(0.3 + k*1.7/63)/3.3   (0.30 .. 2.00 V at VDD=3.3 V)
*   Ports: t0..t63 vdd vss.  One string serves all vdac6 instances.
.subckt vref_string64 t0 t1 t2 t3 t4 t5 t6 t7 t8 t9 t10 t11 t12 t13 t14 t15 t16 t17 t18 t19 t20 t21 t22 t23 t24 t25 t26 t27 t28 t29 t30 t31 t32 t33 t34 t35 t36 t37 t38 t39 t40 t41 t42 t43 t44 t45 t46 t47 t48 t49 t50 t51 t52 t53 t54 t55 t56 t57 t58 t59 t60 t61 t62 t63 vdd vss
XRbot t0 vss vss ppolyf_u_3k r_width=1u r_length=30.1166u
XRs0 t1 t0 vss ppolyf_u_3k r_width=1u r_length=2.5393u
XRs1 t2 t1 vss ppolyf_u_3k r_width=1u r_length=2.5393u
XRs2 t3 t2 vss ppolyf_u_3k r_width=1u r_length=2.5393u
XRs3 t4 t3 vss ppolyf_u_3k r_width=1u r_length=2.5393u
XRs4 t5 t4 vss ppolyf_u_3k r_width=1u r_length=2.5393u
XRs5 t6 t5 vss ppolyf_u_3k r_width=1u r_length=2.5393u
XRs6 t7 t6 vss ppolyf_u_3k r_width=1u r_length=2.5393u
XRs7 t8 t7 vss ppolyf_u_3k r_width=1u r_length=2.5393u
XRs8 t9 t8 vss ppolyf_u_3k r_width=1u r_length=2.5393u
XRs9 t10 t9 vss ppolyf_u_3k r_width=1u r_length=2.5393u
XRs10 t11 t10 vss ppolyf_u_3k r_width=1u r_length=2.5393u
XRs11 t12 t11 vss ppolyf_u_3k r_width=1u r_length=2.5393u
XRs12 t13 t12 vss ppolyf_u_3k r_width=1u r_length=2.5393u
XRs13 t14 t13 vss ppolyf_u_3k r_width=1u r_length=2.5393u
XRs14 t15 t14 vss ppolyf_u_3k r_width=1u r_length=2.5393u
XRs15 t16 t15 vss ppolyf_u_3k r_width=1u r_length=2.5393u
XRs16 t17 t16 vss ppolyf_u_3k r_width=1u r_length=2.5393u
XRs17 t18 t17 vss ppolyf_u_3k r_width=1u r_length=2.5393u
XRs18 t19 t18 vss ppolyf_u_3k r_width=1u r_length=2.5393u
XRs19 t20 t19 vss ppolyf_u_3k r_width=1u r_length=2.5393u
XRs20 t21 t20 vss ppolyf_u_3k r_width=1u r_length=2.5393u
XRs21 t22 t21 vss ppolyf_u_3k r_width=1u r_length=2.5393u
XRs22 t23 t22 vss ppolyf_u_3k r_width=1u r_length=2.5393u
XRs23 t24 t23 vss ppolyf_u_3k r_width=1u r_length=2.5393u
XRs24 t25 t24 vss ppolyf_u_3k r_width=1u r_length=2.5393u
XRs25 t26 t25 vss ppolyf_u_3k r_width=1u r_length=2.5393u
XRs26 t27 t26 vss ppolyf_u_3k r_width=1u r_length=2.5393u
XRs27 t28 t27 vss ppolyf_u_3k r_width=1u r_length=2.5393u
XRs28 t29 t28 vss ppolyf_u_3k r_width=1u r_length=2.5393u
XRs29 t30 t29 vss ppolyf_u_3k r_width=1u r_length=2.5393u
XRs30 t31 t30 vss ppolyf_u_3k r_width=1u r_length=2.5393u
XRs31 t32 t31 vss ppolyf_u_3k r_width=1u r_length=2.5393u
XRs32 t33 t32 vss ppolyf_u_3k r_width=1u r_length=2.5393u
XRs33 t34 t33 vss ppolyf_u_3k r_width=1u r_length=2.5393u
XRs34 t35 t34 vss ppolyf_u_3k r_width=1u r_length=2.5393u
XRs35 t36 t35 vss ppolyf_u_3k r_width=1u r_length=2.5393u
XRs36 t37 t36 vss ppolyf_u_3k r_width=1u r_length=2.5393u
XRs37 t38 t37 vss ppolyf_u_3k r_width=1u r_length=2.5393u
XRs38 t39 t38 vss ppolyf_u_3k r_width=1u r_length=2.5393u
XRs39 t40 t39 vss ppolyf_u_3k r_width=1u r_length=2.5393u
XRs40 t41 t40 vss ppolyf_u_3k r_width=1u r_length=2.5393u
XRs41 t42 t41 vss ppolyf_u_3k r_width=1u r_length=2.5393u
XRs42 t43 t42 vss ppolyf_u_3k r_width=1u r_length=2.5393u
XRs43 t44 t43 vss ppolyf_u_3k r_width=1u r_length=2.5393u
XRs44 t45 t44 vss ppolyf_u_3k r_width=1u r_length=2.5393u
XRs45 t46 t45 vss ppolyf_u_3k r_width=1u r_length=2.5393u
XRs46 t47 t46 vss ppolyf_u_3k r_width=1u r_length=2.5393u
XRs47 t48 t47 vss ppolyf_u_3k r_width=1u r_length=2.5393u
XRs48 t49 t48 vss ppolyf_u_3k r_width=1u r_length=2.5393u
XRs49 t50 t49 vss ppolyf_u_3k r_width=1u r_length=2.5393u
XRs50 t51 t50 vss ppolyf_u_3k r_width=1u r_length=2.5393u
XRs51 t52 t51 vss ppolyf_u_3k r_width=1u r_length=2.5393u
XRs52 t53 t52 vss ppolyf_u_3k r_width=1u r_length=2.5393u
XRs53 t54 t53 vss ppolyf_u_3k r_width=1u r_length=2.5393u
XRs54 t55 t54 vss ppolyf_u_3k r_width=1u r_length=2.5393u
XRs55 t56 t55 vss ppolyf_u_3k r_width=1u r_length=2.5393u
XRs56 t57 t56 vss ppolyf_u_3k r_width=1u r_length=2.5393u
XRs57 t58 t57 vss ppolyf_u_3k r_width=1u r_length=2.5393u
XRs58 t59 t58 vss ppolyf_u_3k r_width=1u r_length=2.5393u
XRs59 t60 t59 vss ppolyf_u_3k r_width=1u r_length=2.5393u
XRs60 t61 t60 vss ppolyf_u_3k r_width=1u r_length=2.5393u
XRs61 t62 t61 vss ppolyf_u_3k r_width=1u r_length=2.5393u
XRs62 t63 t62 vss ppolyf_u_3k r_width=1u r_length=2.5393u
XRtop vdd t63 vss ppolyf_u_3k r_width=1u r_length=131.1267u
.ends vref_string64
* vdac6: 6-bit binary nfet pass-gate tree selecting one string tap (no buffer).
*   Ports: out t0..t63 c0..c5 (c0 = LSB, 3.3 V logic) vdd vss
.subckt vdac6 out t0 t1 t2 t3 t4 t5 t6 t7 t8 t9 t10 t11 t12 t13 t14 t15 t16 t17 t18 t19 t20 t21 t22 t23 t24 t25 t26 t27 t28 t29 t30 t31 t32 t33 t34 t35 t36 t37 t38 t39 t40 t41 t42 t43 t44 t45 t46 t47 t48 t49 t50 t51 t52 t53 t54 t55 t56 t57 t58 t59 t60 t61 t62 t63 c0 c1 c2 c3 c4 c5 vdd vss
XIC0p cb0 c0 vdd vdd pfet_03v3 W=1u L=0.28u ad=0.6p as=0.6p pd=3.2u ps=3.2u
XIC0n cb0 c0 vss vss nfet_03v3 W=0.5u L=0.28u ad=0.3p as=0.3p pd=2.2u ps=2.2u
XIC1p cb1 c1 vdd vdd pfet_03v3 W=1u L=0.28u ad=0.6p as=0.6p pd=3.2u ps=3.2u
XIC1n cb1 c1 vss vss nfet_03v3 W=0.5u L=0.28u ad=0.3p as=0.3p pd=2.2u ps=2.2u
XIC2p cb2 c2 vdd vdd pfet_03v3 W=1u L=0.28u ad=0.6p as=0.6p pd=3.2u ps=3.2u
XIC2n cb2 c2 vss vss nfet_03v3 W=0.5u L=0.28u ad=0.3p as=0.3p pd=2.2u ps=2.2u
XIC3p cb3 c3 vdd vdd pfet_03v3 W=1u L=0.28u ad=0.6p as=0.6p pd=3.2u ps=3.2u
XIC3n cb3 c3 vss vss nfet_03v3 W=0.5u L=0.28u ad=0.3p as=0.3p pd=2.2u ps=2.2u
XIC4p cb4 c4 vdd vdd pfet_03v3 W=1u L=0.28u ad=0.6p as=0.6p pd=3.2u ps=3.2u
XIC4n cb4 c4 vss vss nfet_03v3 W=0.5u L=0.28u ad=0.3p as=0.3p pd=2.2u ps=2.2u
XIC5p cb5 c5 vdd vdd pfet_03v3 W=1u L=0.28u ad=0.6p as=0.6p pd=3.2u ps=3.2u
XIC5n cb5 c5 vss vss nfet_03v3 W=0.5u L=0.28u ad=0.3p as=0.3p pd=2.2u ps=2.2u
XT0_0a t0 cb0 n0_0 vss nfet_03v3 W=0.5u L=0.28u ad=0.3p as=0.3p pd=2.2u ps=2.2u
XT0_0b t1 c0 n0_0 vss nfet_03v3 W=0.5u L=0.28u ad=0.3p as=0.3p pd=2.2u ps=2.2u
XT0_1a t2 cb0 n0_1 vss nfet_03v3 W=0.5u L=0.28u ad=0.3p as=0.3p pd=2.2u ps=2.2u
XT0_1b t3 c0 n0_1 vss nfet_03v3 W=0.5u L=0.28u ad=0.3p as=0.3p pd=2.2u ps=2.2u
XT0_2a t4 cb0 n0_2 vss nfet_03v3 W=0.5u L=0.28u ad=0.3p as=0.3p pd=2.2u ps=2.2u
XT0_2b t5 c0 n0_2 vss nfet_03v3 W=0.5u L=0.28u ad=0.3p as=0.3p pd=2.2u ps=2.2u
XT0_3a t6 cb0 n0_3 vss nfet_03v3 W=0.5u L=0.28u ad=0.3p as=0.3p pd=2.2u ps=2.2u
XT0_3b t7 c0 n0_3 vss nfet_03v3 W=0.5u L=0.28u ad=0.3p as=0.3p pd=2.2u ps=2.2u
XT0_4a t8 cb0 n0_4 vss nfet_03v3 W=0.5u L=0.28u ad=0.3p as=0.3p pd=2.2u ps=2.2u
XT0_4b t9 c0 n0_4 vss nfet_03v3 W=0.5u L=0.28u ad=0.3p as=0.3p pd=2.2u ps=2.2u
XT0_5a t10 cb0 n0_5 vss nfet_03v3 W=0.5u L=0.28u ad=0.3p as=0.3p pd=2.2u ps=2.2u
XT0_5b t11 c0 n0_5 vss nfet_03v3 W=0.5u L=0.28u ad=0.3p as=0.3p pd=2.2u ps=2.2u
XT0_6a t12 cb0 n0_6 vss nfet_03v3 W=0.5u L=0.28u ad=0.3p as=0.3p pd=2.2u ps=2.2u
XT0_6b t13 c0 n0_6 vss nfet_03v3 W=0.5u L=0.28u ad=0.3p as=0.3p pd=2.2u ps=2.2u
XT0_7a t14 cb0 n0_7 vss nfet_03v3 W=0.5u L=0.28u ad=0.3p as=0.3p pd=2.2u ps=2.2u
XT0_7b t15 c0 n0_7 vss nfet_03v3 W=0.5u L=0.28u ad=0.3p as=0.3p pd=2.2u ps=2.2u
XT0_8a t16 cb0 n0_8 vss nfet_03v3 W=0.5u L=0.28u ad=0.3p as=0.3p pd=2.2u ps=2.2u
XT0_8b t17 c0 n0_8 vss nfet_03v3 W=0.5u L=0.28u ad=0.3p as=0.3p pd=2.2u ps=2.2u
XT0_9a t18 cb0 n0_9 vss nfet_03v3 W=0.5u L=0.28u ad=0.3p as=0.3p pd=2.2u ps=2.2u
XT0_9b t19 c0 n0_9 vss nfet_03v3 W=0.5u L=0.28u ad=0.3p as=0.3p pd=2.2u ps=2.2u
XT0_10a t20 cb0 n0_10 vss nfet_03v3 W=0.5u L=0.28u ad=0.3p as=0.3p pd=2.2u ps=2.2u
XT0_10b t21 c0 n0_10 vss nfet_03v3 W=0.5u L=0.28u ad=0.3p as=0.3p pd=2.2u ps=2.2u
XT0_11a t22 cb0 n0_11 vss nfet_03v3 W=0.5u L=0.28u ad=0.3p as=0.3p pd=2.2u ps=2.2u
XT0_11b t23 c0 n0_11 vss nfet_03v3 W=0.5u L=0.28u ad=0.3p as=0.3p pd=2.2u ps=2.2u
XT0_12a t24 cb0 n0_12 vss nfet_03v3 W=0.5u L=0.28u ad=0.3p as=0.3p pd=2.2u ps=2.2u
XT0_12b t25 c0 n0_12 vss nfet_03v3 W=0.5u L=0.28u ad=0.3p as=0.3p pd=2.2u ps=2.2u
XT0_13a t26 cb0 n0_13 vss nfet_03v3 W=0.5u L=0.28u ad=0.3p as=0.3p pd=2.2u ps=2.2u
XT0_13b t27 c0 n0_13 vss nfet_03v3 W=0.5u L=0.28u ad=0.3p as=0.3p pd=2.2u ps=2.2u
XT0_14a t28 cb0 n0_14 vss nfet_03v3 W=0.5u L=0.28u ad=0.3p as=0.3p pd=2.2u ps=2.2u
XT0_14b t29 c0 n0_14 vss nfet_03v3 W=0.5u L=0.28u ad=0.3p as=0.3p pd=2.2u ps=2.2u
XT0_15a t30 cb0 n0_15 vss nfet_03v3 W=0.5u L=0.28u ad=0.3p as=0.3p pd=2.2u ps=2.2u
XT0_15b t31 c0 n0_15 vss nfet_03v3 W=0.5u L=0.28u ad=0.3p as=0.3p pd=2.2u ps=2.2u
XT0_16a t32 cb0 n0_16 vss nfet_03v3 W=0.5u L=0.28u ad=0.3p as=0.3p pd=2.2u ps=2.2u
XT0_16b t33 c0 n0_16 vss nfet_03v3 W=0.5u L=0.28u ad=0.3p as=0.3p pd=2.2u ps=2.2u
XT0_17a t34 cb0 n0_17 vss nfet_03v3 W=0.5u L=0.28u ad=0.3p as=0.3p pd=2.2u ps=2.2u
XT0_17b t35 c0 n0_17 vss nfet_03v3 W=0.5u L=0.28u ad=0.3p as=0.3p pd=2.2u ps=2.2u
XT0_18a t36 cb0 n0_18 vss nfet_03v3 W=0.5u L=0.28u ad=0.3p as=0.3p pd=2.2u ps=2.2u
XT0_18b t37 c0 n0_18 vss nfet_03v3 W=0.5u L=0.28u ad=0.3p as=0.3p pd=2.2u ps=2.2u
XT0_19a t38 cb0 n0_19 vss nfet_03v3 W=0.5u L=0.28u ad=0.3p as=0.3p pd=2.2u ps=2.2u
XT0_19b t39 c0 n0_19 vss nfet_03v3 W=0.5u L=0.28u ad=0.3p as=0.3p pd=2.2u ps=2.2u
XT0_20a t40 cb0 n0_20 vss nfet_03v3 W=0.5u L=0.28u ad=0.3p as=0.3p pd=2.2u ps=2.2u
XT0_20b t41 c0 n0_20 vss nfet_03v3 W=0.5u L=0.28u ad=0.3p as=0.3p pd=2.2u ps=2.2u
XT0_21a t42 cb0 n0_21 vss nfet_03v3 W=0.5u L=0.28u ad=0.3p as=0.3p pd=2.2u ps=2.2u
XT0_21b t43 c0 n0_21 vss nfet_03v3 W=0.5u L=0.28u ad=0.3p as=0.3p pd=2.2u ps=2.2u
XT0_22a t44 cb0 n0_22 vss nfet_03v3 W=0.5u L=0.28u ad=0.3p as=0.3p pd=2.2u ps=2.2u
XT0_22b t45 c0 n0_22 vss nfet_03v3 W=0.5u L=0.28u ad=0.3p as=0.3p pd=2.2u ps=2.2u
XT0_23a t46 cb0 n0_23 vss nfet_03v3 W=0.5u L=0.28u ad=0.3p as=0.3p pd=2.2u ps=2.2u
XT0_23b t47 c0 n0_23 vss nfet_03v3 W=0.5u L=0.28u ad=0.3p as=0.3p pd=2.2u ps=2.2u
XT0_24a t48 cb0 n0_24 vss nfet_03v3 W=0.5u L=0.28u ad=0.3p as=0.3p pd=2.2u ps=2.2u
XT0_24b t49 c0 n0_24 vss nfet_03v3 W=0.5u L=0.28u ad=0.3p as=0.3p pd=2.2u ps=2.2u
XT0_25a t50 cb0 n0_25 vss nfet_03v3 W=0.5u L=0.28u ad=0.3p as=0.3p pd=2.2u ps=2.2u
XT0_25b t51 c0 n0_25 vss nfet_03v3 W=0.5u L=0.28u ad=0.3p as=0.3p pd=2.2u ps=2.2u
XT0_26a t52 cb0 n0_26 vss nfet_03v3 W=0.5u L=0.28u ad=0.3p as=0.3p pd=2.2u ps=2.2u
XT0_26b t53 c0 n0_26 vss nfet_03v3 W=0.5u L=0.28u ad=0.3p as=0.3p pd=2.2u ps=2.2u
XT0_27a t54 cb0 n0_27 vss nfet_03v3 W=0.5u L=0.28u ad=0.3p as=0.3p pd=2.2u ps=2.2u
XT0_27b t55 c0 n0_27 vss nfet_03v3 W=0.5u L=0.28u ad=0.3p as=0.3p pd=2.2u ps=2.2u
XT0_28a t56 cb0 n0_28 vss nfet_03v3 W=0.5u L=0.28u ad=0.3p as=0.3p pd=2.2u ps=2.2u
XT0_28b t57 c0 n0_28 vss nfet_03v3 W=0.5u L=0.28u ad=0.3p as=0.3p pd=2.2u ps=2.2u
XT0_29a t58 cb0 n0_29 vss nfet_03v3 W=0.5u L=0.28u ad=0.3p as=0.3p pd=2.2u ps=2.2u
XT0_29b t59 c0 n0_29 vss nfet_03v3 W=0.5u L=0.28u ad=0.3p as=0.3p pd=2.2u ps=2.2u
XT0_30a t60 cb0 n0_30 vss nfet_03v3 W=0.5u L=0.28u ad=0.3p as=0.3p pd=2.2u ps=2.2u
XT0_30b t61 c0 n0_30 vss nfet_03v3 W=0.5u L=0.28u ad=0.3p as=0.3p pd=2.2u ps=2.2u
XT0_31a t62 cb0 n0_31 vss nfet_03v3 W=0.5u L=0.28u ad=0.3p as=0.3p pd=2.2u ps=2.2u
XT0_31b t63 c0 n0_31 vss nfet_03v3 W=0.5u L=0.28u ad=0.3p as=0.3p pd=2.2u ps=2.2u
XT1_0a n0_0 cb1 n1_0 vss nfet_03v3 W=0.5u L=0.28u ad=0.3p as=0.3p pd=2.2u ps=2.2u
XT1_0b n0_1 c1 n1_0 vss nfet_03v3 W=0.5u L=0.28u ad=0.3p as=0.3p pd=2.2u ps=2.2u
XT1_1a n0_2 cb1 n1_1 vss nfet_03v3 W=0.5u L=0.28u ad=0.3p as=0.3p pd=2.2u ps=2.2u
XT1_1b n0_3 c1 n1_1 vss nfet_03v3 W=0.5u L=0.28u ad=0.3p as=0.3p pd=2.2u ps=2.2u
XT1_2a n0_4 cb1 n1_2 vss nfet_03v3 W=0.5u L=0.28u ad=0.3p as=0.3p pd=2.2u ps=2.2u
XT1_2b n0_5 c1 n1_2 vss nfet_03v3 W=0.5u L=0.28u ad=0.3p as=0.3p pd=2.2u ps=2.2u
XT1_3a n0_6 cb1 n1_3 vss nfet_03v3 W=0.5u L=0.28u ad=0.3p as=0.3p pd=2.2u ps=2.2u
XT1_3b n0_7 c1 n1_3 vss nfet_03v3 W=0.5u L=0.28u ad=0.3p as=0.3p pd=2.2u ps=2.2u
XT1_4a n0_8 cb1 n1_4 vss nfet_03v3 W=0.5u L=0.28u ad=0.3p as=0.3p pd=2.2u ps=2.2u
XT1_4b n0_9 c1 n1_4 vss nfet_03v3 W=0.5u L=0.28u ad=0.3p as=0.3p pd=2.2u ps=2.2u
XT1_5a n0_10 cb1 n1_5 vss nfet_03v3 W=0.5u L=0.28u ad=0.3p as=0.3p pd=2.2u ps=2.2u
XT1_5b n0_11 c1 n1_5 vss nfet_03v3 W=0.5u L=0.28u ad=0.3p as=0.3p pd=2.2u ps=2.2u
XT1_6a n0_12 cb1 n1_6 vss nfet_03v3 W=0.5u L=0.28u ad=0.3p as=0.3p pd=2.2u ps=2.2u
XT1_6b n0_13 c1 n1_6 vss nfet_03v3 W=0.5u L=0.28u ad=0.3p as=0.3p pd=2.2u ps=2.2u
XT1_7a n0_14 cb1 n1_7 vss nfet_03v3 W=0.5u L=0.28u ad=0.3p as=0.3p pd=2.2u ps=2.2u
XT1_7b n0_15 c1 n1_7 vss nfet_03v3 W=0.5u L=0.28u ad=0.3p as=0.3p pd=2.2u ps=2.2u
XT1_8a n0_16 cb1 n1_8 vss nfet_03v3 W=0.5u L=0.28u ad=0.3p as=0.3p pd=2.2u ps=2.2u
XT1_8b n0_17 c1 n1_8 vss nfet_03v3 W=0.5u L=0.28u ad=0.3p as=0.3p pd=2.2u ps=2.2u
XT1_9a n0_18 cb1 n1_9 vss nfet_03v3 W=0.5u L=0.28u ad=0.3p as=0.3p pd=2.2u ps=2.2u
XT1_9b n0_19 c1 n1_9 vss nfet_03v3 W=0.5u L=0.28u ad=0.3p as=0.3p pd=2.2u ps=2.2u
XT1_10a n0_20 cb1 n1_10 vss nfet_03v3 W=0.5u L=0.28u ad=0.3p as=0.3p pd=2.2u ps=2.2u
XT1_10b n0_21 c1 n1_10 vss nfet_03v3 W=0.5u L=0.28u ad=0.3p as=0.3p pd=2.2u ps=2.2u
XT1_11a n0_22 cb1 n1_11 vss nfet_03v3 W=0.5u L=0.28u ad=0.3p as=0.3p pd=2.2u ps=2.2u
XT1_11b n0_23 c1 n1_11 vss nfet_03v3 W=0.5u L=0.28u ad=0.3p as=0.3p pd=2.2u ps=2.2u
XT1_12a n0_24 cb1 n1_12 vss nfet_03v3 W=0.5u L=0.28u ad=0.3p as=0.3p pd=2.2u ps=2.2u
XT1_12b n0_25 c1 n1_12 vss nfet_03v3 W=0.5u L=0.28u ad=0.3p as=0.3p pd=2.2u ps=2.2u
XT1_13a n0_26 cb1 n1_13 vss nfet_03v3 W=0.5u L=0.28u ad=0.3p as=0.3p pd=2.2u ps=2.2u
XT1_13b n0_27 c1 n1_13 vss nfet_03v3 W=0.5u L=0.28u ad=0.3p as=0.3p pd=2.2u ps=2.2u
XT1_14a n0_28 cb1 n1_14 vss nfet_03v3 W=0.5u L=0.28u ad=0.3p as=0.3p pd=2.2u ps=2.2u
XT1_14b n0_29 c1 n1_14 vss nfet_03v3 W=0.5u L=0.28u ad=0.3p as=0.3p pd=2.2u ps=2.2u
XT1_15a n0_30 cb1 n1_15 vss nfet_03v3 W=0.5u L=0.28u ad=0.3p as=0.3p pd=2.2u ps=2.2u
XT1_15b n0_31 c1 n1_15 vss nfet_03v3 W=0.5u L=0.28u ad=0.3p as=0.3p pd=2.2u ps=2.2u
XT2_0a n1_0 cb2 n2_0 vss nfet_03v3 W=0.5u L=0.28u ad=0.3p as=0.3p pd=2.2u ps=2.2u
XT2_0b n1_1 c2 n2_0 vss nfet_03v3 W=0.5u L=0.28u ad=0.3p as=0.3p pd=2.2u ps=2.2u
XT2_1a n1_2 cb2 n2_1 vss nfet_03v3 W=0.5u L=0.28u ad=0.3p as=0.3p pd=2.2u ps=2.2u
XT2_1b n1_3 c2 n2_1 vss nfet_03v3 W=0.5u L=0.28u ad=0.3p as=0.3p pd=2.2u ps=2.2u
XT2_2a n1_4 cb2 n2_2 vss nfet_03v3 W=0.5u L=0.28u ad=0.3p as=0.3p pd=2.2u ps=2.2u
XT2_2b n1_5 c2 n2_2 vss nfet_03v3 W=0.5u L=0.28u ad=0.3p as=0.3p pd=2.2u ps=2.2u
XT2_3a n1_6 cb2 n2_3 vss nfet_03v3 W=0.5u L=0.28u ad=0.3p as=0.3p pd=2.2u ps=2.2u
XT2_3b n1_7 c2 n2_3 vss nfet_03v3 W=0.5u L=0.28u ad=0.3p as=0.3p pd=2.2u ps=2.2u
XT2_4a n1_8 cb2 n2_4 vss nfet_03v3 W=0.5u L=0.28u ad=0.3p as=0.3p pd=2.2u ps=2.2u
XT2_4b n1_9 c2 n2_4 vss nfet_03v3 W=0.5u L=0.28u ad=0.3p as=0.3p pd=2.2u ps=2.2u
XT2_5a n1_10 cb2 n2_5 vss nfet_03v3 W=0.5u L=0.28u ad=0.3p as=0.3p pd=2.2u ps=2.2u
XT2_5b n1_11 c2 n2_5 vss nfet_03v3 W=0.5u L=0.28u ad=0.3p as=0.3p pd=2.2u ps=2.2u
XT2_6a n1_12 cb2 n2_6 vss nfet_03v3 W=0.5u L=0.28u ad=0.3p as=0.3p pd=2.2u ps=2.2u
XT2_6b n1_13 c2 n2_6 vss nfet_03v3 W=0.5u L=0.28u ad=0.3p as=0.3p pd=2.2u ps=2.2u
XT2_7a n1_14 cb2 n2_7 vss nfet_03v3 W=0.5u L=0.28u ad=0.3p as=0.3p pd=2.2u ps=2.2u
XT2_7b n1_15 c2 n2_7 vss nfet_03v3 W=0.5u L=0.28u ad=0.3p as=0.3p pd=2.2u ps=2.2u
XT3_0a n2_0 cb3 n3_0 vss nfet_03v3 W=0.5u L=0.28u ad=0.3p as=0.3p pd=2.2u ps=2.2u
XT3_0b n2_1 c3 n3_0 vss nfet_03v3 W=0.5u L=0.28u ad=0.3p as=0.3p pd=2.2u ps=2.2u
XT3_1a n2_2 cb3 n3_1 vss nfet_03v3 W=0.5u L=0.28u ad=0.3p as=0.3p pd=2.2u ps=2.2u
XT3_1b n2_3 c3 n3_1 vss nfet_03v3 W=0.5u L=0.28u ad=0.3p as=0.3p pd=2.2u ps=2.2u
XT3_2a n2_4 cb3 n3_2 vss nfet_03v3 W=0.5u L=0.28u ad=0.3p as=0.3p pd=2.2u ps=2.2u
XT3_2b n2_5 c3 n3_2 vss nfet_03v3 W=0.5u L=0.28u ad=0.3p as=0.3p pd=2.2u ps=2.2u
XT3_3a n2_6 cb3 n3_3 vss nfet_03v3 W=0.5u L=0.28u ad=0.3p as=0.3p pd=2.2u ps=2.2u
XT3_3b n2_7 c3 n3_3 vss nfet_03v3 W=0.5u L=0.28u ad=0.3p as=0.3p pd=2.2u ps=2.2u
XT4_0a n3_0 cb4 n4_0 vss nfet_03v3 W=0.5u L=0.28u ad=0.3p as=0.3p pd=2.2u ps=2.2u
XT4_0b n3_1 c4 n4_0 vss nfet_03v3 W=0.5u L=0.28u ad=0.3p as=0.3p pd=2.2u ps=2.2u
XT4_1a n3_2 cb4 n4_1 vss nfet_03v3 W=0.5u L=0.28u ad=0.3p as=0.3p pd=2.2u ps=2.2u
XT4_1b n3_3 c4 n4_1 vss nfet_03v3 W=0.5u L=0.28u ad=0.3p as=0.3p pd=2.2u ps=2.2u
XT5_0a n4_0 cb5 out vss nfet_03v3 W=0.5u L=0.28u ad=0.3p as=0.3p pd=2.2u ps=2.2u
XT5_0b n4_1 c5 out vss nfet_03v3 W=0.5u L=0.28u ad=0.3p as=0.3p pd=2.2u ps=2.2u
.ends vdac6
