* idac_n / idac_p: 5-bit binary current-steering DAC on one fixed ladder tap (block B1), rev C.
* I_out = code * LSB, LSB = tap diode current / 8 (see bias_ladder); code 0 = off.
* Units: 31 x (2/2 um) devices (4 um^2), sources on the shifted rail; unselected
* bits are steered to 'dump', so the gate node never moves on a fine-code change.
* Ports (idac_n SINKS current from out, idac_p SOURCES current into out):
*  out   : output, compliance 0.5-2.5 V
*  dump  : tie to vdd (idac_n) / vss (idac_p)
*  b0..b4: fine code (b4 = MSB), active high, 3.3 V logic
*  g     : gate line (vgn<k> for idac_n, vgp<k> for idac_p, from bias_ladder; or any mirror line)
*  vsn / vsp : unit source rail (shifted rail from bias_rails)
*  vcas  : switch-gate level: vgln (~1.8 V) in bias_b1 for both polarities (rev B: vglp for idac_n);  vdd vss
.subckt idac_n out dump b0 b1 b2 b3 b4 g vsn vcas vdd vss
XU0_0 d0 g vsn vss nfet_03v3 W=2u L=2u ad=1.2p as=1.2p pd=5.2u ps=5.2u
XIC0p bd0 b0 vcas vcas pfet_03v3 W=1u L=0.28u ad=0.6p as=0.6p pd=3.2u ps=3.2u
XIC0n bd0 b0 vss vss nfet_03v3 W=0.5u L=0.28u ad=0.3p as=0.3p pd=2.2u ps=2.2u
XID0p bc0 bd0 vcas vcas pfet_03v3 W=1u L=0.28u ad=0.6p as=0.6p pd=3.2u ps=3.2u
XID0n bc0 bd0 vss vss nfet_03v3 W=0.5u L=0.28u ad=0.3p as=0.3p pd=2.2u ps=2.2u
XSO0 out bc0 d0 vss nfet_03v3 W=0.5u L=0.5u ad=0.3p as=0.3p pd=2.2u ps=2.2u
XSD0 dump bd0 d0 vss nfet_03v3 W=0.5u L=0.5u ad=0.3p as=0.3p pd=2.2u ps=2.2u
XU1_0 d1 g vsn vss nfet_03v3 W=2u L=2u ad=1.2p as=1.2p pd=5.2u ps=5.2u
XU1_1 d1 g vsn vss nfet_03v3 W=2u L=2u ad=1.2p as=1.2p pd=5.2u ps=5.2u
XIC1p bd1 b1 vcas vcas pfet_03v3 W=1u L=0.28u ad=0.6p as=0.6p pd=3.2u ps=3.2u
XIC1n bd1 b1 vss vss nfet_03v3 W=0.5u L=0.28u ad=0.3p as=0.3p pd=2.2u ps=2.2u
XID1p bc1 bd1 vcas vcas pfet_03v3 W=1u L=0.28u ad=0.6p as=0.6p pd=3.2u ps=3.2u
XID1n bc1 bd1 vss vss nfet_03v3 W=0.5u L=0.28u ad=0.3p as=0.3p pd=2.2u ps=2.2u
XSO1 out bc1 d1 vss nfet_03v3 W=0.5u L=0.5u ad=0.3p as=0.3p pd=2.2u ps=2.2u
XSD1 dump bd1 d1 vss nfet_03v3 W=0.5u L=0.5u ad=0.3p as=0.3p pd=2.2u ps=2.2u
XU2_0 d2 g vsn vss nfet_03v3 W=2u L=2u ad=1.2p as=1.2p pd=5.2u ps=5.2u
XU2_1 d2 g vsn vss nfet_03v3 W=2u L=2u ad=1.2p as=1.2p pd=5.2u ps=5.2u
XU2_2 d2 g vsn vss nfet_03v3 W=2u L=2u ad=1.2p as=1.2p pd=5.2u ps=5.2u
XU2_3 d2 g vsn vss nfet_03v3 W=2u L=2u ad=1.2p as=1.2p pd=5.2u ps=5.2u
XIC2p bd2 b2 vcas vcas pfet_03v3 W=1u L=0.28u ad=0.6p as=0.6p pd=3.2u ps=3.2u
XIC2n bd2 b2 vss vss nfet_03v3 W=0.5u L=0.28u ad=0.3p as=0.3p pd=2.2u ps=2.2u
XID2p bc2 bd2 vcas vcas pfet_03v3 W=1u L=0.28u ad=0.6p as=0.6p pd=3.2u ps=3.2u
XID2n bc2 bd2 vss vss nfet_03v3 W=0.5u L=0.28u ad=0.3p as=0.3p pd=2.2u ps=2.2u
XSO2 out bc2 d2 vss nfet_03v3 W=0.5u L=0.5u ad=0.3p as=0.3p pd=2.2u ps=2.2u
XSD2 dump bd2 d2 vss nfet_03v3 W=0.5u L=0.5u ad=0.3p as=0.3p pd=2.2u ps=2.2u
XU3_0 d3 g vsn vss nfet_03v3 W=2u L=2u ad=1.2p as=1.2p pd=5.2u ps=5.2u
XU3_1 d3 g vsn vss nfet_03v3 W=2u L=2u ad=1.2p as=1.2p pd=5.2u ps=5.2u
XU3_2 d3 g vsn vss nfet_03v3 W=2u L=2u ad=1.2p as=1.2p pd=5.2u ps=5.2u
XU3_3 d3 g vsn vss nfet_03v3 W=2u L=2u ad=1.2p as=1.2p pd=5.2u ps=5.2u
XU3_4 d3 g vsn vss nfet_03v3 W=2u L=2u ad=1.2p as=1.2p pd=5.2u ps=5.2u
XU3_5 d3 g vsn vss nfet_03v3 W=2u L=2u ad=1.2p as=1.2p pd=5.2u ps=5.2u
XU3_6 d3 g vsn vss nfet_03v3 W=2u L=2u ad=1.2p as=1.2p pd=5.2u ps=5.2u
XU3_7 d3 g vsn vss nfet_03v3 W=2u L=2u ad=1.2p as=1.2p pd=5.2u ps=5.2u
XIC3p bd3 b3 vcas vcas pfet_03v3 W=1u L=0.28u ad=0.6p as=0.6p pd=3.2u ps=3.2u
XIC3n bd3 b3 vss vss nfet_03v3 W=0.5u L=0.28u ad=0.3p as=0.3p pd=2.2u ps=2.2u
XID3p bc3 bd3 vcas vcas pfet_03v3 W=1u L=0.28u ad=0.6p as=0.6p pd=3.2u ps=3.2u
XID3n bc3 bd3 vss vss nfet_03v3 W=0.5u L=0.28u ad=0.3p as=0.3p pd=2.2u ps=2.2u
XSO3 out bc3 d3 vss nfet_03v3 W=0.5u L=0.5u ad=0.3p as=0.3p pd=2.2u ps=2.2u
XSD3 dump bd3 d3 vss nfet_03v3 W=0.5u L=0.5u ad=0.3p as=0.3p pd=2.2u ps=2.2u
XU4_0 d4 g vsn vss nfet_03v3 W=2u L=2u ad=1.2p as=1.2p pd=5.2u ps=5.2u
XU4_1 d4 g vsn vss nfet_03v3 W=2u L=2u ad=1.2p as=1.2p pd=5.2u ps=5.2u
XU4_2 d4 g vsn vss nfet_03v3 W=2u L=2u ad=1.2p as=1.2p pd=5.2u ps=5.2u
XU4_3 d4 g vsn vss nfet_03v3 W=2u L=2u ad=1.2p as=1.2p pd=5.2u ps=5.2u
XU4_4 d4 g vsn vss nfet_03v3 W=2u L=2u ad=1.2p as=1.2p pd=5.2u ps=5.2u
XU4_5 d4 g vsn vss nfet_03v3 W=2u L=2u ad=1.2p as=1.2p pd=5.2u ps=5.2u
XU4_6 d4 g vsn vss nfet_03v3 W=2u L=2u ad=1.2p as=1.2p pd=5.2u ps=5.2u
XU4_7 d4 g vsn vss nfet_03v3 W=2u L=2u ad=1.2p as=1.2p pd=5.2u ps=5.2u
XU4_8 d4 g vsn vss nfet_03v3 W=2u L=2u ad=1.2p as=1.2p pd=5.2u ps=5.2u
XU4_9 d4 g vsn vss nfet_03v3 W=2u L=2u ad=1.2p as=1.2p pd=5.2u ps=5.2u
XU4_10 d4 g vsn vss nfet_03v3 W=2u L=2u ad=1.2p as=1.2p pd=5.2u ps=5.2u
XU4_11 d4 g vsn vss nfet_03v3 W=2u L=2u ad=1.2p as=1.2p pd=5.2u ps=5.2u
XU4_12 d4 g vsn vss nfet_03v3 W=2u L=2u ad=1.2p as=1.2p pd=5.2u ps=5.2u
XU4_13 d4 g vsn vss nfet_03v3 W=2u L=2u ad=1.2p as=1.2p pd=5.2u ps=5.2u
XU4_14 d4 g vsn vss nfet_03v3 W=2u L=2u ad=1.2p as=1.2p pd=5.2u ps=5.2u
XU4_15 d4 g vsn vss nfet_03v3 W=2u L=2u ad=1.2p as=1.2p pd=5.2u ps=5.2u
XIC4p bd4 b4 vcas vcas pfet_03v3 W=1u L=0.28u ad=0.6p as=0.6p pd=3.2u ps=3.2u
XIC4n bd4 b4 vss vss nfet_03v3 W=0.5u L=0.28u ad=0.3p as=0.3p pd=2.2u ps=2.2u
XID4p bc4 bd4 vcas vcas pfet_03v3 W=1u L=0.28u ad=0.6p as=0.6p pd=3.2u ps=3.2u
XID4n bc4 bd4 vss vss nfet_03v3 W=0.5u L=0.28u ad=0.3p as=0.3p pd=2.2u ps=2.2u
XSO4 out bc4 d4 vss nfet_03v3 W=0.5u L=0.5u ad=0.3p as=0.3p pd=2.2u ps=2.2u
XSD4 dump bd4 d4 vss nfet_03v3 W=0.5u L=0.5u ad=0.3p as=0.3p pd=2.2u ps=2.2u
.ends idac_n
.subckt idac_p out dump b0 b1 b2 b3 b4 g vsp vcas vdd vss
XU0_0 d0 g vsp vdd pfet_03v3 W=2u L=2u ad=1.2p as=1.2p pd=5.2u ps=5.2u
XIC0p bc0 b0 vdd vdd pfet_03v3 W=1u L=0.28u ad=0.6p as=0.6p pd=3.2u ps=3.2u
XIC0n bc0 b0 vcas vss nfet_03v3 W=0.5u L=0.28u ad=0.3p as=0.3p pd=2.2u ps=2.2u
XID0p bd0 bc0 vdd vdd pfet_03v3 W=1u L=0.28u ad=0.6p as=0.6p pd=3.2u ps=3.2u
XID0n bd0 bc0 vcas vss nfet_03v3 W=0.5u L=0.28u ad=0.3p as=0.3p pd=2.2u ps=2.2u
XSO0 out bc0 d0 vdd pfet_03v3 W=0.5u L=0.5u ad=0.3p as=0.3p pd=2.2u ps=2.2u
XSD0 dump bd0 d0 vdd pfet_03v3 W=0.5u L=0.5u ad=0.3p as=0.3p pd=2.2u ps=2.2u
XU1_0 d1 g vsp vdd pfet_03v3 W=2u L=2u ad=1.2p as=1.2p pd=5.2u ps=5.2u
XU1_1 d1 g vsp vdd pfet_03v3 W=2u L=2u ad=1.2p as=1.2p pd=5.2u ps=5.2u
XIC1p bc1 b1 vdd vdd pfet_03v3 W=1u L=0.28u ad=0.6p as=0.6p pd=3.2u ps=3.2u
XIC1n bc1 b1 vcas vss nfet_03v3 W=0.5u L=0.28u ad=0.3p as=0.3p pd=2.2u ps=2.2u
XID1p bd1 bc1 vdd vdd pfet_03v3 W=1u L=0.28u ad=0.6p as=0.6p pd=3.2u ps=3.2u
XID1n bd1 bc1 vcas vss nfet_03v3 W=0.5u L=0.28u ad=0.3p as=0.3p pd=2.2u ps=2.2u
XSO1 out bc1 d1 vdd pfet_03v3 W=0.5u L=0.5u ad=0.3p as=0.3p pd=2.2u ps=2.2u
XSD1 dump bd1 d1 vdd pfet_03v3 W=0.5u L=0.5u ad=0.3p as=0.3p pd=2.2u ps=2.2u
XU2_0 d2 g vsp vdd pfet_03v3 W=2u L=2u ad=1.2p as=1.2p pd=5.2u ps=5.2u
XU2_1 d2 g vsp vdd pfet_03v3 W=2u L=2u ad=1.2p as=1.2p pd=5.2u ps=5.2u
XU2_2 d2 g vsp vdd pfet_03v3 W=2u L=2u ad=1.2p as=1.2p pd=5.2u ps=5.2u
XU2_3 d2 g vsp vdd pfet_03v3 W=2u L=2u ad=1.2p as=1.2p pd=5.2u ps=5.2u
XIC2p bc2 b2 vdd vdd pfet_03v3 W=1u L=0.28u ad=0.6p as=0.6p pd=3.2u ps=3.2u
XIC2n bc2 b2 vcas vss nfet_03v3 W=0.5u L=0.28u ad=0.3p as=0.3p pd=2.2u ps=2.2u
XID2p bd2 bc2 vdd vdd pfet_03v3 W=1u L=0.28u ad=0.6p as=0.6p pd=3.2u ps=3.2u
XID2n bd2 bc2 vcas vss nfet_03v3 W=0.5u L=0.28u ad=0.3p as=0.3p pd=2.2u ps=2.2u
XSO2 out bc2 d2 vdd pfet_03v3 W=0.5u L=0.5u ad=0.3p as=0.3p pd=2.2u ps=2.2u
XSD2 dump bd2 d2 vdd pfet_03v3 W=0.5u L=0.5u ad=0.3p as=0.3p pd=2.2u ps=2.2u
XU3_0 d3 g vsp vdd pfet_03v3 W=2u L=2u ad=1.2p as=1.2p pd=5.2u ps=5.2u
XU3_1 d3 g vsp vdd pfet_03v3 W=2u L=2u ad=1.2p as=1.2p pd=5.2u ps=5.2u
XU3_2 d3 g vsp vdd pfet_03v3 W=2u L=2u ad=1.2p as=1.2p pd=5.2u ps=5.2u
XU3_3 d3 g vsp vdd pfet_03v3 W=2u L=2u ad=1.2p as=1.2p pd=5.2u ps=5.2u
XU3_4 d3 g vsp vdd pfet_03v3 W=2u L=2u ad=1.2p as=1.2p pd=5.2u ps=5.2u
XU3_5 d3 g vsp vdd pfet_03v3 W=2u L=2u ad=1.2p as=1.2p pd=5.2u ps=5.2u
XU3_6 d3 g vsp vdd pfet_03v3 W=2u L=2u ad=1.2p as=1.2p pd=5.2u ps=5.2u
XU3_7 d3 g vsp vdd pfet_03v3 W=2u L=2u ad=1.2p as=1.2p pd=5.2u ps=5.2u
XIC3p bc3 b3 vdd vdd pfet_03v3 W=1u L=0.28u ad=0.6p as=0.6p pd=3.2u ps=3.2u
XIC3n bc3 b3 vcas vss nfet_03v3 W=0.5u L=0.28u ad=0.3p as=0.3p pd=2.2u ps=2.2u
XID3p bd3 bc3 vdd vdd pfet_03v3 W=1u L=0.28u ad=0.6p as=0.6p pd=3.2u ps=3.2u
XID3n bd3 bc3 vcas vss nfet_03v3 W=0.5u L=0.28u ad=0.3p as=0.3p pd=2.2u ps=2.2u
XSO3 out bc3 d3 vdd pfet_03v3 W=0.5u L=0.5u ad=0.3p as=0.3p pd=2.2u ps=2.2u
XSD3 dump bd3 d3 vdd pfet_03v3 W=0.5u L=0.5u ad=0.3p as=0.3p pd=2.2u ps=2.2u
XU4_0 d4 g vsp vdd pfet_03v3 W=2u L=2u ad=1.2p as=1.2p pd=5.2u ps=5.2u
XU4_1 d4 g vsp vdd pfet_03v3 W=2u L=2u ad=1.2p as=1.2p pd=5.2u ps=5.2u
XU4_2 d4 g vsp vdd pfet_03v3 W=2u L=2u ad=1.2p as=1.2p pd=5.2u ps=5.2u
XU4_3 d4 g vsp vdd pfet_03v3 W=2u L=2u ad=1.2p as=1.2p pd=5.2u ps=5.2u
XU4_4 d4 g vsp vdd pfet_03v3 W=2u L=2u ad=1.2p as=1.2p pd=5.2u ps=5.2u
XU4_5 d4 g vsp vdd pfet_03v3 W=2u L=2u ad=1.2p as=1.2p pd=5.2u ps=5.2u
XU4_6 d4 g vsp vdd pfet_03v3 W=2u L=2u ad=1.2p as=1.2p pd=5.2u ps=5.2u
XU4_7 d4 g vsp vdd pfet_03v3 W=2u L=2u ad=1.2p as=1.2p pd=5.2u ps=5.2u
XU4_8 d4 g vsp vdd pfet_03v3 W=2u L=2u ad=1.2p as=1.2p pd=5.2u ps=5.2u
XU4_9 d4 g vsp vdd pfet_03v3 W=2u L=2u ad=1.2p as=1.2p pd=5.2u ps=5.2u
XU4_10 d4 g vsp vdd pfet_03v3 W=2u L=2u ad=1.2p as=1.2p pd=5.2u ps=5.2u
XU4_11 d4 g vsp vdd pfet_03v3 W=2u L=2u ad=1.2p as=1.2p pd=5.2u ps=5.2u
XU4_12 d4 g vsp vdd pfet_03v3 W=2u L=2u ad=1.2p as=1.2p pd=5.2u ps=5.2u
XU4_13 d4 g vsp vdd pfet_03v3 W=2u L=2u ad=1.2p as=1.2p pd=5.2u ps=5.2u
XU4_14 d4 g vsp vdd pfet_03v3 W=2u L=2u ad=1.2p as=1.2p pd=5.2u ps=5.2u
XU4_15 d4 g vsp vdd pfet_03v3 W=2u L=2u ad=1.2p as=1.2p pd=5.2u ps=5.2u
XIC4p bc4 b4 vdd vdd pfet_03v3 W=1u L=0.28u ad=0.6p as=0.6p pd=3.2u ps=3.2u
XIC4n bc4 b4 vcas vss nfet_03v3 W=0.5u L=0.28u ad=0.3p as=0.3p pd=2.2u ps=2.2u
XID4p bd4 bc4 vdd vdd pfet_03v3 W=1u L=0.28u ad=0.6p as=0.6p pd=3.2u ps=3.2u
XID4n bd4 bc4 vcas vss nfet_03v3 W=0.5u L=0.28u ad=0.3p as=0.3p pd=2.2u ps=2.2u
XSO4 out bc4 d4 vdd pfet_03v3 W=0.5u L=0.5u ad=0.3p as=0.3p pd=2.2u ps=2.2u
XSD4 dump bd4 d4 vdd pfet_03v3 W=0.5u L=0.5u ad=0.3p as=0.3p pd=2.2u ps=2.2u
.ends idac_p
