* Membrane primitives for the analog neuron family (gf180mcuD, 3.3 V devices)
* Conventions: VDD = 3.3 V, VSS = 0. Membrane window 1.0-2.0 V (NMOS-cap flat region). Nominal EL = 1.30 V.
* Bias inputs are gate voltages from diode-connected mirror masters (vbn_* = nfet sink gate,
* vbp_* = pfet source gate), so every current tracks process like the bias generator.

* ------------------------------------------------------------------ mcap ---
* Membrane capacitor: thick-oxide nfet gate cap (S/D/B = VSS), ~4.0 fF/um^2 for Vg>=1.0 V.
* C ~= 4.0e-3 * W*L (W, L in um) -> 50 fF: 3.54u, 200 fF: 7.07u, 800 fF: 14.1u (square)
.subckt mcap top vss wl=7.07u
XC vss top vss vss nfet_03v3 W={wl} L={wl}
.ends mcap

* ------------------------------------------------------------- leak_ota ---
* Follower-integrator leak: subthreshold 5T OTA, + input = el, output = vm (also - input).
* I(into vm) ~= Ib * tanh((el - vm)/VL).  Optional diode degeneration (deg=1) widens VL.
* Tail current Ib mirrored from vbn (nfet master W/L = wt/lt).
.subckt leak_ota vm el vbn vdd vss wi=2u li=2u wt=2u lt=4u wl=2u ll=4u
XMT  t   vbn vss vss nfet_03v3 W={wt} L={lt}
XM1  a   el  t   vss nfet_03v3 W={wi} L={li}
XM2  vm  vm  t   vss nfet_03v3 W={wi} L={li}
XP1  a   a   vdd vdd pfet_03v3 W={wl} L={ll}
XP2  vm  a   vdd vdd pfet_03v3 W={wl} L={ll}
.ends leak_ota

* 2026-11-19 (D1 track finding, sim/results/dendrite/leak_lin.txt): with inputs 2/2 and diodes 2/2 the tail had
* 1-40 mV of headroom at ss/0 C (EL 1.2 V): g/Ib fell to 2.8 S/A and the OTA sourced only 25 % of Ib.
* Now inputs 4/1, degeneration diodes 8/1, and nominal EL = 1.30 V: g/Ib >= 5.2 S/A, linear range >= 75 mV,
* >= 92 % sourcing at all 15 corner/temperature cases (S = 100 and 2x).
* Level 4 (docs/m2-level4-proposal.md, 2026-11-22): inputs XM1/XM2 and diodes XD1/XD2 L 1 -> 0.5 um, same W (4/0.5,
* 8/0.5), drawn inside the old L = 1 um slots. At S = 10000 the input + diode Vgs stack outgrows EL at ss/0 C, the tail
* falls into triode and g collapses (0.08x of linear at EL 1.3, 0.61x at EL 1.5). L 0.5 lowers the stack Vgs
* (W/L x2, Vt roll-off): g 0.81x at ss/0, EL 1.5 (level 1), and the f-I passes there for every slot type.
* Cost: rest offset +4.5 mV systematic (DIBL, XM1 sees ~1 V more Vds than XM2), mismatch sigma 7.2 -> 9.2 mV.
.subckt leak_ota_deg vm el vbn vdd vss wi=4u li=0.5u wt=2u lt=4u wl=2u ll=4u wd=8u ld=0.5u
XMT  t   vbn vss vss nfet_03v3 W={wt} L={lt}
XM1  a   el  s1  vss nfet_03v3 W={wi} L={li}
XD1  s1  s1  t   vss nfet_03v3 W={wd} L={ld}
XM2  vm  vm  s2  vss nfet_03v3 W={wi} L={li}
XD2  s2  s2  t   vss nfet_03v3 W={wd} L={ld}
XP1  a   a   vdd vdd pfet_03v3 W={wl} L={ll}
XP2  vm  a   vdd vdd pfet_03v3 W={wl} L={ll}
.ends leak_ota_deg

* --------------------------------------------------------------- nmaster ---
* Diode-connected nfet that turns a bias current into a gate voltage (testbench / bias tree)
.subckt nmaster vb vss w=2u l=4u
XM vb vb vss vss nfet_03v3 W={w} L={l}
.ends nmaster
.subckt pmaster vb vdd w=2u l=4u
XM vb vb vdd vdd pfet_03v3 W={w} L={l}
.ends pmaster

* ---------------------------------------------------------------- mcap_r ---
* Rectangular membrane capacitor (same device as mcap): C ~= 4.0e-3 * W*L fF (W, L in um).
* Used by slot_ah_800 to fill the S slot's former trim space (11.7 x 11.6 -> ~540 fF).
.subckt mcap_r top vss w=7.07u l=7.07u
XC vss top vss vss nfet_03v3 W={w} L={l}
.ends mcap_r
