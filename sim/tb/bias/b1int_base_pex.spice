* NGSPICE file created from bias_b1.ext - technology: gf180mcuD

.subckt n_w2_l4_f4 a_n52_n200# a_852_n200# a_n852_n244# a_n956_n200# a_52_n244# a_n1756_n244#
+ a_1756_n200# a_n1844_n200# a_956_n244# VSUBS
X0 a_852_n200# a_52_n244# a_n52_n200# VSUBS nfet_03v3 ad=0.52p pd=2.52u as=0.52p ps=2.52u w=2u l=4u
X1 a_1756_n200# a_956_n244# a_852_n200# VSUBS nfet_03v3 ad=0.88p pd=4.88u as=0.52p ps=2.52u w=2u l=4u
X2 a_n956_n200# a_n1756_n244# a_n1844_n200# VSUBS nfet_03v3 ad=0.52p pd=2.52u as=0.88p ps=4.88u w=2u l=4u
X3 a_n52_n200# a_n852_n244# a_n956_n200# VSUBS nfet_03v3 ad=0.52p pd=2.52u as=0.52p ps=2.52u w=2u l=4u
C0 a_n852_n244# a_n52_n200# 0.07019f
C1 a_n852_n244# a_52_n244# 0.00519f
C2 a_n1844_n200# a_n1756_n244# 0.07019f
C3 a_52_n244# a_956_n244# 0.00519f
C4 a_956_n244# a_852_n200# 0.07019f
C5 a_n956_n200# a_n52_n200# 0.01073f
C6 a_956_n244# a_1756_n200# 0.07019f
C7 a_n852_n244# a_n1756_n244# 0.00519f
C8 a_52_n244# a_n52_n200# 0.07019f
C9 a_n52_n200# a_852_n200# 0.01073f
C10 a_52_n244# a_852_n200# 0.07019f
C11 a_852_n200# a_1756_n200# 0.01073f
C12 a_n956_n200# a_n1756_n244# 0.07019f
C13 a_n956_n200# a_n1844_n200# 0.01073f
C14 a_n852_n244# a_n956_n200# 0.07019f
C15 a_1756_n200# VSUBS 0.41176f
C16 a_852_n200# VSUBS 0.648f
C17 a_n52_n200# VSUBS 0.64292f
C18 a_n956_n200# VSUBS 0.648f
C19 a_n1844_n200# VSUBS 0.41176f
.ends

.subckt rx_n4 line vdd vss
XD vss line line line line line vss vss line vss n_w2_l4_f4
C0 vdd vss 0.06604f
C1 line vss 2.16208f
.ends

.subckt n_w2_l4_f2 a_n52_n200# a_852_n200# a_n852_n244# a_n940_n200# a_52_n244# VSUBS
X0 a_852_n200# a_52_n244# a_n52_n200# VSUBS nfet_03v3 ad=0.88p pd=4.88u as=0.52p ps=2.52u w=2u l=4u
X1 a_n52_n200# a_n852_n244# a_n940_n200# VSUBS nfet_03v3 ad=0.52p pd=2.52u as=0.88p ps=4.88u w=2u l=4u
C0 a_n52_n200# a_n852_n244# 0.07019f
C1 a_52_n244# a_n852_n244# 0.00519f
C2 a_n52_n200# a_52_n244# 0.07019f
C3 a_n940_n200# a_n852_n244# 0.07019f
C4 a_n52_n200# a_n940_n200# 0.01073f
C5 a_n52_n200# a_852_n200# 0.01073f
C6 a_52_n244# a_852_n200# 0.07019f
C7 a_852_n200# VSUBS 0.41176f
C8 a_n52_n200# VSUBS 0.65308f
C9 a_n940_n200# VSUBS 0.41176f
.ends

.subckt rx_n2 line vdd vss
XD line vss line vss line vss n_w2_l4_f2
C0 vdd line 0.00181f
C1 vdd vss 0.06098f
C2 line vss 1.08247f
.ends

.subckt p_w2_l4 a_400_n200# a_n400_n244# w_n574_n330# a_n488_n200# VSUBS
X0 a_400_n200# a_n400_n244# a_n488_n200# w_n574_n330# pfet_03v3 ad=0.88p pd=4.88u as=0.88p ps=4.88u w=2u l=4u
C0 a_400_n200# a_n488_n200# 0.01073f
C1 a_400_n200# a_n400_n244# 0.07019f
C2 a_n400_n244# a_n488_n200# 0.07019f
C3 a_400_n200# w_n574_n330# 0.07409f
C4 a_n488_n200# w_n574_n330# 0.07409f
C5 a_n400_n244# w_n574_n330# 0.42229f
C6 a_400_n200# VSUBS 0.18936f
C7 a_n488_n200# VSUBS 0.18936f
C8 w_n574_n330# VSUBS 2.27304f
.ends

.subckt rx_p24 vss vdd line
XD line line vdd vdd vss p_w2_l4
C0 line vdd 0.78494f
C1 line vss -0.06364f
C2 vdd vss 5.17939f
.ends

.subckt n_w2_l4 a_400_n200# a_n400_n244# a_n488_n200# VSUBS
X0 a_400_n200# a_n400_n244# a_n488_n200# VSUBS nfet_03v3 ad=0.88p pd=4.88u as=0.88p ps=4.88u w=2u l=4u
C0 a_n488_n200# a_400_n200# 0.01073f
C1 a_n400_n244# a_400_n200# 0.07019f
C2 a_n488_n200# a_n400_n244# 0.07019f
C3 a_400_n200# VSUBS 0.41684f
C4 a_n488_n200# VSUBS 0.41684f
.ends

.subckt rx_n1 line vdd vss
XD line line vss vss n_w2_l4
C0 line vdd 0.00323f
C1 vdd vss 0.05846f
C2 line vss 0.60968f
.ends

.subckt p_w1_l4 a_n488_n100# a_400_n100# a_n400_n144# w_n574_n230# VSUBS
X0 a_400_n100# a_n400_n144# a_n488_n100# w_n574_n230# pfet_03v3 ad=0.44p pd=2.88u as=0.44p ps=2.88u w=1u l=4u
C0 a_n488_n100# a_n400_n144# 0.03474f
C1 a_400_n100# w_n574_n230# 0.03707f
C2 a_n488_n100# w_n574_n230# 0.03707f
C3 a_400_n100# a_n488_n100# 0.00531f
C4 w_n574_n230# a_n400_n144# 0.42229f
C5 a_400_n100# a_n400_n144# 0.03474f
C6 a_400_n100# VSUBS 0.15701f
C7 a_n488_n100# VSUBS 0.15701f
C8 w_n574_n230# VSUBS 1.58424f
.ends

.subckt rx_p05 line vdd vss
XD vdd line line vdd vss p_w1_l4
C0 vdd line 0.81576f
C1 line vss 0.00304f
C2 vdd vss 5.0752f
.ends

.subckt p_w4_l2_f5 a_n304_n400# a_704_n400# a_n704_n444# a_n808_n400# a_304_n444#
+ a_n1208_n444# a_n1296_n400# a_1208_n400# w_n1382_n530# a_200_n400# a_808_n444# a_n200_n444#
+ VSUBS
X0 a_1208_n400# a_808_n444# a_704_n400# w_n1382_n530# pfet_03v3 ad=1.76p pd=8.88u as=1.04p ps=4.52u w=4u l=2u
X1 a_704_n400# a_304_n444# a_200_n400# w_n1382_n530# pfet_03v3 ad=1.04p pd=4.52u as=1.04p ps=4.52u w=4u l=2u
X2 a_n808_n400# a_n1208_n444# a_n1296_n400# w_n1382_n530# pfet_03v3 ad=1.04p pd=4.52u as=1.76p ps=8.88u w=4u l=2u
X3 a_n304_n400# a_n704_n444# a_n808_n400# w_n1382_n530# pfet_03v3 ad=1.04p pd=4.52u as=1.04p ps=4.52u w=4u l=2u
X4 a_200_n400# a_n200_n444# a_n304_n400# w_n1382_n530# pfet_03v3 ad=1.04p pd=4.52u as=1.04p ps=4.52u w=4u l=2u
C0 a_200_n400# a_304_n444# 0.11799f
C1 a_n704_n444# w_n1382_n530# 0.21994f
C2 a_808_n444# a_704_n400# 0.11799f
C3 a_n304_n400# a_n200_n444# 0.11799f
C4 a_304_n444# a_808_n444# 0.00519f
C5 a_808_n444# a_1208_n400# 0.11799f
C6 w_n1382_n530# a_n808_n400# 0.18497f
C7 a_n1296_n400# a_n808_n400# 0.04287f
C8 a_n1296_n400# w_n1382_n530# 0.12268f
C9 a_n200_n444# a_304_n444# 0.00519f
C10 a_304_n444# a_704_n400# 0.11799f
C11 a_704_n400# a_1208_n400# 0.04287f
C12 a_n304_n400# a_n704_n444# 0.11799f
C13 a_n704_n444# a_n1208_n444# 0.00519f
C14 a_200_n400# w_n1382_n530# 0.18497f
C15 a_n200_n444# a_n704_n444# 0.00519f
C16 a_n304_n400# a_n808_n400# 0.04287f
C17 a_808_n444# w_n1382_n530# 0.2233f
C18 a_n1208_n444# a_n808_n400# 0.11799f
C19 a_n304_n400# w_n1382_n530# 0.18497f
C20 w_n1382_n530# a_n1208_n444# 0.2233f
C21 a_n1296_n400# a_n1208_n444# 0.11799f
C22 a_n200_n444# w_n1382_n530# 0.21994f
C23 a_704_n400# w_n1382_n530# 0.18497f
C24 a_200_n400# a_n304_n400# 0.04287f
C25 a_304_n444# w_n1382_n530# 0.21994f
C26 a_1208_n400# w_n1382_n530# 0.12268f
C27 a_200_n400# a_n200_n444# 0.11799f
C28 a_n704_n444# a_n808_n400# 0.11799f
C29 a_200_n400# a_704_n400# 0.04287f
C30 a_1208_n400# VSUBS 0.19832f
C31 a_704_n400# VSUBS 0.12191f
C32 a_200_n400# VSUBS 0.11851f
C33 a_n304_n400# VSUBS 0.11851f
C34 a_n808_n400# VSUBS 0.12191f
C35 a_n1296_n400# VSUBS 0.19832f
C36 w_n1382_n530# VSUBS 8.78952f
.ends

.subckt p_w2_l1 a_100_n200# a_n100_n244# w_n274_n330# a_n188_n200# VSUBS
X0 a_100_n200# a_n100_n244# a_n188_n200# w_n274_n330# pfet_03v3 ad=0.88p pd=4.88u as=0.88p ps=4.88u w=2u l=1u
C0 w_n274_n330# a_n100_n244# 0.12884f
C1 a_100_n200# a_n100_n244# 0.04231f
C2 a_100_n200# w_n274_n330# 0.04851f
C3 a_n188_n200# a_n100_n244# 0.04231f
C4 a_n188_n200# w_n274_n330# 0.04851f
C5 a_100_n200# a_n188_n200# 0.03858f
C6 a_100_n200# VSUBS 0.11088f
C7 a_n188_n200# VSUBS 0.11088f
C8 w_n274_n330# VSUBS 1.08504f
.ends

.subckt n_w4_l2_f6 a_n956_n444# a_1060_n444# a_556_n444# a_n52_n400# a_n1548_n400#
+ a_n1060_n400# a_452_n400# a_n452_n444# a_n556_n400# a_n1460_n444# a_1460_n400# a_52_n444#
+ a_956_n400# VSUBS
X0 a_n556_n400# a_n956_n444# a_n1060_n400# VSUBS nfet_03v3 ad=1.04p pd=4.52u as=1.04p ps=4.52u w=4u l=2u
X1 a_n52_n400# a_n452_n444# a_n556_n400# VSUBS nfet_03v3 ad=1.04p pd=4.52u as=1.04p ps=4.52u w=4u l=2u
X2 a_452_n400# a_52_n444# a_n52_n400# VSUBS nfet_03v3 ad=1.04p pd=4.52u as=1.04p ps=4.52u w=4u l=2u
X3 a_n1060_n400# a_n1460_n444# a_n1548_n400# VSUBS nfet_03v3 ad=1.04p pd=4.52u as=1.76p ps=8.88u w=4u l=2u
X4 a_956_n400# a_556_n444# a_452_n400# VSUBS nfet_03v3 ad=1.04p pd=4.52u as=1.04p ps=4.52u w=4u l=2u
X5 a_1460_n400# a_1060_n444# a_956_n400# VSUBS nfet_03v3 ad=1.76p pd=8.88u as=1.04p ps=4.52u w=4u l=2u
C0 a_1060_n444# a_1460_n400# 0.11799f
C1 a_n452_n444# a_n52_n400# 0.11799f
C2 a_52_n444# a_452_n400# 0.11799f
C3 a_n556_n400# a_n956_n444# 0.11799f
C4 a_n1548_n400# a_n1060_n400# 0.04287f
C5 a_n1460_n444# a_n956_n444# 0.00519f
C6 a_956_n400# a_556_n444# 0.11799f
C7 a_956_n400# a_1060_n444# 0.11799f
C8 a_556_n444# a_1060_n444# 0.00519f
C9 a_956_n400# a_452_n400# 0.04287f
C10 a_452_n400# a_n52_n400# 0.04287f
C11 a_452_n400# a_556_n444# 0.11799f
C12 a_n452_n444# a_n956_n444# 0.00519f
C13 a_n1060_n400# a_n956_n444# 0.11799f
C14 a_n452_n444# a_n556_n400# 0.11799f
C15 a_n556_n400# a_n1060_n400# 0.04287f
C16 a_n1460_n444# a_n1060_n400# 0.11799f
C17 a_n52_n400# a_n556_n400# 0.04287f
C18 a_52_n444# a_n452_n444# 0.00519f
C19 a_n1548_n400# a_n1460_n444# 0.11799f
C20 a_52_n444# a_n52_n400# 0.11799f
C21 a_52_n444# a_556_n444# 0.00519f
C22 a_956_n400# a_1460_n400# 0.04287f
C23 a_1460_n400# VSUBS 0.33857f
C24 a_956_n400# VSUBS 0.34773f
C25 a_452_n400# VSUBS 0.34265f
C26 a_n52_n400# VSUBS 0.34265f
C27 a_n556_n400# VSUBS 0.34265f
C28 a_n1060_n400# VSUBS 0.34773f
C29 a_n1548_n400# VSUBS 0.33857f
.ends

.subckt n_w2_l2_f2 a_n52_n200# a_452_n200# a_n452_n244# a_n540_n200# a_52_n244# VSUBS
X0 a_452_n200# a_52_n244# a_n52_n200# VSUBS nfet_03v3 ad=0.88p pd=4.88u as=0.52p ps=2.52u w=2u l=2u
X1 a_n52_n200# a_n452_n244# a_n540_n200# VSUBS nfet_03v3 ad=0.52p pd=2.52u as=0.88p ps=4.88u w=2u l=2u
C0 a_n52_n200# a_52_n244# 0.0587f
C1 a_n540_n200# a_n452_n244# 0.0587f
C2 a_n52_n200# a_n452_n244# 0.0587f
C3 a_452_n200# a_n52_n200# 0.02133f
C4 a_n52_n200# a_n540_n200# 0.02133f
C5 a_52_n244# a_n452_n244# 0.00519f
C6 a_452_n200# a_52_n244# 0.0587f
C7 a_452_n200# VSUBS 0.26162f
C8 a_n52_n200# VSUBS 0.35281f
C9 a_n540_n200# VSUBS 0.26162f
.ends

.subckt n_w2_l1 a_100_n200# a_n100_n244# a_n188_n200# VSUBS
X0 a_100_n200# a_n100_n244# a_n188_n200# VSUBS nfet_03v3 ad=0.88p pd=4.88u as=0.88p ps=4.88u w=2u l=1u
C0 a_100_n200# a_n100_n244# 0.04231f
C1 a_n188_n200# a_n100_n244# 0.04231f
C2 a_100_n200# a_n188_n200# 0.03858f
C3 a_100_n200# VSUBS 0.19164f
C4 a_n188_n200# VSUBS 0.19164f
.ends

.subckt p_w2_l2_f8 a_n52_n200# a_n1060_n200# a_452_n200# a_1564_n244# a_n452_n244#
+ w_n2138_n330# a_n556_n200# a_n1460_n244# a_1460_n200# a_52_n244# a_n1564_n200# a_956_n200#
+ a_n2052_n200# a_n956_n244# a_1060_n244# a_n1964_n244# a_556_n244# a_1964_n200# VSUBS
X0 a_1964_n200# a_1564_n244# a_1460_n200# w_n2138_n330# pfet_03v3 ad=0.88p pd=4.88u as=0.52p ps=2.52u w=2u l=2u
X1 a_452_n200# a_52_n244# a_n52_n200# w_n2138_n330# pfet_03v3 ad=0.52p pd=2.52u as=0.52p ps=2.52u w=2u l=2u
X2 a_956_n200# a_556_n244# a_452_n200# w_n2138_n330# pfet_03v3 ad=0.52p pd=2.52u as=0.52p ps=2.52u w=2u l=2u
X3 a_1460_n200# a_1060_n244# a_956_n200# w_n2138_n330# pfet_03v3 ad=0.52p pd=2.52u as=0.52p ps=2.52u w=2u l=2u
X4 a_n1564_n200# a_n1964_n244# a_n2052_n200# w_n2138_n330# pfet_03v3 ad=0.52p pd=2.52u as=0.88p ps=4.88u w=2u l=2u
X5 a_n1060_n200# a_n1460_n244# a_n1564_n200# w_n2138_n330# pfet_03v3 ad=0.52p pd=2.52u as=0.52p ps=2.52u w=2u l=2u
X6 a_n556_n200# a_n956_n244# a_n1060_n200# w_n2138_n330# pfet_03v3 ad=0.52p pd=2.52u as=0.52p ps=2.52u w=2u l=2u
X7 a_n52_n200# a_n452_n244# a_n556_n200# w_n2138_n330# pfet_03v3 ad=0.52p pd=2.52u as=0.52p ps=2.52u w=2u l=2u
C0 a_n2052_n200# w_n2138_n330# 0.0618f
C1 a_n452_n244# a_n52_n200# 0.0587f
C2 a_556_n244# a_52_n244# 0.00519f
C3 a_1060_n244# w_n2138_n330# 0.21994f
C4 a_1060_n244# a_556_n244# 0.00519f
C5 a_n452_n244# w_n2138_n330# 0.21994f
C6 a_n1460_n244# w_n2138_n330# 0.21994f
C7 a_556_n244# w_n2138_n330# 0.21994f
C8 a_n52_n200# a_n556_n200# 0.02133f
C9 a_n1564_n200# a_n1060_n200# 0.02133f
C10 a_n1564_n200# a_n1964_n244# 0.0587f
C11 a_452_n200# a_956_n200# 0.02133f
C12 a_n556_n200# w_n2138_n330# 0.09155f
C13 a_1460_n200# a_1964_n200# 0.02133f
C14 a_n956_n244# w_n2138_n330# 0.21994f
C15 a_956_n200# a_1460_n200# 0.02133f
C16 a_n452_n244# a_n556_n200# 0.0587f
C17 a_n452_n244# a_n956_n244# 0.00519f
C18 a_n956_n244# a_n1460_n244# 0.00519f
C19 a_52_n244# a_452_n200# 0.0587f
C20 a_1564_n244# a_1964_n200# 0.0587f
C21 a_1564_n244# a_1460_n200# 0.0587f
C22 a_n52_n200# a_452_n200# 0.02133f
C23 a_n2052_n200# a_n1964_n244# 0.0587f
C24 a_n2052_n200# a_n1564_n200# 0.02133f
C25 w_n2138_n330# a_n1060_n200# 0.09155f
C26 w_n2138_n330# a_452_n200# 0.09155f
C27 a_n1964_n244# w_n2138_n330# 0.2233f
C28 a_n1564_n200# w_n2138_n330# 0.09155f
C29 a_1060_n244# a_1460_n200# 0.0587f
C30 a_n1460_n244# a_n1060_n200# 0.0587f
C31 a_n956_n244# a_n556_n200# 0.0587f
C32 w_n2138_n330# a_1964_n200# 0.0618f
C33 a_1060_n244# a_956_n200# 0.0587f
C34 w_n2138_n330# a_1460_n200# 0.09155f
C35 a_n1460_n244# a_n1964_n244# 0.00519f
C36 w_n2138_n330# a_956_n200# 0.09155f
C37 a_n1460_n244# a_n1564_n200# 0.0587f
C38 a_556_n244# a_452_n200# 0.0587f
C39 a_n52_n200# a_52_n244# 0.0587f
C40 a_1564_n244# a_1060_n244# 0.00519f
C41 a_1564_n244# w_n2138_n330# 0.2233f
C42 a_556_n244# a_956_n200# 0.0587f
C43 a_n556_n200# a_n1060_n200# 0.02133f
C44 w_n2138_n330# a_52_n244# 0.21994f
C45 a_n52_n200# w_n2138_n330# 0.09155f
C46 a_n956_n244# a_n1060_n200# 0.0587f
C47 a_n452_n244# a_52_n244# 0.00519f
C48 a_1964_n200# VSUBS 0.13364f
C49 a_1460_n200# VSUBS 0.12191f
C50 a_956_n200# VSUBS 0.11851f
C51 a_452_n200# VSUBS 0.11851f
C52 a_n52_n200# VSUBS 0.11851f
C53 a_n556_n200# VSUBS 0.11851f
C54 a_n1060_n200# VSUBS 0.11851f
C55 a_n1564_n200# VSUBS 0.12191f
C56 a_n2052_n200# VSUBS 0.13364f
C57 w_n2138_n330# VSUBS 8.46648f
.ends

.subckt n_w2_l2_f8 a_n52_n200# a_n1060_n200# a_452_n200# a_1564_n244# a_n452_n244#
+ a_n556_n200# a_n1460_n244# a_1460_n200# a_52_n244# a_n1564_n200# a_956_n200# a_n2052_n200#
+ a_n956_n244# a_1060_n244# a_n1964_n244# a_556_n244# a_1964_n200# VSUBS
X0 a_1964_n200# a_1564_n244# a_1460_n200# VSUBS nfet_03v3 ad=0.88p pd=4.88u as=0.52p ps=2.52u w=2u l=2u
X1 a_452_n200# a_52_n244# a_n52_n200# VSUBS nfet_03v3 ad=0.52p pd=2.52u as=0.52p ps=2.52u w=2u l=2u
X2 a_956_n200# a_556_n244# a_452_n200# VSUBS nfet_03v3 ad=0.52p pd=2.52u as=0.52p ps=2.52u w=2u l=2u
X3 a_1460_n200# a_1060_n244# a_956_n200# VSUBS nfet_03v3 ad=0.52p pd=2.52u as=0.52p ps=2.52u w=2u l=2u
X4 a_n1564_n200# a_n1964_n244# a_n2052_n200# VSUBS nfet_03v3 ad=0.52p pd=2.52u as=0.88p ps=4.88u w=2u l=2u
X5 a_n1060_n200# a_n1460_n244# a_n1564_n200# VSUBS nfet_03v3 ad=0.52p pd=2.52u as=0.52p ps=2.52u w=2u l=2u
X6 a_n556_n200# a_n956_n244# a_n1060_n200# VSUBS nfet_03v3 ad=0.52p pd=2.52u as=0.52p ps=2.52u w=2u l=2u
X7 a_n52_n200# a_n452_n244# a_n556_n200# VSUBS nfet_03v3 ad=0.52p pd=2.52u as=0.52p ps=2.52u w=2u l=2u
C0 a_1060_n244# a_956_n200# 0.0587f
C1 a_n1060_n200# a_n956_n244# 0.0587f
C2 a_452_n200# a_n52_n200# 0.02133f
C3 a_n1460_n244# a_n1564_n200# 0.0587f
C4 a_452_n200# a_956_n200# 0.02133f
C5 a_n1060_n200# a_n1460_n244# 0.0587f
C6 a_n2052_n200# a_n1564_n200# 0.02133f
C7 a_n956_n244# a_n452_n244# 0.00519f
C8 a_52_n244# a_556_n244# 0.00519f
C9 a_n452_n244# a_52_n244# 0.00519f
C10 a_1460_n200# a_1964_n200# 0.02133f
C11 a_n556_n200# a_n1060_n200# 0.02133f
C12 a_n1460_n244# a_n1964_n244# 0.00519f
C13 a_n1060_n200# a_n1564_n200# 0.02133f
C14 a_n1460_n244# a_n956_n244# 0.00519f
C15 a_n52_n200# a_52_n244# 0.0587f
C16 a_n52_n200# a_n452_n244# 0.0587f
C17 a_1060_n244# a_556_n244# 0.00519f
C18 a_1564_n244# a_1964_n200# 0.0587f
C19 a_n1564_n200# a_n1964_n244# 0.0587f
C20 a_956_n200# a_556_n244# 0.0587f
C21 a_n556_n200# a_n956_n244# 0.0587f
C22 a_n2052_n200# a_n1964_n244# 0.0587f
C23 a_1460_n200# a_1060_n244# 0.0587f
C24 a_452_n200# a_556_n244# 0.0587f
C25 a_1460_n200# a_1564_n244# 0.0587f
C26 a_n556_n200# a_n452_n244# 0.0587f
C27 a_452_n200# a_52_n244# 0.0587f
C28 a_1460_n200# a_956_n200# 0.02133f
C29 a_1564_n244# a_1060_n244# 0.00519f
C30 a_n556_n200# a_n52_n200# 0.02133f
C31 a_1964_n200# VSUBS 0.26162f
C32 a_1460_n200# VSUBS 0.34773f
C33 a_956_n200# VSUBS 0.34265f
C34 a_452_n200# VSUBS 0.34265f
C35 a_n52_n200# VSUBS 0.34265f
C36 a_n556_n200# VSUBS 0.34265f
C37 a_n1060_n200# VSUBS 0.34265f
C38 a_n1564_n200# VSUBS 0.34773f
C39 a_n2052_n200# VSUBS 0.26162f
.ends

.subckt p_w2_l2 a_n288_n200# a_200_n200# a_n200_n244# w_n374_n330# VSUBS
X0 a_200_n200# a_n200_n244# a_n288_n200# w_n374_n330# pfet_03v3 ad=0.88p pd=4.88u as=0.88p ps=4.88u w=2u l=2u
C0 a_n288_n200# a_n200_n244# 0.0587f
C1 w_n374_n330# a_200_n200# 0.0618f
C2 a_n288_n200# a_200_n200# 0.02133f
C3 w_n374_n330# a_n288_n200# 0.0618f
C4 a_200_n200# a_n200_n244# 0.0587f
C5 w_n374_n330# a_n200_n244# 0.22666f
C6 a_200_n200# VSUBS 0.13704f
C7 a_n288_n200# VSUBS 0.13704f
C8 w_n374_n330# VSUBS 1.48104f
.ends

.subckt n_w2_l2 a_n288_n200# a_200_n200# a_n200_n244# VSUBS
X0 a_200_n200# a_n200_n244# a_n288_n200# VSUBS nfet_03v3 ad=0.88p pd=4.88u as=0.88p ps=4.88u w=2u l=2u
C0 a_200_n200# a_n288_n200# 0.02133f
C1 a_n200_n244# a_200_n200# 0.0587f
C2 a_n200_n244# a_n288_n200# 0.0587f
C3 a_200_n200# VSUBS 0.2667f
C4 a_n288_n200# VSUBS 0.2667f
.ends

.subckt p_w2_l2_f2 a_n52_n200# a_452_n200# a_n452_n244# a_n540_n200# w_n626_n330#
+ a_52_n244# VSUBS
X0 a_452_n200# a_52_n244# a_n52_n200# w_n626_n330# pfet_03v3 ad=0.88p pd=4.88u as=0.52p ps=2.52u w=2u l=2u
X1 a_n52_n200# a_n452_n244# a_n540_n200# w_n626_n330# pfet_03v3 ad=0.52p pd=2.52u as=0.88p ps=4.88u w=2u l=2u
C0 a_52_n244# a_n452_n244# 0.00519f
C1 w_n626_n330# a_n540_n200# 0.0618f
C2 w_n626_n330# a_52_n244# 0.2233f
C3 a_n52_n200# a_452_n200# 0.02133f
C4 a_n52_n200# a_n452_n244# 0.0587f
C5 w_n626_n330# a_452_n200# 0.0618f
C6 a_52_n244# a_452_n200# 0.0587f
C7 a_n52_n200# a_n540_n200# 0.02133f
C8 a_n540_n200# a_n452_n244# 0.0587f
C9 a_n52_n200# w_n626_n330# 0.09155f
C10 a_n52_n200# a_52_n244# 0.0587f
C11 w_n626_n330# a_n452_n244# 0.2233f
C12 a_452_n200# VSUBS 0.13364f
C13 a_n52_n200# VSUBS 0.12532f
C14 a_n540_n200# VSUBS 0.13364f
C15 w_n626_n330# VSUBS 2.47896f
.ends

.subckt bias_ladder in_n vgp3 m1_4760_1320# m1_6020_10200# m1_3298_2050# m1_5022_10210#
+ m1_4906_9490# m1_3898_9610# a_7580_5314# m1_3530_1930# a_1580_5314# vss vgp5 vdd
+ m1_6282_1450# m1_3666_9610# m1_5516_1920# a_4580_5314# m1_4538_1930# vgn3 a_5188_4156#
+ vgn5 vsp vsn vglp vgp6 a_3036_4156# vgln in_p
XnpSE m1_3898_9610# m1_4906_9490# vglp m1_3666_9610# vglp vglp in_p m1_6020_10200#
+ vdd m1_5022_10210# vglp vglp vss p_w4_l2_f5
XFP3 vgp3 a_1580_5314# vgp3 vss vss p_w2_l1
XnnSE vgln vgln vgln m1_4760_1320# in_n m1_3298_2050# m1_4538_1930# vgln m1_3530_1930#
+ vgln m1_6282_1450# vgln m1_5516_1920# vss n_w4_l2_f6
XnnSH6T m1_6282_1450# vdd vgln a_7580_5314# vgln vss n_w2_l2_f2
XFP5 vgp5 a_4580_5314# vgp5 vss vss p_w2_l1
XFN3 vgn3 a_3036_4156# vdd vss n_w2_l1
XDP3 vsp vsp a_1580_5314# vgp3 vgp3 vdd a_1580_5314# vgp3 a_1580_5314# vgp3 a_1580_5314#
+ vsp vsp vgp3 vgp3 vgp3 vgp3 vsp vss p_w2_l2_f8
XFP6 vgp6 a_7580_5314# vgp6 vss vss p_w2_l1
XFN5 vgn5 a_5188_4156# vdd vss n_w2_l1
XDP5 vsp vsp a_4580_5314# vgp5 vgp5 vdd a_4580_5314# vgp5 a_4580_5314# vgp5 a_4580_5314#
+ vsp vsp vgp5 vgp5 vgp5 vgp5 vsp vss p_w2_l2_f8
XDN3 vsn vsn a_3036_4156# vgn3 vgn3 a_3036_4156# vgn3 a_3036_4156# vgn3 a_3036_4156#
+ vsn vsn vgn3 vgn3 vgn3 vgn3 vsn vss n_w2_l2_f8
XDP6 vsp vsp a_7580_5314# vgp6 vgp6 vdd a_7580_5314# vgp6 a_7580_5314# vgp6 a_7580_5314#
+ vsp vsp vgp6 vgp6 vgp6 vgp6 vsp vss p_w2_l2_f8
XBP3 vsp vgp3 vgp6 vdd vss p_w2_l2
XDN5 vsn vsn a_5188_4156# vgn5 vgn5 a_5188_4156# vgn5 a_5188_4156# vgn5 a_5188_4156#
+ vsn vsn vgn5 vgn5 vgn5 vgn5 vsn vss n_w2_l2_f8
XBP5 vsp vgp5 vgp6 vdd vss p_w2_l2
XBN3 vgn3 vsn vgn5 vss n_w2_l2
XnnSH01 vdd m1_3298_2050# vgln in_n vgln vss n_w2_l2_f2
XBP6 vsp vgp6 vgp6 vdd vss p_w2_l2
XnnSH24 vdd m1_4538_1930# vgln m1_3530_1930# vgln vss n_w2_l2_f2
XBN5 vgn5 vsn vgn5 vss n_w2_l2
XnpSH3 m1_5022_10210# a_3036_4156# vglp vdd vss p_w2_l2
XnpSH5T m1_6020_10200# vss vglp a_5188_4156# vdd vglp vss p_w2_l2_f2
XnpSH01 vss m1_3666_9610# vglp in_p vdd vglp vss p_w2_l2_f2
XnpSH24 vss m1_4906_9490# vglp m1_3898_9610# vdd vglp vss p_w2_l2_f2
XnnSH3 m1_4760_1320# a_1580_5314# vgln vss n_w2_l2
XnnSH5 m1_5516_1920# a_4580_5314# vgln vss n_w2_l2
C0 vgn3 a_3036_4156# 0.80773f
C1 vgp6 a_4580_5314# 0.58598f
C2 vglp m1_4906_9490# 0.38823f
C3 vgp6 vgp5 0.35193f
C4 m1_3898_9610# m1_4906_9490# 0.00256f
C5 vdd a_4580_5314# 1.73154f
C6 vglp m1_3898_9610# 0.4412f
C7 vgln a_7580_5314# 0.10386f
C8 a_3036_4156# vgln 0.00497f
C9 vgn3 a_4580_5314# 0
C10 m1_4906_9490# a_5188_4156# 0
C11 vdd vgp5 3.48321f
C12 vgp6 vgn5 0.00421f
C13 m1_3666_9610# vsp 0.00336f
C14 vglp a_5188_4156# 0.03121f
C15 vgn3 vgp5 0
C16 a_3036_4156# m1_6020_10200# 0.00106f
C17 vgn5 vdd 0.10294f
C18 vgln a_4580_5314# 0.49007f
C19 in_p vsp 0.13384f
C20 vgn3 vgn5 0.06099f
C21 m1_4760_1320# m1_3298_2050# -0
C22 vgp3 m1_3666_9610# 0
C23 vgp6 vdd 5.47456f
C24 m1_4906_9490# vsp 0.00394f
C25 a_3036_4156# m1_5022_10210# 0
C26 vglp a_1580_5314# 0
C27 m1_3530_1930# m1_3298_2050# 0.33404f
C28 vsn m1_3298_2050# 0.01482f
C29 vglp vsp 0.34417f
C30 vgn5 vgln 0.02641f
C31 m1_3530_1930# in_n 0.00742f
C32 vgp5 m1_6020_10200# 0.01029f
C33 vsn in_n 0.17665f
C34 vgp3 in_p 0.0017f
C35 m1_3898_9610# vsp 0.00217f
C36 vgn3 vdd 0.17852f
C37 a_1580_5314# a_5188_4156# 0.12061f
C38 vsp a_5188_4156# 0.36532f
C39 vgp3 m1_4906_9490# 0.0279f
C40 vgp3 vglp 0.48996f
C41 vgln vdd 2.28298f
C42 vgp6 m1_6020_10200# 0.04538f
C43 vgp3 m1_3898_9610# 0.04635f
C44 vgn3 vgln 0.47992f
C45 vgp3 a_5188_4156# 0.00485f
C46 a_1580_5314# vsp 0.66577f
C47 m1_6282_1450# a_5188_4156# 0.00163f
C48 vdd m1_6020_10200# 0.18314f
C49 vgp6 m1_5022_10210# 0.00778f
C50 m1_5516_1920# a_5188_4156# 0
C51 vdd m1_5022_10210# 0.0596f
C52 vgp3 a_1580_5314# 1.41665f
C53 vgp3 vsp 1.5721f
C54 vsn a_5188_4156# 0.39706f
C55 m1_5516_1920# a_1580_5314# 0.05179f
C56 m1_4538_1930# a_1580_5314# 0.00316f
C57 a_3036_4156# m1_4906_9490# 0.00404f
C58 m1_4760_1320# a_1580_5314# -0.02087f
C59 vglp a_7580_5314# 0
C60 a_3036_4156# vglp 0.03135f
C61 m1_5022_10210# m1_6020_10200# 0.0182f
C62 vsn a_1580_5314# 0.16559f
C63 vdd m1_3298_2050# 0.05664f
C64 m1_5516_1920# m1_6282_1450# 0.00546f
C65 a_3036_4156# m1_3898_9610# 0
C66 vgn3 m1_3298_2050# 0.00878f
C67 vdd in_n 0.07179f
C68 m1_4538_1930# m1_6282_1450# 0
C69 a_7580_5314# a_5188_4156# 0.41188f
C70 a_3036_4156# a_5188_4156# 0.27107f
C71 vgn3 in_n 0.00344f
C72 a_4580_5314# vglp 0
C73 vgp6 m1_3666_9610# 0.00881f
C74 m1_4538_1930# m1_5516_1920# 0.04505f
C75 m1_4760_1320# m1_6282_1450# 0
C76 vgp5 vglp 0.1447f
C77 vgln m1_3298_2050# 0.28259f
C78 vdd m1_3666_9610# 0.05802f
C79 a_4580_5314# a_5188_4156# 0.4945f
C80 vgp6 in_p 0
C81 vgln in_n 0.47579f
C82 m1_4760_1320# m1_4538_1930# 0.16397f
C83 a_1580_5314# a_7580_5314# 0.02594f
C84 a_3036_4156# a_1580_5314# 0.14234f
C85 vgp5 a_5188_4156# 0.18257f
C86 a_7580_5314# vsp 0.4942f
C87 a_3036_4156# vsp 0.0883f
C88 vgp6 m1_4906_9490# 0.01016f
C89 vdd in_p 1.4091f
C90 vgp6 vglp 0.49335f
C91 m1_3530_1930# m1_4760_1320# 0
C92 vsn m1_4760_1320# 0
C93 vgn5 a_5188_4156# 1.16612f
C94 vdd m1_4906_9490# 0.08697f
C95 a_4580_5314# a_1580_5314# 0.06015f
C96 vgp6 m1_3898_9610# 0.01466f
C97 vsn m1_3530_1930# 0.01898f
C98 a_4580_5314# vsp 0.80414f
C99 vdd vglp 5.16392f
C100 vgp5 a_1580_5314# 0.16694f
C101 vgp3 a_7580_5314# 0.20875f
C102 vgp3 a_3036_4156# 0.03477f
C103 vgp6 a_5188_4156# 0.14378f
C104 m1_6282_1450# a_7580_5314# 0.00102f
C105 vgp5 vsp 0.78845f
C106 vdd m1_3898_9610# 0.15129f
C107 m1_5516_1920# a_7580_5314# 0
C108 vgn5 a_1580_5314# 0.21481f
C109 vdd a_5188_4156# 0.39619f
C110 m1_6282_1450# a_4580_5314# 0.21332f
C111 vgp6 a_1580_5314# 0.24833f
C112 vgp3 vgp5 0.00867f
C113 m1_4906_9490# m1_6020_10200# 0.00282f
C114 m1_5516_1920# a_4580_5314# -0.00812f
C115 vgp6 vsp 1.5758f
C116 vglp m1_6020_10200# 0.27284f
C117 vsn a_7580_5314# 0.31213f
C118 a_3036_4156# vsn 0.14439f
C119 m1_4538_1930# a_4580_5314# 0.00211f
C120 vgln a_5188_4156# 0.06289f
C121 vdd a_1580_5314# 1.62506f
C122 in_n m1_3298_2050# 0.02053f
C123 vgn5 m1_6282_1450# 0
C124 vdd vsp 3.61245f
C125 vgn3 a_1580_5314# 0.04478f
C126 m1_4906_9490# m1_5022_10210# 0.22756f
C127 m1_4760_1320# a_4580_5314# 0
C128 vglp m1_5022_10210# 0.22247f
C129 vgn5 m1_5516_1920# 0.00187f
C130 a_5188_4156# m1_6020_10200# 0.00728f
C131 vgp3 vgp6 0.38706f
C132 vsn a_4580_5314# 0.36645f
C133 vgn5 m1_4538_1930# 0.00106f
C134 m1_3898_9610# m1_5022_10210# 0
C135 vsn vgp5 0.17915f
C136 vgln a_1580_5314# 0.07765f
C137 vgp3 vdd 3.78758f
C138 a_5188_4156# m1_5022_10210# 0
C139 vdd m1_6282_1450# 0.04143f
C140 vgp3 vgn3 0.00714f
C141 a_3036_4156# a_7580_5314# 0.0745f
C142 vsn vgn5 1.27598f
C143 vdd m1_5516_1920# 0.03975f
C144 vgn3 m1_5516_1920# 0.00897f
C145 vsp m1_6020_10200# 0.02019f
C146 vdd m1_4538_1930# 0.27134f
C147 vgp6 vsn 0.03394f
C148 vgn3 m1_4538_1930# 0.08119f
C149 vdd m1_4760_1320# 0.02112f
C150 vgln m1_6282_1450# 0.19109f
C151 a_4580_5314# a_7580_5314# 0.29998f
C152 a_3036_4156# a_4580_5314# 0.1705f
C153 vgn3 m1_4760_1320# 0.12142f
C154 vsp m1_5022_10210# 0.00393f
C155 vdd m1_3530_1930# 0.05235f
C156 vgln m1_5516_1920# 0.29348f
C157 vgp5 a_7580_5314# 0.32553f
C158 a_3036_4156# vgp5 0.72992f
C159 vsn vdd 0.58029f
C160 vgn3 m1_3530_1930# 0.04819f
C161 vgn3 vsn 1.08253f
C162 in_p m1_3666_9610# 0.0161f
C163 vgln m1_4538_1930# 0.37308f
C164 vgn5 a_7580_5314# 0.26387f
C165 a_3036_4156# vgn5 0.11976f
C166 vgln m1_4760_1320# 0.22369f
C167 vgp5 a_4580_5314# 1.87678f
C168 vgp3 m1_5022_10210# 0.00919f
C169 vglp m1_3666_9610# 0.38355f
C170 vgln m1_3530_1930# 0.4385f
C171 vsn vgln 0.48987f
C172 vgp6 a_7580_5314# 1.8657f
C173 vgp6 a_3036_4156# 0.42099f
C174 m1_3666_9610# m1_3898_9610# 0.08953f
C175 vgn5 a_4580_5314# 0.10109f
C176 vglp in_p 0.7203f
C177 vdd a_7580_5314# 0.83515f
C178 a_3036_4156# vdd 1.03471f
C179 vgn5 vgp5 0.0996f
C180 a_1580_5314# vss 1.70876f
C181 m1_4906_9490# vss -0.04028f
C182 m1_3898_9610# vss 0.09303f
C183 m1_3666_9610# vss -0.03204f
C184 in_p vss -0
C185 vglp vss -0.37909f
C186 vdd vss 86.64923f
C187 vgln vss 3.3753f
C188 vgn5 vss 4.03953f
C189 a_5188_4156# vss 1.44532f
C190 vsp vss -0.14973f
C191 a_7580_5314# vss 1.40837f
C192 vsn vss 4.2523f
C193 a_3036_4156# vss 1.80989f
C194 vgn3 vss 3.02208f
C195 vgp6 vss 2.43502f
C196 a_4580_5314# vss 3.24613f
C197 vgp5 vss 1.91603f
C198 m1_6282_1450# vss 0.17092f
C199 m1_5516_1920# vss -0.01345f
C200 m1_4538_1930# vss 0.07674f
C201 m1_4760_1320# vss -0.06206f
C202 m1_3530_1930# vss 0.05197f
C203 m1_3298_2050# vss 0.04402f
C204 in_n vss 1.35999f
C205 vgp3 vss 2.7134f
C206 m1_6020_10200# vss -0.16436f
C207 m1_5022_10210# vss -0.09509f
.ends

.subckt p_w1_l0p28_f2 a_n196_n100# a_n52_n100# w_n282_n230# a_108_n100# a_52_n144#
+ a_n108_n144# VSUBS
X0 a_n52_n100# a_n108_n144# a_n196_n100# w_n282_n230# pfet_03v3 ad=0.26p pd=1.52u as=0.44p ps=2.88u w=1u l=0.28u
X1 a_108_n100# a_52_n144# a_n52_n100# w_n282_n230# pfet_03v3 ad=0.44p pd=2.88u as=0.26p ps=1.52u w=1u l=0.28u
C0 a_n108_n144# a_n52_n100# 0.00769f
C1 a_n52_n100# w_n282_n230# 0.01828f
C2 a_n108_n144# a_n196_n100# 0.00769f
C3 a_108_n100# w_n282_n230# 0.01808f
C4 a_52_n144# a_n108_n144# 0.00519f
C5 a_n196_n100# w_n282_n230# 0.01808f
C6 a_n52_n100# a_108_n100# 0.04256f
C7 a_n52_n100# a_n196_n100# 0.04256f
C8 a_52_n144# w_n282_n230# 0.05505f
C9 a_52_n144# a_n52_n100# 0.00769f
C10 a_n108_n144# w_n282_n230# 0.05505f
C11 a_52_n144# a_108_n100# 0.00769f
C12 a_108_n100# VSUBS 0.0563f
C13 a_n52_n100# VSUBS 0.03533f
C14 a_n196_n100# VSUBS 0.0563f
C15 w_n282_n230# VSUBS 0.77832f
.ends

.subckt n_w0p5_l0p28_f2 a_n52_n50# a_n196_n50# a_52_n94# a_108_n50# a_n108_n94# VSUBS
X0 a_108_n50# a_52_n94# a_n52_n50# VSUBS nfet_03v3 ad=0.22p pd=1.88u as=0.13p ps=1.02u w=0.5u l=0.28u
X1 a_n52_n50# a_n108_n94# a_n196_n50# VSUBS nfet_03v3 ad=0.13p pd=1.02u as=0.22p ps=1.88u w=0.5u l=0.28u
C0 a_n196_n50# a_n52_n50# 0.02085f
C1 a_52_n94# a_108_n50# 0.00377f
C2 a_52_n94# a_n52_n50# 0.00377f
C3 a_n52_n50# a_n108_n94# 0.00377f
C4 a_108_n50# a_n52_n50# 0.02085f
C5 a_n196_n50# a_n108_n94# 0.00377f
C6 a_52_n94# a_n108_n94# 0.00519f
C7 a_108_n50# VSUBS 0.07479f
C8 a_n52_n50# VSUBS 0.09458f
C9 a_n196_n50# VSUBS 0.07479f
.ends

.subckt p_w2_l2_f7 a_n704_n244# a_n808_n200# a_304_n244# a_n1712_n244# a_1712_n200#
+ a_n1800_n200# a_n1208_n244# a_1208_n200# a_200_n200# a_1312_n244# a_808_n244# a_n200_n244#
+ a_n304_n200# w_n1886_n330# a_n1312_n200# a_704_n200# VSUBS
X0 a_n1312_n200# a_n1712_n244# a_n1800_n200# w_n1886_n330# pfet_03v3 ad=0.52p pd=2.52u as=0.88p ps=4.88u w=2u l=2u
X1 a_n304_n200# a_n704_n244# a_n808_n200# w_n1886_n330# pfet_03v3 ad=0.52p pd=2.52u as=0.52p ps=2.52u w=2u l=2u
X2 a_200_n200# a_n200_n244# a_n304_n200# w_n1886_n330# pfet_03v3 ad=0.52p pd=2.52u as=0.52p ps=2.52u w=2u l=2u
X3 a_1712_n200# a_1312_n244# a_1208_n200# w_n1886_n330# pfet_03v3 ad=0.88p pd=4.88u as=0.52p ps=2.52u w=2u l=2u
X4 a_1208_n200# a_808_n244# a_704_n200# w_n1886_n330# pfet_03v3 ad=0.52p pd=2.52u as=0.52p ps=2.52u w=2u l=2u
X5 a_n808_n200# a_n1208_n244# a_n1312_n200# w_n1886_n330# pfet_03v3 ad=0.52p pd=2.52u as=0.52p ps=2.52u w=2u l=2u
X6 a_704_n200# a_304_n244# a_200_n200# w_n1886_n330# pfet_03v3 ad=0.52p pd=2.52u as=0.52p ps=2.52u w=2u l=2u
C0 a_n1208_n244# a_n704_n244# 0.00519f
C1 a_808_n244# a_304_n244# 0.00519f
C2 a_n808_n200# a_n1208_n244# 0.0587f
C3 a_304_n244# a_704_n200# 0.0587f
C4 a_1712_n200# w_n1886_n330# 0.0618f
C5 a_808_n244# a_1208_n200# 0.0587f
C6 a_n808_n200# a_n1312_n200# 0.02133f
C7 a_1208_n200# a_704_n200# 0.02133f
C8 a_n200_n244# w_n1886_n330# 0.21994f
C9 a_n1208_n244# a_n1312_n200# 0.0587f
C10 a_n304_n200# w_n1886_n330# 0.09155f
C11 a_n1800_n200# a_n1312_n200# 0.02133f
C12 a_200_n200# a_704_n200# 0.02133f
C13 a_n304_n200# a_n200_n244# 0.0587f
C14 a_1312_n244# a_1208_n200# 0.0587f
C15 a_808_n244# a_704_n200# 0.0587f
C16 a_304_n244# w_n1886_n330# 0.21994f
C17 a_n1208_n244# a_n1712_n244# 0.00519f
C18 a_1208_n200# w_n1886_n330# 0.09155f
C19 a_n1712_n244# a_n1800_n200# 0.0587f
C20 a_n704_n244# w_n1886_n330# 0.21994f
C21 a_1712_n200# a_1208_n200# 0.02133f
C22 a_n200_n244# a_304_n244# 0.00519f
C23 a_n808_n200# w_n1886_n330# 0.09155f
C24 a_n1712_n244# a_n1312_n200# 0.0587f
C25 a_1312_n244# a_808_n244# 0.00519f
C26 a_n200_n244# a_n704_n244# 0.00519f
C27 a_n1208_n244# w_n1886_n330# 0.21994f
C28 a_n304_n200# a_n704_n244# 0.0587f
C29 a_200_n200# w_n1886_n330# 0.09155f
C30 a_n1800_n200# w_n1886_n330# 0.0618f
C31 a_n808_n200# a_n304_n200# 0.02133f
C32 w_n1886_n330# a_n1312_n200# 0.09155f
C33 a_808_n244# w_n1886_n330# 0.21994f
C34 a_n200_n244# a_200_n200# 0.0587f
C35 w_n1886_n330# a_704_n200# 0.09155f
C36 a_n304_n200# a_200_n200# 0.02133f
C37 a_n1712_n244# w_n1886_n330# 0.2233f
C38 a_n808_n200# a_n704_n244# 0.0587f
C39 a_1312_n244# w_n1886_n330# 0.2233f
C40 a_304_n244# a_200_n200# 0.0587f
C41 a_1312_n244# a_1712_n200# 0.0587f
C42 a_1712_n200# VSUBS 0.13364f
C43 a_1208_n200# VSUBS 0.12191f
C44 a_704_n200# VSUBS 0.11851f
C45 a_200_n200# VSUBS 0.11851f
C46 a_n304_n200# VSUBS 0.11851f
C47 a_n808_n200# VSUBS 0.11851f
C48 a_n1312_n200# VSUBS 0.12191f
C49 a_n1800_n200# VSUBS 0.13364f
C50 w_n1886_n330# VSUBS 7.46856f
.ends

.subckt p_w0p5_l0p5_f2 a_n52_n50# w_n326_n180# a_52_n94# a_152_n50# a_n240_n50# a_n152_n94#
+ VSUBS
X0 a_152_n50# a_52_n94# a_n52_n50# w_n326_n180# pfet_03v3 ad=0.22p pd=1.88u as=0.13p ps=1.02u w=0.5u l=0.5u
X1 a_n52_n50# a_n152_n94# a_n240_n50# w_n326_n180# pfet_03v3 ad=0.13p pd=1.02u as=0.22p ps=1.88u w=0.5u l=0.5u
C0 a_n240_n50# a_n52_n50# 0.01511f
C1 a_52_n94# a_n52_n50# 0.00625f
C2 a_152_n50# a_n52_n50# 0.01511f
C3 a_n152_n94# w_n326_n180# 0.07657f
C4 a_n240_n50# w_n326_n180# 0.01152f
C5 a_52_n94# w_n326_n180# 0.07657f
C6 a_152_n50# w_n326_n180# 0.01152f
C7 a_n152_n94# a_n240_n50# 0.00625f
C8 a_n152_n94# a_52_n94# 0.00519f
C9 a_152_n50# a_52_n94# 0.00625f
C10 a_n52_n50# w_n326_n180# 0.01225f
C11 a_n152_n94# a_n52_n50# 0.00625f
C12 a_152_n50# VSUBS 0.04588f
C13 a_n52_n50# VSUBS 0.04684f
C14 a_n240_n50# VSUBS 0.04588f
C15 w_n326_n180# VSUBS 0.70416f
.ends

.subckt idac_p b0 b1 b2 b3 b4 out vss m1_988_3464# a_1582_4392# a_2432_4392# m1_988_2804#
+ vdd a_528_4392# a_2228_4392# a_1378_4392# a_3078_4392# a_3928_4392# a_3282_4392#
+ m1_988_888# m1_240_3480# dump a_4132_4392# m1_1500_4312# vcas a_732_4392# vsp g
XU4b vsp vsp m1_988_888# g g vdd m1_988_888# g m1_988_888# g m1_988_888# vsp vsp g
+ g g g vsp vss p_w2_l2_f8
XU3 vsp vsp m1_988_2804# g g vdd m1_988_2804# g m1_988_2804# g m1_988_2804# vsp vsp
+ g g g g vsp vss p_w2_l2_f8
XIP0 a_528_4392# vdd vdd a_732_4392# a_528_4392# b0 vss p_w1_l0p28_f2
XIP1 a_1378_4392# vdd vdd a_1582_4392# a_1378_4392# b1 vss p_w1_l0p28_f2
XIN0 vcas a_528_4392# a_528_4392# a_732_4392# b0 vss n_w0p5_l0p28_f2
XIP2 a_2228_4392# vdd vdd a_2432_4392# a_2228_4392# b2 vss p_w1_l0p28_f2
XIN1 vcas a_1378_4392# a_1378_4392# a_1582_4392# b1 vss n_w0p5_l0p28_f2
XIP3 a_3078_4392# vdd vdd a_3282_4392# a_3078_4392# b3 vss p_w1_l0p28_f2
XIN3 vcas a_3078_4392# a_3078_4392# a_3282_4392# b3 vss n_w0p5_l0p28_f2
XIN2 vcas a_2228_4392# a_2228_4392# a_2432_4392# b2 vss n_w0p5_l0p28_f2
XIP4 a_3928_4392# vdd vdd a_4132_4392# a_3928_4392# b4 vss p_w1_l0p28_f2
XIN4 vcas a_3928_4392# a_3928_4392# a_4132_4392# b4 vss n_w0p5_l0p28_f2
XU210 g vsp g g m1_240_3480# vsp g vsp vsp g g g m1_988_3464# vdd m1_988_3464# m1_1500_4312#
+ vss p_w2_l2_f7
XSW0 m1_240_3480# vdd a_732_4392# dump out a_528_4392# vss p_w0p5_l0p5_f2
XSW2 m1_988_3464# vdd a_2432_4392# dump out a_2228_4392# vss p_w0p5_l0p5_f2
XSW1 m1_1500_4312# vdd a_1582_4392# dump out a_1378_4392# vss p_w0p5_l0p5_f2
XSW3 m1_988_2804# vdd a_3282_4392# dump out a_3078_4392# vss p_w0p5_l0p5_f2
XSW4 m1_988_888# vdd a_4132_4392# dump out a_3928_4392# vss p_w0p5_l0p5_f2
XU4a vsp vsp m1_988_888# g g vdd m1_988_888# g m1_988_888# g m1_988_888# vsp vsp g
+ g g g vsp vss p_w2_l2_f8
C0 out b2 0
C1 a_3928_4392# a_4132_4392# 0.1229f
C2 out vcas 0.13451f
C3 vdd a_4132_4392# 0.5253f
C4 a_3928_4392# g 0.00474f
C5 a_2228_4392# a_1378_4392# 0.0019f
C6 vdd g 8.74367f
C7 b0 a_1378_4392# 0.01025f
C8 a_528_4392# g 0.0015f
C9 b1 a_1378_4392# 0.276f
C10 a_3282_4392# b2 0
C11 a_1582_4392# a_1378_4392# 0.20351f
C12 dump a_2432_4392# 0.12878f
C13 a_3282_4392# vcas 0.02198f
C14 b3 a_3078_4392# 0.27358f
C15 m1_240_3480# a_1378_4392# 0
C16 g a_2228_4392# 0.00218f
C17 b0 g 0
C18 a_732_4392# a_1378_4392# 0.07957f
C19 vdd a_2432_4392# 0.43511f
C20 b1 g 0
C21 g a_1582_4392# 0.00236f
C22 m1_240_3480# a_4132_4392# 0
C23 vsp a_4132_4392# 0
C24 m1_988_3464# a_1378_4392# 0.00387f
C25 out a_3078_4392# 0.01364f
C26 g m1_240_3480# 1.39137f
C27 g vsp 4.05384f
C28 g a_732_4392# 0.00258f
C29 a_2228_4392# a_2432_4392# 0.18456f
C30 vcas b2 0.29794f
C31 b3 g 0
C32 out a_1378_4392# 0.01469f
C33 b4 dump 0
C34 g m1_988_3464# 0.69646f
C35 a_3282_4392# a_3078_4392# 0.17009f
C36 a_3928_4392# dump 0.02728f
C37 m1_1500_4312# a_3078_4392# 0
C38 vdd dump 1.00627f
C39 m1_988_2804# a_3078_4392# 0.00631f
C40 a_3928_4392# b4 0.20796f
C41 b4 vdd 0.36351f
C42 a_528_4392# dump 0.01755f
C43 out g 0.69731f
C44 a_3928_4392# vdd 0.65032f
C45 m1_1500_4312# a_1378_4392# 0.01574f
C46 b3 a_2432_4392# 0
C47 m1_988_888# a_4132_4392# 0.03507f
C48 m1_988_888# g 2.54331f
C49 a_528_4392# vdd 0.44354f
C50 dump a_2228_4392# 0.22128f
C51 m1_988_3464# a_2432_4392# 0.0039f
C52 b0 dump 0
C53 a_3078_4392# b2 0.00848f
C54 vcas a_3078_4392# 0.04594f
C55 a_3282_4392# g 0.00215f
C56 b1 dump 0.03413f
C57 m1_988_2804# a_4132_4392# 0
C58 vdd a_2228_4392# 0.45461f
C59 m1_1500_4312# g 0.40807f
C60 g m1_988_2804# 1.11336f
C61 dump a_1582_4392# 0.29887f
C62 b0 vdd 0.15292f
C63 out a_2432_4392# 0.03176f
C64 b2 a_1378_4392# 0.00157f
C65 dump m1_240_3480# 0.01325f
C66 dump vsp 0.00712f
C67 vcas a_1378_4392# 0.02974f
C68 b1 vdd 0.16268f
C69 a_528_4392# b0 0.35816f
C70 b4 m1_240_3480# 0
C71 b4 vsp 0
C72 dump a_732_4392# 0.11406f
C73 vdd a_1582_4392# 0.31851f
C74 a_528_4392# b1 0.00327f
C75 a_3928_4392# m1_240_3480# 0.00167f
C76 a_3928_4392# vsp 0
C77 b3 dump 0
C78 vdd m1_240_3480# 1.54226f
C79 vdd vsp 1.94491f
C80 a_3282_4392# a_2432_4392# 0
C81 b3 b4 0.00351f
C82 dump m1_988_3464# 0.03151f
C83 vdd a_732_4392# 0.42048f
C84 vcas a_4132_4392# 0.00535f
C85 m1_1500_4312# a_2432_4392# 0.0018f
C86 a_528_4392# m1_240_3480# 0.0165f
C87 a_528_4392# vsp 0
C88 g b2 0
C89 m1_988_2804# a_2432_4392# 0
C90 b1 a_2228_4392# 0
C91 b3 a_3928_4392# 0.00713f
C92 b3 vdd 0.18861f
C93 b1 b0 0.00796f
C94 a_528_4392# a_732_4392# 0.11371f
C95 a_2228_4392# a_1582_4392# 0.06282f
C96 vdd m1_988_3464# 0.12699f
C97 b0 a_1582_4392# 0
C98 out dump 0.14997f
C99 b0 m1_240_3480# 0.0015f
C100 b1 a_1582_4392# 0.02085f
C101 b0 a_732_4392# 0.02072f
C102 m1_988_888# dump 0.05324f
C103 b3 a_2228_4392# 0.00173f
C104 out a_3928_4392# 0.0039f
C105 out vdd 1.27153f
C106 b2 a_2432_4392# 0.25812f
C107 b1 a_732_4392# 0.0505f
C108 m1_988_888# b4 0
C109 vcas a_2432_4392# 0.00805f
C110 m1_988_3464# a_2228_4392# 0.01383f
C111 m1_240_3480# vsp 0.29136f
C112 a_732_4392# a_1582_4392# 0
C113 a_3282_4392# dump 0.08877f
C114 a_528_4392# out 0.16739f
C115 m1_988_888# a_3928_4392# 0.01013f
C116 m1_988_888# vdd 1.79894f
C117 m1_1500_4312# dump 0.07029f
C118 b4 a_3282_4392# 0
C119 a_732_4392# m1_240_3480# 0.00483f
C120 dump m1_988_2804# 0.02557f
C121 a_3078_4392# a_4132_4392# 0
C122 a_3928_4392# a_3282_4392# 0.05112f
C123 a_3282_4392# vdd 0.51129f
C124 out a_2228_4392# 0.01362f
C125 g a_3078_4392# 0.00203f
C126 a_3928_4392# m1_988_2804# 0
C127 m1_1500_4312# vdd 0.16576f
C128 out b0 0.34956f
C129 m1_988_3464# m1_240_3480# 0.00676f
C130 vdd m1_988_2804# 0.36066f
C131 m1_988_3464# vsp 0.09235f
C132 out b1 0.01042f
C133 m1_988_3464# a_732_4392# 0.00112f
C134 g a_1378_4392# 0.00206f
C135 out a_1582_4392# 0.01339f
C136 dump b2 0.03612f
C137 a_3282_4392# a_2228_4392# 0
C138 out m1_240_3480# 0.20558f
C139 out vsp 0
C140 dump vcas 0.09162f
C141 b4 b2 0
C142 m1_1500_4312# a_2228_4392# 0
C143 m1_988_2804# a_2228_4392# 0
C144 b4 vcas 0.21592f
C145 out a_732_4392# 0.05477f
C146 a_3078_4392# a_2432_4392# 0.16749f
C147 m1_988_888# m1_240_3480# 0.04999f
C148 m1_988_888# vsp 0.84877f
C149 g a_4132_4392# 0
C150 vdd b2 0.206f
C151 b3 out 0
C152 a_3928_4392# vcas 0.02838f
C153 vdd vcas 0.12325f
C154 m1_1500_4312# b1 0
C155 out m1_988_3464# 0.21869f
C156 m1_1500_4312# a_1582_4392# 0.0222f
C157 m1_988_2804# a_1582_4392# 0
C158 a_528_4392# vcas 0.05572f
C159 m1_1500_4312# m1_240_3480# 0.0068f
C160 m1_1500_4312# vsp 0.21814f
C161 m1_988_2804# m1_240_3480# 0.46309f
C162 m1_988_2804# vsp 0.24604f
C163 m1_1500_4312# a_732_4392# 0
C164 b3 a_3282_4392# 0.02628f
C165 a_2228_4392# b2 0.1815f
C166 vcas a_2228_4392# 0.02559f
C167 b3 m1_988_2804# 0.0024f
C168 b0 vcas 0.06096f
C169 b1 b2 0.00341f
C170 g a_2432_4392# 0.00264f
C171 m1_1500_4312# m1_988_3464# 0.46191f
C172 b1 vcas 0.16455f
C173 m1_988_2804# m1_988_3464# 0.03356f
C174 m1_988_888# out 0.03269f
C175 dump a_3078_4392# 0.11788f
C176 b2 a_1582_4392# 0
C177 vcas a_1582_4392# 0.01431f
C178 b4 a_3078_4392# 0.00186f
C179 out a_3282_4392# 0.01304f
C180 a_3928_4392# a_3078_4392# 0.01001f
C181 vdd a_3078_4392# 0.51762f
C182 m1_1500_4312# out 0.15763f
C183 dump a_1378_4392# 0.12224f
C184 out m1_988_2804# 0.06468f
C185 vcas a_732_4392# 0.07256f
C186 b3 b2 0.09189f
C187 b3 vcas 0.13187f
C188 m1_988_888# m1_1500_4312# 0
C189 m1_988_888# m1_988_2804# 0.20776f
C190 m1_988_3464# b2 0
C191 vdd a_1378_4392# 0.49318f
C192 dump a_4132_4392# 0.04726f
C193 a_2228_4392# a_3078_4392# 0.00233f
C194 a_3282_4392# m1_988_2804# 0.00333f
C195 a_528_4392# a_1378_4392# 0.00968f
C196 dump g 0.05176f
C197 b4 a_4132_4392# 0.14194f
C198 m1_1500_4312# m1_988_2804# 0.11128f
C199 m1_988_888# vss 1.02294f
C200 vsp vss 0.2353f
C201 g vss -2.45698f
C202 vdd vss 23.98689f
C203 a_4132_4392# vss 0.12907f
C204 a_3928_4392# vss 0.16119f
C205 a_3282_4392# vss 0.00178f
C206 a_3078_4392# vss 0.11146f
C207 m1_1500_4312# vss -0.02333f
C208 a_1582_4392# vss 0.0096f
C209 a_1378_4392# vss 0.1291f
C210 a_2432_4392# vss 0.06008f
C211 a_2228_4392# vss 0.1444f
C212 dump vss 0.07406f
C213 m1_240_3480# vss 0.32442f
C214 out vss 0.5531f
C215 a_732_4392# vss -0.00313f
C216 a_528_4392# vss 0.1515f
C217 m1_988_3464# vss -0.03952f
C218 b4 vss 0.44872f
C219 b3 vss 0.20878f
C220 b2 vss 0.37183f
C221 vcas vss 1.54593f
C222 b1 vss 0.2684f
C223 b0 vss 0.41869f
C224 m1_988_2804# vss -0.01016f
.ends

.subckt r_w4_l3p97 a_n400_n519# a_n400_397# VSUBS
X0 a_n400_397# a_n400_n519# VSUBS ppolyf_u_1k r_width=4u r_length=3.97u
C0 a_n400_n519# a_n400_397# 0.02123f
C1 a_n400_n519# VSUBS 0.80683f
C2 a_n400_397# VSUBS 0.80683f
.ends

.subckt n_w8_l0p5 a_50_n800# a_n50_n844# a_n138_n800# VSUBS
X0 a_50_n800# a_n50_n844# a_n138_n800# VSUBS nfet_03v3 ad=3.52p pd=16.88u as=3.52p ps=16.88u w=8u l=0.5u
C0 a_50_n800# a_n50_n844# 0.10385f
C1 a_50_n800# a_n138_n800# 0.25117f
C2 a_n138_n800# a_n50_n844# 0.10385f
C3 a_50_n800# VSUBS 0.38495f
C4 a_n138_n800# VSUBS 0.38495f
.ends

.subckt n_w4_l0p5 a_n138_n400# a_50_n400# a_n50_n444# VSUBS
X0 a_50_n400# a_n50_n444# a_n138_n400# VSUBS nfet_03v3 ad=1.76p pd=8.88u as=1.76p ps=8.88u w=4u l=0.5u
C0 a_50_n400# a_n50_n444# 0.05179f
C1 a_50_n400# a_n138_n400# 0.12527f
C2 a_n138_n400# a_n50_n444# 0.05179f
C3 a_50_n400# VSUBS 0.23105f
C4 a_n138_n400# VSUBS 0.23105f
.ends

.subckt n_w0p5_l0p28 a_n28_n94# a_n116_n50# a_28_n50# VSUBS
X0 a_28_n50# a_n28_n94# a_n116_n50# VSUBS nfet_03v3 ad=0.22p pd=1.88u as=0.22p ps=1.88u w=0.5u l=0.28u
C0 a_28_n50# a_n28_n94# 0.00377f
C1 a_28_n50# a_n116_n50# 0.02085f
C2 a_n116_n50# a_n28_n94# 0.00377f
C3 a_28_n50# VSUBS 0.07987f
C4 a_n116_n50# VSUBS 0.07987f
.ends

.subckt p_w1_l0p28 w_n202_n230# a_28_n100# a_n28_n144# a_n116_n100# VSUBS
X0 a_28_n100# a_n28_n144# a_n116_n100# w_n202_n230# pfet_03v3 ad=0.44p pd=2.88u as=0.44p ps=2.88u w=1u l=0.28u
C0 a_28_n100# w_n202_n230# 0.01808f
C1 a_n116_n100# w_n202_n230# 0.01808f
C2 a_28_n100# a_n28_n144# 0.00769f
C3 a_n116_n100# a_n28_n144# 0.00769f
C4 a_n116_n100# a_28_n100# 0.04256f
C5 a_n28_n144# w_n202_n230# 0.05841f
C6 a_28_n100# VSUBS 0.0597f
C7 a_n116_n100# VSUBS 0.0597f
C8 w_n202_n230# VSUBS 0.55752f
.ends

.subckt p_w2_l2_f4 a_n52_n200# a_452_n200# a_n452_n244# a_n556_n200# a_52_n244# a_956_n200#
+ a_n1044_n200# w_n1130_n330# a_n956_n244# a_556_n244# VSUBS
X0 a_452_n200# a_52_n244# a_n52_n200# w_n1130_n330# pfet_03v3 ad=0.52p pd=2.52u as=0.52p ps=2.52u w=2u l=2u
X1 a_956_n200# a_556_n244# a_452_n200# w_n1130_n330# pfet_03v3 ad=0.88p pd=4.88u as=0.52p ps=2.52u w=2u l=2u
X2 a_n556_n200# a_n956_n244# a_n1044_n200# w_n1130_n330# pfet_03v3 ad=0.52p pd=2.52u as=0.88p ps=4.88u w=2u l=2u
X3 a_n52_n200# a_n452_n244# a_n556_n200# w_n1130_n330# pfet_03v3 ad=0.52p pd=2.52u as=0.52p ps=2.52u w=2u l=2u
C0 a_52_n244# w_n1130_n330# 0.21994f
C1 a_n452_n244# w_n1130_n330# 0.21994f
C2 a_n556_n200# a_n52_n200# 0.02133f
C3 a_n1044_n200# w_n1130_n330# 0.0618f
C4 a_n556_n200# a_n956_n244# 0.0587f
C5 a_956_n200# a_556_n244# 0.0587f
C6 a_452_n200# w_n1130_n330# 0.09155f
C7 a_52_n244# a_n52_n200# 0.0587f
C8 a_n452_n244# a_n52_n200# 0.0587f
C9 a_52_n244# a_556_n244# 0.00519f
C10 a_n452_n244# a_n956_n244# 0.00519f
C11 a_n452_n244# a_n556_n200# 0.0587f
C12 a_452_n200# a_n52_n200# 0.02133f
C13 a_n1044_n200# a_n956_n244# 0.0587f
C14 a_n556_n200# a_n1044_n200# 0.02133f
C15 a_452_n200# a_556_n244# 0.0587f
C16 a_452_n200# a_956_n200# 0.02133f
C17 a_n452_n244# a_52_n244# 0.00519f
C18 a_452_n200# a_52_n244# 0.0587f
C19 w_n1130_n330# a_n52_n200# 0.09155f
C20 w_n1130_n330# a_556_n244# 0.2233f
C21 a_n956_n244# w_n1130_n330# 0.2233f
C22 a_n556_n200# w_n1130_n330# 0.09155f
C23 a_956_n200# w_n1130_n330# 0.0618f
C24 a_956_n200# VSUBS 0.13364f
C25 a_452_n200# VSUBS 0.12191f
C26 a_n52_n200# VSUBS 0.11851f
C27 a_n556_n200# VSUBS 0.12191f
C28 a_n1044_n200# VSUBS 0.13364f
C29 w_n1130_n330# VSUBS 4.4748f
.ends

.subckt p_w2_l0p5 a_50_n200# a_n50_n244# w_n224_n330# a_n138_n200# VSUBS
X0 a_50_n200# a_n50_n244# a_n138_n200# w_n224_n330# pfet_03v3 ad=0.88p pd=4.88u as=0.88p ps=4.88u w=2u l=0.5u
C0 a_n138_n200# a_n50_n244# 0.02577f
C1 a_50_n200# a_n50_n244# 0.02577f
C2 w_n224_n330# a_n138_n200# 0.03848f
C3 w_n224_n330# a_50_n200# 0.03848f
C4 w_n224_n330# a_n50_n244# 0.07993f
C5 a_50_n200# a_n138_n200# 0.06232f
C6 a_50_n200# VSUBS 0.0978f
C7 a_n138_n200# VSUBS 0.0978f
C8 w_n224_n330# VSUBS 0.88704f
.ends

.subckt n_w2_l0p5 a_50_n200# a_n50_n244# a_n138_n200# VSUBS
X0 a_50_n200# a_n50_n244# a_n138_n200# VSUBS nfet_03v3 ad=0.88p pd=4.88u as=0.88p ps=4.88u w=2u l=0.5u
C0 a_50_n200# a_n138_n200# 0.06232f
C1 a_n50_n244# a_50_n200# 0.02577f
C2 a_n50_n244# a_n138_n200# 0.02577f
C3 a_50_n200# VSUBS 0.1541f
C4 a_n138_n200# VSUBS 0.1541f
.ends

.subckt p_w4_l0p5 a_n138_n400# a_50_n400# a_n50_n444# w_n224_n530# VSUBS
X0 a_50_n400# a_n50_n444# a_n138_n400# w_n224_n530# pfet_03v3 ad=1.76p pd=8.88u as=1.76p ps=8.88u w=4u l=0.5u
C0 a_n138_n400# a_n50_n444# 0.05179f
C1 a_50_n400# a_n50_n444# 0.05179f
C2 w_n224_n530# a_n138_n400# 0.07442f
C3 w_n224_n530# a_50_n400# 0.07442f
C4 w_n224_n530# a_n50_n444# 0.07993f
C5 a_50_n400# a_n138_n400# 0.12527f
C6 a_50_n400# VSUBS 0.16249f
C7 a_n138_n400# VSUBS 0.16249f
C8 w_n224_n530# VSUBS 1.42464f
.ends

.subckt bias_master pad s0 s1 stim intref en in_n in_p iint en_b a_1744_10100# vbp_st
+ ua0_stim a_1744_9182# vss vdd a_1764_11418# a_2240_11218# a_736_5516# a_420_700#
+ a_736_7228#
XOP vss a_1744_10100# a_736_7228# vss n_w2_l2
XRS pad a_420_700# vss r_w4_l3p97
XS1 a_736_5516# s1 a_420_700# vss n_w8_l0p5
XS0 a_420_700# a_736_7228# s0 vss n_w4_l0p5
XOS vss vbp_st a_736_7228# vss n_w2_l2
XIENn en vss en_b vss n_w0p5_l0p28
XIENp vdd en_b en vdd vss p_w1_l0p28
XQX a_1744_9182# vdd a_1744_9182# vdd a_1744_9182# a_736_7228# a_736_7228# vdd a_1744_9182#
+ a_1744_9182# vss p_w2_l2_f4
XDXa vss vss a_736_5516# a_736_5516# a_736_5516# a_736_5516# a_736_5516# a_736_5516#
+ a_736_5516# a_736_5516# vss vss a_736_5516# a_736_5516# a_736_5516# a_736_5516#
+ vss vss n_w2_l2_f8
XOX vss a_1744_9182# a_736_5516# vss n_w2_l2
XDXb vss vss a_736_5516# a_736_5516# a_736_5516# a_736_5516# a_736_5516# a_736_5516#
+ a_736_5516# a_736_5516# vss vss a_736_5516# a_736_5516# a_736_5516# a_736_5516#
+ vss vss n_w2_l2_f8
XISTn stim vss a_1764_11418# vss n_w0p5_l0p28
XISTp vdd a_1764_11418# stim vdd vss p_w1_l0p28
XSWI a_736_7228# a_2240_11218# vdd iint vss p_w2_l0p5
XPD vdd a_1744_10100# a_1744_10100# in_p a_1744_10100# vdd vdd vdd a_1744_10100# a_1744_10100#
+ vss p_w2_l2_f4
XSTN ua0_stim stim a_420_700# vss n_w2_l0p5
XSTP a_420_700# ua0_stim a_1764_11418# vdd vss p_w4_l0p5
XPDN a_736_7228# vss en_b vss n_w4_l0p5
XDa vss vss a_736_7228# a_736_7228# a_736_7228# a_736_7228# a_736_7228# a_736_7228#
+ a_736_7228# a_736_7228# vss vss a_736_7228# a_736_7228# a_736_7228# a_736_7228#
+ vss vss n_w2_l2_f8
XDb vss vss a_736_7228# a_736_7228# a_736_7228# a_736_7228# a_736_7228# a_736_7228#
+ a_736_7228# a_736_7228# vss vss a_736_7228# a_736_7228# a_736_7228# a_736_7228#
+ vss vss n_w2_l2_f8
XIIRn intref vss a_2240_11218# vss n_w0p5_l0p28
XIIRp vdd a_2240_11218# intref vdd vss p_w1_l0p28
XON vss in_n a_736_7228# vss n_w2_l2
D0 vss a_420_700# diode_nd2ps_03v3 pj=22u area=10p
D1 a_420_700# vdd diode_pd2nw_03v3 pj=22u area=10p
C0 s1 a_420_700# 0.34537f
C1 a_1744_9182# a_420_700# 0
C2 en s1 0.05296f
C3 en a_1744_9182# 0
C4 a_2240_11218# a_420_700# 0
C5 en a_2240_11218# 0.0689f
C6 a_1744_10100# a_420_700# 0
C7 en a_1744_10100# 0
C8 s1 a_736_7228# 0.26174f
C9 a_736_5516# a_420_700# 0.22588f
C10 vdd in_n 0.93129f
C11 s0 intref 0
C12 a_736_7228# a_1744_9182# 0.40049f
C13 s1 ua0_stim 0
C14 a_736_5516# en 0.1206f
C15 ua0_stim a_1744_9182# 0
C16 vbp_st a_1744_9182# 0.27778f
C17 a_736_7228# a_2240_11218# 0.1092f
C18 a_1744_9182# a_1764_11418# 0.08433f
C19 ua0_stim a_2240_11218# 0.01891f
C20 s1 stim 0.05023f
C21 a_736_7228# a_1744_10100# 0.21495f
C22 stim a_1744_9182# 0.09507f
C23 pad a_420_700# 0.54069f
C24 ua0_stim a_1744_10100# 0.0495f
C25 a_736_5516# a_736_7228# 0.94834f
C26 en pad 0.07917f
C27 a_736_5516# ua0_stim 0.76166f
C28 vbp_st a_2240_11218# 0.09119f
C29 a_1764_11418# a_2240_11218# 0.0155f
C30 in_p a_1744_9182# 0.0074f
C31 vbp_st a_1744_10100# 0.06941f
C32 a_1744_10100# a_1764_11418# 0.20361f
C33 stim a_2240_11218# 0.02672f
C34 a_736_5516# vbp_st 0.01681f
C35 a_736_5516# a_1764_11418# 0.29581f
C36 stim a_1744_10100# 0.5686f
C37 in_p a_2240_11218# 0
C38 a_736_5516# stim 0.46322f
C39 pad a_736_7228# 0.00246f
C40 s1 en_b 0.04984f
C41 in_p a_1744_10100# 0.1228f
C42 en_b a_2240_11218# 0.55285f
C43 stim pad 0.03728f
C44 en_b a_1744_10100# 0
C45 a_736_5516# en_b 0.10641f
C46 en a_420_700# 1.35379f
C47 vdd s1 0
C48 vdd a_1744_9182# 1.89441f
C49 en_b pad 0.00118f
C50 vdd a_2240_11218# 1.56334f
C51 a_736_7228# a_420_700# 0.60616f
C52 vdd a_1744_10100# 2.14231f
C53 ua0_stim a_420_700# 0.27553f
C54 en a_736_7228# 0.06595f
C55 en ua0_stim 0.04932f
C56 a_736_5516# vdd 0.03946f
C57 vbp_st a_420_700# 0.00221f
C58 a_1764_11418# a_420_700# 0.01871f
C59 en vbp_st 0.4389f
C60 en a_1764_11418# 0.00964f
C61 stim a_420_700# 0.39449f
C62 en stim 0.16867f
C63 ua0_stim a_736_7228# 0.65944f
C64 vdd pad 0.30131f
C65 in_p a_420_700# 0.14384f
C66 en in_p 0.1023f
C67 vbp_st a_736_7228# 0.19283f
C68 a_736_7228# a_1764_11418# 0.58069f
C69 ua0_stim vbp_st 0.28759f
C70 ua0_stim a_1764_11418# 0.39761f
C71 stim a_736_7228# 0.67831f
C72 stim ua0_stim 0.17275f
C73 en_b a_420_700# 0.00238f
C74 en en_b 0.16284f
C75 vbp_st a_1764_11418# 0.24107f
C76 in_p a_736_7228# 0.13123f
C77 s1 s0 0.37932f
C78 iint a_2240_11218# 0.04705f
C79 in_p ua0_stim 0.13299f
C80 s1 intref 0.00169f
C81 stim vbp_st 0.03538f
C82 stim a_1764_11418# 0.89967f
C83 intref a_1744_9182# 0.06003f
C84 a_1744_10100# iint 0.0038f
C85 in_p vbp_st 0.01109f
C86 in_p a_1764_11418# 0.10845f
C87 en_b a_736_7228# 0.01852f
C88 intref a_2240_11218# 0.51277f
C89 in_p stim 0
C90 en_b ua0_stim 0.11556f
C91 intref a_1744_10100# 0.00123f
C92 a_736_5516# s0 0.00164f
C93 a_736_5516# intref 0.42454f
C94 vdd a_420_700# 1.39245f
C95 en_b vbp_st 0.22396f
C96 en_b a_1764_11418# 0.04298f
C97 vdd en 1.40435f
C98 en_b stim 0.09516f
C99 pad s0 0.04859f
C100 pad intref 0.04537f
C101 vdd a_736_7228# 1.34623f
C102 vdd ua0_stim 0.7438f
C103 vdd vbp_st 1.24211f
C104 vdd a_1764_11418# 0.9203f
C105 vdd stim 0.43645f
C106 a_1744_9182# in_n 0.05554f
C107 vdd in_p 0.3992f
C108 en iint 0.04364f
C109 a_1744_10100# in_n 0
C110 s0 a_420_700# 0.23128f
C111 vdd en_b 1.53555f
C112 en s0 0.08622f
C113 intref a_420_700# 0.08048f
C114 en intref 0.18747f
C115 a_736_7228# iint 0.07137f
C116 ua0_stim iint 0.22215f
C117 s0 a_736_7228# 0.08339f
C118 vbp_st iint 0.03426f
C119 iint a_1764_11418# 0.04831f
C120 s0 ua0_stim 0
C121 intref a_736_7228# 1.05564f
C122 intref ua0_stim 0.38842f
C123 stim iint 0
C124 in_p iint 0
C125 intref vbp_st 0.10375f
C126 intref a_1764_11418# 0.13911f
C127 stim s0 0
C128 stim intref 0.10135f
C129 en_b iint 0.00566f
C130 en_b s0 0
C131 a_1744_9182# a_2240_11218# 0.04423f
C132 a_420_700# in_n 0.06513f
C133 en_b intref 0.13348f
C134 en in_n 0.22085f
C135 a_1744_10100# a_1744_9182# 0.21634f
C136 a_736_5516# s1 0.04485f
C137 a_736_5516# a_1744_9182# 0.06682f
C138 a_1744_10100# a_2240_11218# 0.00646f
C139 a_736_5516# a_2240_11218# 0.20875f
C140 vdd iint 0.20167f
C141 a_736_7228# in_n 0.22106f
C142 ua0_stim in_n 0.13986f
C143 s1 pad 0.04303f
C144 vbp_st in_n 0
C145 a_1764_11418# in_n 0
C146 vdd intref 1.1637f
C147 stim in_n 0
C148 in_p in_n 0.00893f
C149 in_n vss 0.4171f
C150 a_2240_11218# vss 1.12079f
C151 intref vss 1.56078f
C152 a_736_7228# vss 7.21627f
C153 en_b vss 2.84339f
C154 ua0_stim vss 1.3904f
C155 stim vss 1.68124f
C156 in_p vss 0.10852f
C157 iint vss -0.02046f
C158 a_1764_11418# vss 0.23987f
C159 a_1744_9182# vss -0.31499f
C160 a_736_5516# vss 5.14983f
C161 vdd vss 48.57603f
C162 en vss 2.99933f
C163 vbp_st vss 0.13312f
C164 a_420_700# vss 2.09001f
C165 s0 vss 0.69974f
C166 s1 vss 0.67954f
C167 pad vss 1.41208f
C168 a_1744_10100# vss -0.2385f
.ends

.subckt n_w2_l2_f7 a_n704_n244# a_n808_n200# a_304_n244# a_n1712_n244# a_1712_n200#
+ a_n1800_n200# a_n1208_n244# a_1208_n200# a_200_n200# a_1312_n244# a_808_n244# a_n200_n244#
+ a_n304_n200# a_n1312_n200# a_704_n200# VSUBS
X0 a_n304_n200# a_n704_n244# a_n808_n200# VSUBS nfet_03v3 ad=0.52p pd=2.52u as=0.52p ps=2.52u w=2u l=2u
X1 a_200_n200# a_n200_n244# a_n304_n200# VSUBS nfet_03v3 ad=0.52p pd=2.52u as=0.52p ps=2.52u w=2u l=2u
X2 a_1712_n200# a_1312_n244# a_1208_n200# VSUBS nfet_03v3 ad=0.88p pd=4.88u as=0.52p ps=2.52u w=2u l=2u
X3 a_1208_n200# a_808_n244# a_704_n200# VSUBS nfet_03v3 ad=0.52p pd=2.52u as=0.52p ps=2.52u w=2u l=2u
X4 a_704_n200# a_304_n244# a_200_n200# VSUBS nfet_03v3 ad=0.52p pd=2.52u as=0.52p ps=2.52u w=2u l=2u
X5 a_n1312_n200# a_n1712_n244# a_n1800_n200# VSUBS nfet_03v3 ad=0.52p pd=2.52u as=0.88p ps=4.88u w=2u l=2u
X6 a_n808_n200# a_n1208_n244# a_n1312_n200# VSUBS nfet_03v3 ad=0.52p pd=2.52u as=0.52p ps=2.52u w=2u l=2u
C0 a_n304_n200# a_n200_n244# 0.0587f
C1 a_200_n200# a_304_n244# 0.0587f
C2 a_808_n244# a_304_n244# 0.00519f
C3 a_200_n200# a_704_n200# 0.02133f
C4 a_704_n200# a_808_n244# 0.0587f
C5 a_n704_n244# a_n808_n200# 0.0587f
C6 a_n1712_n244# a_n1800_n200# 0.0587f
C7 a_n704_n244# a_n200_n244# 0.00519f
C8 a_n1312_n200# a_n1800_n200# 0.02133f
C9 a_1312_n244# a_1712_n200# 0.0587f
C10 a_1312_n244# a_808_n244# 0.00519f
C11 a_200_n200# a_n304_n200# 0.02133f
C12 a_704_n200# a_1208_n200# 0.02133f
C13 a_n200_n244# a_304_n244# 0.00519f
C14 a_n1712_n244# a_n1208_n244# 0.00519f
C15 a_n1312_n200# a_n1208_n244# 0.0587f
C16 a_n1712_n244# a_n1312_n200# 0.0587f
C17 a_1712_n200# a_1208_n200# 0.02133f
C18 a_704_n200# a_304_n244# 0.0587f
C19 a_1208_n200# a_808_n244# 0.0587f
C20 a_1312_n244# a_1208_n200# 0.0587f
C21 a_n304_n200# a_n808_n200# 0.02133f
C22 a_n304_n200# a_n704_n244# 0.0587f
C23 a_n808_n200# a_n1208_n244# 0.0587f
C24 a_200_n200# a_n200_n244# 0.0587f
C25 a_n808_n200# a_n1312_n200# 0.02133f
C26 a_n704_n244# a_n1208_n244# 0.00519f
C27 a_1712_n200# VSUBS 0.26162f
C28 a_1208_n200# VSUBS 0.34773f
C29 a_704_n200# VSUBS 0.34265f
C30 a_200_n200# VSUBS 0.34265f
C31 a_n304_n200# VSUBS 0.34265f
C32 a_n808_n200# VSUBS 0.34265f
C33 a_n1312_n200# VSUBS 0.34773f
C34 a_n1800_n200# VSUBS 0.26162f
.ends

.subckt n_w0p5_l0p5_f2 a_n52_n50# a_52_n94# a_152_n50# a_n240_n50# a_n152_n94# VSUBS
X0 a_152_n50# a_52_n94# a_n52_n50# VSUBS nfet_03v3 ad=0.22p pd=1.88u as=0.13p ps=1.02u w=0.5u l=0.5u
X1 a_n52_n50# a_n152_n94# a_n240_n50# VSUBS nfet_03v3 ad=0.13p pd=1.02u as=0.22p ps=1.88u w=0.5u l=0.5u
C0 a_152_n50# a_n52_n50# 0.01511f
C1 a_152_n50# a_52_n94# 0.00625f
C2 a_n52_n50# a_n152_n94# 0.00625f
C3 a_n52_n50# a_52_n94# 0.00625f
C4 a_n152_n94# a_52_n94# 0.00519f
C5 a_n52_n50# a_n240_n50# 0.01511f
C6 a_n152_n94# a_n240_n50# 0.00625f
C7 a_152_n50# VSUBS 0.09131f
C8 a_n52_n50# VSUBS 0.12761f
C9 a_n240_n50# VSUBS 0.09131f
.ends

.subckt idac_n b0 b1 b2 b3 b4 out vcas vdd g m1_988_3304# a_528_4170# a_2228_4170#
+ a_3928_4170# a_732_4170# a_2432_4170# a_1582_4170# a_3282_4170# m1_988_2644# a_4132_4170#
+ m1_988_888# m1_260_2080# a_1378_4170# dump m1_1500_3762# a_3078_4170# vss vsn
XU4b vsn vsn m1_988_888# g g m1_988_888# g m1_988_888# g m1_988_888# vsn vsn g g g
+ g vsn vss n_w2_l2_f8
XU3 vsn vsn m1_988_2644# g g m1_988_2644# g m1_988_2644# g m1_988_2644# vsn vsn g
+ g g g vsn vss n_w2_l2_f8
XIP0 a_732_4170# vcas vcas a_528_4170# a_732_4170# b0 vss p_w1_l0p28_f2
XIP1 a_1582_4170# vcas vcas a_1378_4170# a_1582_4170# b1 vss p_w1_l0p28_f2
XIP2 a_2432_4170# vcas vcas a_2228_4170# a_2432_4170# b2 vss p_w1_l0p28_f2
XIN0 vss a_732_4170# a_732_4170# a_528_4170# b0 vss n_w0p5_l0p28_f2
XIP3 a_3282_4170# vcas vcas a_3078_4170# a_3282_4170# b3 vss p_w1_l0p28_f2
XIN1 vss a_1582_4170# a_1582_4170# a_1378_4170# b1 vss n_w0p5_l0p28_f2
XIP4 a_4132_4170# vcas vcas a_3928_4170# a_4132_4170# b4 vss p_w1_l0p28_f2
XIN3 vss a_3282_4170# a_3282_4170# a_3078_4170# b3 vss n_w0p5_l0p28_f2
XIN2 vss a_2432_4170# a_2432_4170# a_2228_4170# b2 vss n_w0p5_l0p28_f2
XIN4 vss a_4132_4170# a_4132_4170# a_3928_4170# b4 vss n_w0p5_l0p28_f2
XU210 g vsn g g m1_260_2080# vsn g vsn vsn g g g m1_988_3304# m1_988_3304# m1_1500_3762#
+ vss n_w2_l2_f7
XSW0 m1_260_2080# a_732_4170# dump out a_528_4170# vss n_w0p5_l0p5_f2
XSW2 m1_988_3304# a_2432_4170# dump out a_2228_4170# vss n_w0p5_l0p5_f2
XSW1 m1_1500_3762# a_1582_4170# dump out a_1378_4170# vss n_w0p5_l0p5_f2
XSW3 m1_988_2644# a_3282_4170# dump out a_3078_4170# vss n_w0p5_l0p5_f2
XSW4 m1_988_888# a_4132_4170# dump out a_3928_4170# vss n_w0p5_l0p5_f2
XU4a vsn vsn m1_988_888# g g m1_988_888# g m1_988_888# g m1_988_888# vsn vsn g g g
+ g vsn vss n_w2_l2_f8
C0 a_732_4170# a_528_4170# 0.1853f
C1 out m1_260_2080# 0.07116f
C2 b0 a_1582_4170# 0.00914f
C3 a_3928_4170# m1_260_2080# 0
C4 dump vcas 1.35686f
C5 g b4 0
C6 m1_988_3304# b2 0
C7 m1_988_3304# a_1378_4170# 0
C8 dump a_2432_4170# 0.04021f
C9 out g 0.30711f
C10 m1_988_3304# a_1582_4170# 0
C11 vsn b4 0
C12 a_3928_4170# g 0.00223f
C13 out vsn 0.01026f
C14 dump b3 0.14989f
C15 a_3282_4170# b4 0.0031f
C16 a_3928_4170# vsn 0
C17 a_3078_4170# m1_1500_3762# 0.00387f
C18 out a_3282_4170# 0.02704f
C19 a_2228_4170# dump 0.15915f
C20 out b1 0.39281f
C21 a_3928_4170# a_3282_4170# 0.0068f
C22 g vcas 0.00531f
C23 dump a_732_4170# 0.02697f
C24 out m1_988_2644# 0.06032f
C25 a_3928_4170# m1_988_2644# 0
C26 a_2432_4170# g 0.00286f
C27 dump a_528_4170# 0.07429f
C28 a_3282_4170# vcas 0.29204f
C29 m1_988_888# a_3078_4170# 0.08147f
C30 a_732_4170# m1_260_2080# 0.00987f
C31 vcas b1 0.89272f
C32 b3 g 0
C33 m1_988_3304# m1_1500_3762# 0.11176f
C34 m1_260_2080# a_528_4170# 0.05346f
C35 a_2228_4170# g 0.00553f
C36 a_2432_4170# a_3282_4170# 0.01327f
C37 a_2432_4170# b1 0
C38 a_732_4170# g 0.00276f
C39 a_2228_4170# vsn 0
C40 b3 a_3282_4170# 0.14389f
C41 g a_528_4170# 0.00771f
C42 a_2228_4170# a_3282_4170# 0.01488f
C43 a_2228_4170# b1 0
C44 b3 m1_988_2644# 0
C45 vsn a_528_4170# 0
C46 out b2 0.01329f
C47 a_732_4170# b1 0.00568f
C48 out a_1378_4170# 0.04703f
C49 out a_1582_4170# 0.17521f
C50 a_4132_4170# a_3078_4170# 0.06615f
C51 a_528_4170# b1 0.04801f
C52 b4 vdd 0.0055f
C53 dump m1_260_2080# 0.05465f
C54 b2 vcas 0.3849f
C55 vcas a_1378_4170# 0.15514f
C56 a_4132_4170# m1_988_888# 0.02826f
C57 a_1582_4170# vcas 0.27006f
C58 dump g 0.62788f
C59 a_2432_4170# b2 0.24144f
C60 a_2432_4170# a_1378_4170# 0.06027f
C61 a_2432_4170# a_1582_4170# 0.01867f
C62 vcas vdd 0.00626f
C63 dump vsn 0.45688f
C64 b3 b2 0.01263f
C65 b3 a_1378_4170# 0.00218f
C66 g m1_260_2080# 1.12515f
C67 dump a_3282_4170# 0.04973f
C68 a_2228_4170# b2 0.04686f
C69 out m1_1500_3762# 0.38998f
C70 dump b1 0.0143f
C71 a_2228_4170# a_1378_4170# 0.00673f
C72 a_2228_4170# a_1582_4170# 0.00492f
C73 b4 a_3078_4170# 0.14552f
C74 vsn m1_260_2080# 0.30933f
C75 b3 vdd 0.00415f
C76 a_732_4170# a_1378_4170# 0.00239f
C77 dump m1_988_2644# 0.07098f
C78 out a_3078_4170# 0.08761f
C79 a_732_4170# a_1582_4170# 0.00288f
C80 a_3928_4170# a_3078_4170# 0.27629f
C81 a_528_4170# a_1378_4170# 0.00677f
C82 a_528_4170# a_1582_4170# 0.0056f
C83 vsn g 4.12488f
C84 m1_988_888# b4 0
C85 vcas m1_1500_3762# 0.00146f
C86 m1_260_2080# m1_988_2644# 0.24844f
C87 out m1_988_888# 0.00355f
C88 out b0 0.01654f
C89 a_3282_4170# g 0.00339f
C90 a_3928_4170# m1_988_888# 0.0651f
C91 vcas a_3078_4170# 0.73187f
C92 g b1 0
C93 a_2432_4170# m1_1500_3762# 0
C94 g m1_988_2644# 1.19317f
C95 a_2432_4170# a_3078_4170# 0.0066f
C96 out m1_988_3304# 0.25145f
C97 b3 m1_1500_3762# 0
C98 vsn m1_988_2644# 0.25449f
C99 a_3282_4170# b1 0
C100 a_2228_4170# m1_1500_3762# 0.00184f
C101 b0 vcas 0.36918f
C102 b3 a_3078_4170# 0.09671f
C103 dump b2 0.07018f
C104 dump a_1378_4170# 0.07506f
C105 a_3282_4170# m1_988_2644# 0.00988f
C106 a_2228_4170# a_3078_4170# 0.00113f
C107 dump a_1582_4170# 0.01837f
C108 a_4132_4170# b4 0.25674f
C109 out a_4132_4170# 0.00472f
C110 dump vdd 0.01049f
C111 a_3928_4170# a_4132_4170# 0.12544f
C112 a_2432_4170# m1_988_3304# 0.00578f
C113 a_732_4170# b0 0.2484f
C114 b2 g 0
C115 a_4132_4170# vcas 0.27886f
C116 g a_1378_4170# 0.00374f
C117 a_2228_4170# m1_988_3304# 0.06446f
C118 b0 a_528_4170# 0.02165f
C119 g a_1582_4170# 0.0036f
C120 b2 a_3282_4170# 0
C121 dump m1_1500_3762# 0.09882f
C122 b2 b1 0.0021f
C123 a_3282_4170# a_1378_4170# 0
C124 a_1378_4170# b1 0.03605f
C125 a_3282_4170# a_1582_4170# 0
C126 a_4132_4170# b3 0.00478f
C127 a_1582_4170# b1 0.27926f
C128 dump a_3078_4170# 0.52465f
C129 a_3928_4170# b4 0.02632f
C130 a_3282_4170# vdd 0
C131 m1_260_2080# m1_1500_3762# 0
C132 out a_3928_4170# 0.00435f
C133 m1_260_2080# a_3078_4170# 0.20065f
C134 dump m1_988_888# 0.1173f
C135 b4 vcas 0.34586f
C136 g m1_1500_3762# 0.51943f
C137 out vcas 0.27597f
C138 a_3928_4170# vcas 0.08407f
C139 vsn m1_1500_3762# 0.02504f
C140 g a_3078_4170# 0.13262f
C141 dump m1_988_3304# 0.34162f
C142 m1_988_888# m1_260_2080# 0.55941f
C143 b0 m1_260_2080# 0
C144 out a_2432_4170# 0.02507f
C145 vsn a_3078_4170# 0.01097f
C146 b3 b4 0.0097f
C147 m1_1500_3762# b1 0
C148 b2 a_1378_4170# 0.00837f
C149 out b3 0
C150 a_3282_4170# a_3078_4170# 0.27925f
C151 m1_988_888# g 2.42837f
C152 b0 g 0
C153 b2 a_1582_4170# 0.00172f
C154 a_3928_4170# b3 0
C155 m1_1500_3762# m1_988_2644# 0.09258f
C156 a_2228_4170# out 0.02717f
C157 a_1582_4170# a_1378_4170# 0.12904f
C158 m1_988_888# vsn 0.75155f
C159 dump a_4132_4170# 0.04826f
C160 a_3078_4170# m1_988_2644# 0.08059f
C161 a_2432_4170# vcas 0.31499f
C162 out a_732_4170# 0.01797f
C163 m1_988_3304# g 0.39585f
C164 b3 vcas 0.48197f
C165 out a_528_4170# 0.25397f
C166 b0 b1 0.02437f
C167 m1_988_3304# vsn 0.0562f
C168 a_4132_4170# m1_260_2080# 0
C169 a_2228_4170# vcas 0.08842f
C170 m1_988_888# m1_988_2644# 0.44143f
C171 a_2432_4170# b3 0.00238f
C172 a_732_4170# vcas 0.26007f
C173 a_2228_4170# a_2432_4170# 0.14213f
C174 a_4132_4170# g 0.00123f
C175 a_528_4170# vcas 0.09144f
C176 m1_988_3304# m1_988_2644# 0.00259f
C177 b2 m1_1500_3762# 0
C178 a_2228_4170# b3 0.00226f
C179 a_4132_4170# vsn 0
C180 m1_1500_3762# a_1378_4170# 0.00998f
C181 a_1582_4170# m1_1500_3762# 0.02077f
C182 b2 a_3078_4170# 0
C183 dump b4 0.05108f
C184 a_4132_4170# a_3282_4170# 0.128f
C185 a_3078_4170# a_1378_4170# 0
C186 out dump 0.4373f
C187 dump a_3928_4170# 0.03528f
C188 vdd a_3078_4170# 0
C189 m1_260_2080# b4 0
C190 vdd vss 0.03123f
C191 m1_988_888# vss 1.06123f
C192 vsn vss 1.84736f
C193 g vss 5.72892f
C194 a_3928_4170# vss 0.33427f
C195 a_3078_4170# vss 0.59741f
C196 m1_1500_3762# vss 0.27797f
C197 a_1378_4170# vss 0.34562f
C198 a_2228_4170# vss 0.17252f
C199 dump vss 1.82894f
C200 m1_260_2080# vss 2.17739f
C201 out vss 1.05553f
C202 a_528_4170# vss 0.28429f
C203 m1_988_3304# vss 0.09089f
C204 a_4132_4170# vss 0.41879f
C205 b4 vss 0.21281f
C206 a_2432_4170# vss 0.40441f
C207 b2 vss 0.19167f
C208 a_3282_4170# vss 0.41623f
C209 b3 vss 0.18821f
C210 a_1582_4170# vss 0.4013f
C211 b1 vss 0.38616f
C212 a_732_4170# vss 0.39599f
C213 b0 vss 0.34676f
C214 vcas vss 10.83517f
C215 m1_988_2644# vss 0.29815f
.ends

.subckt r_w1_l7p765 a_n100_n899# a_n100_777# VSUBS
X0 a_n100_777# a_n100_n899# VSUBS ppolyf_u_1k r_width=1u r_length=7.77u
C0 a_n100_n899# VSUBS 0.27003f
C1 a_n100_777# VSUBS 0.27003f
.ends

.subckt r_w2_l1p97 a_n200_n319# a_n200_197# VSUBS
X0 a_n200_197# a_n200_n319# VSUBS ppolyf_u_1k r_width=2u r_length=1.97u
C0 a_n200_n319# a_n200_197# 0.02096f
C1 a_n200_n319# VSUBS 0.42971f
C2 a_n200_197# VSUBS 0.42971f
.ends

.subckt r_w1_l1p94 a_n100_n316# a_n100_194# VSUBS
X0 a_n100_194# a_n100_n316# VSUBS ppolyf_u_1k r_width=1u r_length=1.94u
C0 a_n100_n316# a_n100_194# 0.01052f
C1 a_n100_n316# VSUBS 0.2541f
C2 a_n100_194# VSUBS 0.2541f
.ends

.subckt r_w1_l3p88 a_n100_n510# a_n100_388# VSUBS
X0 a_n100_388# a_n100_n510# VSUBS ppolyf_u_1k r_width=1u r_length=3.88u
C0 a_n100_n510# a_n100_388# 0.00535f
C1 a_n100_n510# VSUBS 0.26053f
C2 a_n100_388# VSUBS 0.26053f
.ends

.subckt n_w0p5_l1 a_100_n50# a_n100_n94# a_n188_n50# VSUBS
X0 a_100_n50# a_n100_n94# a_n188_n50# VSUBS nfet_03v3 ad=0.22p pd=1.88u as=0.22p ps=1.88u w=0.5u l=1u
C0 a_n188_n50# a_n100_n94# 0.01026f
C1 a_n188_n50# a_100_n50# 0.00935f
C2 a_100_n50# a_n100_n94# 0.01026f
C3 a_100_n50# VSUBS 0.13392f
C4 a_n188_n50# VSUBS 0.13392f
.ends

.subckt p_w1_l1 a_n188_n100# a_100_n100# a_n100_n144# w_n274_n230# VSUBS
X0 a_100_n100# a_n100_n144# a_n188_n100# w_n274_n230# pfet_03v3 ad=0.44p pd=2.88u as=0.44p ps=2.88u w=1u l=1u
C0 a_n100_n144# w_n274_n230# 0.12884f
C1 a_n100_n144# a_n188_n100# 0.02094f
C2 a_n100_n144# a_100_n100# 0.02094f
C3 a_n188_n100# w_n274_n230# 0.02517f
C4 a_100_n100# w_n274_n230# 0.02517f
C5 a_100_n100# a_n188_n100# 0.0191f
C6 a_100_n100# VSUBS 0.07854f
C7 a_n188_n100# VSUBS 0.07854f
C8 w_n274_n230# VSUBS 0.75624f
.ends

.subckt r_w1_l11p645 a_n100_1165# a_n100_n1287# VSUBS
X0 a_n100_1165# a_n100_n1287# VSUBS ppolyf_u_1k r_width=1u r_length=11.65u
C0 a_n100_n1287# VSUBS 0.27003f
C1 a_n100_1165# VSUBS 0.27003f
.ends

.subckt n_w4_l0p28_f2 a_n52_n400# a_52_n444# a_108_n400# a_n108_n444# a_n196_n400#
+ VSUBS
X0 a_108_n400# a_52_n444# a_n52_n400# VSUBS nfet_03v3 ad=1.76p pd=8.88u as=1.04p ps=4.52u w=4u l=0.28u
X1 a_n52_n400# a_n108_n444# a_n196_n400# VSUBS nfet_03v3 ad=1.04p pd=4.52u as=1.76p ps=8.88u w=4u l=0.28u
C0 a_52_n444# a_108_n400# 0.03125f
C1 a_n52_n400# a_108_n400# 0.17284f
C2 a_52_n444# a_n108_n444# 0.00519f
C3 a_52_n444# a_n52_n400# 0.03125f
C4 a_n196_n400# a_n108_n444# 0.03125f
C5 a_n52_n400# a_n108_n444# 0.03125f
C6 a_n52_n400# a_n196_n400# 0.17284f
C7 a_108_n400# VSUBS 0.20946f
C8 a_n52_n400# VSUBS 0.09458f
C9 a_n196_n400# VSUBS 0.20946f
.ends

.subckt vdacr_el b0 b1 b2 b3 b4 vdd out m1_3662_4048# a_2224_3416# a_3408_3416# m1_822_4048#
+ a_1632_3416# m1_3310_2880# m1_2742_3250# m1_2242_4966# m1_1262_4048# a_1040_3416#
+ vss a_2816_3416# m1_617_3840# m1_956_3000# m1_382_4048#
XXRS4_0 m1_3662_4048# m1_3310_2880# vss r_w1_l7p765
XXRS4_1 vss m1_3662_4048# vss r_w1_l7p765
XXRS0 m1_617_3840# m1_956_3000# vss r_w2_l1p97
XXRS1 m1_2242_4966# m1_617_3840# vss r_w1_l1p94
XXRS3 m1_3310_2880# m1_2742_3250# vss r_w1_l7p765
XXRS2 m1_2742_3250# m1_2242_4966# vss r_w1_l3p88
XIB4n a_3408_3416# b4 vss vss n_w0p5_l1
XIB3n a_2816_3416# b3 vss vss n_w0p5_l1
XIB4p vdd a_3408_3416# b4 vdd vss p_w1_l1
XIB2n a_2224_3416# b2 vss vss n_w0p5_l1
XIB3p vdd a_2816_3416# b3 vdd vss p_w1_l1
XIB2p vdd a_2224_3416# b2 vdd vss p_w1_l1
XIB1n a_1632_3416# b1 vss vss n_w0p5_l1
XIB0n a_1040_3416# b0 vss vss n_w0p5_l1
XIB1p vdd a_1632_3416# b1 vdd vss p_w1_l1
XIB0p vdd a_1040_3416# b0 vdd vss p_w1_l1
XXRB0 out m1_382_4048# vss r_w1_l11p645
XSW0 m1_617_3840# a_1040_3416# m1_956_3000# a_1040_3416# m1_956_3000# vss n_w4_l0p28_f2
XXRB1 m1_382_4048# m1_822_4048# vss r_w1_l11p645
XSW2 m1_2742_3250# a_2224_3416# m1_2242_4966# a_2224_3416# m1_2242_4966# vss n_w4_l0p28_f2
XSW1 m1_2242_4966# a_1632_3416# m1_617_3840# a_1632_3416# m1_617_3840# vss n_w4_l0p28_f2
XXRB3 m1_1262_4048# m1_956_3000# vss r_w1_l11p645
XXRB2 m1_822_4048# m1_1262_4048# vss r_w1_l11p645
XSW3 m1_3310_2880# a_2816_3416# m1_2742_3250# a_2816_3416# m1_2742_3250# vss n_w4_l0p28_f2
XSW4 vss a_3408_3416# m1_3310_2880# a_3408_3416# m1_3310_2880# vss n_w4_l0p28_f2
C0 m1_617_3840# b1 0.00533f
C1 a_1632_3416# m1_1262_4048# 0.00132f
C2 m1_3310_2880# m1_2742_3250# 0.31172f
C3 m1_2242_4966# m1_3662_4048# 0
C4 a_1632_3416# m1_2742_3250# 0.00921f
C5 m1_3310_2880# a_2816_3416# 0.20114f
C6 m1_617_3840# m1_1262_4048# 0.13358f
C7 b3 vdd 0.44294f
C8 a_2224_3416# b1 0
C9 a_1632_3416# a_2816_3416# 0.00123f
C10 m1_3310_2880# b4 0.01127f
C11 m1_2242_4966# m1_956_3000# 0.15942f
C12 m1_617_3840# m1_2742_3250# 0.01845f
C13 m1_822_4048# m1_956_3000# 0.03636f
C14 m1_617_3840# a_2816_3416# 0
C15 vdd m1_956_3000# 0.00146f
C16 b2 b1 0.04707f
C17 a_2224_3416# m1_2742_3250# 0.23293f
C18 a_2816_3416# a_2224_3416# 0.17309f
C19 b4 a_2224_3416# 0
C20 b3 m1_3310_2880# 0.02434f
C21 b3 a_1632_3416# 0.00127f
C22 m1_3310_2880# m1_3662_4048# 0.3114f
C23 b0 m1_956_3000# 0.00622f
C24 b2 m1_2742_3250# 0.01093f
C25 m1_382_4048# m1_956_3000# 0.00423f
C26 m1_3310_2880# m1_956_3000# 0
C27 a_1632_3416# m1_956_3000# 0.03269f
C28 b4 b2 0
C29 a_1040_3416# b1 0.03315f
C30 m1_617_3840# m1_3662_4048# 0
C31 m1_617_3840# m1_956_3000# 0.75011f
C32 a_3408_3416# m1_2742_3250# 0.01258f
C33 b3 a_2224_3416# 0.05038f
C34 a_3408_3416# a_2816_3416# 0.03415f
C35 a_1040_3416# m1_1262_4048# 0
C36 m1_822_4048# m1_2242_4966# 0
C37 a_3408_3416# b4 0.21422f
C38 vdd m1_2242_4966# 0.0033f
C39 m1_956_3000# a_2224_3416# 0
C40 b3 b2 0.04135f
C41 out m1_1262_4048# 0.01147f
C42 b2 m1_956_3000# 0
C43 b3 a_3408_3416# 0
C44 m1_2242_4966# m1_382_4048# 0
C45 m1_3310_2880# m1_2242_4966# 0
C46 a_3408_3416# m1_3662_4048# 0
C47 a_1632_3416# m1_2242_4966# 0.15001f
C48 b0 vdd 0.49326f
C49 m1_822_4048# m1_382_4048# 0.39941f
C50 m1_3310_2880# vdd 0.00483f
C51 a_1632_3416# vdd 0.17222f
C52 m1_617_3840# m1_2242_4966# 0.32683f
C53 m1_617_3840# m1_822_4048# 0.123f
C54 m1_617_3840# vdd 0
C55 m1_956_3000# a_1040_3416# 0.11081f
C56 m1_2242_4966# a_2224_3416# 0.17274f
C57 vdd a_2224_3416# 0.20102f
C58 a_1632_3416# b0 0.00371f
C59 a_1632_3416# m1_3310_2880# 0
C60 a_2816_3416# b1 0
C61 m1_2242_4966# b2 0.00331f
C62 b4 b1 0.00115f
C63 b0 m1_617_3840# 0
C64 m1_617_3840# m1_382_4048# 0.32274f
C65 m1_617_3840# m1_3310_2880# 0.00278f
C66 vdd b2 0.46487f
C67 m1_2742_3250# m1_1262_4048# 0.009f
C68 a_1632_3416# m1_617_3840# 0.15378f
C69 a_2816_3416# m1_2742_3250# 0.2733f
C70 m1_3310_2880# a_2224_3416# 0.05997f
C71 a_3408_3416# vdd 0.22664f
C72 a_1632_3416# a_2224_3416# 0.03245f
C73 b4 a_2816_3416# 0.05297f
C74 b3 b1 0
C75 m1_617_3840# a_2224_3416# 0.03861f
C76 b0 b2 0.00416f
C77 m1_822_4048# a_1040_3416# 0
C78 vdd a_1040_3416# 0.27317f
C79 a_1632_3416# b2 0.02431f
C80 m1_956_3000# b1 0
C81 b3 m1_2742_3250# 0.00105f
C82 a_3408_3416# m1_3310_2880# 0.07699f
C83 b3 a_2816_3416# 0.2249f
C84 m1_956_3000# m1_1262_4048# 0.07066f
C85 m1_3662_4048# m1_2742_3250# 0.03614f
C86 out m1_822_4048# 0.02257f
C87 b3 b4 0.04052f
C88 m1_956_3000# m1_2742_3250# 0.00197f
C89 b0 a_1040_3416# 0.2598f
C90 b2 a_2224_3416# 0.22771f
C91 m1_382_4048# a_1040_3416# 0
C92 a_1632_3416# a_1040_3416# 0.0443f
C93 a_3408_3416# a_2224_3416# 0
C94 m1_617_3840# a_1040_3416# 0.2193f
C95 out m1_382_4048# 0.02694f
C96 m1_2242_4966# b1 0.00209f
C97 a_1040_3416# a_2224_3416# 0
C98 vdd b1 0.48179f
C99 m1_617_3840# out 0.00314f
C100 m1_956_3000# m1_3662_4048# 0
C101 m1_2242_4966# m1_1262_4048# 0.01042f
C102 m1_822_4048# m1_1262_4048# 0.18781f
C103 b2 a_1040_3416# 0.00223f
C104 m1_2242_4966# m1_2742_3250# 0.46801f
C105 a_2816_3416# m1_2242_4966# 0
C106 vdd m1_2742_3250# 0.00512f
C107 vdd a_2816_3416# 0.1469f
C108 b0 b1 0.02882f
C109 vdd b4 0.59499f
C110 a_1632_3416# b1 0.35929f
C111 m1_3310_2880# vss 1.09895f
C112 m1_1262_4048# vss 0.55221f
C113 m1_2242_4966# vss 0.19454f
C114 m1_2742_3250# vss 0.65139f
C115 m1_822_4048# vss 0.24942f
C116 m1_617_3840# vss 2.00651f
C117 m1_956_3000# vss 0.55486f
C118 m1_382_4048# vss 0.33796f
C119 out vss 0.8541f
C120 vdd vss 10.07211f
C121 a_1040_3416# vss 1.07104f
C122 b0 vss 0.4933f
C123 a_1632_3416# vss 0.5138f
C124 b1 vss 0.49625f
C125 a_2224_3416# vss 0.54715f
C126 b2 vss 0.3102f
C127 a_2816_3416# vss 0.43096f
C128 b3 vss 0.35598f
C129 a_3408_3416# vss 1.10802f
C130 b4 vss 0.34471f
C131 m1_3662_4048# vss 0.38401f
.ends

.subckt r_w1_l13p91 a_n100_n1513# a_n100_1391# VSUBS
X0 a_n100_1391# a_n100_n1513# VSUBS ppolyf_u_1k r_width=1u r_length=13.91u
C0 a_n100_n1513# VSUBS 0.27003f
C1 a_n100_1391# VSUBS 0.27003f
.ends

.subckt vdacr_vr b0 b1 b2 b3 b4 vdd out m1_2862_4048# a_680_3416# vss a_2456_3416#
+ m1_860_4046# m1_462_4048# a_1864_3416# a_3048_3416# m1_2974_2650# m1_756_3120# a_1272_3416#
+ m1_2372_2520# m1_606_2410# m1_1780_5040#
XXRS4_0 m1_2862_4048# m1_2974_2650# vss r_w1_l7p765
XXRS4_1 vss m1_2862_4048# vss r_w1_l7p765
XXRS0 m1_756_3120# m1_606_2410# vss r_w2_l1p97
XXRS1 m1_1780_5040# m1_756_3120# vss r_w1_l1p94
XXRS3 m1_2974_2650# m1_2372_2520# vss r_w1_l7p765
XXRS2 m1_2372_2520# m1_1780_5040# vss r_w1_l3p88
XIB4n a_3048_3416# b4 vss vss n_w0p5_l1
XIB3n a_2456_3416# b3 vss vss n_w0p5_l1
XIB4p vdd a_3048_3416# b4 vdd vss p_w1_l1
XIB2n a_1864_3416# b2 vss vss n_w0p5_l1
XIB3p vdd a_2456_3416# b3 vdd vss p_w1_l1
XIB2p vdd a_1864_3416# b2 vdd vss p_w1_l1
XIB1n a_1272_3416# b1 vss vss n_w0p5_l1
XIB0n a_680_3416# b0 vss vss n_w0p5_l1
XIB1p vdd a_1272_3416# b1 vdd vss p_w1_l1
XIB0p vdd a_680_3416# b0 vdd vss p_w1_l1
XXRB0 m1_462_4048# out vss r_w1_l13p91
XSW0 m1_756_3120# a_680_3416# m1_606_2410# a_680_3416# m1_606_2410# vss n_w4_l0p28_f2
XXRB1 m1_860_4046# m1_462_4048# vss r_w1_l13p91
XSW2 m1_2372_2520# a_1864_3416# m1_1780_5040# a_1864_3416# m1_1780_5040# vss n_w4_l0p28_f2
XSW1 m1_1780_5040# a_1272_3416# m1_756_3120# a_1272_3416# m1_756_3120# vss n_w4_l0p28_f2
XXRB2 m1_606_2410# m1_860_4046# vss r_w1_l13p91
XSW3 m1_2974_2650# a_2456_3416# m1_2372_2520# a_2456_3416# m1_2372_2520# vss n_w4_l0p28_f2
XSW4 vss a_3048_3416# m1_2974_2650# a_3048_3416# m1_2974_2650# vss n_w4_l0p28_f2
C0 b4 b2 0
C1 m1_860_4046# m1_462_4048# 0.19198f
C2 m1_2372_2520# a_1864_3416# 0.27866f
C3 vdd a_1864_3416# 0.23259f
C4 m1_1780_5040# out 0.00646f
C5 b2 a_1864_3416# 0.16397f
C6 m1_606_2410# m1_2372_2520# 0
C7 m1_1780_5040# m1_2862_4048# 0.00262f
C8 b0 m1_756_3120# 0
C9 m1_1780_5040# b1 0.00216f
C10 m1_606_2410# m1_462_4048# 0.01332f
C11 m1_860_4046# out 0.01202f
C12 m1_2974_2650# m1_2372_2520# 0.5557f
C13 vdd m1_2974_2650# 0.01155f
C14 b4 b3 0.04752f
C15 a_1864_3416# b3 0.04632f
C16 a_1272_3416# m1_1780_5040# 0.152f
C17 m1_860_4046# a_680_3416# 0
C18 m1_606_2410# m1_2862_4048# 0
C19 b1 a_1864_3416# 0
C20 m1_1780_5040# a_2456_3416# 0.00741f
C21 vdd m1_2372_2520# 0.00451f
C22 m1_606_2410# b1 0
C23 a_1864_3416# a_680_3416# 0
C24 b2 m1_2372_2520# 0.00692f
C25 b4 a_3048_3416# 0.26257f
C26 a_1272_3416# m1_860_4046# 0
C27 vdd b2 0.57544f
C28 m1_606_2410# a_680_3416# 0.28826f
C29 m1_462_4048# m1_2372_2520# 0
C30 a_3048_3416# a_1864_3416# 0
C31 m1_2974_2650# m1_2862_4048# 0.17897f
C32 m1_2974_2650# b3 0.00379f
C33 b4 a_2456_3416# 0.09406f
C34 a_1272_3416# a_1864_3416# 0.02555f
C35 m1_1780_5040# m1_756_3120# 0.43379f
C36 a_1272_3416# m1_606_2410# 0.01865f
C37 a_1864_3416# a_2456_3416# 0.02335f
C38 m1_2372_2520# out 0
C39 m1_2862_4048# m1_2372_2520# 0.02957f
C40 m1_2372_2520# b3 0.02027f
C41 vdd b3 0.45194f
C42 m1_860_4046# m1_756_3120# 0.01696f
C43 m1_2974_2650# a_3048_3416# 0.1083f
C44 b2 b3 0.03777f
C45 m1_462_4048# out 0.08166f
C46 a_1272_3416# m1_2974_2650# 0
C47 b0 m1_606_2410# 0.01272f
C48 vdd b1 0.41268f
C49 b1 b2 0.05461f
C50 a_1864_3416# m1_756_3120# 0.0068f
C51 m1_2974_2650# a_2456_3416# 0.30479f
C52 vdd a_680_3416# 0.1904f
C53 b2 a_680_3416# 0
C54 m1_606_2410# m1_756_3120# 0.30895f
C55 a_3048_3416# m1_2372_2520# 0
C56 vdd a_3048_3416# 0.14688f
C57 m1_462_4048# a_680_3416# 0.00361f
C58 a_3048_3416# b2 0
C59 a_1272_3416# m1_2372_2520# 0.01394f
C60 a_1272_3416# vdd 0.13505f
C61 a_1272_3416# b2 0.04419f
C62 m1_2372_2520# a_2456_3416# 0.13462f
C63 vdd a_2456_3416# 0.20273f
C64 m1_2974_2650# m1_756_3120# 0.0665f
C65 b2 a_2456_3416# 0
C66 b1 b3 0.00301f
C67 m1_860_4046# m1_1780_5040# 0.08602f
C68 b0 vdd 0.43014f
C69 b0 b2 0
C70 m1_2862_4048# a_3048_3416# 0.00491f
C71 b1 a_680_3416# 0.03391f
C72 m1_2372_2520# m1_756_3120# 0.13736f
C73 vdd m1_756_3120# 0.00214f
C74 m1_1780_5040# a_1864_3416# 0.42554f
C75 a_1272_3416# b3 0
C76 b2 m1_756_3120# 0
C77 m1_606_2410# m1_1780_5040# 0.12918f
C78 m1_2862_4048# a_2456_3416# 0.00561f
C79 m1_462_4048# m1_756_3120# 0
C80 a_2456_3416# b3 0.21262f
C81 a_1272_3416# b1 0.24882f
C82 a_1272_3416# a_680_3416# 0.04759f
C83 m1_860_4046# m1_606_2410# 0.08949f
C84 m1_1780_5040# m1_2974_2650# 0.08507f
C85 b0 b1 0.0391f
C86 a_3048_3416# a_2456_3416# 0.11912f
C87 m1_2862_4048# m1_756_3120# 0
C88 m1_606_2410# a_1864_3416# 0.0027f
C89 b0 a_680_3416# 0.24565f
C90 a_1272_3416# a_2456_3416# 0.00297f
C91 b1 m1_756_3120# 0.00539f
C92 b4 m1_2974_2650# 0.03331f
C93 m1_1780_5040# m1_2372_2520# 0.17871f
C94 vdd m1_1780_5040# 0.0026f
C95 m1_756_3120# a_680_3416# 0.10755f
C96 m1_1780_5040# b2 0
C97 m1_2974_2650# a_1864_3416# 0.00495f
C98 m1_1780_5040# m1_462_4048# 0
C99 m1_606_2410# m1_2974_2650# 0
C100 m1_860_4046# m1_2372_2520# 0
C101 a_1272_3416# m1_756_3120# 0.2354f
C102 b4 vdd 0.55146f
C103 a_2456_3416# m1_756_3120# 0
C104 m1_2974_2650# vss 0.65248f
C105 m1_2372_2520# vss 0.45945f
C106 m1_1780_5040# vss 0.79973f
C107 m1_860_4046# vss 0.58374f
C108 m1_756_3120# vss 0.79001f
C109 m1_606_2410# vss 0.54107f
C110 m1_462_4048# vss 0.74869f
C111 out vss 0.66703f
C112 vdd vss 7.78061f
C113 a_680_3416# vss 0.76469f
C114 b0 vss 0.46453f
C115 a_1272_3416# vss 0.41953f
C116 b1 vss 0.31842f
C117 a_1864_3416# vss 0.56004f
C118 b2 vss 0.2832f
C119 b4 vss 0.38639f
C120 a_2456_3416# vss 0.64752f
C121 b3 vss 0.32156f
C122 a_3048_3416# vss 1.09158f
C123 m1_2862_4048# vss 0.49249f
.ends

.subckt r_w1_l14p555 a_n100_1456# a_n100_n1578# VSUBS
X0 a_n100_1456# a_n100_n1578# VSUBS ppolyf_u_1k r_width=1u r_length=14.56u
C0 a_n100_n1578# VSUBS 0.27003f
C1 a_n100_1456# VSUBS 0.27003f
.ends

.subckt p_w10_l10 w_n1174_n1130# a_n1000_n1044# a_1000_n1000# a_n1088_n1000# VSUBS
X0 a_1000_n1000# a_n1000_n1044# a_n1088_n1000# w_n1174_n1130# pfet_03v3 ad=4.4p pd=20.88u as=4.4p ps=20.88u w=10u l=10u
C0 w_n1174_n1130# a_1000_n1000# 0.41194f
C1 a_n1000_n1044# a_1000_n1000# 0.38624f
C2 w_n1174_n1130# a_n1088_n1000# 0.41194f
C3 a_n1000_n1044# a_n1088_n1000# 0.38624f
C4 w_n1174_n1130# a_n1000_n1044# 1.0092f
C5 a_1000_n1000# VSUBS 0.65771f
C6 a_n1088_n1000# VSUBS 0.65771f
C7 w_n1174_n1130# VSUBS 15.9194f
.ends

.subckt bias_rails vsp vgln en_b vdd m1_782_438# m1_3422_438# vss m1_1222_3522# m1_342_438#
+ vsn m1_1662_438# vglp m1_2542_438#
XR0 vsp m1_342_438# vss r_w1_l14p555
XR1 vsp m1_782_438# vss r_w1_l14p555
XR2 m1_1222_3522# m1_782_438# vss r_w1_l14p555
XR3 m1_1222_3522# m1_1662_438# vss r_w1_l14p555
XR4 vgln m1_1662_438# vss r_w1_l14p555
XHDR vdd m1_342_438# en_b vdd vss p_w4_l0p5
XR5 vgln m1_2542_438# vss r_w1_l14p555
XR6 vglp m1_2542_438# vss r_w1_l14p555
XR7 vglp m1_3422_438# vss r_w1_l14p555
XR9 m1_3862_3522# vsn vss r_w1_l14p555
XR8 m1_3862_3522# m1_3422_438# vss r_w1_l14p555
XR10 vss vsn vss r_w1_l14p555
XC2 vsp vdd vsp vsp vss p_w10_l10
XC1 vss vsn vss vss vss p_w10_l10
C0 vgln m1_1222_3522# 0.01049f
C1 vsp m1_3862_3522# 0.02981f
C2 vsp m1_1222_3522# 0.09037f
C3 vsp vgln 0.07625f
C4 m1_3862_3522# vglp 0.01054f
C5 m1_342_438# m1_782_438# 0.0401f
C6 m1_3862_3522# en_b 0.00238f
C7 m1_2542_438# m1_342_438# 0.02465f
C8 vglp vgln 0.17255f
C9 m1_3862_3522# vdd 0.01537f
C10 vsn m1_1222_3522# 0.063f
C11 vsp vglp 0.16572f
C12 vgln vsn 0.59161f
C13 en_b m1_342_438# 0.02808f
C14 m1_342_438# vsn 0.18087f
C15 vsp en_b 0.24632f
C16 vdd m1_342_438# 0.17301f
C17 vsp vsn 0.81189f
C18 vsp vdd 1.60715f
C19 m1_1662_438# m1_342_438# 0.02539f
C20 m1_2542_438# vsn 0
C21 m1_342_438# m1_3422_438# 0.0285f
C22 vglp en_b 0.00265f
C23 vglp vsn 0.14758f
C24 m1_1662_438# m1_782_438# 0.00961f
C25 vdd vglp 0.06028f
C26 m1_1662_438# m1_2542_438# 0.00961f
C27 en_b vsn 0.00115f
C28 vdd en_b 1.36198f
C29 m1_2542_438# m1_3422_438# 0.00961f
C30 vdd vsn 0.00661f
C31 m1_3422_438# vsn 0.03433f
C32 m1_3862_3522# vss 0.01668f
C33 vsn vss 2.43428f
C34 m1_3422_438# vss 0.00649f
C35 vglp vss 0.71006f
C36 m1_2542_438# vss 0.04057f
C37 en_b vss 0.77429f
C38 vdd vss 2.40243f
C39 vgln vss 0.3466f
C40 m1_1662_438# vss 0.04061f
C41 m1_1222_3522# vss 0.03291f
C42 m1_782_438# vss 0.04119f
C43 m1_342_438# vss 1.80172f
C44 vsp vss 7.7207f
.ends

.subckt r_w2_l1p315 a_n200_n254# a_n200_132# VSUBS
X0 a_n200_132# a_n200_n254# VSUBS ppolyf_u_1k r_width=2u r_length=1.32u
C0 a_n200_132# a_n200_n254# 0.02982f
C1 a_n200_n254# VSUBS 0.42149f
C2 a_n200_132# VSUBS 0.42149f
.ends

.subckt r_w2_l2p625 a_n200_n385# a_n200_263# VSUBS
X0 a_n200_263# a_n200_n385# VSUBS ppolyf_u_1k r_width=2u r_length=2.63u
C0 a_n200_263# a_n200_n385# 0.01591f
C1 a_n200_n385# VSUBS 0.43549f
C2 a_n200_263# VSUBS 0.43549f
.ends

.subckt r_w1_l5p175 a_n100_518# a_n100_n640# VSUBS
X0 a_n100_518# a_n100_n640# VSUBS ppolyf_u_1k r_width=1u r_length=5.18u
C0 a_n100_518# a_n100_n640# 0.00399f
C1 a_n100_n640# VSUBS 0.26263f
C2 a_n100_518# VSUBS 0.26263f
.ends

.subckt r_w1_l2p59 a_n100_n381# a_n100_259# VSUBS
X0 a_n100_259# a_n100_n381# VSUBS ppolyf_u_1k r_width=1u r_length=2.59u
C0 a_n100_259# a_n100_n381# 0.00799f
C1 a_n100_n381# VSUBS 0.25697f
C2 a_n100_259# VSUBS 0.25697f
.ends

.subckt r_w1_l10p35 a_n100_n1157# a_n100_1035# VSUBS
X0 a_n100_1035# a_n100_n1157# VSUBS ppolyf_u_1k r_width=1u r_length=10.35u
C0 a_n100_n1157# VSUBS 0.27003f
C1 a_n100_1035# VSUBS 0.27003f
.ends

.subckt r_w1_l12p86 a_n100_n1408# a_n100_1286# VSUBS
X0 a_n100_1286# a_n100_n1408# VSUBS ppolyf_u_1k r_width=1u r_length=12.86u
C0 a_n100_n1408# VSUBS 0.27003f
C1 a_n100_1286# VSUBS 0.27003f
.ends

.subckt vdacr_vc b0 b1 b2 b3 b4 vdd out vss a_680_3416# a_2456_3416# m1_902_4048#
+ m1_596_3240# a_1864_3416# a_3048_3416# m1_2382_2650# m1_1663_4920# a_1272_3416#
+ m1_756_2640# m1_2964_2640# m1_1342_4048# m1_240_4046#
XXRS0 m1_756_2640# m1_596_3240# vss r_w2_l1p315
XXRS1 m1_1663_4920# m1_756_2640# vss r_w2_l2p625
XXRS3 m1_2382_2650# m1_2964_2640# vss r_w1_l5p175
XXRS2 m1_2382_2650# m1_1663_4920# vss r_w1_l2p59
XXRS4 vss m1_2964_2640# vss r_w1_l10p35
XIB4n a_3048_3416# b4 vss vss n_w0p5_l1
XIB3n a_2456_3416# b3 vss vss n_w0p5_l1
XIB4p vdd a_3048_3416# b4 vdd vss p_w1_l1
XIB2n a_1864_3416# b2 vss vss n_w0p5_l1
XIB3p vdd a_2456_3416# b3 vdd vss p_w1_l1
XIB2p vdd a_1864_3416# b2 vdd vss p_w1_l1
XIB1n a_1272_3416# b1 vss vss n_w0p5_l1
XIB0n a_680_3416# b0 vss vss n_w0p5_l1
XIB1p vdd a_1272_3416# b1 vdd vss p_w1_l1
XIB0p vdd a_680_3416# b0 vdd vss p_w1_l1
XXRB0 m1_240_4046# out vss r_w1_l12p86
XSW0 m1_756_2640# a_680_3416# m1_596_3240# a_680_3416# m1_596_3240# vss n_w4_l0p28_f2
XXRB1 m1_902_4048# m1_240_4046# vss r_w1_l12p86
XSW2 m1_2382_2650# a_1864_3416# m1_1663_4920# a_1864_3416# m1_1663_4920# vss n_w4_l0p28_f2
XSW1 m1_1663_4920# a_1272_3416# m1_756_2640# a_1272_3416# m1_756_2640# vss n_w4_l0p28_f2
XXRB3 m1_596_3240# m1_1342_4048# vss r_w1_l12p86
XXRB2 m1_1342_4048# m1_902_4048# vss r_w1_l12p86
XSW3 m1_2964_2640# a_2456_3416# m1_2382_2650# a_2456_3416# m1_2382_2650# vss n_w4_l0p28_f2
XSW4 vss a_3048_3416# m1_2964_2640# a_3048_3416# m1_2964_2640# vss n_w4_l0p28_f2
C0 m1_1663_4920# m1_596_3240# 0.1127f
C1 a_1272_3416# m1_2964_2640# 0
C2 m1_2382_2650# b3 0.02078f
C3 a_2456_3416# m1_2964_2640# 0.19022f
C4 m1_2382_2650# m1_596_3240# 0.118f
C5 m1_902_4048# m1_2964_2640# 0
C6 m1_1342_4048# m1_596_3240# 0.09677f
C7 m1_756_2640# m1_2964_2640# 0.04178f
C8 out m1_240_4046# 0.07214f
C9 a_1272_3416# a_1864_3416# 0.13781f
C10 m1_1663_4920# m1_240_4046# 0.00215f
C11 a_2456_3416# a_1864_3416# 0.01449f
C12 b0 a_680_3416# 0.36757f
C13 b2 a_1864_3416# 0.30281f
C14 m1_756_2640# a_1864_3416# 0.29457f
C15 m1_1342_4048# m1_240_4046# 0.00103f
C16 vdd b3 0.45495f
C17 b4 m1_2964_2640# 0.01478f
C18 vdd m1_596_3240# 0
C19 m1_1663_4920# a_680_3416# 0
C20 m1_1663_4920# m1_2964_2640# 0.01984f
C21 a_3048_3416# m1_2964_2640# 0.09007f
C22 m1_2382_2650# m1_2964_2640# 0.23693f
C23 b4 a_1864_3416# 0
C24 b1 a_680_3416# 0.0311f
C25 m1_1342_4048# m1_2964_2640# 0
C26 a_2456_3416# a_1272_3416# 0.01813f
C27 a_1272_3416# b2 0.04376f
C28 m1_1663_4920# a_1864_3416# 0.42793f
C29 a_3048_3416# a_1864_3416# 0
C30 a_2456_3416# b2 0.00423f
C31 a_1272_3416# m1_902_4048# 0.00536f
C32 a_1272_3416# m1_756_2640# 0.26733f
C33 m1_2382_2650# a_1864_3416# 0.08393f
C34 a_2456_3416# m1_756_2640# 0.0082f
C35 vdd a_680_3416# 0.29773f
C36 b2 m1_756_2640# 0
C37 m1_240_4046# m1_596_3240# 0.03917f
C38 m1_902_4048# m1_756_2640# 0.00238f
C39 vdd m1_2964_2640# 0.00309f
C40 b1 a_1864_3416# 0.01341f
C41 a_1272_3416# b0 0
C42 a_680_3416# m1_596_3240# 0.14182f
C43 b4 a_2456_3416# 0.08415f
C44 b0 m1_756_2640# 0
C45 b3 m1_2964_2640# 0
C46 vdd a_1864_3416# 0.25499f
C47 m1_596_3240# m1_2964_2640# 0
C48 m1_1663_4920# a_1272_3416# 0.13237f
C49 out m1_902_4048# 0.02561f
C50 a_2456_3416# m1_1663_4920# 0.07447f
C51 a_3048_3416# a_2456_3416# 0.03483f
C52 m1_2382_2650# a_1272_3416# 0.00845f
C53 m1_1663_4920# b2 0.01235f
C54 a_680_3416# m1_240_4046# 0.01577f
C55 m1_2382_2650# a_2456_3416# 0.29266f
C56 m1_1663_4920# m1_902_4048# 0.00281f
C57 m1_1663_4920# m1_756_2640# 0.35225f
C58 a_1272_3416# m1_1342_4048# 0.00204f
C59 m1_2382_2650# b2 0.00779f
C60 b3 a_1864_3416# 0.03231f
C61 m1_2382_2650# m1_902_4048# 0
C62 m1_2382_2650# m1_756_2640# 0.20497f
C63 a_1864_3416# m1_596_3240# 0.00107f
C64 m1_902_4048# m1_1342_4048# 0.53671f
C65 m1_1342_4048# m1_756_2640# 0.00252f
C66 b1 a_1272_3416# 0.2443f
C67 b1 b2 0.03672f
C68 b1 m1_756_2640# 0.02521f
C69 a_3048_3416# b4 0.28941f
C70 vdd a_1272_3416# 0.16599f
C71 a_2456_3416# vdd 0.22632f
C72 out m1_1663_4920# 0.00973f
C73 vdd b2 0.48541f
C74 vdd m1_756_2640# 0.01026f
C75 a_3048_3416# m1_1663_4920# 0
C76 out m1_1342_4048# 0.06792f
C77 b1 b0 0.03223f
C78 m1_2382_2650# m1_1663_4920# 0.69587f
C79 m1_2382_2650# a_3048_3416# 0.00307f
C80 a_680_3416# a_1864_3416# 0.00212f
C81 a_1272_3416# b3 0
C82 m1_1663_4920# m1_1342_4048# 0.26306f
C83 a_2456_3416# b3 0.20171f
C84 a_1272_3416# m1_596_3240# 0.02856f
C85 b2 b3 0.05389f
C86 a_2456_3416# m1_596_3240# 0
C87 m1_2382_2650# m1_1342_4048# 0.01723f
C88 a_1864_3416# m1_2964_2640# 0
C89 b1 m1_1663_4920# 0
C90 m1_902_4048# m1_596_3240# 0.17167f
C91 m1_756_2640# m1_596_3240# 0.31403f
C92 vdd b0 0.4728f
C93 b4 vdd 0.64298f
C94 vdd m1_1663_4920# 0.00412f
C95 a_3048_3416# vdd 0.1443f
C96 m1_902_4048# m1_240_4046# 0.07637f
C97 m1_2382_2650# vdd 0.00156f
C98 b4 b3 0.05196f
C99 b0 m1_596_3240# 0.00377f
C100 a_1272_3416# a_680_3416# 0.03382f
C101 a_3048_3416# b3 0
C102 b1 vdd 0.42955f
C103 m1_902_4048# a_680_3416# 0
C104 a_680_3416# m1_756_2640# 0.04344f
C105 m1_2964_2640# vss 1.70309f
C106 m1_1342_4048# vss 0.15563f
C107 m1_1663_4920# vss 0.55315f
C108 m1_2382_2650# vss 0.81449f
C109 m1_902_4048# vss 0.3341f
C110 m1_756_2640# vss 0.62171f
C111 m1_596_3240# vss 0.55289f
C112 m1_240_4046# vss 1.23966f
C113 out vss 0.55586f
C114 vdd vss 7.67257f
C115 a_680_3416# vss 1.22922f
C116 b0 vss 0.37052f
C117 a_1272_3416# vss 0.44211f
C118 b1 vss 0.28315f
C119 a_1864_3416# vss 0.73162f
C120 b2 vss 0.31706f
C121 b4 vss 0.35606f
C122 a_2456_3416# vss 0.59836f
C123 b3 vss 0.35144f
C124 a_3048_3416# vss 1.11524f
.ends

.subckt r_w1_l9p86 a_n100_n1108# a_n100_986# VSUBS
X0 a_n100_986# a_n100_n1108# VSUBS ppolyf_u_1k r_width=1u r_length=9.86u
C0 a_n100_n1108# VSUBS 0.27003f
C1 a_n100_986# VSUBS 0.27003f
.ends

.subckt r_w2_l2p5 a_n200_250# a_n200_n372# VSUBS
X0 a_n200_250# a_n200_n372# VSUBS ppolyf_u_1k r_width=2u r_length=2.5u
C0 a_n200_250# a_n200_n372# 0.01672f
C1 a_n200_n372# VSUBS 0.4345f
C2 a_n200_250# VSUBS 0.4345f
.ends

.subckt r_w1_l2p465 a_n100_n369# a_n100_247# VSUBS
X0 a_n100_247# a_n100_n369# VSUBS ppolyf_u_1k r_width=1u r_length=2.47u
C0 a_n100_247# a_n100_n369# 0.00837f
C1 a_n100_n369# VSUBS 0.25651f
C2 a_n100_247# VSUBS 0.25651f
.ends

.subckt r_w1_l4p93 a_n100_n615# a_n100_493# VSUBS
X0 a_n100_493# a_n100_n615# VSUBS ppolyf_u_1k r_width=1u r_length=4.93u
C0 a_n100_493# a_n100_n615# 0.0042f
C1 a_n100_n615# VSUBS 0.2623f
C2 a_n100_493# VSUBS 0.2623f
.ends

.subckt r_w1_l13p145 a_n100_1315# a_n100_n1437# VSUBS
X0 a_n100_1315# a_n100_n1437# VSUBS ppolyf_u_1k r_width=1u r_length=13.15u
C0 a_n100_n1437# VSUBS 0.27003f
C1 a_n100_1315# VSUBS 0.27003f
.ends

.subckt r_w1_l13p39 a_n100_n1461# a_n100_1339# VSUBS
X0 a_n100_1339# a_n100_n1461# VSUBS ppolyf_u_1k r_width=1u r_length=13.39u
C0 a_n100_n1461# VSUBS 0.27003f
C1 a_n100_1339# VSUBS 0.27003f
.ends

.subckt n_w6_l0p28_f2 a_52_n644# a_108_n600# a_n108_n644# a_n196_n600# a_n52_n600#
+ VSUBS
X0 a_108_n600# a_52_n644# a_n52_n600# VSUBS nfet_03v3 ad=2.64p pd=12.88u as=1.56p ps=6.52u w=6u l=0.28u
X1 a_n52_n600# a_n108_n644# a_n196_n600# VSUBS nfet_03v3 ad=1.56p pd=6.52u as=2.64p ps=12.88u w=6u l=0.28u
C0 a_108_n600# a_52_n644# 0.04695f
C1 a_n52_n600# a_52_n644# 0.04695f
C2 a_n108_n644# a_n196_n600# 0.04695f
C3 a_n108_n644# a_52_n644# 0.00519f
C4 a_n52_n600# a_108_n600# 0.2597f
C5 a_n52_n600# a_n108_n644# 0.04695f
C6 a_n52_n600# a_n196_n600# 0.2597f
C7 a_108_n600# VSUBS 0.28641f
C8 a_n52_n600# VSUBS 0.09458f
C9 a_n196_n600# VSUBS 0.28641f
.ends

.subckt vdacr_vt b0 b1 b2 b3 b4 b5 vdd m1_2720_2760# a_4584_3816# m1_5422_4448# vss
+ m1_382_4448# m1_822_4448# out a_3400_3816# a_2808_3816# m1_1702_4448# m1_1523_3480#
+ a_3992_3816# m1_4078_3250# m1_3222_4448# m1_4102_4448# m1_3908_2760# a_2216_3816#
+ m1_4982_4448# m1_2408_3600# m1_1262_4448# a_1624_3816#
XXRS4_0 m1_4102_4448# m1_3908_2760# vss r_w1_l9p86
XXRS4_1 m1_4078_3250# m1_4102_4448# vss r_w1_l9p86
XXRS0 m1_1523_3480# m1_2408_3600# vss r_w2_l2p5
XXRS1 m1_2720_2760# m1_2408_3600# vss r_w1_l2p465
XXRS3 m1_3908_2760# m1_3222_4448# vss r_w1_l9p86
XXRS2 m1_3222_4448# m1_2720_2760# vss r_w1_l4p93
XIB5n a_4584_3816# b5 vss vss n_w0p5_l1
XIB4n a_3992_3816# b4 vss vss n_w0p5_l1
XIB5p vdd a_4584_3816# b5 vdd vss p_w1_l1
XIB3n a_3400_3816# b3 vss vss n_w0p5_l1
XIB4p vdd a_3992_3816# b4 vdd vss p_w1_l1
XIB2n a_2808_3816# b2 vss vss n_w0p5_l1
XIB3p vdd a_3400_3816# b3 vdd vss p_w1_l1
XIB2p vdd a_2808_3816# b2 vdd vss p_w1_l1
XIB1n a_2216_3816# b1 vss vss n_w0p5_l1
XIB0n a_1624_3816# b0 vss vss n_w0p5_l1
XIB1p vdd a_2216_3816# b1 vdd vss p_w1_l1
XIB0p vdd a_1624_3816# b0 vdd vss p_w1_l1
XXRS5_0 m1_4078_3250# m1_4982_4448# vss r_w1_l13p145
XXRS5_1 m1_4982_4448# m1_5422_4448# vss r_w1_l13p145
XXRB0 m1_382_4448# out vss r_w1_l13p39
XSW0 a_1624_3816# m1_1523_3480# a_1624_3816# m1_1523_3480# m1_2408_3600# vss n_w6_l0p28_f2
XXRS5_2 m1_5422_4448# vss vss r_w1_l13p145
XXRB1 m1_822_4448# m1_382_4448# vss r_w1_l13p39
XSW2 a_2808_3816# m1_2720_2760# a_2808_3816# m1_2720_2760# m1_3222_4448# vss n_w6_l0p28_f2
XSW1 a_2216_3816# m1_2408_3600# a_2216_3816# m1_2408_3600# m1_2720_2760# vss n_w6_l0p28_f2
XXRB3 m1_1702_4448# m1_1262_4448# vss r_w1_l13p39
XXRB2 m1_1262_4448# m1_822_4448# vss r_w1_l13p39
XSW3 a_3400_3816# m1_3222_4448# a_3400_3816# m1_3222_4448# m1_3908_2760# vss n_w6_l0p28_f2
XXRB4 m1_1523_3480# m1_1702_4448# vss r_w1_l13p39
XSW4 a_3992_3816# m1_3908_2760# a_3992_3816# m1_3908_2760# m1_4078_3250# vss n_w6_l0p28_f2
XSW5 a_4584_3816# m1_4078_3250# a_4584_3816# m1_4078_3250# vss vss n_w6_l0p28_f2
C0 a_2216_3816# m1_1523_3480# 0.06767f
C1 m1_1702_4448# m1_2720_2760# 0
C2 a_3992_3816# m1_2720_2760# 0
C3 vdd m1_3908_2760# 0.00273f
C4 m1_3222_4448# m1_2408_3600# 0.04242f
C5 m1_1262_4448# m1_2720_2760# 0
C6 vdd a_2808_3816# 0.27798f
C7 m1_4102_4448# a_3992_3816# 0.00406f
C8 a_4584_3816# m1_4078_3250# 0.111f
C9 b5 b4 0.04472f
C10 a_3400_3816# m1_2720_2760# 0.00201f
C11 vdd b2 0.50217f
C12 a_4584_3816# m1_3908_2760# 0.00224f
C13 a_1624_3816# m1_2720_2760# 0
C14 b0 a_1624_3816# 0.15697f
C15 vdd m1_2408_3600# 0.00431f
C16 m1_822_4448# m1_1523_3480# 0
C17 m1_382_4448# m1_1523_3480# 0
C18 m1_1702_4448# m1_1523_3480# 0.11064f
C19 m1_1262_4448# m1_1523_3480# 0
C20 a_2808_3816# a_2216_3816# 0.04827f
C21 b3 m1_3908_2760# 0.00485f
C22 a_2216_3816# b2 0.05886f
C23 a_2808_3816# b3 0.06713f
C24 b3 b2 0.04625f
C25 a_1624_3816# m1_1523_3480# 0.24354f
C26 a_2216_3816# m1_2408_3600# 0.39348f
C27 b1 a_2808_3816# 0
C28 b1 b2 0.03795f
C29 m1_4982_4448# m1_4102_4448# 0
C30 a_3992_3816# m1_4078_3250# 0.46129f
C31 m1_1702_4448# m1_3908_2760# 0
C32 b1 m1_2408_3600# 0.03027f
C33 a_3992_3816# m1_3908_2760# 0.28733f
C34 m1_4102_4448# m1_2720_2760# 0
C35 a_3400_3816# m1_4078_3250# 0.02137f
C36 a_2808_3816# a_3992_3816# 0
C37 m1_2408_3600# m1_822_4448# 0
C38 vdd m1_3222_4448# 0
C39 a_3400_3816# m1_3908_2760# 0.22332f
C40 a_3400_3816# a_2808_3816# 0.12718f
C41 m1_1702_4448# m1_2408_3600# 0.06983f
C42 a_4584_3816# m1_3222_4448# 0
C43 a_3400_3816# b2 0.0044f
C44 a_2808_3816# a_1624_3816# 0
C45 m1_1262_4448# m1_2408_3600# 0
C46 b4 m1_4078_3250# 0.00389f
C47 m1_2720_2760# m1_1523_3480# 0.1053f
C48 b0 m1_1523_3480# 0.00106f
C49 b4 m1_3908_2760# 0.01955f
C50 m1_4102_4448# m1_1523_3480# 0
C51 b5 m1_4078_3250# 0.00647f
C52 a_4584_3816# vdd 0.20323f
C53 a_1624_3816# m1_2408_3600# 0.06776f
C54 a_2216_3816# m1_3222_4448# 0.00993f
C55 b4 b2 0
C56 m1_822_4448# out 0.03993f
C57 b3 m1_3222_4448# 0.02397f
C58 m1_4982_4448# m1_5422_4448# 0.22446f
C59 m1_382_4448# out 0.05592f
C60 m1_4982_4448# m1_4078_3250# 0.28435f
C61 m1_1702_4448# out 0.0205f
C62 m1_4982_4448# m1_3908_2760# 0
C63 vdd a_2216_3816# 0.16862f
C64 m1_2720_2760# m1_4078_3250# 0
C65 m1_1262_4448# out 0.01815f
C66 m1_4102_4448# m1_5422_4448# 0
C67 vdd b3 0.48325f
C68 m1_2720_2760# m1_3908_2760# 0.00425f
C69 m1_4102_4448# m1_4078_3250# 0.24673f
C70 a_2808_3816# m1_2720_2760# 0.18059f
C71 m1_4102_4448# m1_3908_2760# 0.13034f
C72 b0 a_2808_3816# 0
C73 m1_1702_4448# m1_3222_4448# 0.01015f
C74 b1 vdd 0.57997f
C75 b2 m1_2720_2760# 0.00703f
C76 m1_3222_4448# a_3992_3816# 0.00131f
C77 b0 b2 0
C78 m1_2408_3600# m1_2720_2760# 0.46666f
C79 a_3400_3816# m1_3222_4448# 0.21689f
C80 b0 m1_2408_3600# 0
C81 m1_2408_3600# m1_4102_4448# 0
C82 vdd a_3992_3816# 0.2529f
C83 b3 a_2216_3816# 0
C84 m1_3908_2760# m1_1523_3480# 0
C85 a_2808_3816# m1_1523_3480# 0
C86 a_3400_3816# vdd 0.23735f
C87 a_4584_3816# a_3992_3816# 0.07047f
C88 b1 a_2216_3816# 0.2531f
C89 vdd a_1624_3816# 0.18717f
C90 b1 b3 0
C91 a_4584_3816# a_3400_3816# 0.00726f
C92 m1_2408_3600# m1_1523_3480# 0.469f
C93 m1_5422_4448# m1_4078_3250# 0.00347f
C94 vdd b4 0.42881f
C95 m1_5422_4448# m1_3908_2760# 0
C96 m1_3908_2760# m1_4078_3250# 0.30336f
C97 b5 vdd 0.43768f
C98 a_3400_3816# a_2216_3816# 0
C99 a_2808_3816# m1_3908_2760# 0.05146f
C100 m1_3222_4448# m1_2720_2760# 0.29322f
C101 m1_382_4448# m1_822_4448# 0.24532f
C102 a_3400_3816# b3 0.22216f
C103 a_2216_3816# a_1624_3816# 0.04096f
C104 a_4584_3816# b5 0.25028f
C105 m1_3222_4448# m1_4102_4448# 0.00515f
C106 a_2808_3816# b2 0.15545f
C107 m1_1702_4448# m1_382_4448# 0
C108 m1_1262_4448# m1_822_4448# 0.1481f
C109 m1_2408_3600# m1_3908_2760# 0.00121f
C110 vdd m1_2720_2760# 0.00518f
C111 m1_1262_4448# m1_382_4448# 0
C112 a_2808_3816# m1_2408_3600# 0.00831f
C113 a_4584_3816# m1_4982_4448# 0.00404f
C114 b0 vdd 0.93369f
C115 b1 a_1624_3816# 0.07746f
C116 b3 b4 0.0464f
C117 m1_1262_4448# m1_1702_4448# 0.26271f
C118 a_3400_3816# a_3992_3816# 0.06572f
C119 m1_3222_4448# m1_1523_3480# 0.00589f
C120 m1_1702_4448# a_1624_3816# 0.00126f
C121 m1_1262_4448# a_1624_3816# 0.01883f
C122 a_2216_3816# m1_2720_2760# 0.18569f
C123 vdd m1_1523_3480# 0.00181f
C124 b0 a_2216_3816# 0
C125 b4 a_3992_3816# 0.14825f
C126 a_3400_3816# b4 0.05013f
C127 b5 a_3992_3816# 0.04355f
C128 m1_3222_4448# m1_4078_3250# 0.00268f
C129 b1 m1_2720_2760# 0
C130 m1_2408_3600# out 0.00379f
C131 b1 b0 0.07045f
C132 m1_3222_4448# m1_3908_2760# 0.79372f
C133 a_2808_3816# m1_3222_4448# 0.33661f
C134 m1_3222_4448# b2 0.02027f
C135 vdd m1_4078_3250# 0
C136 m1_4078_3250# vss 1.0193f
C137 m1_3908_2760# vss 0.6176f
C138 m1_1262_4448# vss 0.46622f
C139 m1_1702_4448# vss 0.50469f
C140 m1_3222_4448# vss 0.36281f
C141 m1_2720_2760# vss 0.22391f
C142 m1_822_4448# vss 0.40669f
C143 m1_2408_3600# vss 0.34795f
C144 m1_1523_3480# vss 0.30041f
C145 m1_382_4448# vss 0.76813f
C146 out vss 0.89235f
C147 m1_5422_4448# vss 0.76804f
C148 m1_4982_4448# vss 0.40392f
C149 vdd vss 15.03409f
C150 a_1624_3816# vss 1.18395f
C151 b0 vss 0.66386f
C152 a_2216_3816# vss 0.49587f
C153 b1 vss 0.50743f
C154 b2 vss 0.53627f
C155 a_2808_3816# vss 0.53292f
C156 a_3400_3816# vss 0.52169f
C157 b3 vss 0.32078f
C158 a_3992_3816# vss 0.54027f
C159 b4 vss 0.29907f
C160 a_4584_3816# vss 0.98136f
C161 b5 vss 0.41509f
C162 m1_4102_4448# vss 0.36138f
.ends

.subckt p_w0p8_l2 w_n374_n210# a_n288_n80# a_200_n80# a_n200_n124# VSUBS
X0 a_200_n80# a_n200_n124# a_n288_n80# w_n374_n210# pfet_03v3 ad=0.352p pd=2.48u as=0.352p ps=2.48u w=0.8u l=2u
C0 a_200_n80# a_n200_n124# 0.02312f
C1 a_n200_n124# w_n374_n210# 0.22666f
C2 a_n288_n80# a_n200_n124# 0.02312f
C3 a_200_n80# w_n374_n210# 0.02527f
C4 a_n288_n80# a_200_n80# 0.0084f
C5 a_n288_n80# w_n374_n210# 0.02527f
C6 a_200_n80# VSUBS 0.09823f
C7 a_n288_n80# VSUBS 0.09823f
C8 w_n374_n210# VSUBS 0.94248f
.ends

.subckt p_w4_l2_f4 w_n1130_n530# a_n956_n444# a_556_n444# a_n52_n400# a_452_n400#
+ a_n452_n444# a_n556_n400# a_52_n444# a_956_n400# a_n1044_n400# VSUBS
X0 a_n556_n400# a_n956_n444# a_n1044_n400# w_n1130_n530# pfet_03v3 ad=1.04p pd=4.52u as=1.76p ps=8.88u w=4u l=2u
X1 a_n52_n400# a_n452_n444# a_n556_n400# w_n1130_n530# pfet_03v3 ad=1.04p pd=4.52u as=1.04p ps=4.52u w=4u l=2u
X2 a_452_n400# a_52_n444# a_n52_n400# w_n1130_n530# pfet_03v3 ad=1.04p pd=4.52u as=1.04p ps=4.52u w=4u l=2u
X3 a_956_n400# a_556_n444# a_452_n400# w_n1130_n530# pfet_03v3 ad=1.76p pd=8.88u as=1.04p ps=4.52u w=4u l=2u
C0 a_n556_n400# a_n1044_n400# 0.04287f
C1 w_n1130_n530# a_556_n444# 0.2233f
C2 a_n1044_n400# w_n1130_n530# 0.12268f
C3 a_452_n400# a_556_n444# 0.11799f
C4 a_52_n444# a_n52_n400# 0.11799f
C5 a_n556_n400# a_n956_n444# 0.11799f
C6 a_n956_n444# w_n1130_n530# 0.2233f
C7 a_n556_n400# a_n52_n400# 0.04287f
C8 w_n1130_n530# a_n52_n400# 0.18497f
C9 a_n452_n444# a_n956_n444# 0.00519f
C10 a_956_n400# w_n1130_n530# 0.12268f
C11 a_n52_n400# a_452_n400# 0.04287f
C12 a_52_n444# w_n1130_n530# 0.21994f
C13 a_956_n400# a_452_n400# 0.04287f
C14 a_52_n444# a_452_n400# 0.11799f
C15 a_n452_n444# a_n52_n400# 0.11799f
C16 a_n556_n400# w_n1130_n530# 0.18497f
C17 a_n452_n444# a_52_n444# 0.00519f
C18 w_n1130_n530# a_452_n400# 0.18497f
C19 a_n956_n444# a_n1044_n400# 0.11799f
C20 a_n556_n400# a_n452_n444# 0.11799f
C21 a_n452_n444# w_n1130_n530# 0.21994f
C22 a_956_n400# a_556_n444# 0.11799f
C23 a_52_n444# a_556_n444# 0.00519f
C24 a_956_n400# VSUBS 0.19832f
C25 a_452_n400# VSUBS 0.12191f
C26 a_n52_n400# VSUBS 0.11851f
C27 a_n556_n400# VSUBS 0.12191f
C28 a_n1044_n400# VSUBS 0.19832f
C29 w_n1130_n530# VSUBS 7.1868f
.ends

.subckt p_w0p5_l10 a_n1088_n50# a_1000_n50# w_n1174_n180# a_n1000_n94# VSUBS
X0 a_1000_n50# a_n1000_n94# a_n1088_n50# w_n1174_n180# pfet_03v3 ad=0.22p pd=1.88u as=0.22p ps=1.88u w=0.5u l=10u
C0 a_n1000_n94# a_1000_n50# 0.01858f
C1 a_n1088_n50# a_n1000_n94# 0.01858f
C2 a_1000_n50# w_n1174_n180# 0.02013f
C3 a_n1000_n94# w_n1174_n180# 1.0092f
C4 a_n1088_n50# w_n1174_n180# 0.02013f
C5 a_1000_n50# VSUBS 0.30033f
C6 a_n1088_n50# VSUBS 0.30033f
C7 w_n1174_n180# VSUBS 2.53584f
.ends

.subckt n_w2_l2_f4 a_n52_n200# a_452_n200# a_n452_n244# a_n556_n200# a_52_n244# a_956_n200#
+ a_n1044_n200# a_n956_n244# a_556_n244# VSUBS
X0 a_452_n200# a_52_n244# a_n52_n200# VSUBS nfet_03v3 ad=0.52p pd=2.52u as=0.52p ps=2.52u w=2u l=2u
X1 a_956_n200# a_556_n244# a_452_n200# VSUBS nfet_03v3 ad=0.88p pd=4.88u as=0.52p ps=2.52u w=2u l=2u
X2 a_n556_n200# a_n956_n244# a_n1044_n200# VSUBS nfet_03v3 ad=0.52p pd=2.52u as=0.88p ps=4.88u w=2u l=2u
X3 a_n52_n200# a_n452_n244# a_n556_n200# VSUBS nfet_03v3 ad=0.52p pd=2.52u as=0.52p ps=2.52u w=2u l=2u
C0 a_556_n244# a_956_n200# 0.0587f
C1 a_452_n200# a_n52_n200# 0.02133f
C2 a_452_n200# a_956_n200# 0.02133f
C3 a_52_n244# a_556_n244# 0.00519f
C4 a_52_n244# a_n452_n244# 0.00519f
C5 a_n452_n244# a_n556_n200# 0.0587f
C6 a_n452_n244# a_n956_n244# 0.00519f
C7 a_n1044_n200# a_n556_n200# 0.02133f
C8 a_556_n244# a_452_n200# 0.0587f
C9 a_n556_n200# a_n956_n244# 0.0587f
C10 a_n1044_n200# a_n956_n244# 0.0587f
C11 a_52_n244# a_452_n200# 0.0587f
C12 a_n452_n244# a_n52_n200# 0.0587f
C13 a_52_n244# a_n52_n200# 0.0587f
C14 a_n556_n200# a_n52_n200# 0.02133f
C15 a_956_n200# VSUBS 0.26162f
C16 a_452_n200# VSUBS 0.34773f
C17 a_n52_n200# VSUBS 0.34265f
C18 a_n556_n200# VSUBS 0.34773f
C19 a_n1044_n200# VSUBS 0.26162f
.ends

.subckt p_w4_l1_f4 a_252_n400# a_n556_n444# a_n644_n400# a_n252_n444# a_n356_n400#
+ a_n52_n400# a_356_n444# w_n730_n530# a_52_n444# a_556_n400# VSUBS
X0 a_n356_n400# a_n556_n444# a_n644_n400# w_n730_n530# pfet_03v3 ad=1.04p pd=4.52u as=1.76p ps=8.88u w=4u l=1u
X1 a_556_n400# a_356_n444# a_252_n400# w_n730_n530# pfet_03v3 ad=1.76p pd=8.88u as=1.04p ps=4.52u w=4u l=1u
X2 a_n52_n400# a_n252_n444# a_n356_n400# w_n730_n530# pfet_03v3 ad=1.04p pd=4.52u as=1.04p ps=4.52u w=4u l=1u
X3 a_252_n400# a_52_n444# a_n52_n400# w_n730_n530# pfet_03v3 ad=1.04p pd=4.52u as=1.04p ps=4.52u w=4u l=1u
C0 a_n252_n444# w_n730_n530# 0.12212f
C1 a_252_n400# a_52_n444# 0.08505f
C2 a_n556_n444# w_n730_n530# 0.12548f
C3 a_52_n444# w_n730_n530# 0.12212f
C4 a_n644_n400# w_n730_n530# 0.09518f
C5 a_252_n400# a_556_n400# 0.07756f
C6 w_n730_n530# a_556_n400# 0.09518f
C7 a_n356_n400# w_n730_n530# 0.12997f
C8 a_52_n444# a_356_n444# 0.00519f
C9 a_356_n444# a_556_n400# 0.08505f
C10 a_n52_n400# a_n252_n444# 0.08505f
C11 a_n52_n400# a_52_n444# 0.08505f
C12 a_n556_n444# a_n252_n444# 0.00519f
C13 a_52_n444# a_n252_n444# 0.00519f
C14 a_n356_n400# a_n52_n400# 0.07756f
C15 a_n356_n400# a_n252_n444# 0.08505f
C16 a_n644_n400# a_n556_n444# 0.08505f
C17 a_n356_n400# a_n556_n444# 0.08505f
C18 a_252_n400# w_n730_n530# 0.12997f
C19 a_n356_n400# a_n644_n400# 0.07756f
C20 a_252_n400# a_356_n444# 0.08505f
C21 a_356_n444# w_n730_n530# 0.12548f
C22 a_n52_n400# a_252_n400# 0.07756f
C23 a_n52_n400# w_n730_n530# 0.12997f
C24 a_556_n400# VSUBS 0.17216f
C25 a_252_n400# VSUBS 0.0696f
C26 a_n52_n400# VSUBS 0.06619f
C27 a_n356_n400# VSUBS 0.0696f
C28 a_n644_n400# VSUBS 0.17216f
C29 w_n730_n530# VSUBS 4.6428f
.ends

.subckt n_w4_l2_f2 a_n52_n400# a_452_n400# a_n452_n444# a_n540_n400# a_52_n444# VSUBS
X0 a_n52_n400# a_n452_n444# a_n540_n400# VSUBS nfet_03v3 ad=1.04p pd=4.52u as=1.76p ps=8.88u w=4u l=2u
X1 a_452_n400# a_52_n444# a_n52_n400# VSUBS nfet_03v3 ad=1.76p pd=8.88u as=1.04p ps=4.52u w=4u l=2u
C0 a_n540_n400# a_n452_n444# 0.11799f
C1 a_n540_n400# a_n52_n400# 0.04287f
C2 a_n452_n444# a_52_n444# 0.00519f
C3 a_n52_n400# a_52_n444# 0.11799f
C4 a_452_n400# a_n52_n400# 0.04287f
C5 a_n452_n444# a_n52_n400# 0.11799f
C6 a_452_n400# a_52_n444# 0.11799f
C7 a_452_n400# VSUBS 0.33857f
C8 a_n52_n400# VSUBS 0.35281f
C9 a_n540_n400# VSUBS 0.33857f
.ends

.subckt p_w1_l0p5 a_n138_n100# a_50_n100# a_n50_n144# w_n224_n230# VSUBS
X0 a_50_n100# a_n50_n144# a_n138_n100# w_n224_n230# pfet_03v3 ad=0.44p pd=2.88u as=0.44p ps=2.88u w=1u l=0.5u
C0 a_n138_n100# w_n224_n230# 0.0205f
C1 a_n138_n100# a_50_n100# 0.03085f
C2 w_n224_n230# a_n50_n144# 0.07993f
C3 a_50_n100# a_n50_n144# 0.01275f
C4 a_n138_n100# a_n50_n144# 0.01275f
C5 w_n224_n230# a_50_n100# 0.0205f
C6 a_50_n100# VSUBS 0.06546f
C7 a_n138_n100# VSUBS 0.06546f
C8 w_n224_n230# VSUBS 0.61824f
.ends

.subckt p_w4_l2 w_n374_n530# a_n288_n400# a_200_n400# a_n200_n444# VSUBS
X0 a_200_n400# a_n200_n444# a_n288_n400# w_n374_n530# pfet_03v3 ad=1.76p pd=8.88u as=1.76p ps=8.88u w=4u l=2u
C0 a_n288_n400# w_n374_n530# 0.12268f
C1 a_n288_n400# a_200_n400# 0.04287f
C2 w_n374_n530# a_n200_n444# 0.22666f
C3 a_200_n400# a_n200_n444# 0.11799f
C4 a_n288_n400# a_n200_n444# 0.11799f
C5 w_n374_n530# a_200_n400# 0.12268f
C6 a_200_n400# VSUBS 0.20173f
C7 a_n288_n400# VSUBS 0.20173f
C8 w_n374_n530# VSUBS 2.37864f
.ends

.subckt n_w4_l2 a_n288_n400# a_200_n400# a_n200_n444# VSUBS
X0 a_200_n400# a_n200_n444# a_n288_n400# VSUBS nfet_03v3 ad=1.76p pd=8.88u as=1.76p ps=8.88u w=4u l=2u
C0 a_200_n400# a_n200_n444# 0.11799f
C1 a_n200_n444# a_n288_n400# 0.11799f
C2 a_200_n400# a_n288_n400# 0.04287f
C3 a_200_n400# VSUBS 0.34365f
C4 a_n288_n400# VSUBS 0.34365f
.ends

.subckt p_w4_l1 a_n188_n400# a_100_n400# a_n100_n444# w_n274_n530# VSUBS
X0 a_100_n400# a_n100_n444# a_n188_n400# w_n274_n530# pfet_03v3 ad=1.76p pd=8.88u as=1.76p ps=8.88u w=4u l=1u
C0 a_n188_n400# w_n274_n530# 0.09518f
C1 a_n188_n400# a_100_n400# 0.07756f
C2 w_n274_n530# a_n100_n444# 0.12884f
C3 a_100_n400# a_n100_n444# 0.08505f
C4 a_n188_n400# a_n100_n444# 0.08505f
C5 w_n274_n530# a_100_n400# 0.09518f
C6 a_100_n400# VSUBS 0.17557f
C7 a_n188_n400# VSUBS 0.17557f
C8 w_n274_n530# VSUBS 1.74264f
.ends

.subckt r_w1_l14p19 a_n100_1419# a_n100_n1541# VSUBS
X0 a_n100_1419# a_n100_n1541# VSUBS ppolyf_u_1k r_width=1u r_length=14.19u
C0 a_n100_n1541# VSUBS 0.27003f
C1 a_n100_1419# VSUBS 0.27003f
.ends

.subckt p_w0p5_l4 a_n488_n50# a_400_n50# a_n400_n94# w_n574_n180# VSUBS
X0 a_400_n50# a_n400_n94# a_n488_n50# w_n574_n180# pfet_03v3 ad=0.22p pd=1.88u as=0.22p ps=1.88u w=0.5u l=4u
C0 a_n488_n50# w_n574_n180# 0.01856f
C1 a_n488_n50# a_400_n50# 0.0026f
C2 w_n574_n180# a_n400_n94# 0.42229f
C3 a_400_n50# a_n400_n94# 0.01702f
C4 a_n488_n50# a_n400_n94# 0.01702f
C5 w_n574_n180# a_400_n50# 0.01856f
C6 a_400_n50# VSUBS 0.14084f
C7 a_n488_n50# VSUBS 0.14084f
C8 w_n574_n180# VSUBS 1.23984f
.ends

.subckt bias_vi en vglp vgln vth_cmp vth_ref m1_8646_1098# m1_942_738# vreset_src
+ iint m1_8042_6360# vss m1_7102_850# ib_x2 m1_7440_2050# m1_5388_6960# m1_4894_1238#
+ a_5712_1328# a_2102_5152# m1_4546_7560# m1_502_738# m1_1276_6360# vdd m1_1382_738#
+ vbn_prb a_4976_1528# m1_8332_7080# el a_864_6450# ib_r1
XPP vdd vdd vbn_prb a_864_6450# vss p_w0p8_l2
XMO vdd a_864_6450# a_864_6450# vdd m1_1276_6360# a_864_6450# m1_1276_6360# a_864_6450#
+ vdd vdd vss p_w4_l2_f4
XPS vdd m1_7102_850# vdd vgln vss p_w0p5_l10
XOR vss ib_r1 vbn_prb ib_r1 vbn_prb vss vss vbn_prb vbn_prb vss n_w2_l2_f4
XKO a_4976_1528# vglp m1_1276_6360# vglp a_4976_1528# m1_1276_6360# vglp vdd vglp
+ m1_1276_6360# vss p_w4_l1_f4
XMR vdd a_864_6450# a_864_6450# vdd m1_5388_6960# a_864_6450# m1_5388_6960# a_864_6450#
+ vdd vdd vss p_w4_l2_f4
XP1 vdd a_2102_5152# a_2102_5152# vdd vss p_w2_l2
XNS vss m1_7102_850# a_5712_1328# m1_7102_850# a_5712_1328# vss n_w4_l2_f2
XPOFF vdd a_864_6450# en vdd vss p_w1_l0p5
XP2 vdd a_864_6450# a_2102_5152# vdd vss p_w2_l2
XMS2 vss en m1_8646_1098# vss n_w0p5_l1
XMS1 m1_8646_1098# m1_7102_850# a_864_6450# vss n_w0p5_l1
XNT vss m1_4894_1238# a_5712_1328# vss n_w2_l2
XMT vdd vdd m1_8332_7080# a_864_6450# vss p_w4_l2
XKR vreset_src vglp m1_5388_6960# vglp vreset_src m1_5388_6960# vglp vdd vglp m1_5388_6960#
+ vss p_w4_l1_f4
XN1 m1_4894_1238# a_864_6450# vglp vss n_w4_l2
XN2 m1_4894_1238# a_2102_5152# a_4976_1528# vss n_w4_l2
XKT m1_8332_7080# vth_ref vglp vdd vss p_w4_l1
XOX vss m1_7440_2050# vbn_prb m1_7440_2050# vbn_prb vss vss vbn_prb vbn_prb vss n_w2_l2_f4
XXR00 a_4976_1528# m1_502_738# vss r_w1_l14p19
XXR01 m1_502_738# m1_942_738# vss r_w1_l14p19
XXR03 m1_1382_738# vss vss r_w1_l14p19
XXR02 m1_942_738# m1_1382_738# vss r_w1_l14p19
XPB vdd a_5712_1328# a_864_6450# vdd vss p_w0p5_l4
XNB vss a_5712_1328# a_5712_1328# vss n_w2_l2
XMC vdd a_864_6450# a_864_6450# vdd m1_8042_6360# a_864_6450# m1_8042_6360# a_864_6450#
+ vdd vdd vss p_w4_l2_f4
XKC vth_cmp vglp m1_8042_6360# vglp vth_cmp m1_8042_6360# vglp vdd vglp m1_8042_6360#
+ vss p_w4_l1_f4
XME vdd a_864_6450# a_864_6450# vdd m1_4546_7560# a_864_6450# m1_4546_7560# a_864_6450#
+ vdd vdd vss p_w4_l2_f4
XPI vdd vdd iint a_864_6450# vss p_w0p8_l2
XSX2 m1_7440_2050# ib_r1 ib_x2 vss n_w4_l0p5
XKE el vglp m1_4546_7560# vglp el m1_4546_7560# vglp vdd vglp m1_4546_7560# vss p_w4_l1_f4
XDB vss vbn_prb vbn_prb vss n_w2_l2
C0 m1_5388_6960# vreset_src 0.26696f
C1 m1_5388_6960# vgln 0.00536f
C2 vbn_prb vglp 0.48983f
C3 m1_7102_850# a_864_6450# 0.14649f
C4 en m1_1382_738# 0.14813f
C5 iint vbn_prb 0.08998f
C6 m1_8042_6360# en 0
C7 m1_502_738# vdd 0.00342f
C8 m1_8646_1098# vbn_prb 0
C9 ib_r1 vbn_prb 0.81062f
C10 m1_7102_850# vglp 0.18545f
C11 en a_864_6450# 0.33221f
C12 m1_7102_850# iint 0.3658f
C13 a_4976_1528# m1_1382_738# 0.00776f
C14 m1_7102_850# m1_8646_1098# -0.00509f
C15 m1_7102_850# ib_r1 0.03826f
C16 en vglp 0.59159f
C17 m1_5388_6960# m1_8042_6360# 0.11312f
C18 iint en 0.17194f
C19 a_5712_1328# a_864_6450# 0.04659f
C20 a_4976_1528# a_864_6450# 0.73462f
C21 m1_1276_6360# a_2102_5152# 0.00961f
C22 m1_8646_1098# en 0.001f
C23 ib_r1 en 0.13773f
C24 vdd m1_942_738# 0.00344f
C25 m1_5388_6960# a_864_6450# 0.32262f
C26 m1_1276_6360# vdd 0.61385f
C27 a_5712_1328# vglp 0.16841f
C28 a_4976_1528# vglp 0.38892f
C29 m1_502_738# m1_1382_738# 0
C30 m1_5388_6960# vth_cmp 0.00607f
C31 m1_4546_7560# el 0.12283f
C32 vth_ref el 0.71135f
C33 m1_5388_6960# vglp 0.15331f
C34 a_5712_1328# iint 0.29607f
C35 iint a_4976_1528# 0
C36 ib_r1 a_5712_1328# 0.15887f
C37 ib_r1 a_4976_1528# 0.24273f
C38 vdd a_2102_5152# 1.73077f
C39 vgln m1_7440_2050# 0
C40 vgln a_2102_5152# 0.08399f
C41 a_2102_5152# m1_4894_1238# 0.06382f
C42 vdd vreset_src 0.46224f
C43 vgln vdd 2.2258f
C44 ib_x2 vbn_prb 0.06125f
C45 vgln vreset_src 0
C46 m1_942_738# m1_1382_738# 0.08765f
C47 m1_7102_850# ib_x2 0.07339f
C48 m1_1276_6360# a_864_6450# 0.39666f
C49 vdd m1_8332_7080# 0.82484f
C50 a_2102_5152# m1_1382_738# 0
C51 m1_1276_6360# vglp 0.16358f
C52 vreset_src m1_8332_7080# 0.01543f
C53 en ib_x2 0.14421f
C54 vdd m1_1382_738# 0.0035f
C55 m1_8042_6360# vdd 0.53891f
C56 m1_8042_6360# vreset_src 0.26401f
C57 m1_7440_2050# a_864_6450# 0.06786f
C58 a_2102_5152# a_864_6450# 0.40639f
C59 vdd a_864_6450# 10.38485f
C60 a_5712_1328# ib_x2 0.10242f
C61 vreset_src a_864_6450# 0.08448f
C62 ib_x2 a_4976_1528# 0.04795f
C63 vglp m1_7440_2050# 0.05819f
C64 m1_7102_850# vbn_prb 0.11192f
C65 vgln a_864_6450# 0.12647f
C66 m1_4894_1238# a_864_6450# 0.3222f
C67 a_2102_5152# vglp 0.09855f
C68 el a_4976_1528# 0.00185f
C69 vdd vth_cmp 0.17797f
C70 vdd vglp 5.25107f
C71 m1_5388_6960# el 0
C72 vth_cmp vreset_src 0.14964f
C73 a_5712_1328# m1_4546_7560# 0
C74 m1_4546_7560# a_4976_1528# 0.00278f
C75 vglp vreset_src 0.54612f
C76 iint m1_7440_2050# 0
C77 iint a_2102_5152# 0
C78 vgln vglp 0
C79 m1_4894_1238# vglp 0.286f
C80 m1_5388_6960# m1_4546_7560# 0.09335f
C81 vdd iint 0.18374f
C82 m1_5388_6960# vth_ref 0
C83 m1_8646_1098# m1_7440_2050# 0.00687f
C84 ib_r1 m1_7440_2050# 0.00546f
C85 ib_r1 a_2102_5152# 0.11035f
C86 en vbn_prb 0.26578f
C87 m1_8042_6360# m1_8332_7080# 0.13476f
C88 ib_r1 vdd 0
C89 vgln iint 0.12915f
C90 iint m1_4894_1238# 0.00172f
C91 ib_r1 vgln 0.04275f
C92 ib_r1 m1_4894_1238# 0.16682f
C93 a_864_6450# m1_8332_7080# 0.09337f
C94 m1_7102_850# en 0.14198f
C95 a_5712_1328# vbn_prb 0.18056f
C96 vth_cmp m1_8332_7080# 0.00111f
C97 m1_8042_6360# a_864_6450# 0.5698f
C98 vbn_prb a_4976_1528# 0.11005f
C99 vglp m1_8332_7080# 0.0652f
C100 vglp m1_1382_738# 0.00131f
C101 m1_8042_6360# vth_cmp 0.21651f
C102 m1_8042_6360# vglp 0.2232f
C103 m1_7102_850# a_5712_1328# 0.54324f
C104 m1_8042_6360# iint 0
C105 vth_cmp a_864_6450# 0.02777f
C106 vglp a_864_6450# 0.83998f
C107 m1_1276_6360# el 0.00217f
C108 vth_cmp vglp 0.28484f
C109 m1_1276_6360# m1_4546_7560# 0.14038f
C110 a_5712_1328# en 0.05214f
C111 iint a_864_6450# 0.13343f
C112 en a_4976_1528# 0.05046f
C113 m1_8646_1098# a_864_6450# 0.03779f
C114 ib_r1 a_864_6450# 0.24976f
C115 iint vglp 0.04831f
C116 m1_8646_1098# vglp 0
C117 ib_x2 m1_7440_2050# 0.08935f
C118 a_2102_5152# ib_x2 0.01217f
C119 ib_r1 vglp 0.44719f
C120 vdd ib_x2 0
C121 vdd el 0.94055f
C122 a_5712_1328# a_4976_1528# 0.0106f
C123 ib_r1 iint 0.10242f
C124 a_2102_5152# m1_4546_7560# 0.0186f
C125 m1_5388_6960# a_5712_1328# 0.00317f
C126 el vreset_src 0.03609f
C127 vgln ib_x2 0.26925f
C128 ib_x2 m1_4894_1238# 0.06226f
C129 m1_502_738# en 0.01007f
C130 vdd m1_4546_7560# 0.40586f
C131 vth_ref vdd 0.31053f
C132 m1_4546_7560# vreset_src 0.00447f
C133 vth_ref vreset_src 0.1174f
C134 m1_502_738# a_4976_1528# 0.04144f
C135 vbn_prb m1_7440_2050# 0.36218f
C136 a_2102_5152# vbn_prb 0.11077f
C137 el m1_8332_7080# 0.00199f
C138 vdd vbn_prb 0.24855f
C139 ib_x2 m1_1382_738# 0
C140 m1_942_738# en 0.00966f
C141 vth_ref m1_8332_7080# 0.06042f
C142 vgln vbn_prb 0.23038f
C143 vbn_prb m1_4894_1238# 0.02997f
C144 m1_7102_850# m1_7440_2050# 0.02863f
C145 m1_8042_6360# vth_ref 0.00285f
C146 m1_7102_850# vdd 0.12129f
C147 ib_x2 a_864_6450# 0.02181f
C148 el a_864_6450# 0.02982f
C149 m1_7102_850# vgln 0.08937f
C150 m1_7102_850# m1_4894_1238# 0
C151 m1_942_738# a_4976_1528# 0.00922f
C152 m1_1276_6360# a_4976_1528# 0.30906f
C153 m1_4546_7560# a_864_6450# 0.73f
C154 vth_cmp el 0.048f
C155 vth_ref a_864_6450# 0.00723f
C156 ib_x2 vglp 0.10572f
C157 en m1_7440_2050# 0.05869f
C158 el vglp 0.41693f
C159 a_2102_5152# en 0.04646f
C160 vdd en 0.32674f
C161 vth_ref vth_cmp 0.05697f
C162 iint ib_x2 0.04728f
C163 m1_4546_7560# vglp 0.73349f
C164 vth_ref vglp 0.06719f
C165 en m1_4894_1238# 0
C166 vgln en 0.06792f
C167 vbn_prb m1_1382_738# 0
C168 m1_8646_1098# ib_x2 0.01147f
C169 ib_r1 ib_x2 0.20298f
C170 m1_8042_6360# vbn_prb 0
C171 a_5712_1328# m1_7440_2050# 0.03242f
C172 a_5712_1328# a_2102_5152# 0.15699f
C173 a_2102_5152# a_4976_1528# 0.4055f
C174 m1_502_738# m1_942_738# 0.42104f
C175 a_5712_1328# vdd 0.56694f
C176 vdd a_4976_1528# 1.4633f
C177 vbn_prb a_864_6450# 0.59172f
C178 m1_5388_6960# vdd 0.62183f
C179 a_5712_1328# m1_4894_1238# 0.16211f
C180 a_5712_1328# vgln 0.3298f
C181 vgln a_4976_1528# 0
C182 a_4976_1528# m1_4894_1238# 0.17878f
C183 m1_8042_6360# vss -0.29705f
C184 vbn_prb vss 3.71278f
C185 el vss 0.65712f
C186 m1_4546_7560# vss -0.26802f
C187 ib_x2 vss 3.37258f
C188 iint vss 1.91268f
C189 vth_cmp vss 0.07828f
C190 m1_1382_738# vss 1.13003f
C191 m1_942_738# vss 0.5126f
C192 m1_502_738# vss 0.71186f
C193 m1_7440_2050# vss 0.52223f
C194 vth_ref vss 0.57598f
C195 m1_8332_7080# vss -0.04322f
C196 a_2102_5152# vss 0.19991f
C197 a_4976_1528# vss 1.61618f
C198 a_864_6450# vss -0.98223f
C199 m1_4894_1238# vss 0.33472f
C200 vglp vss 1.49743f
C201 vreset_src vss 0.10863f
C202 m1_5388_6960# vss -0.271f
C203 a_5712_1328# vss 1.81802f
C204 m1_8646_1098# vss 0.01901f
C205 en vss 2.7871f
C206 m1_7102_850# vss 0.68137f
C207 m1_1276_6360# vss -0.17835f
C208 ib_r1 vss 1.6597f
C209 vgln vss 0.40803f
C210 vdd vss 64.84496f
.ends

.subckt bias_b1 vth_ref vreset_src ib_r1 ua0 vbn_leak vbn_ref vbp_syn vbp_st vbn_prb
+ el vth_cmp vbn_ax vbp_w ua0_stim_out r0_b0 r0_b1 r0_b2 r0_b3 r0_b4 r2_b0 r2_b1 r2_b2
+ r2_b3 r2_b4 r1_b0 r1_b1 r1_b2 r1_b3 r1_b4 i2_b0 i4_b0 i2_b1 i4_b1 i2_b2 i4_b2 i2_b3
+ i4_b3 i2_b4 i4_b4 i0_b0 i1_b0 i3_b0 i0_b1 i1_b1 i3_b1 i0_b2 i1_b2 i3_b2 i0_b3 i1_b3
+ i3_b3 i0_b4 i1_b4 i3_b4 v0_c0 v0_c1 v0_c2 v0_c3 v0_c4 v0_c5 bias_en ib_x2 ua0_s0
+ ua0_s1 ua0_stim ua0_int vdd vss
XXx0 vbn_leak vdd vss rx_n4
XXx1 vbn_ref vdd vss rx_n2
XXx2 vss vdd vbp_syn rx_p24
XXx3 vbn_ax vdd vss rx_n1
XXx4 vbp_w vdd vss rx_p05
XXg Xm/in_n Xi1/g Xg/m1_4760_1320# Xg/m1_6020_10200# Xg/m1_3298_2050# Xg/m1_5022_10210#
+ Xg/m1_4906_9490# Xg/m1_3898_9610# Xg/a_7580_5314# Xg/m1_3530_1930# Xg/a_1580_5314#
+ vss Xi0/g vdd Xg/m1_6282_1450# Xg/m1_3666_9610# Xg/m1_5516_1920# Xg/a_4580_5314#
+ Xg/m1_4538_1930# Xi4/g Xg/a_5188_4156# Xi2/g Xr/vsp Xr/vsn Xr/vglp Xi3/g Xg/a_3036_4156#
+ Xr/vgln Xm/in_p bias_ladder
XXi0 i0_b0 i0_b1 i0_b2 i0_b3 i0_b4 vbn_leak vss Xi0/m1_988_3464# Xi0/a_1582_4392#
+ Xi0/a_2432_4392# Xi0/m1_988_2804# vdd Xi0/a_528_4392# Xi0/a_2228_4392# Xi0/a_1378_4392#
+ Xi0/a_3078_4392# Xi0/a_3928_4392# Xi0/a_3282_4392# Xi0/m1_988_888# Xi0/m1_240_3480#
+ vss Xi0/a_4132_4392# Xi0/m1_1500_4312# Xr/vgln Xi0/a_732_4392# Xr/vsp Xi0/g idac_p
XXi1 i1_b0 i1_b1 i1_b2 i1_b3 i1_b4 vbn_ref vss Xi1/m1_988_3464# Xi1/a_1582_4392# Xi1/a_2432_4392#
+ Xi1/m1_988_2804# vdd Xi1/a_528_4392# Xi1/a_2228_4392# Xi1/a_1378_4392# Xi1/a_3078_4392#
+ Xi1/a_3928_4392# Xi1/a_3282_4392# Xi1/m1_988_888# Xi1/m1_240_3480# vss Xi1/a_4132_4392#
+ Xi1/m1_1500_4312# Xr/vgln Xi1/a_732_4392# Xr/vsp Xi1/g idac_p
XXm ua0 ua0_s0 ua0_s1 ua0_stim ua0_int bias_en Xm/in_n Xm/in_p Xm/iint Xr/en_b Xm/a_1744_10100#
+ vbp_st ua0_stim_out Xm/a_1744_9182# vss vdd Xm/a_1764_11418# Xm/a_2240_11218# Xm/a_736_5516#
+ Xm/a_420_700# Xm/a_736_7228# bias_master
XXi2 i2_b0 i2_b1 i2_b2 i2_b3 i2_b4 vbp_syn Xr/vgln vdd Xi2/g Xi2/m1_988_3304# Xi2/a_528_4170#
+ Xi2/a_2228_4170# Xi2/a_3928_4170# Xi2/a_732_4170# Xi2/a_2432_4170# Xi2/a_1582_4170#
+ Xi2/a_3282_4170# Xi2/m1_988_2644# Xi2/a_4132_4170# Xi2/m1_988_888# Xi2/m1_260_2080#
+ Xi2/a_1378_4170# vdd Xi2/m1_1500_3762# Xi2/a_3078_4170# vss Xr/vsn idac_n
XXxst vbp_st vdd vss rx_p05
XXi3 i3_b0 i3_b1 i3_b2 i3_b3 i3_b4 vbn_ax vss Xi3/m1_988_3464# Xi3/a_1582_4392# Xi3/a_2432_4392#
+ Xi3/m1_988_2804# vdd Xi3/a_528_4392# Xi3/a_2228_4392# Xi3/a_1378_4392# Xi3/a_3078_4392#
+ Xi3/a_3928_4392# Xi3/a_3282_4392# Xi3/m1_988_888# Xi3/m1_240_3480# vss Xi3/a_4132_4392#
+ Xi3/m1_1500_4312# Xr/vgln Xi3/a_732_4392# Xr/vsp Xi3/g idac_p
XXi4 i4_b0 i4_b1 i4_b2 i4_b3 i4_b4 vbp_w Xr/vgln vdd Xi4/g Xi4/m1_988_3304# Xi4/a_528_4170#
+ Xi4/a_2228_4170# Xi4/a_3928_4170# Xi4/a_732_4170# Xi4/a_2432_4170# Xi4/a_1582_4170#
+ Xi4/a_3282_4170# Xi4/m1_988_2644# Xi4/a_4132_4170# Xi4/m1_988_888# Xi4/m1_260_2080#
+ Xi4/a_1378_4170# vdd Xi4/m1_1500_3762# Xi4/a_3078_4170# vss Xr/vsn idac_n
XXd0 r0_b0 r0_b1 r0_b2 r0_b3 r0_b4 vdd el Xd0/m1_3662_4048# Xd0/a_2224_3416# Xd0/a_3408_3416#
+ Xd0/m1_822_4048# Xd0/a_1632_3416# Xd0/m1_3310_2880# Xd0/m1_2742_3250# Xd0/m1_2242_4966#
+ Xd0/m1_1262_4048# Xd0/a_1040_3416# vss Xd0/a_2816_3416# Xd0/m1_617_3840# Xd0/m1_956_3000#
+ Xd0/m1_382_4048# vdacr_el
XXd1 r1_b0 r1_b1 r1_b2 r1_b3 r1_b4 vdd vreset_src Xd1/m1_2862_4048# Xd1/a_680_3416#
+ vss Xd1/a_2456_3416# Xd1/m1_860_4046# Xd1/m1_462_4048# Xd1/a_1864_3416# Xd1/a_3048_3416#
+ Xd1/m1_2974_2650# Xd1/m1_756_3120# Xd1/a_1272_3416# Xd1/m1_2372_2520# Xd1/m1_606_2410#
+ Xd1/m1_1780_5040# vdacr_vr
XXr Xr/vsp Xr/vgln Xr/en_b vdd Xr/m1_782_438# Xr/m1_3422_438# vss Xr/m1_1222_3522#
+ Xr/m1_342_438# Xr/vsn Xr/m1_1662_438# Xr/vglp Xr/m1_2542_438# bias_rails
XXd2 r2_b0 r2_b1 r2_b2 r2_b3 r2_b4 vdd vth_cmp vss Xd2/a_680_3416# Xd2/a_2456_3416#
+ Xd2/m1_902_4048# Xd2/m1_596_3240# Xd2/a_1864_3416# Xd2/a_3048_3416# Xd2/m1_2382_2650#
+ Xd2/m1_1663_4920# Xd2/a_1272_3416# Xd2/m1_756_2640# Xd2/m1_2964_2640# Xd2/m1_1342_4048#
+ Xd2/m1_240_4046# vdacr_vc
XXd3 v0_c0 v0_c1 v0_c2 v0_c3 v0_c4 v0_c5 vdd Xd3/m1_2720_2760# Xd3/a_4584_3816# Xd3/m1_5422_4448#
+ vss Xd3/m1_382_4448# Xd3/m1_822_4448# vth_ref Xd3/a_3400_3816# Xd3/a_2808_3816#
+ Xd3/m1_1702_4448# Xd3/m1_1523_3480# Xd3/a_3992_3816# Xd3/m1_4078_3250# Xd3/m1_3222_4448#
+ Xd3/m1_4102_4448# Xd3/m1_3908_2760# Xd3/a_2216_3816# Xd3/m1_4982_4448# Xd3/m1_2408_3600#
+ Xd3/m1_1262_4448# Xd3/a_1624_3816# vdacr_vt
XXvi bias_en Xr/vglp Xr/vgln vth_cmp vth_ref Xvi/m1_8646_1098# Xvi/m1_942_738# vreset_src
+ Xm/iint Xvi/m1_8042_6360# vss Xvi/m1_7102_850# ib_x2 Xvi/m1_7440_2050# Xvi/m1_5388_6960#
+ Xvi/m1_4894_1238# Xvi/a_5712_1328# Xvi/a_2102_5152# Xvi/m1_4546_7560# Xvi/m1_502_738#
+ Xvi/m1_1276_6360# vdd Xvi/m1_1382_738# vbn_prb Xvi/a_4976_1528# Xvi/m1_8332_7080#
+ el Xvi/a_864_6450# ib_r1 bias_vi
C0 vbn_prb Xd0/a_2224_3416# 0
C1 i0_b2 Xi0/a_2432_4392# 0
C2 vbp_st Xi2/a_528_4170# 0
C3 Xr/en_b Xm/in_p 0.05767f
C4 Xg/a_4580_5314# i4_b3 0.10123f
C5 i3_b0 Xi2/m1_260_2080# 0
C6 ua0_stim v0_c5 0.13976f
C7 r0_b4 r2_b2 0
C8 vreset_src vbp_w 0.06416f
C9 Xd0/m1_956_3000# vbn_prb 0.08188f
C10 ua0_stim_out Xm/in_p 0.25271f
C11 vreset_src Xi4/a_3928_4170# 0.0908f
C12 vth_ref Xr/vsn 0.5774f
C13 vbp_syn r1_b4 0
C14 Xr/vgln r2_b0 0.15973f
C15 i4_b1 Xi4/a_1378_4170# 0.0078f
C16 r0_b0 r1_b4 0.34551f
C17 Xi1/m1_988_888# vbn_leak 0.01686f
C18 i2_b1 i2_b0 1.13584f
C19 vdd Xi0/g 0.61125f
C20 i0_b1 i3_b0 0.00941f
C21 Xvi/a_4976_1528# Xvi/m1_1382_738# -0.00745f
C22 Xg/m1_3530_1930# Xm/in_n 0.03597f
C23 Xi0/m1_988_888# Xi0/g -0.17634f
C24 Xi2/g i3_b4 0.25335f
C25 Xi3/g Xm/in_p 0.16093f
C26 vbp_st ua0_s0 0.03f
C27 Xd3/m1_1523_3480# Xd3/m1_2408_3600# -0.00161f
C28 Xr/vsn Xi2/g 0.68588f
C29 r0_b2 vbp_syn 0.05433f
C30 el vbp_w 0.10835f
C31 v0_c0 ua0_int 0.03788f
C32 i0_b3 v0_c0 0.00305f
C33 r0_b0 r0_b2 0.52543f
C34 Xg/m1_6282_1450# Xg/a_5188_4156# -0.00163f
C35 i0_b2 i1_b4 0.31024f
C36 r1_b0 Xd1/m1_2372_2520# 0.08911f
C37 vdd Xd1/a_1864_3416# -0.00192f
C38 Xi0/a_3282_4392# Xr/vgln -0.00223f
C39 i2_b2 Xg/m1_4906_9490# 0
C40 vth_cmp Xi4/m1_260_2080# 0.0053f
C41 r1_b3 Xm/in_p 0.41892f
C42 Xvi/m1_4894_1238# Xm/iint -0
C43 Xr/vgln i4_b0 0.17383f
C44 r1_b0 Xg/a_1580_5314# 0
C45 vbp_syn r0_b3 0.05207f
C46 Xd1/a_680_3416# r2_b4 0
C47 Xg/m1_4760_1320# Xi2/g 0.02399f
C48 r0_b0 r0_b3 0.82636f
C49 vbn_ax r1_b4 0.13223f
C50 r1_b2 r2_b2 0.23125f
C51 Xr/vglp Xi0/a_2432_4392# 0.01652f
C52 vbp_st i3_b0 0.21754f
C53 v0_c5 v0_c3 1.24203f
C54 i3_b3 r1_b1 0.03446f
C55 vdd Xd2/m1_756_2640# -0
C56 Xi3/g Xg/m1_4538_1930# 0.0021f
C57 vdd Xi3/m1_240_3480# -0.01263f
C58 i3_b1 i1_b1 0.11177f
C59 Xm/a_420_700# Xm/a_736_5516# -0.00332f
C60 i0_b2 Xi0/a_2228_4392# 0.00184f
C61 vdd Xi1/a_732_4392# -0
C62 vreset_src Xvi/m1_8042_6360# 0.09976f
C63 vth_cmp Xd0/m1_2742_3250# 0.01185f
C64 Xr/vsn Xg/m1_3530_1930# 0.08641f
C65 Xi0/m1_988_2804# Xr/vsp -0.01041f
C66 vbn_prb Xd1/m1_2974_2650# 0.04136f
C67 i0_b3 Xm/in_p 0.04612f
C68 vdd i3_b2 0.36766f
C69 Xi0/m1_988_2804# Xi0/m1_1500_4312# -0.01255f
C70 r0_b2 vbn_ax 0.05454f
C71 Xg/a_4580_5314# Xi2/g 0.02054f
C72 i3_b1 Xi2/m1_260_2080# 0
C73 i3_b0 r2_b1 0.04633f
C74 i0_b4 i3_b3 0.29009f
C75 i3_b3 Xi1/g 0.04749f
C76 Xg/m1_6020_10200# i4_b1 0
C77 vdd vbp_syn 0.40761f
C78 i4_b3 Xi4/a_2228_4170# 0
C79 Xvi/m1_8042_6360# bias_en 0.00424f
C80 vdd r0_b0 0.24997f
C81 i0_b0 vbn_leak 0.14129f
C82 vbp_st i4_b2 0.90603f
C83 vbn_prb Xd1/a_3048_3416# 0.00238f
C84 Xr/vglp i4_b4 0.18118f
C85 el Xvi/m1_8042_6360# 0.00826f
C86 i3_b3 Xi4/g 0.2477f
C87 Xg/m1_5022_10210# Xg/m1_4906_9490# -0
C88 i3_b4 Xi0/a_3078_4392# 0.05548f
C89 Xd3/a_2216_3816# v0_c0 0.13505f
C90 Xi1/m1_988_2804# Xm/in_p 0.07874f
C91 i0_b1 i3_b1 0.05157f
C92 r2_b3 r2_b2 0.15258f
C93 vbn_prb Xi4/a_3078_4170# 0.00393f
C94 i4_b1 r1_b1 0.00142f
C95 Xvi/m1_1276_6360# Xr/vsn 0.10131f
C96 Xr/vsn Xi0/a_3078_4392# 0.00393f
C97 i0_b4 Xi0/a_3928_4392# 0
C98 vbn_ax r0_b3 0.15908f
C99 Xi1/g Xi0/a_3928_4392# 0
C100 Xi3/m1_988_3464# r1_b4 0.00145f
C101 r0_b4 Xi2/g 0.45234f
C102 r2_b4 Xi2/m1_260_2080# 0.0226f
C103 Xi2/a_4132_4170# Xr/vgln 0
C104 Xg/m1_5516_1920# Xr/vgln 0.03322f
C105 i4_b2 r2_b1 0.85711f
C106 vth_cmp vbp_w 0.05187f
C107 i2_b2 r2_b1 0.04048f
C108 i4_b4 vbn_prb 0.00491f
C109 vth_ref Xg/m1_6282_1450# 0.00128f
C110 Xr/m1_342_438# Xm/iint 0.08281f
C111 Xd3/a_2808_3816# ua0_stim_out 0.02792f
C112 vbn_ref ua0_stim_out 0.15938f
C113 Xr/vgln Xi3/m1_988_2804# 0.17915f
C114 v0_c0 Xm/in_p 0
C115 Xr/vglp Xm/iint 0.07922f
C116 r1_b0 r2_b0 0.32929f
C117 Xi1/m1_1500_4312# Xi1/m1_988_2804# -0.00133f
C118 Xi1/g i4_b1 0.04124f
C119 Xi0/m1_240_3480# vbn_leak -0.00128f
C120 Xr/vglp Xi0/a_2228_4392# 0.01658f
C121 Xd3/m1_2408_3600# ua0_s1 0.00697f
C122 vbp_st Xi2/a_3928_4170# 0
C123 Xi2/g Xg/m1_6282_1450# 0.07853f
C124 ib_x2 vbn_leak 0.01136f
C125 Xi4/g i4_b1 0.15156f
C126 vbn_ref Xi3/g 0
C127 Xi0/g ua0_stim_out 0
C128 Xr/vglp Xg/a_1580_5314# 0.05127f
C129 Xd3/a_2216_3816# Xm/in_p 0
C130 vdd vbn_ax 0.42473f
C131 Xd3/m1_4078_3250# v0_c1 0.08711f
C132 vbp_st i3_b1 0.0431f
C133 Xd3/m1_4102_4448# ua0_stim_out 0.01184f
C134 Xi1/m1_240_3480# Xi1/m1_988_2804# -0.01754f
C135 Xvi/m1_5388_6960# Xvi/m1_8042_6360# -0.00145f
C136 Xd3/m1_1262_4448# vbp_st 0.14043f
C137 Xm/iint vbn_prb 0.06689f
C138 vbn_prb Xd1/m1_2372_2520# 0.04809f
C139 Xd1/a_3048_3416# Xd0/a_1040_3416# 0.01464f
C140 Xm/a_736_5516# ua0_s1 0.62008f
C141 r2_b3 Xd0/m1_822_4048# 0.00218f
C142 i3_b3 Xi3/a_4132_4392# 0.00856f
C143 Xd3/a_3400_3816# ua0_s0 0.04773f
C144 el vbn_leak 0.36387f
C145 Xr/vgln Xi2/a_3078_4170# 0.00383f
C146 Xi0/g Xi3/g 0.15513f
C147 vbn_ref r1_b3 0.04705f
C148 Xi4/m1_1500_3762# r2_b2 0.00549f
C149 Xd1/m1_2862_4048# vbp_w 0
C150 el Xd0/m1_617_3840# 0.0215f
C151 Xd2/a_3048_3416# r2_b3 0.00599f
C152 i3_b1 r2_b1 0.04391f
C153 Xd3/m1_2408_3600# bias_en 0.04718f
C154 r1_b0 i4_b0 0.03833f
C155 vbp_st r2_b4 0.04642f
C156 Xi1/m1_988_888# i0_b0 0.01605f
C157 i2_b4 r1_b4 0.04324f
C158 i1_b3 i3_b1 0
C159 vth_cmp Xvi/m1_8042_6360# 0.07204f
C160 Xm/a_736_5516# Xm/a_1744_9182# -0.00606f
C161 bias_en Xm/a_736_5516# 0.21578f
C162 Xd3/a_2808_3816# ua0_int 0
C163 i2_b2 Xg/m1_3898_9610# 0
C164 i4_b3 Xvi/m1_1382_738# 0
C165 vreset_src Xd1/m1_1780_5040# 0.00772f
C166 Xr/vgln vbp_w 0.02012f
C167 vdd Xi3/m1_988_3464# -0.01953f
C168 Xi1/m1_1500_4312# Xm/in_p 0.04796f
C169 i3_b0 r1_b1 0.03563f
C170 r2_b4 r2_b1 0.03711f
C171 Xr/vgln Xi4/a_3928_4170# -0
C172 Xd0/a_1632_3416# r0_b2 0.00807f
C173 vdd Xi3/a_2432_4392# 0.01198f
C174 i3_b3 Xi0/a_4132_4392# 0.00822f
C175 Xr/vsn r1_b4 0.28108f
C176 Xr/vsp Xi2/m1_260_2080# 0.08901f
C177 v0_c4 Xd3/a_3992_3816# 0.00129f
C178 v0_c1 i3_b4 0.03316f
C179 Xi3/a_3078_4392# i3_b1 0
C180 i3_b2 ua0_stim_out 0.51127f
C181 Xr/vsp Xg/m1_4906_9490# 0.02517f
C182 Xd2/m1_2964_2640# vreset_src 0.02746f
C183 r1_b3 Xd1/a_1864_3416# -0.0032f
C184 Xd3/m1_1523_3480# ua0_s1 0.00551f
C185 Xi2/a_2228_4170# Xi2/m1_988_3304# 0
C186 i2_b3 r1_b4 0.0368f
C187 Xvi/a_2102_5152# Xi4/g 0.08126f
C188 i4_b4 Xvi/m1_7102_850# 0.02315f
C189 Xi3/m1_240_3480# Xi3/g -0.04083f
C190 Xi3/a_528_4392# r1_b4 0
C191 Xg/m1_6020_10200# i4_b2 0.00103f
C192 i0_b1 Xr/vsp 0.40438f
C193 Xi1/m1_240_3480# Xm/in_p 0.12303f
C194 vbp_syn ua0_stim_out 0.00337f
C195 vbn_prb Xd2/m1_1663_4920# 0
C196 r2_b4 Xi4/a_1378_4170# 0.00457f
C197 r1_b2 Xd0/a_2816_3416# 0.04099f
C198 Xr/vglp r2_b0 0.46106f
C199 r0_b0 ua0_stim_out 0.22877f
C200 Xvi/a_4976_1528# r2_b1 0.06656f
C201 vdd Xi3/a_732_4392# 0.0506f
C202 Xi1/g i3_b0 0.23884f
C203 Xd3/m1_3908_2760# v0_c1 0.19873f
C204 vdd Xm/in_n 0.96929f
C205 i3_b2 Xi3/g 0.21974f
C206 vbn_ref Xi1/m1_988_2804# -0
C207 vdd Xi2/a_1582_4170# 0.04422f
C208 r2_b2 Xd2/a_1272_3416# 0.00135f
C209 i4_b2 r1_b1 0.01347f
C210 Xi0/m1_988_888# Xm/in_n 0.08498f
C211 r1_b3 Xi3/m1_240_3480# 0.01553f
C212 i3_b3 Xi3/a_3928_4392# 0.01564f
C213 Xi2/a_4132_4170# r1_b0 0.05188f
C214 i2_b2 r1_b1 0.10994f
C215 Xm/a_420_700# ua0_s1 0.17709f
C216 r0_b0 Xi3/g 0
C217 Xi3/a_3282_4392# Xr/vsp 0.00153f
C218 r0_b0 Xd0/a_3408_3416# 0.00213f
C219 Xm/iint Xvi/m1_7102_850# 0.05208f
C220 Xd1/m1_606_2410# Xd2/a_3048_3416# 0.00237f
C221 vbn_prb r2_b0 0.31723f
C222 i3_b2 r1_b3 0.1709f
C223 Xd3/m1_1523_3480# bias_en 0.04175f
C224 v0_c0 Xd3/a_2808_3816# 0.06889f
C225 vth_cmp vbn_leak 0.28077f
C226 ua0_s0 Xm/a_1744_10100# 0.30757f
C227 vth_cmp Xd0/m1_617_3840# 0.01046f
C228 Xg/a_7580_5314# Xg/a_1580_5314# -0.01424f
C229 Xd0/a_2816_3416# r2_b3 0.04223f
C230 Xr/vglp Xi0/a_3282_4392# 0.0214f
C231 Xi1/g i4_b2 0.18622f
C232 Xi1/g i2_b2 0.38769f
C233 i2_b3 r0_b3 0
C234 vdd Xd0/a_1632_3416# 0.07282f
C235 Xd3/a_2216_3816# Xd3/a_2808_3816# -0.00458f
C236 vbp_st Xr/vsp 0.88612f
C237 bias_en Xd3/m1_4982_4448# 0.04797f
C238 Xi1/a_1378_4392# ua0_stim_out 0
C239 Xi4/g i4_b2 0
C240 Xg/a_4580_5314# r1_b4 0
C241 Xr/vglp i4_b0 0.47409f
C242 vdd i2_b4 1.41783f
C243 Xvi/m1_502_738# r2_b1 0.05755f
C244 r1_b0 Xd0/m1_2742_3250# 0.07479f
C245 v0_c0 Xd3/m1_4102_4448# 0.08992f
C246 Xg/m1_6020_10200# Xg/m1_5022_10210# -0.0182f
C247 Xm/a_420_700# bias_en 0.37195f
C248 Xi2/a_2228_4170# Xi2/a_1378_4170# -0.00485f
C249 Xg/a_3036_4156# i4_b0 0.02949f
C250 i3_b3 Xi0/a_2432_4392# 0.01437f
C251 vdd i3_b4 1.9856f
C252 Xi1/a_528_4392# ua0_stim_out 0
C253 i0_b3 i3_b2 0.00661f
C254 Xi0/m1_988_888# i3_b4 0
C255 vdd Xr/vsn 1.4473f
C256 Xr/vsp r2_b1 0.06801f
C257 Xi2/m1_988_888# r2_b0 0.0552f
C258 r1_b0 Xi2/a_3078_4170# 0.16231f
C259 i3_b1 r1_b1 0.03809f
C260 Xr/vsn Xvi/m1_942_738# 0
C261 vbn_ax Xd0/a_3408_3416# 0.00102f
C262 Xi3/a_2228_4392# Xi2/g 0
C263 Xi0/m1_988_888# Xr/vsn 0.02051f
C264 vbn_ref Xm/in_p 0.01175f
C265 vbn_ax Xi3/g -0
C266 r0_b4 r1_b4 0.55489f
C267 vdd i2_b3 0.52017f
C268 vdd Xi3/a_528_4392# 0.07225f
C269 i0_b1 Xi0/a_1378_4392# 0
C270 r2_b2 Xi2/m1_260_2080# 0
C271 vdd Xd3/m1_3908_2760# -0
C272 vdd Xi3/m1_1500_4312# -0.01142f
C273 vdd Xi0/a_732_4392# 0.01721f
C274 Xd1/a_680_3416# Xd2/a_3048_3416# 0.02267f
C275 Xd1/m1_2862_4048# Xd0/m1_617_3840# 0
C276 ua0_stim Xm/a_736_5516# 0.05857f
C277 Xg/a_5188_4156# Xg/m1_4906_9490# -0
C278 vdd Xi1/a_3282_4392# 0.05611f
C279 i4_b4 i3_b3 0.0432f
C280 Xd1/m1_1780_5040# vth_cmp 0.06213f
C281 Xi0/g Xm/in_p 0.29831f
C282 Xi1/g i3_b1 0.27042f
C283 r1_b3 vbn_ax 0.03616f
C284 r0_b2 r0_b4 0.05527f
C285 Xd3/m1_4102_4448# Xm/in_p 0.03017f
C286 Xi1/g Xg/m1_5022_10210# -0
C287 r1_b0 vbp_w 0.55447f
C288 Xi3/a_3078_4392# Xr/vsp 0
C289 Xi1/m1_1500_4312# vbn_ref 0
C290 r2_b4 r1_b1 0.38828f
C291 i3_b3 i1_b4 0.21656f
C292 vbp_st v0_c2 0.00432f
C293 Xvi/a_864_6450# Xvi/m1_8042_6360# -0.04739f
C294 r1_b1 Xi3/m1_988_888# 0.04039f
C295 vbp_st Xi2/m1_988_2644# 0.333f
C296 vdd Xi1/a_2432_4392# 0
C297 Xd2/m1_2964_2640# vth_cmp 0.0294f
C298 Xr/vgln vbn_leak 0.20537f
C299 Xr/vglp Xg/m1_5516_1920# 0
C300 i4_b1 Xi4/a_3078_4170# 0.04964f
C301 v0_c5 Xd3/a_3992_3816# -0.00147f
C302 Xr/vgln i2_b0 0.0454f
C303 i1_b0 i1_b1 -0.00581f
C304 Xd1/a_2456_3416# r1_b2 0.04627f
C305 r0_b4 r0_b3 0.4352f
C306 Xi3/m1_988_3464# Xi3/g -0.06051f
C307 Xi4/g r2_b4 0.10095f
C308 r1_b2 r1_b4 0.07694f
C309 vth_ref Xr/m1_1222_3522# 0.02069f
C310 vdd Xg/a_4580_5314# -0.01421f
C311 Xd3/m1_4078_3250# ua0_stim_out 0.00912f
C312 Xi4/a_1582_4170# i4_b1 0.00569f
C313 i4_b4 i4_b1 0.48381f
C314 Xr/en_b Xm/in_n 0.10748f
C315 i3_b3 Xi0/a_2228_4392# 0.0316f
C316 Xi1/a_1582_4392# Xm/in_p 0.00118f
C317 vbn_prb Xi4/m1_260_2080# 0.09764f
C318 ua0_s1 Xm/a_1744_9182# 0.17686f
C319 Xm/in_n ua0_stim_out 0
C320 i3_b3 Xg/a_1580_5314# 0.05604f
C321 vbp_st r2_b2 0.38168f
C322 Xi1/m1_240_3480# Xi0/g 0
C323 bias_en ua0_s1 0.29547f
C324 Xi4/g Xg/m1_3298_2050# -0.00447f
C325 vreset_src ib_x2 0.03733f
C326 Xi0/m1_240_3480# ib_x2 0.07859f
C327 Xr/vsp Xg/m1_3898_9610# 0.01146f
C328 vbp_st Xg/a_5188_4156# 0.05347f
C329 Xr/vsn Xi4/a_4132_4170# 0
C330 Xvi/a_4976_1528# Xi4/g 0.08949f
C331 r1_b3 Xi3/m1_988_3464# 0.24712f
C332 r1_b3 Xi3/a_2432_4392# 0.05447f
C333 i3_b2 Xm/in_p 0.16708f
C334 r0_b2 r1_b2 1.21363f
C335 Xm/in_n Xi3/g 0.28039f
C336 Xi0/m1_240_3480# bias_en 0.00577f
C337 vdd r0_b4 0.53114f
C338 i0_b1 i1_b0 0.05128f
C339 vbp_st i4_b3 0.03785f
C340 vreset_src bias_en 0.25372f
C341 ib_x2 bias_en 0.7138f
C342 Xd1/a_2456_3416# r2_b3 0.01131f
C343 Xd1/m1_756_3120# Xd1/a_2456_3416# -0
C344 vreset_src el 0.34072f
C345 r2_b2 r2_b1 0.36201f
C346 Xg/a_7580_5314# i4_b0 0.04049f
C347 Xg/m1_6020_10200# Xr/vsp 0.01364f
C348 vdd Xi1/a_3078_4392# 0.00208f
C349 ua0_stim Xm/a_420_700# 0.18001f
C350 vbn_prb Xd0/m1_2742_3250# 0.05668f
C351 r2_b3 r1_b4 0
C352 r1_b3 Xi3/a_732_4392# 0.00293f
C353 i2_b4 ua0_stim_out 0.04014f
C354 i4_b1 Xg/a_1580_5314# 0.03023f
C355 Xd3/m1_3222_4448# vbp_st 0
C356 vdd Xi1/a_2228_4392# 0
C357 r1_b1 Xr/vsp 0.82197f
C358 i4_b3 r2_b1 0.0383f
C359 el bias_en 0.29173f
C360 vdd Xg/m1_6282_1450# -0.00169f
C361 r1_b2 r0_b3 0.08178f
C362 i3_b4 ua0_stim_out 0.11704f
C363 r2_b4 Xi3/a_4132_4392# 0
C364 r0_b1 Xd0/a_2816_3416# 0.0357f
C365 Xm/iint Xvi/m1_7440_2050# 0.0747f
C366 r0_b2 r2_b3 0.5463f
C367 i3_b2 Xi1/m1_240_3480# 0.00418f
C368 i2_b4 Xi3/g 0.16797f
C369 Xr/vgln i2_b1 0.01494f
C370 Xi4/m1_988_888# Xi4/m1_988_2644# -0.0121f
C371 Xi4/g Xvi/m1_502_738# 0.03646f
C372 i4_b3 Xi4/a_1378_4170# 0
C373 i0_b4 Xr/vsp 0.28874f
C374 i2_b3 ua0_stim_out 0.3699f
C375 Xi1/m1_988_888# Xr/vgln 0.29262f
C376 Xi1/g Xr/vsp 0.89924f
C377 Xvi/a_2102_5152# i4_b4 0.25022f
C378 Xm/iint Xm/a_1764_11418# 0.05457f
C379 i3_b4 Xi3/g 0.06408f
C380 Xd3/m1_3908_2760# ua0_stim_out 0.14708f
C381 Xi1/a_1378_4392# Xm/in_p 0
C382 vbn_ref Xi0/g 0
C383 Xr/vsn Xi3/g 0.96122f
C384 Xvi/m1_5388_6960# vreset_src 0.0772f
C385 vbn_prb vbp_w 0.17399f
C386 vdd r1_b2 1.18321f
C387 ua0_s0 Xm/iint 0.06178f
C388 r1_b3 i2_b4 0.0561f
C389 Xi1/a_3282_4392# ua0_stim_out 0
C390 r2_b3 r0_b3 0.2472f
C391 i2_b3 Xi3/g 0
C392 i4_b4 i3_b0 0.04529f
C393 v0_c4 ua0_s0 0.13565f
C394 Xi1/a_528_4392# Xm/in_p 0
C395 Xi3/m1_1500_4312# Xi3/g -0.00176f
C396 Xg/m1_5516_1920# Xg/a_7580_5314# -0
C397 Xi2/a_2228_4170# r2_b0 0.00153f
C398 r1_b3 i3_b4 0.12903f
C399 vbn_leak r1_b0 0.0353f
C400 vth_ref vbp_st 0.37127f
C401 Xvi/m1_5388_6960# bias_en 0.32406f
C402 r1_b0 Xd0/m1_617_3840# 0.06868f
C403 vdd Xi3/a_1582_4392# 0.01461f
C404 vdd Xi0/a_1582_4392# 0.01223f
C405 Xr/vsn r1_b3 0.02799f
C406 Xi2/a_3282_4170# i2_b3 0.00164f
C407 Xvi/a_2102_5152# Xm/iint 0
C408 vreset_src Xvi/m1_4546_7560# 0.00237f
C409 Xvi/m1_5388_6960# el 0.01048f
C410 Xd3/a_3400_3816# v0_c2 0.09212f
C411 i4_b2 Xi4/a_3078_4170# 0
C412 Xd3/m1_382_4448# ua0_s0 0
C413 r1_b0 i2_b0 0.03696f
C414 Xg/m1_4760_1320# Xi3/g 0.00353f
C415 r1_b3 i2_b3 0.04083f
C416 r1_b3 Xi3/m1_1500_4312# 0.10166f
C417 r1_b3 Xi3/a_528_4392# 0
C418 i3_b3 Xi0/a_3282_4392# 0.01377f
C419 vbp_st Xi2/g 0.40347f
C420 vreset_src vth_cmp 0.47618f
C421 vdd r2_b3 0.25008f
C422 Xd3/m1_4078_3250# v0_c0 0.11419f
C423 ua0_stim ua0_s1 0.44392f
C424 i0_b2 vbn_leak 0.00436f
C425 Xvi/m1_4546_7560# bias_en 0.00205f
C426 i4_b4 i4_b2 0.01284f
C427 i3_b3 i4_b0 0.07648f
C428 i0_b4 v0_c2 0
C429 vdd ua0 0.00948f
C430 Xvi/m1_4546_7560# el 0.01661f
C431 r2_b4 Xi3/a_3928_4392# 0
C432 i0_b3 i3_b4 0.67077f
C433 i0_b3 Xr/vsn 0
C434 Xi1/a_732_4392# vbn_ref 0
C435 Xi2/g r2_b1 0.05062f
C436 Xi3/a_4132_4392# Xr/vsp 0.02698f
C437 i3_b0 Xg/a_1580_5314# 0.19368f
C438 vth_cmp bias_en 0.84726f
C439 vbp_w Xd0/a_1040_3416# 0.05201f
C440 r0_b2 Xd0/m1_2242_4966# -0.00258f
C441 i3_b2 vbn_ref 0.2189f
C442 Xr/vsn Xi4/m1_988_2644# -0.03684f
C443 r2_b4 Xi4/a_732_4170# 0.00287f
C444 el vth_cmp 1.26625f
C445 Xg/a_4580_5314# Xi3/g 0.22071f
C446 r1_b1 r2_b2 1.21169f
C447 i0_b0 Xr/vgln 0.11026f
C448 Xi1/g Xi0/a_1378_4392# 0
C449 Xi2/a_528_4170# r2_b0 0.00134f
C450 r0_b4 ua0_stim_out 0.10231f
C451 ua0_stim Xm/a_1744_9182# 0
C452 vbn_ref vbp_syn 0.54264f
C453 ua0_stim bias_en 0.26465f
C454 Xm/a_1744_10100# Xm/a_736_7228# -0.03623f
C455 vbn_ref r0_b0 0.10067f
C456 Xd1/m1_1780_5040# r1_b0 0.13139f
C457 i3_b2 Xi0/g 0.18397f
C458 Xd3/m1_4078_3250# Xm/in_p 0.00912f
C459 r1_b0 Xg/m1_3666_9610# 0.12694f
C460 Xi1/a_3078_4392# ua0_stim_out 0.0017f
C461 r0_b4 Xd0/a_3408_3416# 0
C462 Xi1/g r2_b2 0.19848f
C463 i4_b1 i4_b0 0.00452f
C464 vreset_src Xi4/a_3282_4170# 0.03006f
C465 Xm/in_n Xm/in_p 0
C466 Xi3/a_3078_4392# Xi2/g 0
C467 i4_b2 Xg/a_1580_5314# 0.17907f
C468 Xi1/g Xg/a_5188_4156# -0.00186f
C469 vdd i1_b2 0
C470 vreset_src Xi4/m1_988_3304# 0.00782f
C471 vdd Xi3/a_1378_4392# 0.03371f
C472 Xi4/g r2_b2 0.58091f
C473 Xi1/a_2228_4392# ua0_stim_out 0
C474 i4_b4 i3_b1 0.04544f
C475 v0_c0 i3_b4 0.02714f
C476 Xi0/a_4132_4392# Xr/vsp 0
C477 Xd3/m1_3222_4448# Xd3/a_3400_3816# -0.00349f
C478 Xvi/m1_5388_6960# Xvi/m1_4546_7560# -0
C479 r0_b4 Xi2/a_3282_4170# 0
C480 v0_c3 ua0_s1 0.10135f
C481 r1_b0 i2_b1 0.04045f
C482 vdd Xi0/m1_988_2804# -0.00212f
C483 Xi1/g i4_b3 0.05229f
C484 r1_b3 r0_b4 0
C485 el Xd1/m1_2862_4048# 0.00511f
C486 r0_b1 r1_b4 0
C487 Xr/vglp vbn_leak 0.10007f
C488 r2_b4 Xi4/a_3078_4170# 0.13461f
C489 Xg/m1_6282_1450# Xi3/g 0
C490 Xvi/m1_942_738# Xvi/m1_1382_738# -0.01045f
C491 Xi4/g i4_b3 0.05541f
C492 vreset_src Xr/vgln 0.29946f
C493 Xvi/m1_5388_6960# vth_cmp 0.24179f
C494 vdd Xi3/a_2228_4392# 0.03696f
C495 Xg/a_3036_4156# vbn_leak 0.04667f
C496 ib_x2 Xr/vgln 0.18849f
C497 Xd3/m1_3908_2760# v0_c0 0.28011f
C498 vdd Xd0/m1_2242_4966# 0.02786f
C499 ib_x2 v0_c3 0.03218f
C500 r2_b4 Xi4/a_1582_4170# 0.00237f
C501 i4_b4 r2_b4 0.02362f
C502 vbn_ref vbn_ax 0.04838f
C503 vdd Xi1/a_4132_4392# 0.02583f
C504 r1_b2 ua0_stim_out 0.10877f
C505 Xr/vgln Xi1/m1_988_3464# 0.00863f
C506 i2_b4 Xm/in_p 0.12176f
C507 Xi1/a_528_4392# vbn_ref 0
C508 Xr/vgln bias_en 0.44256f
C509 r0_b2 r0_b1 0.49491f
C510 Xi3/a_3928_4392# Xr/vsp 0.01228f
C511 Xm/in_n Xg/m1_4538_1930# 0.03882f
C512 vbn_prb vbn_leak 0.36418f
C513 Xi1/m1_988_888# i0_b2 0.35831f
C514 bias_en v0_c3 0.13524f
C515 vbn_prb Xd0/m1_617_3840# 0.19833f
C516 i3_b4 Xm/in_p 0.04488f
C517 Xvi/m1_4546_7560# vth_cmp 0.00116f
C518 el Xr/vgln 0.28997f
C519 r1_b2 Xd0/a_3408_3416# 0.04002f
C520 i3_b1 Xg/a_1580_5314# 0.15627f
C521 Xvi/a_4976_1528# i4_b4 0.04626f
C522 r0_b0 Xi3/m1_240_3480# 0
C523 r1_b4 Xi2/m1_260_2080# 0.15819f
C524 ua0_s0 v0_c5 0.04219f
C525 Xi1/g i1_b0 0.00168f
C526 Xg/m1_5516_1920# i4_b1 0.03898f
C527 r1_b4 Xg/m1_4906_9490# 0.0707f
C528 i2_b3 Xm/in_p 0.088f
C529 i0_b3 Xi1/a_3078_4392# 0
C530 r0_b1 r0_b3 1.28732f
C531 Xd3/m1_3908_2760# Xm/in_p 0.02238f
C532 i2_b2 r2_b0 0.0385f
C533 r0_b0 vbp_syn 0.04457f
C534 r2_b3 ua0_stim_out 1.3177f
C535 r1_b3 r1_b2 0.1916f
C536 Xi1/a_3282_4392# Xm/in_p 0
C537 vdd Xd1/a_680_3416# 0.00321f
C538 vbn_leak Xi2/m1_988_888# 0.13512f
C539 Xi2/g r1_b1 0.1019f
C540 Xd3/m1_2720_2760# Xd3/a_3400_3816# -0.0012f
C541 Xr/vglp Xg/m1_3666_9610# -0.02505f
C542 vreset_src Xvi/a_864_6450# 0.48905f
C543 Xi0/a_2432_4392# Xr/vsp 0
C544 i3_b0 i4_b0 0.03393f
C545 Xvi/a_4976_1528# Xm/iint -0
C546 Xvi/a_864_6450# ib_x2 0.00673f
C547 v0_c4 Xd3/a_4584_3816# 0.00142f
C548 vth_ref Xi4/g 0.05277f
C549 r2_b3 Xd0/a_3408_3416# 0.07422f
C550 Xi1/a_2432_4392# Xm/in_p 0.00171f
C551 Xvi/m1_5388_6960# Xr/vgln -0
C552 Xd1/m1_1780_5040# vbn_prb 0.05115f
C553 r1_b3 Xi3/a_1582_4392# 0.01733f
C554 Xr/vsn Xg/m1_4538_1930# 0.02014f
C555 vdd r0_b1 0.68487f
C556 Xi1/a_1378_4392# Xi1/a_732_4392# -0
C557 Xvi/a_864_6450# bias_en 0.21409f
C558 Xr/vglp i2_b1 0
C559 Xi1/a_1378_4392# i3_b2 0
C560 Xd2/m1_596_3240# Xd2/m1_756_2640# -0.00779f
C561 vth_cmp Xd1/m1_2862_4048# 0.00111f
C562 vbn_ax Xi3/m1_240_3480# -0.00374f
C563 vdd Xi1/a_3928_4392# 0.0491f
C564 Xi4/g Xi2/g 0.0268f
C565 Xd2/m1_2964_2640# vbn_prb 0.14216f
C566 i4_b4 Xr/vsp 0.0475f
C567 r1_b3 r2_b3 0
C568 vbp_st r1_b4 0.34066f
C569 Xg/a_4580_5314# Xm/in_p 0
C570 Xi2/a_3928_4170# r2_b0 0.02792f
C571 i4_b2 i4_b0 0.52366f
C572 i2_b2 i4_b0 0.03899f
C573 i3_b2 Xi1/a_528_4392# 0
C574 vbp_syn vbn_ax 0.04448f
C575 i1_b2 ua0_stim_out 0.09976f
C576 r0_b0 vbn_ax 0.07145f
C577 Xg/a_7580_5314# vbn_leak 0.03378f
C578 i4_b1 vbp_w 0.04775f
C579 Xm/in_n Xi0/g 0.50204f
C580 Xi3/a_3928_4392# r2_b2 0
C581 r1_b4 r2_b1 0.03429f
C582 vbp_st r0_b2 0.04172f
C583 i4_b1 Xi4/a_3928_4170# 0.00944f
C584 vth_cmp Xr/vgln 0.17747f
C585 vdd Xi2/m1_260_2080# 0.04752f
C586 vreset_src r1_b0 0.04154f
C587 Xm/iint Xr/vsp 0.36429f
C588 vdd Xg/m1_4906_9490# -0.00925f
C589 Xi1/a_3078_4392# Xm/in_p 0
C590 vdd i0_b1 0.26221f
C591 vbn_ref i2_b4 0.04608f
C592 ua0 ua0_int 0.01257f
C593 vdd Xi0/a_528_4392# 0.0275f
C594 Xd3/m1_2408_3600# Xd3/a_1624_3816# -0.01581f
C595 Xi0/a_2228_4392# Xr/vsp 0
C596 r2_b4 r2_b0 0.07956f
C597 ua0_stim v0_c3 0.63319f
C598 Xvi/m1_4894_1238# ib_x2 0.00723f
C599 Xvi/m1_5388_6960# Xvi/a_864_6450# -0.06876f
C600 Xi4/g Xg/m1_3530_1930# -0.02119f
C601 Xm/iint Xm/a_736_7228# 0.00663f
C602 Xr/vsp Xg/a_1580_5314# 0.02416f
C603 ib_r1 i4_b4 0.21048f
C604 r0_b2 r2_b1 0
C605 Xi1/a_4132_4392# ua0_stim_out 0.00111f
C606 el r1_b0 0.0616f
C607 vbp_st r0_b3 0.06369f
C608 Xd1/a_2456_3416# Xd1/a_1272_3416# -0
C609 Xi1/a_2228_4392# Xm/in_p 0.00201f
C610 i3_b1 i4_b0 0.04103f
C611 Xi3/a_4132_4392# Xi2/g 0.02493f
C612 r1_b3 Xi3/a_1378_4392# 0.00957f
C613 i3_b2 Xi3/a_2432_4392# -0.00984f
C614 Xg/m1_5022_10210# i4_b0 0.0432f
C615 Xvi/m1_4894_1238# bias_en 0.0013f
C616 vdd Xi3/a_3282_4392# -0.00251f
C617 i2_b4 Xi0/g 0.06266f
C618 Xd2/a_1864_3416# r2_b0 0.04354f
C619 Xi2/a_4132_4170# i2_b2 0.00543f
C620 vbn_ref i2_b3 0.70509f
C621 Xvi/a_864_6450# Xvi/m1_4546_7560# -0.0069f
C622 Xi1/g Xi0/a_3078_4392# 0
C623 Xd3/m1_3908_2760# Xd3/a_2808_3816# -0.00297f
C624 Xr/vgln Xi4/a_3282_4170# -0.01029f
C625 i3_b4 Xi0/g 0.04613f
C626 Xr/vglp i0_b0 0
C627 r0_b3 r2_b1 0.00162f
C628 ib_r1 Xm/iint 0.98719f
C629 r1_b3 Xi3/a_2228_4392# 0.0548f
C630 Xvi/m1_1276_6360# Xi4/g 0.00182f
C631 Xr/vsn Xi0/g 0.2709f
C632 r2_b4 i4_b0 0.03406f
C633 Xi4/a_3078_4170# r2_b2 0.06105f
C634 Xvi/a_864_6450# vth_cmp 0.38209f
C635 vdd vbp_st 1.53408f
C636 ib_x2 Xd3/m1_5422_4448# 0.00652f
C637 i0_b3 i1_b2 0
C638 r1_b2 Xm/in_p 0.01082f
C639 i2_b3 Xi0/g 0.01028f
C640 i4_b0 Xi3/m1_988_888# 0.19954f
C641 Xd3/m1_1702_4448# bias_en 0.04204f
C642 Xd3/m1_3908_2760# Xd3/m1_4102_4448# -0.02295f
C643 i4_b4 r2_b2 0.02374f
C644 Xi2/g Xi2/m1_988_3304# -0.05972f
C645 v0_c4 v0_c2 0.19904f
C646 bias_en Xd3/m1_5422_4448# 0.06031f
C647 r1_b4 Xg/m1_3898_9610# 0
C648 i4_b3 Xi4/a_3078_4170# 0.07357f
C649 Xi2/m1_1500_3762# r1_b4 0.00901f
C650 vdd r2_b1 1.25698f
C651 r0_b1 ua0_stim_out 0.95108f
C652 Xvi/m1_942_738# r2_b1 0
C653 vreset_src Xr/m1_342_438# 0.00121f
C654 i3_b3 vbn_leak 0.06316f
C655 v0_c5 Xd3/a_4584_3816# 0.00231f
C656 i2_b2 Xi2/a_3078_4170# 0.01499f
C657 i4_b4 i4_b3 1.93946f
C658 vreset_src Xr/vglp 0.32764f
C659 Xm/iint Xr/m1_1662_438# 0.07389f
C660 Xr/vglp Xi0/m1_240_3480# 0.01093f
C661 Xd3/m1_1523_3480# Xd3/a_1624_3816# -0.02485f
C662 Xg/m1_6020_10200# r1_b4 0.04993f
C663 i0_b3 Xi1/a_4132_4392# 0
C664 vdd Xi4/a_1378_4170# -0
C665 Xi3/m1_988_3464# vbn_ax -0.00616f
C666 Xr/vglp ib_x2 0.4298f
C667 Xr/vsp r2_b0 0
C668 Xi1/a_3928_4392# ua0_stim_out 0.00147f
C669 vdd i1_b3 0.00297f
C670 Xr/m1_342_438# bias_en 0.04813f
C671 r0_b1 Xd0/a_3408_3416# 0.0362f
C672 Xi3/a_3928_4392# Xi2/g 0.00313f
C673 ua0_stim_out i1_b1 0.05155f
C674 r0_b0 Xd0/a_1632_3416# 0
C675 i3_b2 i3_b4 0.77597f
C676 Xr/vglp bias_en 0.56781f
C677 r1_b1 r1_b4 0.15046f
C678 vdd Xi3/a_3078_4392# -0.00101f
C679 i3_b2 Xr/vsn 0.34719f
C680 r2_b2 Xg/a_1580_5314# 0.1501f
C681 vreset_src vbn_prb 0.17819f
C682 Xr/vglp el 0.19586f
C683 Xi3/a_732_4392# vbn_ax 0
C684 Xd3/a_3400_3816# v0_c1 0.30585f
C685 Xg/a_4580_5314# Xi0/g 0.00691f
C686 vbn_ref r0_b4 0.03864f
C687 ib_x2 vbn_prb 0.23769f
C688 vdd Xd1/a_1272_3416# 0.00316f
C689 i4_b2 vbp_w -0.00912f
C690 Xi2/a_4132_4170# r2_b4 0.00117f
C691 r2_b4 Xi4/m1_260_2080# 0.10874f
C692 Xm/iint i4_b3 0.00395f
C693 i4_b1 vbn_leak 0.04029f
C694 Xvi/a_864_6450# Xr/vgln 0.14502f
C695 r0_b0 Xr/vsn 0.01309f
C696 Xvi/m1_4894_1238# vth_cmp 0
C697 Xi1/g r1_b4 0.20643f
C698 i4_b4 i1_b0 0
C699 i4_b1 i2_b0 0
C700 vbn_prb bias_en 0.35104f
C701 i0_b1 ua0_stim_out 0.07014f
C702 el vbn_prb 0.57494f
C703 i0_b4 v0_c1 0.04934f
C704 Xi3/m1_988_2804# Xi3/m1_988_888# -0
C705 r0_b0 Xi3/a_528_4392# 0
C706 i4_b0 Xr/vsp 0.80622f
C707 Xd3/a_3992_3816# ua0_s1 0.04781f
C708 Xi3/g Xg/m1_4906_9490# -0
C709 Xi0/a_4132_4392# Xi0/a_3078_4392# -0
C710 i3_b2 Xi1/a_2432_4392# 0
C711 vdd Xg/m1_3898_9610# 0
C712 Xd0/m1_3310_2880# r1_b2 0
C713 vdd Xi2/m1_1500_3762# -0
C714 vth_ref i4_b4 0.0291f
C715 r1_b0 Xd1/m1_2862_4048# 0
C716 Xi2/m1_988_2644# r2_b0 0.07489f
C717 Xi2/a_528_4170# i2_b0 0
C718 r1_b3 Xi2/m1_260_2080# 0
C719 Xvi/m1_5388_6960# Xr/vglp -0.02283f
C720 r2_b4 Xi2/a_3078_4170# 0.00481f
C721 i0_b3 Xi1/a_3928_4392# 0
C722 r1_b3 Xg/m1_4906_9490# 0.12095f
C723 Xg/a_4580_5314# i3_b2 0.08416f
C724 vdd Xg/m1_6020_10200# -0.0139f
C725 vbn_ref r1_b2 1.34098f
C726 i4_b4 Xi2/g 0
C727 Xd3/a_3992_3816# bias_en 0
C728 Xi1/m1_988_888# i3_b3 0.25213f
C729 Xr/en_b vbp_st 0.1318f
C730 vbp_st ua0_stim_out 0.02631f
C731 Xi1/a_4132_4392# Xm/in_p 0.00109f
C732 vdd Xd3/a_3400_3816# -0.0015f
C733 r2_b2 r2_b0 0.01077f
C734 Xr/vglp Xvi/m1_4546_7560# -0
C735 vth_ref Xm/iint 0.76536f
C736 Xi3/a_528_4392# vbn_ax 0.00306f
C737 Xr/vgln r1_b0 0.37427f
C738 vdd r1_b1 1.12867f
C739 Xi3/m1_1500_4312# vbn_ax -0.00441f
C740 Xd0/m1_3310_2880# r2_b3 0.07406f
C741 Xd3/m1_2408_3600# ua0_s0 0.16194f
C742 r2_b4 vbp_w 0.12044f
C743 el Xd0/a_1040_3416# 0.01838f
C744 Xi1/m1_988_888# Xi0/a_3928_4392# 0
C745 Xd3/a_1624_3816# ua0_s1 0.0436f
C746 r2_b4 Xi4/a_3928_4170# 0.00846f
C747 r1_b3 Xi3/a_3282_4392# 0.04968f
C748 vbp_st Xi3/g 0.25883f
C749 Xvi/m1_4894_1238# Xr/vgln 0.01676f
C750 vreset_src Xvi/m1_7102_850# 0
C751 vbp_w Xi3/m1_988_888# 0.00593f
C752 Xr/vglp vth_cmp 0.22781f
C753 v0_c2 v0_c5 0.04986f
C754 i4_b1 i2_b1 0.02959f
C755 ua0_stim_out r2_b1 0.0343f
C756 ib_x2 Xvi/m1_7102_850# 0.01268f
C757 Xi3/m1_988_2804# Xr/vsp 0.12726f
C758 vbp_syn r0_b4 0.00906f
C759 vdd i0_b4 1.31845f
C760 i0_b2 Xr/vgln 0.47312f
C761 ua0_s0 Xm/a_736_5516# 0.41573f
C762 r0_b0 r0_b4 0.28655f
C763 vbn_leak i3_b0 2.07338f
C764 vdd Xi1/g 0.16398f
C765 vbn_ref r2_b3 0.41596f
C766 r1_b2 Xd1/a_1864_3416# 0.03492f
C767 Xi2/g Xg/a_1580_5314# 0
C768 vdd Xi4/g 0.63078f
C769 vbp_st r1_b3 0.07357f
C770 bias_en Xvi/m1_7102_850# 0
C771 Xi3/g r2_b1 0.04015f
C772 i3_b2 Xi1/a_2228_4392# 0.0034f
C773 i1_b3 ua0_stim_out 0.17696f
C774 Xi4/g Xvi/m1_942_738# 0.08274f
C775 vbn_prb vth_cmp 0.65902f
C776 Xd3/a_1624_3816# bias_en 0.00164f
C777 i4_b0 r2_b2 0.83585f
C778 Xvi/m1_8332_7080# i4_b4 0.15454f
C779 i0_b1 Xi1/m1_988_2804# 0.05844f
C780 Xr/vsn Xi4/m1_988_888# -0.06232f
C781 Xi2/m1_988_3304# r1_b4 0.00444f
C782 i4_b0 Xg/a_5188_4156# 0.00312f
C783 Xd0/m1_822_4048# r2_b0 0.04109f
C784 Xi3/m1_1500_4312# Xi3/m1_988_3464# -0.00543f
C785 r0_b2 Xd0/a_2224_3416# 0.07514f
C786 r1_b3 r2_b1 0.1205f
C787 Xi3/a_2432_4392# Xi3/m1_1500_4312# -0
C788 i4_b2 vbn_leak 0.1168f
C789 i3_b3 i0_b0 0.02786f
C790 Xr/vsn Xm/in_n 0.53524f
C791 i0_b3 vbp_st 0.04575f
C792 Xi2/a_1378_4170# Xi2/a_2432_4170# -0
C793 i2_b2 i2_b0 0.02931f
C794 Xi1/a_3928_4392# Xm/in_p 0.00168f
C795 Xvi/m1_1276_6360# i4_b4 0.01032f
C796 Xvi/m1_4894_1238# Xvi/a_864_6450# -0.00138f
C797 Xd1/a_1864_3416# r2_b3 0.00881f
C798 Xd3/m1_3908_2760# Xd3/m1_4078_3250# -0
C799 Xvi/m1_8332_7080# Xm/iint 0.188f
C800 r0_b4 vbn_ax 0.091f
C801 Xd3/m1_1523_3480# ua0_s0 0.11202f
C802 Xm/in_p i1_b1 0
C803 vbp_syn r1_b2 0.47016f
C804 vbn_prb Xd1/m1_2862_4048# 0.09123f
C805 r0_b0 r1_b2 0.11522f
C806 Xd0/a_2224_3416# r0_b3 -0
C807 r1_b3 Xi3/a_3078_4392# 0.06703f
C808 Xr/vglp Xr/vgln 0.67264f
C809 vbp_st Xi1/m1_988_2804# 0.00889f
C810 vbn_prb Xi4/m1_988_3304# 0.11721f
C811 vdd Xm/a_1744_10100# -0
C812 ua0_s0 Xd3/m1_4982_4448# 0
C813 Xd2/m1_756_2640# Xd2/m1_902_4048# -0.00124f
C814 Xd2/m1_756_2640# r2_b3 0.02059f
C815 Xi4/m1_988_2644# r2_b1 0
C816 ua0_stim Xd3/a_3992_3816# 0.03322f
C817 Xg/m1_4760_1320# Xm/in_n 0.02983f
C818 ua0_s0 Xm/a_420_700# 0.21467f
C819 Xm/in_p Xg/m1_4906_9490# 0.05103f
C820 i0_b3 i1_b3 0.12898f
C821 r2_b2 Xi4/m1_260_2080# 0.19702f
C822 Xi2/g r2_b0 0.3056f
C823 i0_b1 Xm/in_p 0.06177f
C824 i3_b1 vbn_leak 0.45199f
C825 vbn_prb Xr/vgln 0.15679f
C826 Xi0/m1_988_2804# Xi0/g -0.03516f
C827 Xi2/a_1378_4170# r1_b4 0
C828 vdd Xd0/a_2224_3416# 0.06048f
C829 Xi2/a_732_4170# r2_b0 0
C830 vbp_syn r2_b3 0.22383f
C831 i2_b2 Xg/m1_3666_9610# 0
C832 i2_b3 i2_b4 0.06481f
C833 Xr/vsn i3_b4 0.42145f
C834 r0_b0 r2_b3 0.04451f
C835 vdd Xd0/m1_956_3000# 0
C836 Xd3/a_3400_3816# ua0_stim_out 0
C837 vth_cmp Xvi/m1_7102_850# 0
C838 Xg/a_4580_5314# Xm/in_n 0.02064f
C839 r1_b3 Xg/m1_3898_9610# 0.03138f
C840 r1_b1 ua0_stim_out 0.03601f
C841 Xi0/m1_240_3480# Xi0/m1_988_3464# -0
C842 vdd Xi0/a_4132_4392# 0.00615f
C843 vbn_ax r1_b2 0.04105f
C844 vdd Xi2/m1_988_3304# -0.02921f
C845 Xd1/a_3048_3416# r1_b4 0.00114f
C846 ib_x2 Xi0/m1_988_3464# 0.00381f
C847 Xi0/a_732_4392# i3_b4 0.00983f
C848 ib_x2 Xi0/a_3928_4392# 0
C849 r2_b4 vbn_leak 0.03871f
C850 Xi1/m1_1500_4312# i0_b1 0.02784f
C851 Xi0/a_732_4392# Xr/vsn 0.0028f
C852 i2_b2 i2_b1 0.00655f
C853 r2_b4 i2_b0 0.1043f
C854 r1_b1 Xi3/g 0.83363f
C855 i0_b4 ua0_stim_out 0.28001f
C856 vreset_src i4_b1 0.04368f
C857 Xr/vglp Xvi/a_864_6450# 0.15728f
C858 Xi2/g i4_b0 0.06205f
C859 Xr/vgln Xi2/m1_988_888# 0.37495f
C860 r1_b3 Xg/m1_6020_10200# 0
C861 Xd0/m1_3310_2880# r0_b1 0
C862 ua0_stim Xd3/a_1624_3816# 0.0808f
C863 Xi1/m1_240_3480# i0_b1 0.00282f
C864 Xi1/g ua0_stim_out 0
C865 Xi4/a_528_4170# vbp_w 0
C866 Xr/vsn Xg/m1_4760_1320# 0.01807f
C867 vbp_st Xm/in_p 0.74965f
C868 Xd3/a_3992_3816# v0_c3 0.00887f
C869 i1_b2 i3_b2 0.12328f
C870 vreset_src Xi4/a_2432_4170# 0.02758f
C871 vdd Xi3/a_3928_4392# 0
C872 r1_b3 r1_b1 1.23205f
C873 Xi1/g Xi3/g 0.12106f
C874 Xd2/m1_596_3240# r2_b3 0.00237f
C875 Xvi/a_864_6450# vbn_prb -0.01456f
C876 el i4_b1 0.23413f
C877 vbn_ax r2_b3 0.18352f
C878 vbn_ref r0_b1 0.05286f
C879 Xm/a_1764_11418# ua0_s1 0.06469f
C880 Xi4/g Xi3/g 0.05093f
C881 vdd Xi4/a_732_4170# 0
C882 Xg/m1_6282_1450# Xm/in_n 0.03936f
C883 i3_b2 Xi3/a_2228_4392# -0.00581f
C884 Xm/in_p r2_b1 0.12646f
C885 r2_b2 vbp_w 0.00197f
C886 Xd1/a_2456_3416# Xd1/m1_2372_2520# -0
C887 Xg/a_4580_5314# i3_b4 0.0372f
C888 Xi4/a_3928_4170# r2_b2 0.00105f
C889 Xg/a_4580_5314# Xr/vsn 0.08335f
C890 ua0_s0 ua0_s1 0.67224f
C891 Xd3/m1_822_4448# bias_en 0.22136f
C892 vdd Xi2/a_1378_4170# 0.04936f
C893 Xi1/g r1_b3 0.28792f
C894 i0_b0 i3_b0 0.20527f
C895 vbn_ref i1_b1 -0.00858f
C896 vdd Xd1/m1_2974_2650# 0
C897 r0_b4 i2_b4 0.03997f
C898 vbp_st Xi1/m1_240_3480# 0.00377f
C899 Xr/vgln Xvi/m1_7102_850# 0.08184f
C900 ib_r1 Xvi/m1_8042_6360# 0
C901 vth_ref Xg/m1_5516_1920# 0.0016f
C902 Xr/vgln Xg/a_7580_5314# -0.00742f
C903 v0_c4 v0_c1 0
C904 vth_cmp Xd2/m1_240_4046# 0.01255f
C905 i4_b3 vbp_w 0
C906 r1_b4 Xg/a_1580_5314# 0.01789f
C907 ua0_s0 ib_x2 0.0038f
C908 i4_b3 Xi4/a_3928_4170# 0.04559f
C909 vdd Xi0/a_2432_4392# 0.02339f
C910 Xr/vglp r1_b0 0.44518f
C911 Xm/in_n Xr/m1_3422_438# 0.09283f
C912 Xr/vsn r0_b4 0.17134f
C913 Xd2/m1_756_2640# Xd2/a_1272_3416# -0.03797f
C914 vdd Xd1/a_3048_3416# 0.08881f
C915 ua0_s0 Xm/a_1744_9182# 0.0878f
C916 Xg/m1_5516_1920# Xi2/g 0.0322f
C917 r2_b4 i2_b1 0.03315f
C918 Xi0/a_3282_4392# Xi0/a_3078_4392# -0
C919 i0_b3 i0_b4 0.45679f
C920 vbn_leak Xr/vsp 0.069f
C921 r0_b4 i2_b3 0.04739f
C922 i0_b3 Xi1/g 0.02602f
C923 ua0_s0 bias_en 0.42156f
C924 Xvi/a_2102_5152# ib_x2 0
C925 Xr/vglp Xvi/m1_4894_1238# 0.12931f
C926 vreset_src Xvi/a_2102_5152# 0.09989f
C927 Xvi/m1_5388_6960# i4_b1 0
C928 Xi2/g Xi3/m1_988_2804# 0
C929 vdd Xi4/a_3078_4170# 0.00301f
C930 vbn_ref i0_b1 0.04289f
C931 Xi4/g Xvi/a_5712_1328# 0.06086f
C932 Xr/vglp i0_b2 0
C933 Xi2/a_2432_4170# r2_b0 0.00127f
C934 Xd0/m1_822_4048# vbp_w 0
C935 Xr/vsn Xg/m1_6282_1450# 0.0217f
C936 Xi4/g Xi4/m1_988_2644# -0.04402f
C937 Xvi/a_2102_5152# bias_en 0.3082f
C938 vdd Xi4/a_1582_4170# 0.00319f
C939 vdd i4_b4 3.13344f
C940 Xvi/m1_4894_1238# vbn_prb -0.00203f
C941 Xd3/a_3400_3816# v0_c0 0.02416f
C942 vdd i1_b4 0.10087f
C943 Xvi/m1_4546_7560# i4_b1 0.14539f
C944 Xd0/a_1632_3416# r1_b2 0.04146f
C945 Xi1/g Xi1/m1_988_2804# -0.01835f
C946 r1_b2 i2_b4 0
C947 Xi0/g Xi0/a_528_4392# 0
C948 Xm/in_p Xg/m1_3898_9610# 0.01896f
C949 r1_b3 Xi3/a_4132_4392# 0.00711f
C950 Xd3/a_4584_3816# Xd3/m1_4982_4448# -0.0031f
C951 vbp_syn r0_b1 0.03595f
C952 i0_b4 v0_c0 0.03736f
C953 Xm/a_736_7228# Xm/a_736_5516# -0.09446f
C954 Xd0/a_1632_3416# Xd0/m1_1262_4048# -0
C955 Xr/vsn Xr/m1_3422_438# -0.01713f
C956 vdd Xm/iint 1.62007f
C957 Xi2/m1_988_888# r1_b0 0.00195f
C958 Xi1/a_732_4392# i1_b1 -0.04022f
C959 vreset_src i4_b2 0.00575f
C960 i4_b3 Xvi/m1_8042_6360# 0.12765f
C961 r0_b0 r0_b1 0.34132f
C962 vbp_st vbn_ref 0.04528f
C963 Xg/m1_6020_10200# Xm/in_p 0.0617f
C964 i3_b2 i1_b1 0.05225f
C965 Xi0/m1_988_888# Xm/iint 0.4105f
C966 vdd v0_c4 1.05694f
C967 i0_b0 i3_b1 0.27095f
C968 r1_b4 r2_b0 0.01156f
C969 i2_b3 r1_b2 0.52583f
C970 vdd Xi0/a_2228_4392# 0.02749f
C971 Xr/vsp Xg/m1_3666_9610# 0.0128f
C972 Xd2/m1_756_2640# Xd2/a_2456_3416# -0.00464f
C973 vbn_leak Xi2/m1_988_2644# 0.0058f
C974 vdd Xg/a_1580_5314# -0.07888f
C975 Xi0/a_1582_4392# i3_b4 0.00678f
C976 Xi1/a_1582_4392# i0_b1 0.01247f
C977 Xd0/a_1632_3416# r2_b3 0.04476f
C978 r1_b0 Xd0/a_1040_3416# 0.06021f
C979 Xr/vsn Xi0/a_1582_4392# 0.005f
C980 r1_b1 Xm/in_p 0.14874f
C981 Xd2/m1_596_3240# Xd2/a_1272_3416# -0.02852f
C982 Xd3/m1_382_4448# vdd 0
C983 vbp_st Xi0/g 0.30561f
C984 el i4_b2 0.15696f
C985 vbn_ref r2_b1 0.10506f
C986 i3_b3 Xr/vgln 0.67864f
C987 Xg/a_4580_5314# Xg/m1_6282_1450# -0
C988 r0_b2 r2_b0 0.02694f
C989 Xi1/a_732_4392# i0_b1 0.08612f
C990 Xi0/a_732_4392# Xi0/a_1582_4392# -0
C991 Xr/vglp Xg/a_3036_4156# 0.0634f
C992 i0_b4 Xm/in_p 0.04226f
C993 r2_b3 Xd1/m1_462_4048# 0.00794f
C994 i4_b1 Xi4/a_3282_4170# 0.0091f
C995 r0_b0 Xi2/m1_260_2080# 0.03621f
C996 Xi1/m1_988_888# Xr/vsp 0.52219f
C997 Xi2/a_2228_4170# Xr/vgln 0.10451f
C998 i3_b2 i0_b1 0.05338f
C999 Xi0/m1_988_2804# Xm/in_n 0.26122f
C1000 vbn_leak r2_b2 0.03739f
C1001 Xi1/g Xm/in_p 0.59646f
C1002 Xm/iint Xm/a_2240_11218# 0.00704f
C1003 Xr/vgln Xi0/a_3928_4392# 0
C1004 vbn_ax r0_b1 0.35528f
C1005 i2_b0 r2_b2 0.05559f
C1006 Xr/vglp vbn_prb 0.17307f
C1007 ua0_stim Xm/a_1764_11418# -0
C1008 i4_b4 Xi4/a_4132_4170# 0
C1009 Xvi/a_2102_5152# Xvi/m1_4546_7560# -0
C1010 vbn_leak Xg/a_5188_4156# 0.03609f
C1011 Xg/a_7580_5314# r1_b0 0
C1012 i4_b0 r1_b4 1.37696f
C1013 r0_b3 r2_b0 0.1535f
C1014 ua0_stim ua0_s0 0.37648f
C1015 i0_b3 Xi0/a_4132_4392# 0
C1016 vbn_leak i4_b3 0.03675f
C1017 Xvi/a_2102_5152# vth_cmp 0.14797f
C1018 Xd0/a_2816_3416# vbp_w 0.01584f
C1019 i3_b2 Xi3/a_3282_4392# 0
C1020 r1_b3 Xi3/a_3928_4392# 0.01565f
C1021 i4_b1 Xr/vgln 1.32062f
C1022 i3_b1 Xi1/m1_988_3464# 0.00145f
C1023 vth_ref Xvi/m1_8042_6360# 0
C1024 Xi1/m1_1500_4312# Xi1/g -0.00532f
C1025 Xi1/a_528_4392# i1_b1 -0
C1026 Xm/a_420_700# Xm/a_736_7228# -0.0333f
C1027 Xd3/m1_1262_4448# bias_en 0.09852f
C1028 vreset_src r2_b4 0.51421f
C1029 Xr/vgln Xi4/a_2432_4170# -0.00255f
C1030 vbp_st i3_b2 0.04195f
C1031 Xd2/m1_596_3240# Xd2/a_2456_3416# -0
C1032 Xd3/a_4584_3816# ua0_s1 0.06497f
C1033 Xi1/g Xi1/m1_240_3480# 0.04363f
C1034 r0_b4 r1_b2 0.07387f
C1035 vdd r2_b0 0.60316f
C1036 Xr/vgln Xvi/m1_7440_2050# 0.00299f
C1037 Xi2/a_528_4170# Xr/vgln 0.00191f
C1038 Xi1/a_1378_4392# i0_b1 0.05075f
C1039 Xi4/g Xg/m1_4538_1930# 0
C1040 Xd0/a_1632_3416# Xd0/m1_2242_4966# -0.00719f
C1041 Xd3/m1_2408_3600# Xd3/m1_3222_4448# -0.0235f
C1042 vbp_st vbp_syn 0.05288f
C1043 i4_b4 ua0_stim_out 0.05055f
C1044 Xi4/a_3078_4170# Xi3/g 0
C1045 Xi0/m1_988_2804# i3_b4 0
C1046 vbp_st r0_b0 0.04313f
C1047 vreset_src Xvi/a_4976_1528# 0.28435f
C1048 Xr/vsn Xi0/m1_988_2804# 0.03873f
C1049 r2_b2 Xg/m1_3666_9610# 0
C1050 i1_b4 ua0_stim_out 0.05632f
C1051 Xvi/a_4976_1528# ib_x2 0.00323f
C1052 r2_b4 el 0.03946f
C1053 i3_b2 r2_b1 0.05039f
C1054 Xd1/a_1864_3416# Xd1/a_1272_3416# -0
C1055 Xi1/a_528_4392# i0_b1 0.00266f
C1056 i4_b4 Xi3/g 0
C1057 el Xi3/m1_988_888# 0.18063f
C1058 Xm/in_n Xr/m1_2542_438# 0.08362f
C1059 Xi2/a_4132_4170# r1_b4 0
C1060 v0_c2 Xd3/m1_4982_4448# 0.00655f
C1061 Xi1/m1_988_888# Xi0/a_1378_4392# 0
C1062 Xvi/a_4976_1528# bias_en 0.05009f
C1063 i0_b0 Xr/vsp 0.2206f
C1064 Xd3/a_4584_3816# bias_en 0.00101f
C1065 Xi1/a_4132_4392# i3_b4 0
C1066 Xr/en_b Xm/iint 0.03152f
C1067 vdd Xi0/a_3282_4392# 0.09239f
C1068 ua0_s0 v0_c3 0.04014f
C1069 i2_b1 r2_b2 0.03275f
C1070 i3_b2 i1_b3 0.03756f
C1071 Xvi/a_864_6450# i4_b1 0.41644f
C1072 Xvi/a_4976_1528# el 0.00416f
C1073 Xm/iint ua0_stim_out 0.0679f
C1074 r0_b4 r2_b3 0.08073f
C1075 Xr/m1_1222_3522# Xm/in_n 0.00171f
C1076 vbn_prb Xd0/a_1040_3416# 0.00198f
C1077 Xd3/a_3400_3816# Xd3/a_2808_3816# -0.07589f
C1078 vdd i4_b0 1.30343f
C1079 i3_b2 Xi3/a_3078_4392# 0.00163f
C1080 vbn_ref r1_b1 0.2667f
C1081 Xr/vglp Xvi/m1_7102_850# -0.00383f
C1082 Xvi/a_2102_5152# Xr/vgln 0.02164f
C1083 Xr/vglp Xg/a_7580_5314# 0.03981f
C1084 vdd v0_c5 0.78119f
C1085 Xg/m1_6020_10200# Xi0/g 0
C1086 Xvi/m1_8332_7080# Xvi/m1_8042_6360# -0.01591f
C1087 Xd3/m1_382_4448# Xr/en_b 0.02918f
C1088 Xg/a_3036_4156# Xg/a_7580_5314# -0
C1089 Xd3/m1_382_4448# ua0_stim_out 0.00941f
C1090 vbn_leak Xi2/g 0.32911f
C1091 vbp_st vbn_ax 0.22499f
C1092 vreset_src Xvi/m1_502_738# 0
C1093 Xr/vgln i3_b0 0.11768f
C1094 Xi3/g Xg/a_1580_5314# 0.04478f
C1095 Xi2/a_2228_4170# r1_b0 0.10955f
C1096 Xm/a_736_7228# ua0_s1 0.44794f
C1097 Xi0/m1_240_3480# Xr/vsp -0.0258f
C1098 Xi2/a_3078_4170# r1_b4 0.01501f
C1099 Xi1/g vbn_ref 0.34646f
C1100 vbn_prb Xvi/m1_7102_850# -0.00751f
C1101 Xi4/m1_988_2644# Xi4/a_3078_4170# -0.00242f
C1102 vreset_src Xr/vsp 0.08296f
C1103 ib_x2 Xr/vsp 0.7378f
C1104 i4_b4 Xvi/a_5712_1328# 0.09032f
C1105 r0_b2 Xd0/m1_2742_3250# 0.00182f
C1106 Xd0/a_1632_3416# r0_b1 0.03326f
C1107 i3_b3 i0_b2 0.49489f
C1108 Xvi/m1_502_738# bias_en 0.00118f
C1109 Xd1/a_680_3416# Xd1/m1_462_4048# -0
C1110 Xr/vsn Xr/m1_2542_438# -0
C1111 Xd3/m1_1523_3480# Xd3/m1_3222_4448# -0.00441f
C1112 Xd3/m1_2408_3600# Xd3/m1_2720_2760# -0.00144f
C1113 Xi2/a_732_4170# i2_b0 0.0018f
C1114 i0_b3 i1_b4 0.1617f
C1115 Xd2/m1_2964_2640# Xd2/a_3048_3416# -0.00106f
C1116 ib_x2 Xi0/m1_1500_4312# 0.11882f
C1117 r1_b3 Xg/a_1580_5314# 0.08888f
C1118 Xr/vsp Xi1/m1_988_3464# -0.01716f
C1119 bias_en Xr/vsp 0.17791f
C1120 Xi1/g Xi0/g 0.04701f
C1121 r1_b2 r2_b3 0.45945f
C1122 Xd1/a_2456_3416# vbp_w 0.10999f
C1123 Xi3/a_2432_4392# Xi3/a_3282_4392# -0
C1124 i4_b2 Xr/vgln 0.10138f
C1125 el Xr/vsp 0.46052f
C1126 Xm/in_n Xi0/a_528_4392# 0
C1127 Xr/vgln i2_b2 0.31012f
C1128 vbp_w r1_b4 0.00374f
C1129 Xm/a_736_7228# Xm/a_1744_9182# -0.00151f
C1130 Xi1/a_3928_4392# i3_b4 0
C1131 r0_b1 i2_b3 0
C1132 r2_b4 vth_cmp 0
C1133 Xm/a_736_7228# bias_en 0.29778f
C1134 vdd Xi2/a_4132_4170# 0
C1135 Xm/iint Xvi/a_5712_1328# 0.04435f
C1136 vdd Xi4/m1_260_2080# 0
C1137 Xvi/a_864_6450# Xvi/a_2102_5152# -0.0254f
C1138 v0_c4 ua0_int 0.02437f
C1139 Xvi/a_4976_1528# Xvi/m1_4546_7560# -0
C1140 i1_b2 Xi1/a_2228_4392# 0
C1141 Xd0/m1_1262_4048# r2_b3 0.00274f
C1142 vdd Xi3/m1_988_2804# -0.04998f
C1143 ib_r1 vreset_src 0.75518f
C1144 ib_r1 ib_x2 0.21222f
C1145 Xi3/m1_240_3480# r1_b1 0.11958f
C1146 v0_c2 ua0_s1 0.28076f
C1147 Xi2/a_528_4170# r1_b0 0.07029f
C1148 ua0_stim_out r2_b0 0.05605f
C1149 Xvi/a_4976_1528# vth_cmp 0.15663f
C1150 r0_b2 vbp_w 0.00413f
C1151 i2_b4 Xg/m1_4906_9490# 0.00124f
C1152 i3_b2 r1_b1 0.04273f
C1153 vth_cmp Xd2/a_1864_3416# 0.01302f
C1154 i1_b4 v0_c0 0.00786f
C1155 Xd2/m1_756_2640# Xd2/m1_2382_2650# -0
C1156 Xd1/m1_756_3120# r2_b3 0.12308f
C1157 ib_x2 v0_c2 0.70605f
C1158 ib_r1 bias_en 0.1646f
C1159 vdd Xd0/m1_2742_3250# 0.0207f
C1160 vbp_st Xm/in_n 0.00843f
C1161 vreset_src Xi4/a_528_4170# 0.0813f
C1162 ua0_stim Xd3/a_4584_3816# 0.04627f
C1163 i0_b0 i4_b3 0
C1164 Xi4/m1_988_888# r2_b1 0.36498f
C1165 Xd0/a_3408_3416# r2_b0 0
C1166 Xr/vglp i3_b3 0.3394f
C1167 i0_b1 i3_b4 0
C1168 Xi1/g Xi1/a_732_4392# 0.00829f
C1169 Xr/vsn i0_b1 0
C1170 vdd Xi2/a_3078_4170# 0
C1171 i3_b2 Xi1/g 0.17296f
C1172 i3_b1 Xr/vgln 0.27916f
C1173 r2_b4 Xi4/a_3282_4170# 0.00241f
C1174 r0_b3 vbp_w 0
C1175 i3_b3 Xg/a_3036_4156# 0.30949f
C1176 i3_b4 Xi0/a_528_4392# 0.02065f
C1177 v0_c2 bias_en 0.0612f
C1178 i2_b3 Xg/m1_4906_9490# 0
C1179 Xr/vsn Xi0/a_528_4392# 0.00207f
C1180 Xi2/a_3282_4170# r2_b0 0.01203f
C1181 r2_b4 Xi4/m1_988_3304# 0.18021f
C1182 i3_b2 Xi4/g 0.00417f
C1183 v0_c4 v0_c0 0.01075f
C1184 r1_b3 r2_b0 0
C1185 vreset_src r2_b2 0.04993f
C1186 Xi0/a_732_4392# i0_b1 -0
C1187 Xr/vglp Xi0/a_3928_4392# 0.08694f
C1188 i4_b0 ua0_stim_out 0.05712f
C1189 i4_b4 Xm/in_p 0.03708f
C1190 Xd0/m1_2242_4966# r1_b2 0
C1191 Xr/vglp Xi0/m1_988_3464# 0.00743f
C1192 vth_cmp Xvi/m1_502_738# 0.16407f
C1193 Xr/m1_1662_438# bias_en 0.01343f
C1194 r2_b4 Xr/vgln 0.08501f
C1195 Xvi/m1_4894_1238# Xvi/a_2102_5152# -0.00349f
C1196 Xr/vgln Xi3/m1_988_888# 0.08732f
C1197 r0_b4 r0_b1 0.04352f
C1198 Xr/vglp i4_b1 0.47382f
C1199 vdd vbp_w 0.79754f
C1200 i0_b0 i1_b0 0.02164f
C1201 vdd Xi4/a_3928_4170# -0
C1202 vreset_src i4_b3 0.78609f
C1203 i4_b0 Xi3/g 0.97122f
C1204 Xi1/a_2432_4392# i0_b1 0.0034f
C1205 el r2_b2 0.0332f
C1206 vbp_st i3_b4 0.04503f
C1207 Xr/vgln Xg/m1_3298_2050# 0.00854f
C1208 Xd3/m1_3222_4448# ua0_s1 0.01089f
C1209 vbn_ax r1_b1 0.01214f
C1210 vbp_st Xr/vsn 0.10934f
C1211 Xvi/a_4976_1528# Xr/vgln 0.34887f
C1212 Xm/iint Xm/in_p 0.07422f
C1213 i2_b0 Xi2/a_2432_4170# 0
C1214 ua0_s0 Xd3/m1_5422_4448# 0
C1215 i2_b4 r2_b1 0.03267f
C1216 Xd2/m1_596_3240# Xd2/m1_2382_2650# -0
C1217 i3_b3 Xi2/m1_988_888# 0
C1218 Xd3/a_4584_3816# v0_c3 0.0183f
C1219 Xd1/m1_606_2410# r2_b3 0.10867f
C1220 i4_b3 bias_en 0.10528f
C1221 r1_b3 i4_b0 0.65087f
C1222 Xd3/m1_3908_2760# vbp_st 0
C1223 Xr/vglp Xvi/m1_7440_2050# -0
C1224 el i4_b3 0.01252f
C1225 Xd0/m1_2242_4966# r2_b3 0.06248f
C1226 i3_b4 r2_b1 0.03965f
C1227 ua0_stim Xm/a_736_7228# -0.02726f
C1228 Xr/vsn r2_b1 0.52724f
C1229 r1_b0 i2_b2 0.13288f
C1230 Xi1/g Xi1/a_528_4392# 0.02749f
C1231 Xd3/m1_382_4448# Xm/in_p 0.05562f
C1232 r0_b4 Xi2/m1_260_2080# 0.08881f
C1233 Xd3/m1_3222_4448# bias_en 0.05026f
C1234 i2_b3 r2_b1 0.03827f
C1235 ib_r1 vth_cmp 0
C1236 vreset_src Xd2/a_3048_3416# 0.01878f
C1237 Xi1/m1_988_888# Xi0/a_3078_4392# 0
C1238 i0_b3 Xi0/a_3282_4392# 0
C1239 vbn_leak r1_b4 0.16844f
C1240 Xvi/a_864_6450# r2_b4 0
C1241 r0_b1 r1_b2 1.3791f
C1242 i2_b0 r1_b4 0.08307f
C1243 Xi3/m1_988_3464# r1_b1 0.03827f
C1244 el Xd0/m1_822_4048# 0.00647f
C1245 v0_c5 ua0_int 0.13608f
C1246 Xr/vgln Xvi/m1_502_738# 0.01434f
C1247 vdd Xvi/m1_8042_6360# 0.17386f
C1248 Xi3/a_2432_4392# r1_b1 0
C1249 Xr/vsn Xi3/a_3078_4392# 0
C1250 Xd2/m1_902_4048# Xd2/a_1272_3416# -0.0052f
C1251 Xg/m1_5516_1920# Xi3/g 0.00196f
C1252 r2_b3 Xd2/a_1272_3416# 0.00745f
C1253 vth_ref Xi0/m1_240_3480# 0
C1254 r0_b2 vbn_leak 0.04632f
C1255 i3_b3 Xg/a_7580_5314# 0.04835f
C1256 Xd3/m1_2408_3600# v0_c1 -0.00762f
C1257 Xvi/a_864_6450# Xvi/a_4976_1528# -0.06888f
C1258 Xr/vglp Xvi/a_2102_5152# 0.11866f
C1259 vreset_src vth_ref 0.29966f
C1260 Xi3/m1_988_2804# Xi3/g -0.12872f
C1261 r0_b0 Xd0/a_2224_3416# 0
C1262 vth_ref ib_x2 0.0736f
C1263 Xg/a_4580_5314# vbp_st 0.11316f
C1264 Xi2/a_3928_4170# r1_b0 0.05009f
C1265 Xr/vgln Xr/vsp 1.33458f
C1266 Xi1/a_3282_4392# i1_b3 -0
C1267 r0_b2 i2_b0 0.01266f
C1268 Xd1/a_680_3416# r2_b3 0.02028f
C1269 Xvi/m1_5388_6960# i4_b3 0.0304f
C1270 ua0_stim v0_c2 0.22497f
C1271 Xi1/a_2228_4392# i0_b1 0.00666f
C1272 Xi3/m1_1500_4312# Xi3/a_3078_4392# -0
C1273 Xd3/m1_2720_2760# ua0_s1 0.00195f
C1274 vbp_syn Xi2/m1_988_3304# -0.02055f
C1275 Xi3/a_732_4392# r1_b1 0
C1276 i2_b1 Xi2/a_2432_4170# 0
C1277 r1_b0 Xg/m1_5022_10210# 0
C1278 vreset_src Xi2/g 0
C1279 Xr/vglp i3_b0 0.03335f
C1280 vth_ref bias_en 0.35724f
C1281 i2_b4 Xg/m1_3898_9610# 0
C1282 vth_cmp r2_b2 0.12004f
C1283 Xd1/m1_1780_5040# Xd1/a_2456_3416# -0
C1284 vth_ref el 0.16692f
C1285 vbn_leak r0_b3 0.06155f
C1286 r0_b1 r2_b3 0.63903f
C1287 Xi3/a_3928_4392# Xi3/m1_240_3480# -0
C1288 r1_b3 Xi3/m1_988_2804# 0.13059f
C1289 Xg/a_3036_4156# i3_b0 0.04604f
C1290 vbp_st r0_b4 0.3123f
C1291 i4_b4 vbn_ref 0.04061f
C1292 Xm/in_p r2_b0 0
C1293 Xi4/g Xi4/m1_988_888# 0.25075f
C1294 Xvi/m1_4546_7560# i4_b3 0.06322f
C1295 i2_b0 r0_b3 0.00246f
C1296 i0_b2 i3_b1 0.01392f
C1297 Xi2/g bias_en 0.17298f
C1298 Xg/m1_6020_10200# i2_b4 0
C1299 v0_c5 v0_c0 0.00191f
C1300 i4_b1 Xg/a_7580_5314# 0.34811f
C1301 r2_b4 r1_b0 0.69194f
C1302 vth_cmp i4_b3 0.04692f
C1303 Xd3/m1_2720_2760# bias_en 0.06752f
C1304 ib_r1 Xr/vgln 0.34943f
C1305 Xi4/g Xm/in_n 0.03042f
C1306 ua0_s0 Xd3/a_3992_3816# 0.06368f
C1307 r0_b4 r2_b1 0.02911f
C1308 i4_b4 Xi0/g 0.68837f
C1309 Xr/vglp i4_b2 0.27049f
C1310 Xr/vglp i2_b2 0.16937f
C1311 vbp_w ua0_stim_out 0.00905f
C1312 Xi4/m1_988_2644# Xi4/m1_260_2080# -0.00848f
C1313 Xg/a_3036_4156# i4_b2 0.07404f
C1314 r1_b1 i2_b4 0.1304f
C1315 i2_b1 r1_b4 0.04243f
C1316 vdd vbn_leak 1.76486f
C1317 r2_b3 Xd2/a_2456_3416# 0.18689f
C1318 vdd Xd0/m1_617_3840# 0.00331f
C1319 i0_b1 Xi0/a_1582_4392# -0.00361f
C1320 vdd i2_b0 0.32519f
C1321 Xvi/m1_7440_2050# Xvi/m1_7102_850# -0.00402f
C1322 Xd0/a_3408_3416# vbp_w 0.01187f
C1323 i3_b4 r1_b1 0.03562f
C1324 Xr/vgln Xi2/m1_988_2644# 0.10856f
C1325 v0_c2 v0_c3 0.41806f
C1326 Xd2/m1_756_2640# Xd2/a_680_3416# -0.00139f
C1327 r2_b2 Xi4/a_3282_4170# 0
C1328 vbp_w Xi3/g 0.00178f
C1329 Xd3/m1_2408_3600# vdd -0.00399f
C1330 Xr/vsn r1_b1 0.0501f
C1331 Xvi/m1_4894_1238# Xvi/a_4976_1528# -0.00766f
C1332 Xvi/m1_5388_6960# vth_ref 0.00324f
C1333 vreset_src Xvi/m1_8332_7080# 0.00365f
C1334 i4_b0 Xm/in_p 0.24437f
C1335 Xi4/m1_988_3304# r2_b2 0
C1336 vth_cmp Xd0/m1_822_4048# 0.04479f
C1337 Xm/iint Xi0/g 0.5762f
C1338 i3_b0 Xi2/m1_988_888# 0.27733f
C1339 Xi1/g i2_b4 0.18071f
C1340 r0_b2 i2_b1 0.00147f
C1341 Xr/vgln Xi0/a_1378_4392# 0.00116f
C1342 Xd3/a_3400_3816# Xd3/m1_3908_2760# -0.02962f
C1343 i2_b3 r1_b1 0.05174f
C1344 vbp_st r1_b2 0.03718f
C1345 v0_c1 Xd3/m1_4982_4448# 0.00998f
C1346 Xi3/m1_1500_4312# r1_b1 0.08634f
C1347 i0_b4 i3_b4 0.12267f
C1348 i4_b3 Xi4/a_3282_4170# 0.10414f
C1349 r1_b3 vbp_w 0.05588f
C1350 i0_b4 Xr/vsn 0.11462f
C1351 Xi0/g Xg/a_1580_5314# -0.01419f
C1352 Xi1/g i3_b4 0
C1353 i1_b2 i1_b1 0.00197f
C1354 Xr/vgln r2_b2 0.25691f
C1355 Xvi/m1_1276_6360# vreset_src 0
C1356 Xvi/m1_8332_7080# el 0.01432f
C1357 r0_b0 Xd1/a_3048_3416# 0
C1358 Xr/vgln Xg/a_5188_4156# -0.00616f
C1359 Xi4/g i3_b4 0.02612f
C1360 Xr/vglp i3_b1 0.04255f
C1361 ua0_s0 Xd3/a_1624_3816# 0.33503f
C1362 r1_b2 r2_b1 0.12782f
C1363 Xd1/a_1864_3416# Xd1/m1_2372_2520# -0.00219f
C1364 ib_r1 Xvi/a_864_6450# 0.05205f
C1365 Xi4/g Xr/vsn 0.43357f
C1366 Xr/vglp Xg/m1_5022_10210# -0.0145f
C1367 Xi1/g i2_b3 0.26025f
C1368 i2_b1 r0_b3 0.00169f
C1369 i4_b4 i3_b2 0.03977f
C1370 Xg/a_3036_4156# i3_b1 0.05531f
C1371 vth_ref vth_cmp 0.00519f
C1372 Xg/a_3036_4156# Xg/m1_5022_10210# -0
C1373 Xr/vgln i4_b3 0.66846f
C1374 i3_b3 Xi0/a_3928_4392# 0.01633f
C1375 Xvi/m1_1276_6360# el 0.00733f
C1376 vbp_st r2_b3 0.04133f
C1377 r1_b0 Xr/vsp 0.14691f
C1378 Xd0/m1_3310_2880# r2_b0 0.07267f
C1379 r0_b4 Xi2/m1_1500_3762# 0.03913f
C1380 Xg/a_7580_5314# i3_b0 0.03429f
C1381 Xr/vglp r2_b4 0.09524f
C1382 i1_b2 i0_b1 0.00229f
C1383 Xm/a_2240_11218# Xm/a_736_5516# -0.03195f
C1384 Xi4/g Xg/m1_4760_1320# 0
C1385 i3_b3 i4_b1 0.18032f
C1386 Xr/vglp Xg/m1_3298_2050# 0.00181f
C1387 Xd3/m1_3222_4448# v0_c3 0
C1388 vdd i2_b1 0.13577f
C1389 Xd3/m1_1523_3480# vdd 0.00187f
C1390 i0_b2 Xr/vsp 0.46345f
C1391 Xd2/m1_596_3240# Xd2/a_680_3416# -0
C1392 r2_b3 r2_b1 0.1145f
C1393 vdd Xi1/m1_988_888# -0.13611f
C1394 vbn_ref r2_b0 0.04591f
C1395 Xr/vglp Xvi/a_4976_1528# 0.1709f
C1396 r2_b4 vbn_prb 0.48685f
C1397 i3_b2 Xg/a_1580_5314# 0.08808f
C1398 Xvi/a_864_6450# r2_b2 0
C1399 r0_b4 r1_b1 0.09085f
C1400 Xi3/a_4132_4392# i3_b4 0.00117f
C1401 i4_b2 Xg/a_7580_5314# 0.18457f
C1402 Xd0/a_1632_3416# Xd0/a_2224_3416# -0.00694f
C1403 Xr/vsn Xi3/a_4132_4392# 0.00151f
C1404 i3_b1 Xi2/m1_988_888# 0.10206f
C1405 Xg/a_4580_5314# Xi4/g -0
C1406 vdd Xm/a_420_700# -0.00894f
C1407 Xvi/a_4976_1528# vbn_prb -0
C1408 vbn_prb Xd2/a_1864_3416# 0
C1409 Xvi/a_864_6450# i4_b3 0.67477f
C1410 Xi3/a_3282_4392# Xi3/a_2228_4392# -0
C1411 i4_b4 Xi1/a_528_4392# 0
C1412 ib_r1 Xvi/m1_4894_1238# 0.10233f
C1413 Xd1/m1_756_3120# Xd1/a_1272_3416# -0
C1414 v0_c1 ua0_s1 0.2063f
C1415 r2_b3 Xd1/a_1272_3416# 0.00854f
C1416 r1_b0 Xi2/m1_988_2644# 0.0019f
C1417 Xvi/m1_8332_7080# vth_cmp 0
C1418 vth_ref Xr/vgln 0.7709f
C1419 i2_b0 ua0_stim_out 1.38201f
C1420 vbn_ref i4_b0 0.03883f
C1421 i4_b1 Xi4/a_2432_4170# 0.02051f
C1422 r2_b4 Xi2/m1_988_888# 0.00184f
C1423 Xd2/m1_756_2640# Xd2/m1_1663_4920# -0
C1424 ib_x2 v0_c1 0.70066f
C1425 Xvi/m1_1276_6360# Xvi/m1_4546_7560# -0.00679f
C1426 Xd0/m1_3662_4048# r2_b3 0
C1427 vbn_leak Xd0/a_3408_3416# 0.00173f
C1428 Xi0/a_4132_4392# i3_b4 0.02396f
C1429 Xd3/m1_2408_3600# ua0_stim_out 0.08631f
C1430 Xr/vsn Xi2/m1_988_3304# -0.00847f
C1431 vbn_leak Xi3/g 0.19525f
C1432 el Xd1/a_2456_3416# 0.00179f
C1433 Xr/vsn Xi0/a_4132_4392# 0.01174f
C1434 Xr/vgln Xi2/g 1.42901f
C1435 el r1_b4 0.08982f
C1436 Xr/vglp Xr/vsp 0.54543f
C1437 i4_b0 Xi0/g 0.03783f
C1438 r1_b0 r2_b2 0.03237f
C1439 i1_b2 i1_b3 0.0145f
C1440 Xd0/m1_382_4048# r2_b3 0.00468f
C1441 i3_b1 Xg/a_7580_5314# 0.0562f
C1442 Xr/vgln Xi2/a_732_4170# 0
C1443 v0_c1 bias_en 0.25163f
C1444 Xd2/m1_756_2640# r2_b0 0.30337f
C1445 r1_b2 r1_b1 0.09582f
C1446 ua0_stim_out Xm/a_736_5516# -0.00761f
C1447 Xg/a_3036_4156# Xr/vsp -0.01296f
C1448 r1_b3 vbn_leak 0.03477f
C1449 vbn_prb Xvi/m1_502_738# 0.04186f
C1450 Xr/vglp Xi0/m1_1500_4312# 0.00972f
C1451 Xi2/a_3282_4170# i2_b0 0
C1452 vdd i0_b0 0.10258f
C1453 r1_b3 i2_b0 0.06512f
C1454 Xi3/a_3928_4392# i3_b4 0.00173f
C1455 r0_b2 el 0
C1456 v0_c2 Xd3/m1_5422_4448# 0.08537f
C1457 Xr/vsn Xi3/a_3928_4392# 0
C1458 vbp_syn r2_b0 0.04664f
C1459 Xi1/g r1_b2 0
C1460 i0_b1 i1_b1 0.32535f
C1461 Xvi/a_2102_5152# i4_b1 0.00268f
C1462 ib_r1 Xr/m1_342_438# 0.09245f
C1463 r0_b0 r2_b0 0.04783f
C1464 Xd3/m1_822_4448# ua0_s0 0
C1465 i4_b4 Xm/in_n 0.03361f
C1466 Xm/iint Xr/m1_782_438# 0.00486f
C1467 Xr/vgln Xg/m1_3530_1930# -0.02235f
C1468 vdd ua0_s1 1.80303f
C1469 i3_b3 i4_b2 0.03906f
C1470 ib_r1 Xr/vglp 0.34952f
C1471 r2_b3 r1_b1 0
C1472 Xi3/m1_240_3480# i4_b0 0.00246f
C1473 i4_b1 i3_b0 0.04076f
C1474 i2_b1 ua0_stim_out 0.5876f
C1475 vdd Xi0/m1_240_3480# 0.19968f
C1476 Xd3/m1_1523_3480# Xr/en_b 0
C1477 vbp_st r0_b1 0.03899f
C1478 Xd2/m1_2382_2650# r2_b3 0.06032f
C1479 Xd1/m1_860_4046# r2_b3 0.00683f
C1480 vdd vreset_src 2.38836f
C1481 ua0_s0 Xm/a_1764_11418# 0.10303f
C1482 i3_b2 i4_b0 0.04123f
C1483 vdd ib_x2 0.68908f
C1484 Xd3/m1_1523_3480# ua0_stim_out 0.09477f
C1485 Xi2/m1_988_888# Xr/vsp 0.02319f
C1486 vreset_src Xvi/m1_942_738# 0
C1487 Xi0/m1_240_3480# Xi0/m1_988_888# -0.00944f
C1488 Xi0/a_2432_4392# i3_b4 0.0139f
C1489 vreset_src Xi0/m1_988_888# 0.02089f
C1490 Xr/vsn Xi0/a_2432_4392# 0.00582f
C1491 Xi0/m1_988_888# ib_x2 0.18262f
C1492 ib_r1 vbn_prb 0.14682f
C1493 r1_b0 Xd2/a_3048_3416# 0.012f
C1494 r1_b3 Xg/m1_3666_9610# 0.02679f
C1495 Xvi/m1_1276_6360# Xr/vgln 0.02743f
C1496 Xm/iint Xm/in_n 0.84794f
C1497 Xr/vgln Xi0/a_3078_4392# 0
C1498 vdd Xi1/m1_988_3464# -0.00719f
C1499 ua0_int Xm/a_736_5516# 0.06377f
C1500 Xr/m1_342_438# Xr/m1_1662_438# -0.00622f
C1501 vdd bias_en 1.07744f
C1502 Xr/vglp Xi0/a_1378_4392# 0.01148f
C1503 Xd3/m1_4982_4448# ua0_stim_out 0.01205f
C1504 Xvi/m1_942_738# bias_en 0.00345f
C1505 r0_b4 Xi2/m1_988_3304# 0.10263f
C1506 i4_b4 i2_b4 0.02888f
C1507 Xd2/m1_596_3240# r2_b0 0.11495f
C1508 Xr/en_b Xm/a_420_700# -0.00121f
C1509 Xi0/m1_988_888# bias_en 0.47034f
C1510 vbn_ax r2_b0 0.57848f
C1511 vdd el 1.29244f
C1512 Xi2/a_3282_4170# i2_b1 0
C1513 Xm/a_420_700# ua0_stim_out -0.0055f
C1514 Xi4/a_528_4170# vbn_prb 0
C1515 Xr/vsn Xi4/a_3078_4170# -0.00198f
C1516 Xm/in_n Xg/a_1580_5314# 0
C1517 Xm/a_2240_11218# ua0_s1 0.17103f
C1518 i4_b1 i4_b2 0.28266f
C1519 i4_b1 i2_b2 0.14283f
C1520 Xd3/m1_3222_4448# Xd3/m1_1702_4448# -0.01015f
C1521 r1_b3 i2_b1 0.04196f
C1522 Xd3/m1_382_4448# Xm/in_n 0.00402f
C1523 Xr/vglp r2_b2 0.1585f
C1524 i4_b4 i3_b4 0.04057f
C1525 i3_b3 i3_b1 0
C1526 vbp_st Xi2/m1_260_2080# 0.10852f
C1527 i4_b2 Xi4/a_2432_4170# 0
C1528 i4_b4 Xr/vsn 0.08578f
C1529 Xd0/m1_3310_2880# vbp_w 0.0559f
C1530 Xr/vglp Xg/a_5188_4156# 0.09977f
C1531 i1_b4 i3_b4 0.00918f
C1532 Xd3/m1_2408_3600# v0_c0 0.1341f
C1533 Xg/a_3036_4156# Xg/a_5188_4156# -0.00174f
C1534 i4_b4 i2_b3 0
C1535 Xvi/a_864_6450# Xvi/m1_8332_7080# -0.02196f
C1536 Xg/a_7580_5314# Xr/vsp -0.0111f
C1537 Xr/vglp i4_b3 0.23169f
C1538 vbp_st i0_b1 0.04964f
C1539 ua0_stim v0_c1 0.12302f
C1540 Xi2/g r1_b0 0.02545f
C1541 vbn_prb r2_b2 0.23692f
C1542 Xd2/m1_1342_4048# Xd2/a_1272_3416# -0
C1543 Xm/a_2240_11218# Xm/a_1744_9182# -0
C1544 Xd0/a_2224_3416# r1_b2 0.04389f
C1545 Xd3/m1_2408_3600# Xd3/a_2216_3816# -0.00452f
C1546 Xr/vgln Xi2/a_2432_4170# 0.06678f
C1547 vbn_ref vbp_w 0.16297f
C1548 i3_b3 r2_b4 0.03119f
C1549 Xi3/m1_240_3480# Xi3/m1_988_2804# -0.03118f
C1550 vbn_ax i4_b0 0.13962f
C1551 r1_b0 Xi2/a_732_4170# 0.02394f
C1552 Xd0/m1_956_3000# r1_b2 0
C1553 v0_c2 Xd3/a_3992_3816# 0.05156f
C1554 Xr/vsn Xm/iint 0.0078f
C1555 i0_b3 Xi1/m1_988_888# 0.04904f
C1556 Xvi/m1_1276_6360# Xvi/a_864_6450# -0.07821f
C1557 vdd Xvi/m1_5388_6960# 0.01751f
C1558 Xi0/a_2228_4392# i3_b4 0.01343f
C1559 vreset_src Xi4/a_4132_4170# 0.02234f
C1560 vbn_prb i4_b3 0
C1561 Xr/vsn Xi0/a_2228_4392# 0.00421f
C1562 i3_b4 Xg/a_1580_5314# 0.06478f
C1563 i4_b1 i3_b1 0.05801f
C1564 i0_b0 ua0_stim_out 0.06304f
C1565 Xr/vsn Xg/a_1580_5314# 0.0212f
C1566 v0_c4 Xd3/m1_3908_2760# -0
C1567 Xi4/g Xvi/m1_1382_738# 0.05991f
C1568 Xd0/m1_956_3000# Xd0/m1_1262_4048# -0.00196f
C1569 Xd3/m1_2408_3600# Xm/in_p 0.073f
C1570 ib_r1 Xvi/m1_7102_850# 0.11548f
C1571 Xm/a_420_700# ua0_int 0.06811f
C1572 vdd Xvi/m1_4546_7560# -0.00565f
C1573 r1_b0 Xd0/a_2816_3416# 0.04542f
C1574 Xi2/m1_988_888# r2_b2 0
C1575 Xd0/a_2224_3416# r2_b3 0.05028f
C1576 r2_b4 i4_b1 0.03341f
C1577 Xd1/a_1864_3416# vbp_w 0.05942f
C1578 Xr/en_b ua0_s1 0.08128f
C1579 Xd3/m1_822_4448# Xd3/m1_1262_4448# -0.04026f
C1580 Xr/vgln r1_b4 0.14423f
C1581 ua0_stim_out ua0_s1 0.38052f
C1582 Xd0/m1_956_3000# r2_b3 0.06557f
C1583 i4_b1 Xi3/m1_988_888# 0.00324f
C1584 vbn_prb Xd0/m1_822_4048# 0.04491f
C1585 vdd vth_cmp 1.06907f
C1586 vth_cmp Xvi/m1_942_738# 0.0518f
C1587 vth_ref Xr/m1_342_438# 0.04095f
C1588 i4_b1 Xg/m1_3298_2050# 0.02658f
C1589 i4_b2 i3_b0 0.04737f
C1590 v0_c1 v0_c3 0.0664f
C1591 Xi3/m1_988_3464# i4_b0 0.19815f
C1592 Xd3/m1_1523_3480# v0_c0 0.01948f
C1593 vbn_prb Xd2/a_3048_3416# 0.07659f
C1594 r2_b4 Xi4/a_2432_4170# 0.00238f
C1595 Xi3/a_2432_4392# i4_b0 0.01225f
C1596 vbp_st r2_b1 0.03207f
C1597 Xr/vglp vth_ref 0.26732f
C1598 Xvi/a_4976_1528# i4_b1 0.16801f
C1599 vdd ua0_stim 2.35022f
C1600 ib_x2 ua0_stim_out 0.05622f
C1601 Xi3/a_3078_4392# Xi3/a_3282_4392# -0
C1602 Xm/in_p Xg/m1_3666_9610# 0.02301f
C1603 Xd3/m1_1262_4448# ua0_s0 0
C1604 Xd3/m1_1523_3480# Xd3/a_2216_3816# -0
C1605 v0_c0 Xd3/m1_4982_4448# 0.10231f
C1606 vbn_ax Xi3/m1_988_2804# -0.00761f
C1607 Xr/vglp Xi2/g 0.44592f
C1608 Xr/en_b bias_en 0.07575f
C1609 r1_b2 Xd1/m1_2974_2650# 0
C1610 bias_en ua0_stim_out 0.16548f
C1611 Xg/a_7580_5314# r2_b2 0
C1612 i2_b4 r2_b0 0.03184f
C1613 Xg/a_4580_5314# Xg/a_1580_5314# -0
C1614 i3_b3 Xr/vsp 0.30264f
C1615 i4_b2 i2_b2 0.12344f
C1616 Xg/a_7580_5314# Xg/a_5188_4156# -0.00311f
C1617 Xg/a_3036_4156# Xi2/g 0
C1618 vbp_syn vbp_w 0.52345f
C1619 r0_b0 vbp_w 0
C1620 Xd1/m1_462_4048# r2_b0 0.05631f
C1621 vdd Xi4/a_3282_4170# 0.00142f
C1622 Xd1/a_3048_3416# r1_b2 0.05966f
C1623 Xd3/m1_1523_3480# Xm/in_p 0.00522f
C1624 Xr/vsn r2_b0 0.13468f
C1625 Xg/m1_6020_10200# Xg/m1_4906_9490# -0.00176f
C1626 Xi1/m1_988_888# Xm/in_p 0.02772f
C1627 i4_b3 Xvi/m1_7102_850# 0
C1628 el Xi3/g 0.53089f
C1629 Xd0/m1_3310_2880# vbn_leak 0.00207f
C1630 Xr/vsp Xi0/a_3928_4392# 0
C1631 i3_b1 i3_b0 0.83707f
C1632 i2_b3 r2_b0 0.04112f
C1633 i4_b1 Xvi/m1_502_738# 0
C1634 ua0_stim Xm/a_2240_11218# 0.26195f
C1635 Xd0/m1_2242_4966# Xd0/a_2224_3416# -0.0131f
C1636 ua0_int ua0_s1 0.81873f
C1637 Xd3/m1_4982_4448# Xm/in_p 0.011f
C1638 ua0_s0 Xd3/a_4584_3816# 0.10891f
C1639 Xd1/m1_2974_2650# r2_b3 0.04671f
C1640 r1_b0 Xi2/a_2432_4170# 0.02032f
C1641 Xd0/m1_956_3000# Xd0/m1_2242_4966# -0
C1642 i4_b0 i2_b4 0.03779f
C1643 vdd Xr/vgln 3.05915f
C1644 Xr/vgln Xvi/m1_942_738# 0.01767f
C1645 r1_b3 el 0.14076f
C1646 Xi0/a_3282_4392# i3_b4 0.04925f
C1647 vdd v0_c3 1.2084f
C1648 i4_b1 Xr/vsp 0.21766f
C1649 Xr/vglp Xg/m1_3530_1930# 0.00128f
C1650 Xi2/a_3928_4170# i2_b2 0.0033f
C1651 vbn_ref vbn_leak 0.49954f
C1652 r2_b4 i3_b0 0.03637f
C1653 r2_b3 Xd2/a_680_3416# 0
C1654 Xi4/m1_988_888# Xi4/m1_260_2080# 0
C1655 Xi3/a_2432_4392# Xi3/m1_988_2804# -0
C1656 Xi3/m1_988_3464# Xi3/m1_988_2804# -0.01753f
C1657 Xr/vsn Xi0/a_3282_4392# 0.00422f
C1658 ib_x2 Xvi/a_5712_1328# 0.0375f
C1659 Xvi/a_4976_1528# Xvi/a_2102_5152# -0.00936f
C1660 vreset_src Xvi/a_5712_1328# 0.00272f
C1661 i4_b0 i3_b4 0.09362f
C1662 i3_b1 i4_b2 0.06476f
C1663 vbp_st Xi2/m1_1500_3762# 0
C1664 vbn_ref i2_b0 0.12605f
C1665 Xd1/a_3048_3416# r2_b3 0.01549f
C1666 Xr/vsn i4_b0 0.09685f
C1667 Xi2/g Xi2/m1_988_888# 0.01879f
C1668 Xd3/m1_2408_3600# Xd3/a_2808_3816# -0
C1669 i2_b2 Xg/m1_5022_10210# 0
C1670 Xi1/g Xg/m1_4906_9490# -0
C1671 vreset_src Xi4/m1_988_2644# 0.00664f
C1672 vbn_prb Xd0/a_2816_3416# 0
C1673 vbn_ax vbp_w 0.81166f
C1674 Xi1/m1_988_888# Xi1/m1_240_3480# -0.01051f
C1675 ua0_int Xm/a_1744_9182# -0
C1676 Xi1/g i0_b1 0.76283f
C1677 i2_b3 i4_b0 0.05438f
C1678 bias_en ua0_int 0.1728f
C1679 Xg/m1_5516_1920# Xm/in_n 0.0409f
C1680 vbn_leak Xi0/g 0.09148f
C1681 bias_en Xvi/a_5712_1328# 0.10519f
C1682 r1_b2 Xd1/m1_2372_2520# 0
C1683 Xd1/a_2456_3416# r1_b0 0.06484f
C1684 Xm/iint Xr/m1_3422_438# 0.03956f
C1685 Xi1/g Xi0/a_528_4392# 0
C1686 Xi3/m1_1500_4312# i4_b0 0.09953f
C1687 Xvi/m1_1276_6360# Xr/vglp 0.14968f
C1688 Xr/vglp Xi0/a_3078_4392# 0.02418f
C1689 r1_b0 r1_b4 0.01443f
C1690 r2_b4 i4_b2 0.07823f
C1691 i3_b3 Xi0/a_1378_4392# 0.0256f
C1692 v0_c0 ua0_s1 0.09788f
C1693 r2_b4 i2_b2 0.17461f
C1694 vbp_st r1_b1 0.03639f
C1695 i4_b2 Xi3/m1_988_888# 0.08807f
C1696 Xi1/m1_988_2804# Xi1/m1_988_3464# -0.01416f
C1697 i3_b3 r2_b2 0.03348f
C1698 Xi4/a_4132_4170# Xi4/a_3282_4170# -0
C1699 i0_b0 Xm/in_p 0.04049f
C1700 vdd Xvi/a_864_6450# 0.48308f
C1701 Xm/a_736_7228# Xm/a_1764_11418# -0.00596f
C1702 r0_b2 r1_b0 0.07287f
C1703 i3_b3 Xg/a_5188_4156# 0.12331f
C1704 Xd3/a_2216_3816# ua0_s1 0.05429f
C1705 r0_b4 r2_b0 1.57625f
C1706 Xi2/a_4132_4170# i2_b4 0
C1707 r0_b1 Xd0/a_2224_3416# 0.047f
C1708 Xr/en_b ua0_stim 0.76704f
C1709 ib_x2 v0_c0 0.06624f
C1710 i0_b4 vbp_st 0.04739f
C1711 ua0_stim ua0_stim_out -0.09574f
C1712 ua0_s0 Xm/a_736_7228# 0.52806f
C1713 Xg/a_7580_5314# Xi2/g -0.00929f
C1714 vbp_st Xi1/g 0.66825f
C1715 r1_b1 r2_b1 0.05359f
C1716 ib_r1 Xvi/m1_7440_2050# 0.08764f
C1717 Xd1/m1_756_3120# Xd1/m1_2372_2520# -0
C1718 Xd1/m1_2372_2520# r2_b3 0.05025f
C1719 i3_b3 i4_b3 0.04203f
C1720 v0_c0 bias_en 0.21432f
C1721 Xr/vsn Xi4/m1_260_2080# -0.00236f
C1722 Xr/vgln Xi4/a_4132_4170# -0
C1723 Xg/m1_5516_1920# Xr/vsn 0.01328f
C1724 Xd3/m1_2720_2760# Xd3/a_1624_3816# -0
C1725 i3_b2 vbn_leak 0.04206f
C1726 r2_b4 Xi2/a_3928_4170# 0
C1727 Xd0/a_1632_3416# Xd0/m1_2742_3250# -0.0017f
C1728 r1_b0 r0_b3 0.04799f
C1729 vbn_ref i2_b1 1.56093f
C1730 Xi2/a_4132_4170# i2_b3 0.00152f
C1731 Xd3/m1_1523_3480# Xd3/a_2808_3816# -0
C1732 Xi1/g r2_b1 0.03386f
C1733 i3_b0 Xr/vsp 0.25374f
C1734 i4_b1 r2_b2 0.034f
C1735 r2_b4 i3_b1 0.04222f
C1736 Xd3/a_2216_3816# bias_en 0
C1737 vbp_syn vbn_leak 0.31869f
C1738 Xi1/m1_240_3480# i0_b0 0.00222f
C1739 v0_c1 Xd3/m1_5422_4448# 0.03904f
C1740 r0_b0 vbn_leak 0.04216f
C1741 Xi4/g r2_b1 0.9999f
C1742 i4_b1 Xg/a_5188_4156# 0.173f
C1743 r0_b4 i4_b0 0.00578f
C1744 ib_x2 Xm/in_p 0.06699f
C1745 Xd1/m1_1780_5040# Xd1/a_1864_3416# -0.00328f
C1746 Xi3/m1_1500_4312# Xi3/m1_988_2804# -0.00171f
C1747 vbp_syn i2_b0 0.18174f
C1748 i2_b1 Xi0/g 0.00182f
C1749 Xvi/m1_4546_7560# Xvi/a_5712_1328# -0
C1750 r0_b0 i2_b0 0.01382f
C1751 Xi2/a_3078_4170# i2_b4 0.00407f
C1752 i4_b1 i4_b3 0.20109f
C1753 Xm/in_p Xi1/m1_988_3464# 0.05063f
C1754 ua0_s0 v0_c2 0.06892f
C1755 r1_b2 r2_b0 0.06232f
C1756 ib_r1 Xvi/a_2102_5152# 0.0624f
C1757 bias_en Xm/in_p 0.44878f
C1758 vdd r1_b0 2.72098f
C1759 i2_b2 Xr/vsp 0.28998f
C1760 i4_b2 Xr/vsp 0.89493f
C1761 vth_cmp Xvi/a_5712_1328# 0.06506f
C1762 Xr/vglp r1_b4 0.31801f
C1763 Xi1/a_4132_4392# i1_b4 0
C1764 Xr/vgln ua0_stim_out 0.01935f
C1765 v0_c3 ua0_stim_out 0
C1766 Xd2/a_1272_3416# Xd2/a_680_3416# -0.02076f
C1767 r2_b4 Xi3/m1_988_888# 0.05793f
C1768 Xd2/m1_902_4048# Xd2/m1_1663_4920# -0.00161f
C1769 vth_cmp Xi4/m1_988_2644# 0
C1770 Xd2/m1_1663_4920# r2_b3 0.06333f
C1771 Xi4/a_2432_4170# i4_b3 0
C1772 Xm/iint Xi0/m1_988_2804# 0
C1773 i2_b3 Xi2/a_3078_4170# 0
C1774 Xd0/a_1632_3416# vbp_w 0.06159f
C1775 ua0_stim ua0_int 0.67168f
C1776 Xg/a_3036_4156# r1_b4 0.15892f
C1777 vbn_prb Xd1/a_2456_3416# 0
C1778 Xd0/m1_1262_4048# r2_b0 0.05427f
C1779 vdd i0_b2 0.77026f
C1780 Xvi/a_4976_1528# r2_b4 0
C1781 Xr/vgln Xi3/g 1.1522f
C1782 r1_b1 Xg/m1_3898_9610# 0
C1783 Xi1/m1_1500_4312# Xi1/m1_988_3464# -0
C1784 Xd2/m1_2964_2640# Xd2/m1_756_2640# -0
C1785 vbn_ax vbn_leak 0.07828f
C1786 Xd2/m1_902_4048# r2_b0 0.00138f
C1787 Xd1/m1_756_3120# r2_b0 0.00992f
C1788 Xi2/a_3282_4170# Xr/vgln 0.00558f
C1789 r2_b3 r2_b0 0.31099f
C1790 Xr/vsn Xi4/a_3928_4170# 0
C1791 r1_b3 Xr/vgln 0.1532f
C1792 i3_b3 Xi2/g 0.16058f
C1793 Xi2/a_4132_4170# r0_b4 0
C1794 vbn_ref i0_b0 0.04521f
C1795 vbp_st Xi2/m1_988_3304# 0
C1796 i3_b1 Xr/vsp 0.12159f
C1797 vbp_syn i2_b1 0.06221f
C1798 Xg/m1_5022_10210# Xr/vsp 0.01548f
C1799 Xi3/a_1582_4392# i4_b0 0
C1800 i3_b0 r2_b2 0.0357f
C1801 r0_b0 i2_b1 0.0085f
C1802 vth_ref i4_b1 0.00238f
C1803 Xvi/a_2102_5152# i4_b3 0.17691f
C1804 ua0_stim v0_c0 0.31122f
C1805 Xi2/m1_988_888# r1_b4 0.10973f
C1806 Xd3/m1_3222_4448# ua0_s0 0.06039f
C1807 i3_b0 Xg/a_5188_4156# 0.06476f
C1808 i0_b0 Xi0/g 0.0552f
C1809 Xr/vgln Xvi/a_5712_1328# 0.47806f
C1810 vdd Xr/m1_342_438# -0.02273f
C1811 v0_c3 ua0_int 0.04546f
C1812 i0_b3 Xr/vgln 0.3094f
C1813 Xvi/a_864_6450# Xi3/g 0.01943f
C1814 Xm/iint Xr/m1_2542_438# 0.04702f
C1815 i4_b1 Xi2/g 0.51766f
C1816 Xd3/a_2808_3816# ua0_s1 0.08883f
C1817 v0_c1 Xd3/a_3992_3816# 0.04106f
C1818 r2_b4 Xr/vsp 0.43578f
C1819 Xi1/a_3928_4392# i1_b4 0
C1820 i3_b0 i4_b3 0.05105f
C1821 Xi1/g r1_b1 0.0044f
C1822 r1_b4 Xd0/a_1040_3416# 0
C1823 Xr/vsp Xi3/m1_988_888# 0.30302f
C1824 vdd Xr/vglp 1.50674f
C1825 r0_b4 Xi2/a_3078_4170# 0.12563f
C1826 Xi4/g r1_b1 0
C1827 Xr/vglp Xi0/m1_988_888# 0.007f
C1828 i4_b2 r2_b2 0.49868f
C1829 vdd Xg/a_3036_4156# -0.0093f
C1830 i2_b2 r2_b2 0.03286f
C1831 Xd0/m1_3310_2880# el 0.00486f
C1832 i0_b4 Xi1/g 0.00392f
C1833 i4_b2 Xg/a_5188_4156# 0.04752f
C1834 Xr/vgln Xi1/m1_988_2804# 0.27469f
C1835 vbn_leak Xm/in_n 0.0019f
C1836 Xd1/m1_606_2410# r2_b0 0.00231f
C1837 r0_b2 Xd0/a_1040_3416# 0
C1838 vdd vbn_prb 0.84708f
C1839 vbn_prb Xvi/m1_942_738# 0.00429f
C1840 i4_b2 i4_b3 0.00825f
C1841 Xi0/m1_240_3480# Xi0/g -0.02453f
C1842 Xd0/m1_2242_4966# r2_b0 0.00919f
C1843 Xd3/a_2808_3816# bias_en 0
C1844 Xi2/a_1582_4170# i2_b0 0
C1845 i2_b2 i4_b3 0
C1846 vreset_src Xi0/g 0.35424f
C1847 ib_x2 Xi0/g 0.82107f
C1848 Xg/a_7580_5314# r1_b4 0.07851f
C1849 i3_b3 Xi0/a_3078_4392# 0.0174f
C1850 vbn_ref el 0.78767f
C1851 r1_b0 ua0_stim_out 0.03561f
C1852 r0_b4 vbp_w 0
C1853 i4_b4 Xi0/a_528_4392# 0
C1854 i3_b0 i1_b0 0.13008f
C1855 v0_c0 v0_c3 0.08966f
C1856 i3_b2 i0_b0 0.04513f
C1857 Xd2/m1_1663_4920# Xd2/a_1272_3416# -0
C1858 i4_b1 Xg/m1_3530_1930# 0.17991f
C1859 Xvi/a_864_6450# Xvi/a_5712_1328# -0.00407f
C1860 bias_en Xi0/g 0.4693f
C1861 r1_b2 Xd0/m1_2742_3250# 0
C1862 Xi3/a_1582_4392# Xi3/m1_988_2804# -0
C1863 Xi3/a_1378_4392# i4_b0 0.00305f
C1864 Xd3/a_1624_3816# v0_c1 -0.04314f
C1865 r1_b0 Xd0/a_3408_3416# 0.06867f
C1866 bias_en Xd3/m1_4102_4448# 0.04426f
C1867 Xd3/m1_2720_2760# ua0_s0 0.1003f
C1868 r1_b0 Xi3/g 0.01133f
C1869 ib_r1 Xvi/a_4976_1528# 0.05839f
C1870 r2_b3 Xi4/m1_260_2080# 0.00645f
C1871 r2_b4 Xi4/a_528_4170# 0.00754f
C1872 Xi0/a_3078_4392# Xi0/a_3928_4392# -0
C1873 vdd Xi2/m1_988_888# -0
C1874 i0_b2 ua0_stim_out 0.17437f
C1875 i3_b1 r2_b2 0.04946f
C1876 Xd0/a_1632_3416# Xd0/m1_617_3840# -0.00168f
C1877 Xi3/a_2228_4392# i4_b0 0.00384f
C1878 Xi3/a_4132_4392# r1_b1 0
C1879 i3_b1 Xg/a_5188_4156# 0.06832f
C1880 vdd Xd3/a_3992_3816# -0.00441f
C1881 Xi2/a_3282_4170# r1_b0 0.07238f
C1882 Xg/m1_5022_10210# Xg/a_5188_4156# -0
C1883 Xd2/a_1272_3416# r2_b0 0.07527f
C1884 i2_b0 i2_b4 0.01616f
C1885 i4_b4 vbp_st 0.03868f
C1886 Xvi/m1_1276_6360# i4_b1 0.39539f
C1887 vbn_leak i3_b4 0.03306f
C1888 v0_c2 Xd3/a_4584_3816# 0.06018f
C1889 r1_b3 r1_b0 0.18428f
C1890 Xr/vsn vbn_leak 0.39185f
C1891 Xr/vgln Xm/in_p 0.1049f
C1892 i3_b1 i4_b3 0.03765f
C1893 vdd Xd0/a_1040_3416# 0.05518f
C1894 Xd3/m1_1702_4448# ua0_stim_out 0.00616f
C1895 Xr/vsp Xi0/m1_1500_4312# -0.00262f
C1896 r2_b3 Xd0/m1_2742_3250# 0.074f
C1897 i3_b0 Xi2/g 0.37362f
C1898 r2_b4 r2_b2 1.65582f
C1899 Xd3/m1_5422_4448# ua0_stim_out 0.01367f
C1900 Xd1/m1_2974_2650# Xd1/a_1272_3416# -0
C1901 r1_b2 vbp_w 0.21733f
C1902 r2_b2 Xi3/m1_988_888# 0.00169f
C1903 Xi0/a_732_4392# vbn_leak 0
C1904 i2_b3 i2_b0 0.19506f
C1905 r0_b1 r2_b0 0.05134f
C1906 i4_b4 r2_b1 0.07047f
C1907 Xd0/m1_3310_2880# vth_cmp 0.00867f
C1908 i3_b2 Xi1/m1_988_3464# 0
C1909 Xi2/a_1582_4170# i2_b1 0
C1910 el Xi3/m1_240_3480# 0.00183f
C1911 vbp_st Xm/iint 0.04826f
C1912 Xi1/m1_1500_4312# Xr/vgln 0.10982f
C1913 Xd2/m1_1663_4920# Xd2/a_2456_3416# -0
C1914 Xvi/a_4976_1528# r2_b2 0.00166f
C1915 r2_b4 i4_b3 0.04496f
C1916 vdd Xg/a_7580_5314# -0.08472f
C1917 vdd Xvi/m1_7102_850# -0.00353f
C1918 Xd0/m1_1262_4048# vbp_w 0
C1919 Xr/en_b Xr/m1_342_438# -0.00464f
C1920 Xi1/a_528_4392# i0_b0 0
C1921 i4_b2 Xi2/g 0.05599f
C1922 ib_r1 Xr/vsp 0.08302f
C1923 vdd Xd3/a_1624_3816# 0.07586f
C1924 vbp_st Xg/a_1580_5314# 0.14281f
C1925 Xvi/m1_4894_1238# Xvi/a_5712_1328# -0
C1926 Xr/vgln Xg/m1_4538_1930# 0.02697f
C1927 Xr/en_b Xr/vglp -0.00127f
C1928 vbn_ref vth_cmp 0.25173f
C1929 Xi1/m1_240_3480# Xr/vgln 0.02725f
C1930 el vbp_syn 0.11687f
C1931 i2_b4 Xg/m1_3666_9610# 0
C1932 i1_b4 i1_b3 0.00624f
C1933 i3_b1 i1_b0 0.05306f
C1934 Xd3/m1_382_4448# vbp_st 0.06284f
C1935 Xvi/a_4976_1528# i4_b3 0.04676f
C1936 r0_b0 el 0.02953f
C1937 i0_b3 i0_b2 0.03522f
C1938 Xd2/a_2456_3416# r2_b0 0
C1939 Xd1/m1_756_3120# vbp_w 0.00607f
C1940 r2_b3 vbp_w 0.89093f
C1941 Xi3/a_3928_4392# r1_b1 0.00238f
C1942 ua0_stim Xd3/a_2808_3816# 0
C1943 Xi2/m1_260_2080# r2_b0 0.04661f
C1944 Xi3/a_2228_4392# Xi3/m1_988_2804# -0
C1945 Xi2/m1_988_2644# Xr/vsp 0
C1946 Xg/a_4580_5314# vbn_leak 0.09483f
C1947 i2_b1 i2_b4 0
C1948 Xr/vglp Xi3/g 0.79573f
C1949 r2_b1 Xg/a_1580_5314# 0.10509f
C1950 Xvi/m1_1276_6360# Xvi/a_2102_5152# -0
C1951 Xd2/m1_2964_2640# Xd1/m1_462_4048# 0.03886f
C1952 Xg/a_3036_4156# Xi3/g 0.00122f
C1953 r2_b4 Xd2/a_3048_3416# 0.002f
C1954 i0_b2 Xi1/m1_988_2804# 0.00464f
C1955 Xvi/m1_502_738# r2_b2 0
C1956 r0_b4 vbn_leak 0.07902f
C1957 Xd0/m1_2242_4966# Xd0/m1_2742_3250# -0.00407f
C1958 vbn_prb Xd0/a_3408_3416# 0.00108f
C1959 Xr/vglp r1_b3 0.51801f
C1960 Xd1/m1_2372_2520# Xd1/a_1272_3416# -0
C1961 i3_b1 Xi2/g 0.21323f
C1962 r2_b2 Xr/vsp 0.33021f
C1963 i2_b3 i2_b1 0.02567f
C1964 r0_b4 i2_b0 0.14599f
C1965 Xr/vsp Xg/a_5188_4156# 0
C1966 el vbn_ax 0.00305f
C1967 i4_b3 Xvi/m1_502_738# 0
C1968 i4_b0 Xg/m1_4906_9490# 0.02383f
C1969 i4_b3 Xr/vsp 0.12838f
C1970 vth_cmp Xd2/m1_756_2640# 0.17567f
C1971 vbp_st r2_b0 0.89447f
C1972 r2_b4 Xi2/g 0.07611f
C1973 vbn_ref Xr/vgln 0.06588f
C1974 Xr/vglp Xvi/a_5712_1328# 0.04345f
C1975 i0_b3 Xr/vglp 0.00127f
C1976 Xd3/a_2808_3816# v0_c3 0.01786f
C1977 r1_b0 Xm/in_p 0.4843f
C1978 ib_r1 Xr/m1_1662_438# 0.01672f
C1979 Xi2/g Xi3/m1_988_888# 0.00359f
C1980 Xd1/m1_606_2410# vbp_w 0.00216f
C1981 vdd i3_b3 1.4469f
C1982 Xd0/m1_2242_4966# vbp_w 0.27302f
C1983 Xg/m1_3298_2050# Xi2/g 0.04438f
C1984 v0_c0 Xd3/m1_5422_4448# 0.18385f
C1985 Xd3/m1_4078_3250# ua0_s1 0.00743f
C1986 vth_cmp vbp_syn 0.05328f
C1987 Xr/vgln Xi0/g 0.05364f
C1988 r2_b1 r2_b0 0.38928f
C1989 vreset_src Xi4/m1_988_888# 0.01389f
C1990 Xi3/a_3282_4392# i4_b0 0.0403f
C1991 i0_b2 Xm/in_p 0.06911f
C1992 vdd Xi2/a_2228_4170# 0
C1993 vbn_prb Xvi/a_5712_1328# -0.00408f
C1994 Xr/m1_782_438# bias_en 0
C1995 vbn_leak r1_b2 0.03894f
C1996 r1_b2 Xd0/m1_617_3840# 0
C1997 vdd Xi0/a_3928_4392# 0.01735f
C1998 r1_b3 Xi2/m1_988_888# 0
C1999 ua0_s0 v0_c1 0.19694f
C2000 i0_b0 i2_b4 0
C2001 Xi4/g Xi4/a_3078_4170# -0.00783f
C2002 vbn_prb Xi4/m1_988_2644# 0.1379f
C2003 vdd Xi0/m1_988_3464# 0.00172f
C2004 ib_r1 i4_b3 0
C2005 Xi0/m1_240_3480# Xm/in_n 0.16247f
C2006 i4_b4 Xi1/g 0.05069f
C2007 i2_b0 r1_b2 0.60215f
C2008 i0_b4 i1_b4 0.11538f
C2009 ib_x2 Xm/in_n 0.34873f
C2010 vbp_st i4_b0 0.03584f
C2011 i4_b4 Xi4/g 0.08485f
C2012 i0_b0 i3_b4 0
C2013 Xr/en_b Xd3/a_1624_3816# 0.00351f
C2014 Xd3/m1_1702_4448# Xm/in_p 0.05724f
C2015 i2_b2 Xi2/a_2432_4170# 0
C2016 Xd0/m1_1262_4048# Xd0/m1_617_3840# -0.00649f
C2017 Xd3/a_1624_3816# ua0_stim_out 0.08804f
C2018 Xi1/m1_1500_4312# i0_b2 0
C2019 Xd3/m1_4078_3250# bias_en 0.05495f
C2020 vdd i4_b1 2.09214f
C2021 r0_b4 i2_b1 0.04432f
C2022 i4_b1 Xvi/m1_942_738# 0
C2023 Xd3/m1_5422_4448# Xm/in_p 0.0015f
C2024 Xm/in_n bias_en 0.85797f
C2025 Xg/a_7580_5314# Xi3/g 0.0323f
C2026 r1_b1 Xg/a_1580_5314# 0
C2027 i0_b0 i2_b3 0.00194f
C2028 Xd2/m1_1342_4048# Xd2/m1_1663_4920# -0.00126f
C2029 i3_b0 r1_b4 0.02816f
C2030 Xi1/a_1582_4392# Xr/vgln 0.00433f
C2031 i4_b0 r2_b1 0.05727f
C2032 vdd Xi4/a_2432_4170# -0
C2033 vth_ref Xr/vsp 0.67668f
C2034 Xd3/a_3992_3816# ua0_int 0
C2035 Xd1/a_680_3416# vbp_w 0.00161f
C2036 vbn_leak r2_b3 0.0644f
C2037 Xi1/m1_240_3480# i0_b2 0.14054f
C2038 vth_cmp vbn_ax 0.0149f
C2039 vth_cmp Xd2/m1_596_3240# 0.10582f
C2040 Xi3/m1_240_3480# Xr/vgln 0.08075f
C2041 r2_b3 Xd0/m1_617_3840# 0.0783f
C2042 i2_b0 r2_b3 0.04922f
C2043 Xd0/m1_3662_4048# r2_b0 0.10111f
C2044 Xi1/g Xi0/a_2228_4392# 0
C2045 Xd3/m1_3222_4448# v0_c2 -0.00549f
C2046 vdd Xi2/a_528_4170# 0.01853f
C2047 Xi2/g Xr/vsp 0.28718f
C2048 Xi1/g Xg/a_1580_5314# -0.01334f
C2049 i3_b2 Xr/vgln 0.29988f
C2050 r0_b1 vbp_w 0
C2051 Xd2/m1_1342_4048# r2_b0 0.01581f
C2052 i4_b3 r2_b2 0.05104f
C2053 Xi0/m1_240_3480# i3_b4 0
C2054 i2_b2 r1_b4 0.06101f
C2055 Xd0/m1_382_4048# r2_b0 0.04529f
C2056 vdd Xm/a_1764_11418# 0
C2057 Xd3/m1_3908_2760# ua0_s1 0.00512f
C2058 i4_b2 r1_b4 0.17015f
C2059 vbp_syn Xr/vgln 0.1276f
C2060 Xr/vglp Xm/in_p 0.4643f
C2061 vreset_src Xr/vsn 0.04487f
C2062 vreset_src Xd1/m1_462_4048# 0.03273f
C2063 ib_x2 i3_b4 0.01241f
C2064 Xi3/a_3078_4392# i4_b0 0.06064f
C2065 Xi0/m1_240_3480# Xr/vsn 0.04246f
C2066 r0_b0 Xr/vgln 0.00765f
C2067 Xd0/a_1632_3416# el 0
C2068 Xd0/m1_3310_2880# r1_b0 0.06483f
C2069 Xr/vsn ib_x2 0.81531f
C2070 Xi2/m1_1500_3762# r2_b0 0.07463f
C2071 Xg/a_3036_4156# Xm/in_p 0.01169f
C2072 Xvi/m1_1276_6360# Xvi/a_4976_1528# -0.01602f
C2073 vdd ua0_s0 0.83609f
C2074 ib_r1 vth_ref 0.28907f
C2075 i2_b1 r1_b2 0.21122f
C2076 Xvi/m1_7102_850# Xvi/a_5712_1328# -0.0348f
C2077 Xr/vsn bias_en 0.00185f
C2078 v0_c0 Xd3/a_3992_3816# 0.00183f
C2079 vbn_ref r1_b0 0.03642f
C2080 Xr/vsn el 0.1635f
C2081 Xd2/m1_2382_2650# Xd2/m1_1663_4920# -0
C2082 vdd Xvi/a_2102_5152# -0.02147f
C2083 Xd1/m1_1780_5040# r2_b3 0.05537f
C2084 Xd3/m1_3908_2760# bias_en 0.06151f
C2085 i4_b1 Xi4/a_4132_4170# 0.01153f
C2086 Xi4/m1_260_2080# r2_b1 0.03987f
C2087 Xi4/m1_988_888# vth_cmp 0.23424f
C2088 Xi2/a_3928_4170# r1_b4 0
C2089 Xi1/a_1378_4392# Xr/vgln 0.00313f
C2090 r1_b1 r2_b0 0.07042f
C2091 Xd2/m1_2964_2640# r2_b3 0.10096f
C2092 Xr/vglp Xg/m1_4538_1930# 0
C2093 Xi1/m1_988_888# Xi0/a_1582_4392# 0
C2094 i3_b3 ua0_stim_out 0.04562f
C2095 Xm/iint Xm/a_1744_10100# 0.0056f
C2096 i4_b0 Xg/m1_3898_9610# 0.00178f
C2097 vdd i3_b0 0.90715f
C2098 vbn_ref i0_b2 0.00619f
C2099 Xi2/g Xi2/m1_988_2644# -0.10894f
C2100 Xd2/m1_2382_2650# r2_b0 0.29594f
C2101 Xd1/m1_860_4046# r2_b0 0.05192f
C2102 Xd0/m1_2242_4966# Xd0/m1_617_3840# -0.04488f
C2103 vbn_ax Xr/vgln 0.06884f
C2104 Xg/m1_5022_10210# r1_b4 0.0189f
C2105 ua0_s0 Xm/a_2240_11218# 0.0223f
C2106 Xd3/m1_2720_2760# v0_c2 -0.00586f
C2107 vbp_st Xi2/a_3078_4170# 0
C2108 i2_b1 r2_b3 0.22075f
C2109 i3_b3 Xi3/g 0.08723f
C2110 Xg/m1_6020_10200# i4_b0 0.08469f
C2111 Xi0/a_3078_4392# Xr/vsp 0
C2112 Xd3/m1_4078_3250# ua0_stim 0
C2113 r1_b0 Xd1/a_1864_3416# 0.04977f
C2114 Xd3/a_1624_3816# v0_c0 0.10337f
C2115 r2_b4 r1_b4 0.04519f
C2116 vdd i4_b2 1.63501f
C2117 vdd i2_b2 1.13521f
C2118 i3_b3 r1_b3 0.3899f
C2119 Xi2/g r2_b2 0.08495f
C2120 i4_b1 ua0_stim_out 0.04905f
C2121 vth_ref i4_b3 0.07537f
C2122 i4_b0 r1_b1 0.79957f
C2123 ib_r1 Xvi/m1_8332_7080# 0.01645f
C2124 Xi2/g Xg/a_5188_4156# -0.07602f
C2125 vbp_st vbp_w 0.39336f
C2126 ua0 Xm/a_420_700# 0.02032f
C2127 Xd3/a_2216_3816# Xd3/a_1624_3816# -0.01923f
C2128 Xr/vsn Xvi/m1_4546_7560# 0
C2129 Xi2/g i4_b3 0.18118f
C2130 Xd3/m1_822_4448# Xr/en_b 0.00713f
C2131 i4_b1 Xi3/g 0.46348f
C2132 Xi3/m1_988_3464# Xr/vgln 0.00272f
C2133 Xd3/m1_822_4448# ua0_stim_out 0.00641f
C2134 v0_c1 Xd3/a_4584_3816# 0.04351f
C2135 Xi1/g i4_b0 0.09745f
C2136 Xi3/a_2432_4392# Xr/vgln 0.07194f
C2137 Xg/a_7580_5314# Xm/in_p 0.0038f
C2138 Xm/iint Xvi/m1_8646_1098# 0
C2139 Xr/vsn vth_cmp 0.602f
C2140 vth_cmp Xd1/m1_462_4048# 0.10776f
C2141 Xd0/m1_3310_2880# vbn_prb 0.07922f
C2142 Xi4/g i4_b0 0.00295f
C2143 i0_b3 i3_b3 0.3129f
C2144 Xr/vglp vbn_ref 0.0037f
C2145 Xd3/a_1624_3816# Xm/in_p 0
C2146 vbp_syn r1_b0 0.07452f
C2147 r0_b0 r1_b0 0.04973f
C2148 Xr/en_b Xm/a_1764_11418# 0
C2149 r0_b1 vbn_leak 0.03889f
C2150 ua0_stim_out Xm/a_1764_11418# -0.01374f
C2151 Xi3/a_732_4392# Xr/vgln 0
C2152 r0_b1 i2_b0 0.00145f
C2153 Xd3/m1_2720_2760# Xd3/m1_3222_4448# -0.06083f
C2154 Xi2/a_1582_4170# Xr/vgln 0.00982f
C2155 i3_b2 i0_b2 0.06077f
C2156 Xr/vgln Xm/in_n 0.66679f
C2157 Xr/en_b ua0_s0 0.19336f
C2158 vdd Xg/m1_5022_10210# -0.0196f
C2159 vdd i3_b1 0.30494f
C2160 i0_b3 Xi0/a_3928_4392# 0.00135f
C2161 ua0_s0 ua0_stim_out 0.33949f
C2162 Xr/vglp Xi0/g 0.04067f
C2163 vbn_ref vbn_prb 0.07428f
C2164 i3_b3 Xi1/m1_988_2804# 0
C2165 Xg/a_3036_4156# Xi0/g -0
C2166 i4_b4 Xi4/a_3078_4170# 0.00903f
C2167 Xd1/a_1272_3416# vbp_w 0.02032f
C2168 vreset_src Xi4/a_2228_4170# 0.07756f
C2169 vdd r2_b4 1.17623f
C2170 Xvi/m1_8332_7080# i4_b3 0.14852f
C2171 Xi3/m1_988_2804# r1_b1 0.17061f
C2172 vbn_leak Xi2/m1_260_2080# 0.01446f
C2173 r1_b4 Xr/vsp 0.66985f
C2174 i3_b3 v0_c0 0
C2175 Xd0/m1_956_3000# r2_b0 0.00255f
C2176 vdd Xi3/m1_988_888# -0.03421f
C2177 Xd0/m1_3662_4048# vbp_w 0.00921f
C2178 bias_en Xr/m1_3422_438# 0.00105f
C2179 el r1_b2 0.16988f
C2180 vbn_ax r1_b0 0.03254f
C2181 Xi2/m1_988_3304# r2_b0 0.23f
C2182 i3_b0 ua0_stim_out 0.15734f
C2183 vth_ref Xi2/g 0.05047f
C2184 Xi3/a_4132_4392# i4_b0 0.02598f
C2185 i0_b1 vbn_leak 0.08917f
C2186 Xr/vgln i2_b4 0.04793f
C2187 vdd Xvi/a_4976_1528# -0.0981f
C2188 vdd Xd3/a_4584_3816# -0.00464f
C2189 Xvi/m1_7440_2050# Xvi/a_5712_1328# -0
C2190 ua0 ua0_s1 0.03374f
C2191 Xi4/g Xi4/m1_260_2080# 0.05865f
C2192 Xd0/m1_382_4048# vbp_w 0
C2193 vbn_leak Xi0/a_528_4392# 0
C2194 Xvi/a_4976_1528# Xvi/m1_942_738# -0
C2195 Xvi/m1_1276_6360# i4_b3 0.00259f
C2196 Xr/vgln i3_b4 0.11318f
C2197 vreset_src r2_b3 0.05069f
C2198 vreset_src Xd1/m1_756_3120# 0.01f
C2199 Xr/vsn Xr/vgln 1.69021f
C2200 i4_b4 Xm/iint 0.44333f
C2201 Xd0/m1_1262_4048# el 0.00849f
C2202 Xi2/a_3078_4170# r1_b1 0
C2203 i3_b0 Xi3/g 0.27827f
C2204 Xr/vglp i3_b2 0.10287f
C2205 Xm/a_1764_11418# ua0_int 0
C2206 Xr/vgln i2_b3 0.03723f
C2207 r0_b1 i2_b1 0
C2208 i4_b2 ua0_stim_out 0.04068f
C2209 Xi3/m1_1500_4312# Xr/vgln 0.00908f
C2210 ua0_s0 ua0_int 0.03285f
C2211 i3_b2 Xg/a_3036_4156# 0.08986f
C2212 Xi0/a_732_4392# Xr/vgln 0.00107f
C2213 Xd3/m1_3908_2760# v0_c3 -0.00245f
C2214 i3_b3 Xm/in_p 0.06612f
C2215 i2_b2 ua0_stim_out 0.05343f
C2216 vbn_prb Xd2/m1_756_2640# 0
C2217 el r2_b3 0.0648f
C2218 r1_b3 i3_b0 0.03208f
C2219 Xi1/a_3282_4392# Xr/vgln 0.01307f
C2220 ua0 bias_en 0.02462f
C2221 vbp_st vbn_leak 0.40307f
C2222 Xg/m1_4760_1320# Xr/vgln 0.02637f
C2223 Xi2/m1_988_2644# r1_b4 0.22384f
C2224 i4_b2 Xi3/g 0.75267f
C2225 i2_b2 Xi3/g 0.0796f
C2226 r1_b1 vbp_w 0.0998f
C2227 Xi1/a_2432_4392# Xr/vgln 0.03088f
C2228 Xvi/a_2102_5152# Xvi/a_5712_1328# -0.05631f
C2229 v0_c2 v0_c1 0.62008f
C2230 vbn_prb vbp_syn 0.07975f
C2231 Xd3/m1_2408_3600# vbp_st 0.00239f
C2232 Xi1/m1_1500_4312# i3_b3 0
C2233 Xd1/m1_2974_2650# r2_b0 0.01582f
C2234 Xi2/a_3282_4170# i2_b2 0.00624f
C2235 r2_b4 Xi4/a_4132_4170# 0.00229f
C2236 Xg/m1_3530_1930# Xi2/g 0.03323f
C2237 vdd Xr/vsp 2.08928f
C2238 vbn_leak r2_b1 0.05464f
C2239 r1_b3 i4_b2 0.00279f
C2240 i4_b1 Xm/in_p 0.04071f
C2241 Xi0/m1_988_888# Xr/vsp 0.20377f
C2242 Xg/a_7580_5314# Xi0/g -0.00764f
C2243 r1_b3 i2_b2 0.09017f
C2244 r2_b0 Xd2/a_680_3416# 0.16892f
C2245 vreset_src Xi4/m1_1500_3762# 0.00358f
C2246 Xvi/a_864_6450# Xr/vsn 0.13966f
C2247 vdd Xi0/m1_1500_4312# -0.00401f
C2248 Xi3/a_3928_4392# i4_b0 0.0377f
C2249 Xi2/a_1582_4170# r1_b0 0.02145f
C2250 i3_b3 Xi1/m1_240_3480# 0.0047f
C2251 i2_b0 r2_b1 0.04436f
C2252 vdd Xm/a_736_7228# -0
C2253 ib_x2 Xi0/m1_988_2804# 0.28184f
C2254 Xg/a_4580_5314# Xr/vgln 0.2059f
C2255 r2_b2 r1_b4 0.08314f
C2256 vreset_src Xvi/m1_1382_738# 0.00465f
C2257 i3_b2 Xi2/m1_988_888# 0
C2258 ua0_s0 v0_c0 0.17599f
C2259 i3_b1 ua0_stim_out 0.06047f
C2260 ib_x2 Xvi/m1_1382_738# 0
C2261 vreset_src Xd1/m1_606_2410# 0.01395f
C2262 i4_b0 Xi4/a_732_4170# 0.00139f
C2263 Xd3/m1_1262_4448# Xr/en_b 0.00113f
C2264 r1_b4 Xg/a_5188_4156# 0.06886f
C2265 Xd3/m1_1262_4448# ua0_stim_out 0.00833f
C2266 Xi1/m1_988_888# i0_b1 0.12538f
C2267 Xd3/m1_822_4448# Xm/in_p 0.04261f
C2268 Xi0/m1_988_2804# bias_en 0.02417f
C2269 i3_b1 Xi3/g 0.16705f
C2270 Xd3/a_2216_3816# ua0_s0 0.1548f
C2271 Xvi/m1_1382_738# bias_en 0.07111f
C2272 r0_b4 Xr/vgln 0.09494f
C2273 Xd0/m1_1262_4048# vth_cmp 0.04769f
C2274 vdd ib_r1 0.4512f
C2275 vbn_prb vbn_ax 0.01241f
C2276 r2_b4 ua0_stim_out 0.03267f
C2277 Xd0/a_1632_3416# r1_b0 0.06324f
C2278 Xd0/m1_2242_4966# el 0
C2279 Xi1/a_3078_4392# Xr/vgln 0.04837f
C2280 ib_r1 Xi0/m1_988_888# 0.0101f
C2281 Xd0/a_2224_3416# Xd0/m1_2742_3250# -0.00355f
C2282 i4_b1 Xg/m1_4538_1930# 0.02791f
C2283 r1_b0 i2_b4 0.07958f
C2284 r0_b0 Xd0/a_1040_3416# 0.00191f
C2285 Xd0/m1_3662_4048# vbn_leak 0
C2286 vth_cmp Xd2/m1_902_4048# 0.29248f
C2287 r1_b3 i3_b1 0.03978f
C2288 ua0_s0 Xm/in_p 0.00929f
C2289 r1_b3 Xg/m1_5022_10210# 0.07378f
C2290 vth_cmp r2_b3 0.06082f
C2291 Xm/a_736_7228# Xm/a_2240_11218# -0.00585f
C2292 Xr/m1_342_438# Xr/m1_782_438# -0
C2293 r2_b4 Xi3/g 0.05613f
C2294 Xr/vgln Xg/m1_6282_1450# 0.0229f
C2295 Xd3/m1_3222_4448# v0_c1 0.17206f
C2296 vdd v0_c2 0.48349f
C2297 Xi1/a_2228_4392# Xr/vgln 0.01878f
C2298 vdd Xi4/a_528_4170# 0
C2299 vdd Xi2/m1_988_2644# -0.01191f
C2300 Xi3/g Xi3/m1_988_888# 0.09996f
C2301 i3_b2 Xg/a_7580_5314# 0.2339f
C2302 Xr/vsn r1_b0 0.00454f
C2303 Xi1/m1_988_888# vbp_st 0.37362f
C2304 Xd1/m1_2372_2520# r2_b0 0.06206f
C2305 Xg/m1_3298_2050# Xi3/g 0.01206f
C2306 vreset_src Xd1/a_680_3416# 0.02303f
C2307 vdd Xi0/a_1378_4392# 0.0167f
C2308 i2_b3 r1_b0 0.05361f
C2309 Xvi/a_4976_1528# Xi3/g 0.02733f
C2310 vbn_ax Xi2/m1_988_888# 0.00143f
C2311 i2_b1 r2_b1 0.11376f
C2312 r1_b3 r2_b4 0.91483f
C2313 ua0 ua0_stim 0.18601f
C2314 i0_b2 i3_b4 0.00102f
C2315 r1_b3 Xi3/m1_988_888# 0.04957f
C2316 Xr/m1_342_438# Xm/in_n 0.36645f
C2317 Xr/vsn i0_b2 0
C2318 vdd r2_b2 0.59515f
C2319 i3_b0 Xm/in_p 0.06641f
C2320 Xd1/m1_1780_5040# Xd1/a_1272_3416# -0.00104f
C2321 vbp_st Xm/a_420_700# 0
C2322 bias_en Xr/m1_2542_438# 0.00318f
C2323 Xd0/a_2224_3416# vbp_w 0.06403f
C2324 Xr/vglp Xm/in_n 0.15794f
C2325 Xr/m1_1222_3522# ib_x2 0
C2326 vdd Xg/a_5188_4156# -0.01586f
C2327 i3_b3 Xi0/g 0.04653f
C2328 i0_b1 i0_b0 0.02588f
C2329 Xi4/m1_988_888# vbn_prb 0.05754f
C2330 Xd1/m1_2862_4048# r2_b3 0.02055f
C2331 Xd0/m1_956_3000# vbp_w 0.07257f
C2332 i0_b0 Xi0/a_528_4392# 0.00273f
C2333 Xi3/a_1582_4392# Xr/vgln 0.00128f
C2334 Xi1/a_3282_4392# i0_b2 0.01279f
C2335 vbn_leak r1_b1 0.04094f
C2336 Xr/vgln Xi0/a_1582_4392# 0
C2337 vdd i4_b3 2.03543f
C2338 i4_b3 Xvi/m1_942_738# 0
C2339 el r0_b1 0.00449f
C2340 i2_b0 r1_b1 0.08157f
C2341 vbn_ref i4_b1 0.04378f
C2342 Xr/en_b Xr/vsp 0.16156f
C2343 Xi2/g r1_b4 0.5151f
C2344 v0_c4 v0_c5 0.36514f
C2345 r2_b4 Xi4/m1_988_2644# 0.04078f
C2346 i4_b0 Xg/a_1580_5314# 0.00206f
C2347 i4_b2 Xm/in_p 0.20254f
C2348 vth_cmp Xvi/m1_1382_738# 0.04169f
C2349 i2_b2 Xm/in_p 0.19187f
C2350 Xi1/a_2432_4392# i0_b2 0
C2351 Xd2/m1_1663_4920# r2_b0 0.16734f
C2352 Xr/en_b Xm/a_736_7228# -0.00166f
C2353 Xvi/a_4976_1528# Xvi/a_5712_1328# -0
C2354 Xd0/m1_2242_4966# vth_cmp 0.00351f
C2355 Xi1/g vbn_leak 0.11816f
C2356 Xd3/m1_2720_2760# v0_c1 0.04257f
C2357 Xm/a_736_7228# ua0_stim_out -0.01497f
C2358 Xr/vglp i2_b4 0.2073f
C2359 Xi3/g Xr/vsp 0.80465f
C2360 Xi1/g i2_b0 0
C2361 i4_b1 Xi0/g 0.35684f
C2362 vbp_st i0_b0 0.21587f
C2363 Xr/vsn Xr/m1_342_438# -0.00175f
C2364 Xr/vglp i3_b4 1.19703f
C2365 vdd i1_b0 0.00202f
C2366 vdd Xd2/a_3048_3416# 0.01236f
C2367 Xr/vglp Xr/vsn 2.30109f
C2368 r0_b4 r1_b0 0.04152f
C2369 Xi4/a_732_4170# vbp_w 0.00259f
C2370 Xd0/a_1632_3416# vbn_prb 0.00326f
C2371 Xg/a_3036_4156# i3_b4 0.22027f
C2372 i0_b1 Xi1/m1_988_3464# 0.10156f
C2373 i3_b2 i3_b3 0.09068f
C2374 r1_b3 Xr/vsp 0.9488f
C2375 Xr/vglp i2_b3 0.24146f
C2376 Xi4/a_4132_4170# r2_b2 0
C2377 Xr/vglp Xi0/a_732_4392# 0.01708f
C2378 r1_b1 Xg/m1_3666_9610# 0
C2379 ua0_s0 Xd3/a_2808_3816# 0.06431f
C2380 vbp_st ua0_s1 0.02156f
C2381 vth_cmp Xd2/a_1272_3416# 0.2962f
C2382 Xr/vsn vbn_prb 0.37198f
C2383 vbn_prb Xd1/m1_462_4048# 0.05572f
C2384 Xd1/m1_2974_2650# vbp_w 0.09117f
C2385 Xg/m1_5022_10210# Xm/in_p 0.03049f
C2386 i3_b1 Xm/in_p 0.04412f
C2387 r0_b2 Xd0/a_2816_3416# 0.03883f
C2388 Xd3/m1_1262_4448# Xm/in_p 0.03889f
C2389 vdd vth_ref 0.41585f
C2390 vbp_syn Xi2/a_2228_4170# -0.00172f
C2391 i1_b2 Xr/vgln 0.11406f
C2392 Xi3/a_1378_4392# Xr/vgln 0.0015f
C2393 v0_c0 Xd3/a_4584_3816# 0
C2394 v0_c2 ua0_stim_out 0.18769f
C2395 Xi1/a_3078_4392# i0_b2 0.0102f
C2396 vth_ref Xi0/m1_988_888# 0.40172f
C2397 Xr/vglp Xg/m1_4760_1320# 0
C2398 vbp_st ib_x2 0.06172f
C2399 i4_b3 Xi4/a_4132_4170# 0.05309f
C2400 i2_b1 r1_b1 0.25033f
C2401 Xd1/a_3048_3416# vbp_w 0.07575f
C2402 i0_b3 Xr/vsp 0.35418f
C2403 i4_b0 r2_b0 0.0045f
C2404 i3_b2 i4_b1 0.05455f
C2405 vdd Xi2/g 0.44535f
C2406 Xi1/a_2228_4392# i0_b2 0
C2407 Xr/vgln Xvi/m1_1382_738# 0.35449f
C2408 Xm/a_736_7228# ua0_int 0.10443f
C2409 Xi3/a_2228_4392# Xr/vgln 0.03906f
C2410 Xd3/m1_2720_2760# vdd -0.00518f
C2411 r2_b4 Xm/in_p 0.27547f
C2412 r1_b0 r1_b2 0.16984f
C2413 Xd0/a_2816_3416# r0_b3 0.02464f
C2414 vbp_st bias_en 0.21623f
C2415 vdd Xi2/a_732_4170# 0.02888f
C2416 vbn_ref i3_b0 0.03983f
C2417 vbp_st el 0.06713f
C2418 Xi1/a_4132_4392# Xr/vgln 0
C2419 r2_b2 ua0_stim_out 0.07466f
C2420 vreset_src r2_b1 0.04515f
C2421 Xr/vglp Xg/a_4580_5314# 0.04152f
C2422 Xr/vsn Xi2/m1_988_888# -0.00219f
C2423 Xi1/g i2_b1 0
C2424 i0_b4 Xi1/m1_988_888# 0.01652f
C2425 Xi1/m1_988_2804# Xr/vsp 0.07431f
C2426 Xi1/m1_240_3480# i3_b1 0.03502f
C2427 i4_b4 Xi4/a_3928_4170# 0.0066f
C2428 Xi1/m1_988_888# Xi1/g -0.04641f
C2429 r1_b3 Xi2/m1_988_2644# 0
C2430 vreset_src Xi4/a_1378_4170# 0.08241f
C2431 Xd0/m1_1262_4048# r1_b0 0
C2432 Xd0/a_2224_3416# Xd0/m1_617_3840# -0.00574f
C2433 i3_b0 Xi0/g 0.31436f
C2434 Xd3/m1_3908_2760# Xd3/a_3992_3816# -0
C2435 r2_b2 Xi3/g 0.04358f
C2436 el r2_b1 0.04044f
C2437 Xd0/m1_956_3000# Xd0/m1_617_3840# -0.00821f
C2438 vbn_ref i4_b2 0.04419f
C2439 i4_b3 ua0_stim_out 0.1936f
C2440 ib_r1 Xvi/a_5712_1328# 0.19089f
C2441 vdd Xd0/a_2816_3416# 0.05515f
C2442 Xi3/g Xg/a_5188_4156# 0.25305f
C2443 r0_b0 Xi2/a_528_4170# 0
C2444 vbn_ref i2_b2 0.04641f
C2445 Xr/vglp r0_b4 0.01314f
C2446 vdd Xg/m1_3530_1930# -0.00571f
C2447 vreset_src Xd1/a_1272_3416# 0.00397f
C2448 r1_b0 r2_b3 0.74903f
C2449 Xd1/m1_756_3120# r1_b0 0.01271f
C2450 Xd1/m1_2372_2520# vbp_w 0.10459f
C2451 i4_b3 Xi3/g 0.01377f
C2452 v0_c2 ua0_int 0.04746f
C2453 vdd Xvi/m1_8332_7080# 0.10926f
C2454 r1_b3 r2_b2 0.33673f
C2455 Xd3/m1_3222_4448# ua0_stim_out 0.30152f
C2456 Xg/a_7580_5314# i3_b4 0.06209f
C2457 Xi2/a_4132_4170# r2_b0 0.01054f
C2458 i4_b2 Xi0/g 0.41594f
C2459 i2_b2 Xi0/g 0.06878f
C2460 Xr/vsn Xg/a_7580_5314# 0.01775f
C2461 Xvi/m1_1276_6360# vdd -0.10591f
C2462 vdd Xi0/a_3078_4392# 0.02956f
C2463 i1_b0 ua0_stim_out 0.03782f
C2464 Xr/vsp Xm/in_p 0.82075f
C2465 i4_b4 Xvi/m1_8042_6360# 0.03563f
C2466 Xd0/m1_3662_4048# el 0.02414f
C2467 Xi1/a_3928_4392# Xr/vgln 0.00393f
C2468 Xr/m1_342_438# Xr/m1_3422_438# -0.00432f
C2469 Xd0/m1_2742_3250# r2_b0 0.05361f
C2470 i3_b2 i3_b0 0.44104f
C2471 vbn_ref i3_b1 0.28571f
C2472 Xi4/m1_988_2644# r2_b2 0.34468f
C2473 Xr/vglp r1_b2 0.00671f
C2474 Xr/vgln i1_b1 -0.0148f
C2475 vbp_st vth_cmp 0.48034f
C2476 r0_b4 Xi2/m1_988_888# 0.03866f
C2477 Xi1/g i0_b0 0.32713f
C2478 Xd0/m1_382_4048# el 0.01331f
C2479 r0_b0 i3_b0 0
C2480 Xr/en_b vth_ref 0.10643f
C2481 v0_c2 v0_c0 0.23212f
C2482 Xd3/a_3400_3816# ua0_s1 0.03302f
C2483 Xi2/a_3078_4170# r2_b0 0.08889f
C2484 i4_b3 Xvi/a_5712_1328# 0.00138f
C2485 vth_ref ua0_stim_out 0.01172f
C2486 i2_b0 Xi2/a_1378_4170# 0
C2487 r0_b2 r1_b4 0
C2488 Xi1/m1_1500_4312# Xr/vsp -0.00192f
C2489 Xi3/m1_988_2804# i4_b0 0.11144f
C2490 i3_b1 Xi0/g 0.28044f
C2491 Xr/vgln Xi2/m1_260_2080# 0.0235f
C2492 Xi2/a_1582_4170# Xi2/a_2228_4170# -0
C2493 Xm/iint Xvi/m1_8042_6360# 0
C2494 vbp_st ua0_stim 0
C2495 Xd3/a_2216_3816# v0_c2 -0.02999f
C2496 i3_b2 i4_b2 0.05308f
C2497 vbn_ref r2_b4 0.03111f
C2498 Xd1/m1_606_2410# r1_b0 0.00335f
C2499 Xr/vglp Xi0/a_1582_4392# 0.01524f
C2500 i1_b2 i0_b2 0.06618f
C2501 vth_cmp r2_b1 1.09727f
C2502 vreset_src r1_b1 0.04056f
C2503 Xd0/m1_2242_4966# r1_b0 0.05209f
C2504 Xm/in_n Xi0/a_3928_4392# 0
C2505 vdd Xi2/a_2432_4170# 0.00415f
C2506 vbn_prb Xi4/a_2228_4170# 0
C2507 Xi0/m1_988_3464# Xm/in_n 0.00992f
C2508 Xg/a_4580_5314# Xg/a_7580_5314# -0.01199f
C2509 Xi1/m1_240_3480# Xr/vsp 0.04166f
C2510 Xd3/m1_2720_2760# ua0_stim_out 0.15704f
C2511 vbp_syn i2_b2 -0.01301f
C2512 i0_b1 Xr/vgln 0.17374f
C2513 vreset_src Xd2/m1_2382_2650# 0.00158f
C2514 Xr/vgln Xi0/a_528_4392# 0.00225f
C2515 vreset_src Xd1/m1_860_4046# 0.01507f
C2516 r0_b3 r1_b4 0.00169f
C2517 vbp_w r2_b0 0.3812f
C2518 Xd3/a_3400_3816# bias_en 0
C2519 Xd0/m1_1262_4048# vbn_prb 0.07467f
C2520 i4_b1 Xm/in_n 0.03249f
C2521 Xi2/g Xi3/g 0.46664f
C2522 i0_b4 ib_x2 0.23437f
C2523 v0_c2 Xm/in_p 0.15818f
C2524 i4_b4 vbn_leak 0.04069f
C2525 el r1_b1 0.07521f
C2526 vreset_src Xi4/g 0.05845f
C2527 vbn_ax i3_b0 0.10241f
C2528 Xi3/a_3282_4392# Xr/vgln 0.00997f
C2529 i3_b3 i3_b4 1.47226f
C2530 Xi1/a_4132_4392# i0_b2 0.02357f
C2531 Xd1/m1_756_3120# vbn_prb 0.04882f
C2532 vdd Xd1/a_2456_3416# 0.00215f
C2533 r0_b2 r0_b3 1.09631f
C2534 i3_b3 Xr/vsn 0.26718f
C2535 Xi1/g Xi1/m1_988_3464# -0.02983f
C2536 Xi1/a_528_4392# i3_b0 0
C2537 vbn_prb r2_b3 0.80661f
C2538 r1_b3 Xi2/g 0.04729f
C2539 Xi2/a_1582_4170# Xi2/a_528_4170# -0
C2540 vdd r1_b4 0.89871f
C2541 Xi1/a_732_4392# i3_b1 0.01001f
C2542 Xi4/g bias_en 0.1791f
C2543 i3_b2 i3_b1 1.15722f
C2544 Xd0/m1_3662_4048# vth_cmp 0.01716f
C2545 i3_b3 Xi0/a_732_4392# 0.04281f
C2546 i3_b4 Xi0/a_3928_4392# 0.01945f
C2547 Xd3/m1_3222_4448# v0_c0 0.07967f
C2548 vdd v0_c1 0.77303f
C2549 vbp_st Xr/vgln 0.18222f
C2550 r2_b2 Xm/in_p 0.07399f
C2551 Xd1/a_680_3416# r1_b0 0.03128f
C2552 i4_b0 vbp_w 0.09113f
C2553 r1_b2 Xd0/a_1040_3416# 0.09489f
C2554 Xi4/g el 0.27023f
C2555 Xi0/m1_988_3464# i3_b4 0
C2556 Xr/vsn Xi0/a_3928_4392# 0.0048f
C2557 Xm/in_p Xg/a_5188_4156# 0.01964f
C2558 i4_b1 i2_b4 0.04185f
C2559 i2_b1 Xi2/a_1378_4170# 0
C2560 Xr/vsn Xi0/m1_988_3464# 0.15338f
C2561 Xd2/m1_1342_4048# vth_cmp 0.31172f
C2562 r2_b4 Xi3/m1_240_3480# 0.00572f
C2563 Xg/m1_3530_1930# Xi3/g 0.00893f
C2564 vdd r0_b2 0.74335f
C2565 Xd3/m1_3222_4448# Xd3/a_2216_3816# -0
C2566 Xd3/m1_4078_3250# ua0_s0 0.07438f
C2567 Xd0/m1_382_4048# vth_cmp 0.04552f
C2568 vbn_leak Xg/a_1580_5314# 0.13407f
C2569 ua0_s0 Xm/in_n 0.00461f
C2570 r0_b1 r1_b0 0.04303f
C2571 Xi3/m1_240_3480# Xi3/m1_988_888# -0.00112f
C2572 i4_b1 i3_b4 0.06247f
C2573 i4_b3 Xm/in_p 0.03385f
C2574 i3_b2 r2_b4 0.04268f
C2575 Xr/vgln r2_b1 0.40857f
C2576 Xm/a_1744_10100# ua0_s1 0.02095f
C2577 Xr/vglp Xi0/m1_988_2804# 0.00753f
C2578 Xr/vsn i4_b1 1.20731f
C2579 vbn_ref Xr/vsp 0
C2580 Xr/vglp Xvi/m1_1382_738# 0
C2581 i4_b1 i2_b3 0.06333f
C2582 Xr/vgln Xi4/a_1378_4170# -0.00174f
C2583 vdd r0_b3 0.26632f
C2584 Xd3/m1_3222_4448# Xm/in_p 0.16094f
C2585 i1_b3 Xr/vgln 0.06942f
C2586 Xvi/m1_1276_6360# Xi3/g 0.07496f
C2587 r2_b3 Xd0/a_1040_3416# 0.04943f
C2588 Xi0/g Xr/vsp 0.25621f
C2589 vbn_prb Xi4/m1_1500_3762# 0.03081f
C2590 Xg/a_4580_5314# i3_b3 0.05672f
C2591 Xi1/a_1378_4392# i3_b1 0
C2592 Xi1/a_3928_4392# i0_b2 0.04356f
C2593 vbn_prb Xvi/m1_1382_738# 0.00575f
C2594 Xvi/m1_5388_6960# Xi4/g 0.01394f
C2595 Xi0/g Xi0/m1_1500_4312# -0.01583f
C2596 Xi3/a_3078_4392# Xr/vgln 0.01661f
C2597 Xd1/m1_606_2410# vbn_prb 0.08271f
C2598 Xg/m1_4760_1320# i4_b1 0.02685f
C2599 r1_b0 Xi2/m1_260_2080# 0.02518f
C2600 i0_b2 i1_b1 0.0026f
C2601 Xd1/m1_1780_5040# Xd1/m1_2372_2520# -0.0036f
C2602 Xd0/m1_382_4048# Xd1/m1_2862_4048# 0.00158f
C2603 Xd0/m1_2242_4966# vbn_prb 0.05238f
C2604 vbn_ax i3_b1 0.01405f
C2605 r1_b0 Xg/m1_4906_9490# 0
C2606 Xi1/a_528_4392# i3_b1 0.02618f
C2607 vth_cmp Xd2/m1_2382_2650# 0.03007f
C2608 Xd1/m1_860_4046# vth_cmp 0.05245f
C2609 Xd3/m1_2720_2760# v0_c0 0.16764f
C2610 Xi4/g Xvi/m1_4546_7560# 0.14567f
C2611 vdd Xi0/m1_988_888# -0.08437f
C2612 ib_x2 Xi0/a_4132_4392# 0
C2613 Xvi/a_864_6450# r2_b1 0
C2614 r0_b4 Xi2/a_2228_4170# 0
C2615 Xi1/a_3078_4392# i3_b3 0
C2616 Xr/m1_342_438# Xr/m1_2542_438# -0.01626f
C2617 v0_c2 Xd3/a_2808_3816# 0.01852f
C2618 Xg/a_4580_5314# i4_b1 0.14116f
C2619 ib_r1 Xi0/g 0.01776f
C2620 Xd3/m1_2720_2760# Xd3/a_2216_3816# -0
C2621 Xd3/m1_3908_2760# ua0_s0 0.0954f
C2622 Xd0/m1_956_3000# el 0.0064f
C2623 Xi4/g vth_cmp 1.19474f
C2624 vbn_leak r2_b0 0.19734f
C2625 vth_ref Xm/in_p 0.01698f
C2626 Xvi/a_2102_5152# Xr/vsn 0.00581f
C2627 r2_b0 Xd0/m1_617_3840# 0.04678f
C2628 Xi3/m1_240_3480# Xr/vsp 0.10126f
C2629 i0_b1 i0_b2 0.00962f
C2630 i3_b0 i2_b4 0
C2631 i2_b0 r2_b0 0.09333f
C2632 Xd0/m1_2742_3250# vbp_w 0.13186f
C2633 Xi1/m1_988_888# Xi0/a_2228_4392# 0
C2634 i0_b3 Xi0/a_3078_4392# 0.00105f
C2635 Xr/vgln Xi2/m1_1500_3762# 0.02189f
C2636 vbn_prb Xd2/a_1272_3416# 0
C2637 i3_b2 Xr/vsp 0.23674f
C2638 v0_c2 Xd3/m1_4102_4448# 0
C2639 ib_x2 Xvi/m1_8646_1098# 0
C2640 Xd1/a_680_3416# vbn_prb 0
C2641 Xr/vsn i3_b0 0.20482f
C2642 Xm/iint Xm/a_420_700# 0.01579f
C2643 Xd3/m1_2720_2760# Xm/in_p 0.10674f
C2644 vbp_st r1_b0 0.04244f
C2645 vbn_ref r2_b2 0.03483f
C2646 r0_b0 Xr/vsp 0.00105f
C2647 vdd Xm/a_2240_11218# -0.00153f
C2648 ua0_stim_out r1_b4 0.03914f
C2649 vreset_src Xi4/a_732_4170# 0.02273f
C2650 v0_c1 ua0_stim_out 0.89163f
C2651 i2_b2 i2_b4 0.99578f
C2652 i4_b2 i2_b4 0.06268f
C2653 vbn_leak i4_b0 0.03591f
C2654 Xr/vgln r1_b1 0.23278f
C2655 Xd3/a_3400_3816# v0_c3 0.00802f
C2656 Xd2/m1_2964_2640# Xd2/m1_1663_4920# -0.00254f
C2657 i4_b1 Xg/m1_6282_1450# 0.00135f
C2658 r0_b4 Xi2/a_528_4170# 0
C2659 Xi3/g r1_b4 0.19973f
C2660 r0_b2 ua0_stim_out 0.2449f
C2661 i4_b2 i3_b4 0.03542f
C2662 r1_b0 r2_b1 0.03477f
C2663 vbn_ref i4_b3 0.04216f
C2664 i4_b4 i0_b0 0.44759f
C2665 vbp_st i0_b2 0.32502f
C2666 i2_b0 i4_b0 0.08404f
C2667 Xi0/g Xg/a_5188_4156# -0.01188f
C2668 Xr/vsn i4_b2 0.04422f
C2669 Xd1/m1_1780_5040# r2_b0 0.08221f
C2670 Xi4/m1_988_888# r2_b4 0.04159f
C2671 i3_b3 Xi0/a_1582_4392# 0.00915f
C2672 i4_b2 i2_b3 0.09162f
C2673 vdd Xi4/a_4132_4170# 0
C2674 Xi2/g Xg/m1_4538_1930# 0.03792f
C2675 Xr/vglp Xg/m1_4906_9490# -0.02037f
C2676 i0_b4 Xr/vgln 0.47162f
C2677 r0_b2 Xd0/a_3408_3416# 0.05726f
C2678 Xd3/m1_3222_4448# Xd3/a_2808_3816# -0.01486f
C2679 Xi1/g Xr/vgln 0.65104f
C2680 r1_b3 r1_b4 0.22487f
C2681 i2_b3 i2_b2 0.30091f
C2682 Xd2/m1_2964_2640# r2_b0 0.06705f
C2683 Xr/vglp i0_b1 0
C2684 i4_b3 Xi0/g 0.07447f
C2685 Xg/a_3036_4156# Xg/m1_4906_9490# -0
C2686 Xi4/g Xr/vgln 0.0417f
C2687 Xd3/m1_1702_4448# vbp_st 0.03049f
C2688 r0_b3 ua0_stim_out 0.1447f
C2689 vbn_prb Xd2/a_2456_3416# 0.13313f
C2690 el Xd1/m1_2974_2650# 0.00653f
C2691 ua0_stim Xm/a_1744_10100# 0
C2692 Xr/vglp Xi0/a_528_4392# 0.01289f
C2693 vreset_src Xi4/a_3078_4170# 0.11856f
C2694 vbn_ax Xr/vsp 0.07115f
C2695 Xi2/a_3928_4170# i2_b4 0.00456f
C2696 i2_b1 r2_b0 0.09935f
C2697 i4_b1 Xi4/a_2228_4170# 0.00754f
C2698 Xi1/a_528_4392# Xr/vsp 0
C2699 r1_b0 Xd1/a_1272_3416# 0.10224f
C2700 Xg/m1_3298_2050# Xm/in_n 0.03849f
C2701 Xg/a_4580_5314# i3_b0 0.18055f
C2702 i3_b1 i2_b4 0
C2703 Xd0/m1_956_3000# vth_cmp 0.00129f
C2704 vbn_ref i1_b0 0.0615f
C2705 i0_b2 i1_b3 0.13736f
C2706 vreset_src i4_b4 0.16173f
C2707 el Xd1/a_3048_3416# 0.01208f
C2708 r0_b3 Xd0/a_3408_3416# 0.01374f
C2709 Xg/m1_5022_10210# i2_b4 0
C2710 i4_b4 ib_x2 0.06366f
C2711 vreset_src Xi4/a_1582_4170# 0.0213f
C2712 Xi3/m1_240_3480# r2_b2 0
C2713 r0_b1 Xd0/a_1040_3416# 0
C2714 Xd0/m1_3662_4048# r1_b0 0
C2715 vdd Xr/en_b 0.27849f
C2716 v0_c1 ua0_int 0.06507f
C2717 i4_b0 Xg/m1_3666_9610# 0
C2718 i3_b2 r2_b2 0.04943f
C2719 Xr/vsn i3_b1 0.24613f
C2720 vdd ua0_stim_out 0.20856f
C2721 r0_b4 i3_b0 0
C2722 v0_c4 ua0_s1 0.10946f
C2723 i4_b4 bias_en 0.10079f
C2724 i3_b2 Xg/a_5188_4156# 0.0558f
C2725 Xi2/a_4132_4170# i2_b0 0
C2726 Xr/vglp vbp_st 0.03188f
C2727 Xd0/m1_382_4048# r1_b0 0
C2728 i4_b4 el 0
C2729 Xg/a_4580_5314# i4_b2 0.02527f
C2730 r2_b4 i2_b4 0.03716f
C2731 vdd Xd0/a_3408_3416# 0.06905f
C2732 i2_b1 i4_b0 0.11343f
C2733 vreset_src Xm/iint 0.06191f
C2734 vreset_src Xd1/m1_2372_2520# -0
C2735 Xi0/m1_240_3480# Xm/iint 0
C2736 Xi1/m1_988_888# Xi0/a_3282_4392# 0
C2737 vbp_st Xg/a_3036_4156# 0.05325f
C2738 r1_b0 Xg/m1_3898_9610# 0.05943f
C2739 vdd Xi3/g 1.92096f
C2740 i3_b2 i4_b3 0.74725f
C2741 Xm/iint ib_x2 0.37435f
C2742 r1_b0 Xi2/m1_1500_3762# 0.00968f
C2743 v0_c4 ib_x2 0.0683f
C2744 Xi3/m1_988_3464# Xr/vsp -0.01292f
C2745 r2_b4 i3_b4 0.03433f
C2746 Xvi/a_864_6450# Xi4/g 0.58392f
C2747 Xr/vsn r2_b4 0.32106f
C2748 vth_ref Xi0/g 0.51389f
C2749 Xd3/m1_2720_2760# Xd3/a_2808_3816# -0
C2750 vbp_st vbn_prb 0.20088f
C2751 vdd Xi2/a_3282_4170# 0
C2752 Xr/vglp r2_b1 1.09785f
C2753 Xm/iint bias_en 1.64931f
C2754 r0_b4 i2_b2 0.04572f
C2755 Xr/vsn Xg/m1_3298_2050# 0.02555f
C2756 r2_b4 i2_b3 0.21217f
C2757 vdd r1_b3 1.67517f
C2758 v0_c4 bias_en 0.05955f
C2759 el Xd1/m1_2372_2520# 0
C2760 Xm/iint el 0
C2761 Xr/en_b Xm/a_2240_11218# -0.09963f
C2762 Xvi/a_4976_1528# Xr/vsn 0.08936f
C2763 Xi2/g Xi0/g 0
C2764 ua0_stim_out Xm/a_2240_11218# 0
C2765 v0_c1 v0_c0 0.39383f
C2766 Xm/in_n Xr/vsp 0.24198f
C2767 i3_b3 Xi1/a_4132_4392# 0.04958f
C2768 vbn_prb r2_b1 0.1749f
C2769 r1_b0 r1_b1 0.47408f
C2770 vth_cmp Xd1/m1_2974_2650# 0.0012f
C2771 Xd3/m1_382_4448# bias_en 0.05571f
C2772 Xvi/m1_5388_6960# i4_b4 0.00174f
C2773 Xm/in_n Xi0/m1_1500_4312# 0.00767f
C2774 Xg/a_4580_5314# i3_b1 0.13297f
C2775 i3_b2 i1_b0 0.07938f
C2776 ib_r1 Xr/m1_782_438# 0.03231f
C2777 Xd3/a_2216_3816# v0_c1 0.14328f
C2778 Xr/vgln Xi2/m1_988_3304# 0.16367f
C2779 vth_cmp Xd2/a_680_3416# 0.03685f
C2780 vbp_st Xi2/m1_988_888# 0.08242f
C2781 vdd ua0_int 1.20112f
C2782 ua0 ua0_s0 0.01874f
C2783 vdd Xvi/a_5712_1328# -0.00388f
C2784 vdd i0_b3 0.28562f
C2785 r0_b4 Xi2/a_3928_4170# 0.00139f
C2786 Xi1/g r1_b0 0.00194f
C2787 vbn_leak vbp_w 0.1852f
C2788 vbp_w Xd0/m1_617_3840# 0.18324f
C2789 r1_b4 Xm/in_p 0.06018f
C2790 i4_b4 Xvi/m1_4546_7560# 0
C2791 v0_c1 Xm/in_p 0
C2792 Xi1/a_528_4392# i4_b3 0
C2793 i2_b2 r1_b2 0
C2794 vbn_prb Xd1/a_1272_3416# 0
C2795 i2_b4 Xr/vsp 0.87852f
C2796 Xvi/m1_8646_1098# Xr/vgln 0.01366f
C2797 Xr/vsn Xvi/m1_502_738# 0
C2798 i0_b4 i0_b2 0.00785f
C2799 vdd Xi1/m1_988_2804# -0.00983f
C2800 i4_b4 vth_cmp 0.16232f
C2801 Xi3/a_3928_4392# Xr/vgln 0
C2802 Xi1/g i0_b2 0.41297f
C2803 i3_b4 Xr/vsp 0.34208f
C2804 vreset_src r2_b0 0.05991f
C2805 Xd0/m1_3662_4048# vbn_prb 0.04626f
C2806 Xd3/m1_4078_3250# v0_c2 0.00835f
C2807 Xr/vglp Xg/m1_3898_9610# -0.00419f
C2808 i3_b2 Xi2/g 0.12116f
C2809 Xr/vsn Xr/vsp 0.6119f
C2810 ua0_int Xm/a_2240_11218# 0.00166f
C2811 i3_b4 Xi0/m1_1500_4312# 0
C2812 r2_b4 r0_b4 0.11432f
C2813 i2_b3 Xr/vsp 0.03034f
C2814 Xr/vsn Xi0/m1_1500_4312# 0.11637f
C2815 vdd v0_c0 1.22878f
C2816 vbp_st Xg/a_7580_5314# 0.06183f
C2817 Xd0/m1_382_4048# vbn_prb 0.05278f
C2818 Xr/en_b ua0_stim_out 0.07976f
C2819 r0_b0 Xi2/g 0
C2820 Xr/vgln Xi2/a_1378_4170# 0.01111f
C2821 Xr/vglp Xg/m1_6020_10200# -0.01299f
C2822 Xi4/m1_988_888# r2_b2 0.37169f
C2823 i3_b3 Xi1/a_3928_4392# 0.0032f
C2824 Xm/iint vth_cmp 0
C2825 vth_cmp Xd1/m1_2372_2520# 0.00529f
C2826 el r2_b0 0.14329f
C2827 Xg/a_3036_4156# Xg/m1_6020_10200# -0
C2828 vbp_syn Xi2/a_732_4170# 0
C2829 Xi4/a_3078_4170# Xi4/a_3282_4170# -0.00427f
C2830 Xd1/m1_1780_5040# vbp_w 0.09125f
C2831 Xm/in_n Xr/m1_1662_438# 0.0049f
C2832 vdd Xd3/a_2216_3816# 0.03703f
C2833 Xi0/a_2432_4392# Xr/vgln 0.00161f
C2834 v0_c5 ua0_s1 0.06597f
C2835 Xr/vglp r1_b1 0.28091f
C2836 ua0_stim_out Xi3/g 0
C2837 vreset_src i4_b0 0.00691f
C2838 v0_c4 ua0_stim 0.30841f
C2839 Xm/in_n Xg/a_5188_4156# 0
C2840 ib_x2 v0_c5 0.13626f
C2841 Xr/vgln Xi4/a_3078_4170# -0.01288f
C2842 Xr/vglp i0_b4 0.0027f
C2843 vdd Xm/in_p 1.32333f
C2844 Xm/in_n i4_b3 0.05109f
C2845 Xi3/a_1582_4392# i3_b1 0.00135f
C2846 Xr/vglp Xi1/g -0.00338f
C2847 r1_b3 ua0_stim_out 0.03891f
C2848 r1_b0 Xd0/a_2224_3416# 0.05462f
C2849 r2_b4 r1_b2 0.07776f
C2850 i4_b4 Xr/vgln 0.44232f
C2851 el i4_b0 0.11635f
C2852 vbn_ax Xi2/g 0
C2853 i3_b3 i0_b1 0.06489f
C2854 Xr/vsn Xi2/m1_988_2644# -0.00865f
C2855 Xg/a_4580_5314# Xr/vsp -0.00366f
C2856 Xi1/g Xg/a_3036_4156# -0
C2857 v0_c5 bias_en 0.29094f
C2858 r2_b4 Xi4/a_2228_4170# 0.00721f
C2859 Xi4/a_1582_4170# Xr/vgln -0.00151f
C2860 Xd0/m1_956_3000# r1_b0 0.02127f
C2861 Xr/vglp Xi4/g 0.73281f
C2862 i3_b3 Xi0/a_528_4392# 0.05521f
C2863 vbn_prb Xd2/m1_2382_2650# 0.01457f
C2864 Xd1/m1_860_4046# vbn_prb 0.05134f
C2865 i1_b4 Xr/vgln 0.00804f
C2866 i3_b4 Xi0/a_1378_4392# 0.01481f
C2867 Xd3/m1_3908_2760# v0_c2 0
C2868 r1_b0 Xi2/m1_988_3304# 0.02763f
C2869 r1_b3 Xi3/g 0.35633f
C2870 Xr/vsn Xi0/a_1378_4392# 0.00405f
C2871 r2_b2 i2_b4 0.03512f
C2872 vdd Xi1/m1_1500_4312# -0
C2873 vth_cmp Xd2/m1_1663_4920# 0.0914f
C2874 Xr/en_b ua0_int 0.08237f
C2875 ua0_stim_out ua0_int 0.01283f
C2876 i3_b3 Xi3/a_3282_4392# 0.01672f
C2877 r0_b4 Xr/vsp 0
C2878 i0_b3 ua0_stim_out 0.30247f
C2879 i3_b4 r2_b2 0.03384f
C2880 Xi4/g vbn_prb 0.67704f
C2881 r0_b2 Xd0/m1_3310_2880# 0
C2882 vbn_ref r1_b4 0.03898f
C2883 Xm/iint Xr/vgln 0.30855f
C2884 i3_b4 Xg/a_5188_4156# 0.15253f
C2885 Xi2/m1_988_888# r1_b1 0
C2886 Xr/vsn r2_b2 0.44989f
C2887 i4_b3 i2_b4 0.19455f
C2888 vth_ref Xr/m1_782_438# 0.00182f
C2889 Xr/vsn Xg/a_5188_4156# 0.25783f
C2890 v0_c1 Xd3/a_2808_3816# 0.21379f
C2891 vdd Xi1/m1_240_3480# -0.05952f
C2892 r2_b4 r2_b3 0.04945f
C2893 Xr/vgln Xi0/a_2228_4392# 0.00202f
C2894 v0_c4 v0_c3 2.12544f
C2895 i2_b3 r2_b2 0.06589f
C2896 vreset_src Xi4/m1_260_2080# 0.02462f
C2897 Xr/vgln Xg/a_1580_5314# -0.00228f
C2898 vbp_st i3_b3 0.0643f
C2899 vth_cmp r2_b0 1.044f
C2900 i4_b3 i3_b4 0.03735f
C2901 Xi0/g r1_b4 0.01899f
C2902 vbn_ref r0_b2 0.04517f
C2903 Xr/vsn i4_b3 0.40701f
C2904 Xi3/a_2432_4392# Xi2/g 0
C2905 v0_c1 Xd3/m1_4102_4448# 0.00477f
C2906 i2_b3 i4_b3 0.06415f
C2907 Xvi/a_864_6450# i4_b4 0.68163f
C2908 Xd1/a_2456_3416# Xd1/a_1864_3416# -0
C2909 vth_ref Xm/in_n 0.09293f
C2910 i1_b2 i3_b1 0.07719f
C2911 r2_b3 Xd2/a_1864_3416# 0.05539f
C2912 i3_b3 r2_b1 0.04419f
C2913 Xi3/a_1378_4392# i3_b1 0.0029f
C2914 r1_b0 Xi2/a_1378_4170# 0.08427f
C2915 el Xi3/m1_988_2804# 0.00511f
C2916 v0_c0 ua0_stim_out 0.4163f
C2917 vbn_ref r0_b3 0.05381f
C2918 r1_b0 Xd1/m1_2974_2650# 0.09367f
C2919 Xi2/g Xm/in_n 1.29293f
C2920 vbp_st i4_b1 0.06303f
C2921 Xd3/m1_3222_4448# Xd3/m1_3908_2760# -0
C2922 i3_b3 i1_b3 0.0078f
C2923 vdd Xd0/m1_3310_2880# 0.01869f
C2924 Xi3/a_2228_4392# i3_b1 0
C2925 r0_b4 Xi2/m1_988_2644# 0.18818f
C2926 Xvi/a_864_6450# Xm/iint 0.07359f
C2927 Xd1/m1_2862_4048# r2_b0 0.01369f
C2928 Xd3/a_2216_3816# ua0_stim_out 0.02596f
C2929 i3_b0 i1_b1 0
C2930 r1_b0 Xd1/a_3048_3416# 0.06043f
C2931 el Xd0/m1_2742_3250# 0.00151f
C2932 r2_b4 Xi4/m1_1500_3762# 0.0556f
C2933 Xi3/m1_240_3480# r1_b4 0.05804f
C2934 i3_b3 Xi3/a_3078_4392# 0.00582f
C2935 Xg/a_4580_5314# Xg/a_5188_4156# -0
C2936 Xr/vglp Xi0/a_4132_4392# 0.0496f
C2937 i4_b1 r2_b1 0.04689f
C2938 Xd3/m1_822_4448# vbp_st 0.06179f
C2939 vdd Xd3/a_2808_3816# -0.00211f
C2940 vdd vbn_ref 1.01336f
C2941 Xvi/m1_8042_6360# vss -0.34513f
C2942 vbn_prb vss 1.21583f
C2943 el vss 4.20213f
C2944 Xvi/m1_4546_7560# vss -0.34405f
C2945 ib_x2 vss 3.38591f
C2946 Xm/iint vss 1.22578f
C2947 vth_cmp vss 2.37746f
C2948 Xvi/m1_1382_738# vss -0.27404f
C2949 Xvi/m1_942_738# vss -0.31018f
C2950 Xvi/m1_502_738# vss -0.26531f
C2951 Xvi/m1_7440_2050# vss -0.42145f
C2952 vth_ref vss 2.82234f
C2953 Xvi/m1_8332_7080# vss -0.29867f
C2954 Xvi/a_2102_5152# vss -0.50803f
C2955 Xvi/a_4976_1528# vss -0.84244f
C2956 Xvi/a_864_6450# vss -2.91518f
C2957 Xvi/m1_4894_1238# vss -0.72153f
C2958 Xr/vglp vss 0.94617f
C2959 vreset_src vss 3.0106f
C2960 Xvi/m1_5388_6960# vss -0.33944f
C2961 Xvi/a_5712_1328# vss -1.74946f
C2962 Xvi/m1_8646_1098# vss -0.08118f
C2963 bias_en vss 2.6265f
C2964 Xvi/m1_7102_850# vss -0.72324f
C2965 Xvi/m1_1276_6360# vss -0.31248f
C2966 ib_r1 vss 0.83027f
C2967 vdd vss -0.29753p
C2968 Xd3/m1_4078_3250# vss -0.84258f
C2969 Xd3/m1_3908_2760# vss -0.87519f
C2970 Xd3/m1_1262_4448# vss -0.25195f
C2971 Xd3/m1_1702_4448# vss -0.25059f
C2972 Xd3/m1_3222_4448# vss -0.87155f
C2973 Xd3/m1_2720_2760# vss -0.86275f
C2974 Xd3/m1_822_4448# vss -0.29374f
C2975 Xd3/m1_2408_3600# vss -0.9332f
C2976 Xd3/m1_1523_3480# vss -0.75282f
C2977 Xd3/m1_382_4448# vss -0.24624f
C2978 Xd3/m1_5422_4448# vss -0.30933f
C2979 Xd3/m1_4982_4448# vss -0.3051f
C2980 Xd3/a_1624_3816# vss -0.35285f
C2981 v0_c0 vss 1.23602f
C2982 Xd3/a_2216_3816# vss -0.43341f
C2983 v0_c1 vss 1.27503f
C2984 v0_c2 vss 1.3402f
C2985 Xd3/a_2808_3816# vss -0.41954f
C2986 Xd3/a_3400_3816# vss -0.36433f
C2987 v0_c3 vss 1.36488f
C2988 Xd3/a_3992_3816# vss -0.48079f
C2989 v0_c4 vss 1.95556f
C2990 Xd3/a_4584_3816# vss -0.29224f
C2991 v0_c5 vss 1.42489f
C2992 Xd3/m1_4102_4448# vss -0.2692f
C2993 Xd2/m1_2964_2640# vss -0.68189f
C2994 Xd2/m1_1342_4048# vss -0.29349f
C2995 Xd2/m1_1663_4920# vss -0.83061f
C2996 Xd2/m1_2382_2650# vss -0.75633f
C2997 Xd2/m1_902_4048# vss -0.30856f
C2998 Xd2/m1_756_2640# vss -0.91293f
C2999 Xd2/m1_596_3240# vss -0.71561f
C3000 Xd2/m1_240_4046# vss -0.26202f
C3001 Xd2/a_680_3416# vss -0.27118f
C3002 r2_b0 vss 1.99886f
C3003 Xd2/a_1272_3416# vss -0.35328f
C3004 r2_b1 vss 2.08585f
C3005 Xd2/a_1864_3416# vss -0.40912f
C3006 r2_b2 vss 0.86869f
C3007 r2_b4 vss 1.33645f
C3008 Xd2/a_2456_3416# vss -0.38497f
C3009 r2_b3 vss 1.24231f
C3010 Xd2/a_3048_3416# vss -0.26432f
C3011 Xr/m1_3862_3522# vss -0.25117f
C3012 Xr/m1_3422_438# vss -0.23644f
C3013 Xr/m1_2542_438# vss -0.23644f
C3014 Xr/m1_1662_438# vss -0.23613f
C3015 Xr/m1_1222_3522# vss -0.25114f
C3016 Xr/m1_782_438# vss -0.23409f
C3017 Xr/m1_342_438# vss -0.33805f
C3018 Xd1/m1_2974_2650# vss -0.76409f
C3019 Xd1/m1_2372_2520# vss -0.79747f
C3020 Xd1/m1_1780_5040# vss -0.75014f
C3021 Xd1/m1_860_4046# vss -0.26332f
C3022 Xd1/m1_756_3120# vss -0.7821f
C3023 Xd1/m1_606_2410# vss -0.69776f
C3024 Xd1/m1_462_4048# vss -0.28598f
C3025 Xd1/a_680_3416# vss -0.29657f
C3026 r1_b0 vss 0.95188f
C3027 Xd1/a_1272_3416# vss -0.34744f
C3028 r1_b1 vss 0.69803f
C3029 Xd1/a_1864_3416# vss -0.40704f
C3030 r1_b2 vss 0.43312f
C3031 r1_b4 vss 1.05806f
C3032 Xd1/a_2456_3416# vss -0.33818f
C3033 r1_b3 vss 0.77273f
C3034 Xd1/a_3048_3416# vss -0.28492f
C3035 Xd1/m1_2862_4048# vss -0.27443f
C3036 Xd0/m1_3310_2880# vss -0.73045f
C3037 Xd0/m1_1262_4048# vss -0.25366f
C3038 Xd0/m1_2242_4966# vss -0.70543f
C3039 Xd0/m1_2742_3250# vss -0.71543f
C3040 Xd0/m1_822_4048# vss -0.24452f
C3041 Xd0/m1_617_3840# vss -0.84316f
C3042 Xd0/m1_956_3000# vss -0.63802f
C3043 Xd0/m1_382_4048# vss -0.29187f
C3044 Xd0/a_1040_3416# vss -0.25322f
C3045 r0_b0 vss 1.98743f
C3046 Xd0/a_1632_3416# vss -0.36427f
C3047 r0_b1 vss -0.10006f
C3048 Xd0/a_2224_3416# vss -0.28994f
C3049 r0_b2 vss 1.22224f
C3050 Xd0/a_2816_3416# vss -0.26589f
C3051 r0_b3 vss 0.7132f
C3052 Xd0/a_3408_3416# vss -0.21381f
C3053 r0_b4 vss 0.27417f
C3054 Xd0/m1_3662_4048# vss -0.26754f
C3055 Xi4/m1_988_888# vss -1.35084f
C3056 Xr/vsn vss -8.41593f
C3057 Xi4/g vss -11.78633f
C3058 Xi4/a_3928_4170# vss -0.18606f
C3059 Xi4/a_3078_4170# vss -0.24239f
C3060 Xi4/m1_1500_3762# vss -0.1144f
C3061 Xi4/a_1378_4170# vss -0.18612f
C3062 Xi4/a_2228_4170# vss -0.18393f
C3063 Xi4/m1_260_2080# vss 0.06557f
C3064 vbp_w vss 1.28318f
C3065 Xi4/a_528_4170# vss -0.18271f
C3066 Xi4/m1_988_3304# vss -0.26784f
C3067 Xi4/a_4132_4170# vss -0.26623f
C3068 i4_b4 vss 0.5072f
C3069 Xi4/a_2432_4170# vss -0.27151f
C3070 i4_b2 vss 1.2689f
C3071 Xi4/a_3282_4170# vss -0.27223f
C3072 i4_b3 vss 0.70048f
C3073 Xi4/a_1582_4170# vss -0.27184f
C3074 i4_b1 vss 0.87144f
C3075 Xi4/a_732_4170# vss -0.27127f
C3076 i4_b0 vss 0.50531f
C3077 Xi4/m1_988_2644# vss -0.63614f
C3078 Xi3/m1_988_888# vss -0.17489f
C3079 Xr/vsp vss -17.77169f
C3080 Xi3/g vss -4.97053f
C3081 Xi3/a_4132_4392# vss -0.12f
C3082 Xi3/a_3928_4392# vss -0.20245f
C3083 Xi3/a_3282_4392# vss -0.12356f
C3084 Xi3/a_3078_4392# vss -0.20726f
C3085 Xi3/m1_1500_4312# vss -0.03907f
C3086 Xi3/a_1582_4392# vss -0.11988f
C3087 Xi3/a_1378_4392# vss -0.204f
C3088 Xi3/a_2432_4392# vss -0.11999f
C3089 Xi3/a_2228_4392# vss -0.20497f
C3090 Xi3/m1_240_3480# vss -0.09904f
C3091 vbn_ax vss 0.7046f
C3092 Xi3/a_732_4392# vss -0.12367f
C3093 Xi3/a_528_4392# vss -0.2073f
C3094 Xi3/m1_988_3464# vss -0.04504f
C3095 i3_b4 vss 0.55675f
C3096 i3_b3 vss 0.94948f
C3097 i3_b2 vss 1.06493f
C3098 i3_b1 vss 1.45783f
C3099 i3_b0 vss 1.14201f
C3100 Xi3/m1_988_2804# vss -0.07925f
C3101 vbp_st vss 0.84811f
C3102 Xi2/m1_988_888# vss -1.39996f
C3103 Xi2/g vss -13.54916f
C3104 Xi2/a_3928_4170# vss -0.18615f
C3105 Xi2/a_3078_4170# vss -0.25001f
C3106 Xi2/m1_1500_3762# vss -0.11611f
C3107 Xi2/a_1378_4170# vss -0.18612f
C3108 Xi2/a_2228_4170# vss -0.18393f
C3109 Xi2/m1_260_2080# vss -0.18583f
C3110 vbp_syn vss 0.10186f
C3111 Xi2/a_528_4170# vss -0.18553f
C3112 Xi2/m1_988_3304# vss -0.27572f
C3113 Xi2/a_4132_4170# vss -0.26647f
C3114 i2_b4 vss 0.57745f
C3115 Xi2/a_2432_4170# vss -0.27133f
C3116 i2_b2 vss 0.40044f
C3117 Xi2/a_3282_4170# vss -0.27201f
C3118 i2_b3 vss 0.77174f
C3119 Xi2/a_1582_4170# vss -0.27165f
C3120 i2_b1 vss 0.62692f
C3121 Xi2/a_732_4170# vss -0.27263f
C3122 i2_b0 vss 0.15584f
C3123 Xi2/m1_988_2644# vss -0.71384f
C3124 Xm/a_2240_11218# vss -0.57232f
C3125 ua0_int vss 1.68765f
C3126 Xm/a_736_7228# vss -7.07998f
C3127 Xr/en_b vss 0.07171f
C3128 ua0_stim_out vss 1.4184f
C3129 ua0_stim vss 0.40242f
C3130 Xm/a_1764_11418# vss -0.44562f
C3131 Xm/a_1744_9182# vss -0.51398f
C3132 Xm/a_736_5516# vss -6.5814f
C3133 Xm/a_420_700# vss -1.48974f
C3134 ua0_s0 vss 1.6187f
C3135 ua0_s1 vss 1.00944f
C3136 ua0 vss 0.5688f
C3137 Xm/a_1744_10100# vss -0.56385f
C3138 Xi1/m1_988_888# vss -0.15731f
C3139 Xi1/g vss -5.16777f
C3140 Xi1/a_4132_4392# vss -0.12f
C3141 Xi1/a_3928_4392# vss -0.20302f
C3142 Xi1/a_3282_4392# vss -0.12232f
C3143 Xi1/a_3078_4392# vss -0.20561f
C3144 Xi1/m1_1500_4312# vss -0.02797f
C3145 Xi1/a_1582_4392# vss -0.10915f
C3146 Xi1/a_1378_4392# vss -0.17201f
C3147 Xi1/a_2432_4392# vss -0.11847f
C3148 Xi1/a_2228_4392# vss -0.20144f
C3149 Xi1/m1_240_3480# vss 0.0251f
C3150 vbn_ref vss -0.74122f
C3151 Xi1/a_732_4392# vss -0.00967f
C3152 Xi1/a_528_4392# vss -0.18009f
C3153 Xi1/m1_988_3464# vss 0.12042f
C3154 i1_b4 vss 0.18565f
C3155 i1_b3 vss 0.21569f
C3156 i1_b2 vss 0.17252f
C3157 i1_b1 vss 0.19993f
C3158 i1_b0 vss 0.29801f
C3159 Xi1/m1_988_2804# vss -0.07425f
C3160 Xi0/m1_988_888# vss 0.26608f
C3161 Xi0/g vss -4.2926f
C3162 Xi0/a_4132_4392# vss -0.12082f
C3163 Xi0/a_3928_4392# vss -0.20655f
C3164 Xi0/a_3282_4392# vss -0.12232f
C3165 Xi0/a_3078_4392# vss -0.20552f
C3166 Xi0/m1_1500_4312# vss -0.03019f
C3167 Xi0/a_1582_4392# vss -0.0919f
C3168 Xi0/a_1378_4392# vss -0.15575f
C3169 Xi0/a_2432_4392# vss -0.11919f
C3170 Xi0/a_2228_4392# vss -0.20437f
C3171 Xi0/m1_240_3480# vss -0.09498f
C3172 vbn_leak vss 0.07423f
C3173 Xi0/a_732_4392# vss -0.07494f
C3174 Xi0/a_528_4392# vss -0.16407f
C3175 Xi0/m1_988_3464# vss -0.0453f
C3176 i0_b4 vss 0.27459f
C3177 i0_b3 vss 0.75806f
C3178 i0_b2 vss 0.41213f
C3179 i0_b1 vss 0.815f
C3180 i0_b0 vss 0.35821f
C3181 Xi0/m1_988_2804# vss -0.07584f
C3182 Xg/a_1580_5314# vss -0.48465f
C3183 Xg/m1_4906_9490# vss -0.10136f
C3184 Xg/m1_3898_9610# vss -0.0946f
C3185 Xg/m1_3666_9610# vss -0.09597f
C3186 Xm/in_p vss 0.76341f
C3187 Xr/vgln vss -9.0581f
C3188 Xg/a_5188_4156# vss -0.90814f
C3189 Xg/a_7580_5314# vss -0.09017f
C3190 Xg/a_3036_4156# vss -0.88298f
C3191 Xg/a_4580_5314# vss -0.14327f
C3192 Xg/m1_6282_1450# vss -0.11827f
C3193 Xg/m1_5516_1920# vss -0.24903f
C3194 Xg/m1_4538_1930# vss -0.22136f
C3195 Xg/m1_4760_1320# vss -0.18652f
C3196 Xg/m1_3530_1930# vss -0.41559f
C3197 Xg/m1_3298_2050# vss -0.25631f
C3198 Xm/in_n vss 0.10885f
C3199 Xg/m1_6020_10200# vss -0.14796f
C3200 Xg/m1_5022_10210# vss -0.09562f
.ends
