* find AH starved-inverter trip vs vsrc
.include /foss/pdks/gf180mcuD/libs.tech/ngspice/design.ngspice
.lib /foss/pdks/gf180mcuD/libs.tech/ngspice/sm141064.ngspice typical
.lib /foss/pdks/gf180mcuD/libs.tech/ngspice/sm141064.ngspice moscap_typical
.include /work/cells/neuron/membrane.spice
.include /work/cells/neuron/lif.spice
Vdd vdd 0 3.3
Vs vsrc 0 0.8
Ibs vbs 0 100n
Xbs vbs vdd pmaster w=1u l=2u
Vm vm 0 1.0
XPS s   vbs vdd vdd pfet_03v3 W=1u L=2u
XPI n1  vm  s   vdd pfet_03v3 W=1u L=0.5u
XNI n1  vm  vsrc 0 nfet_03v3 W=1u L=0.5u
.control
foreach vs 0.6 0.7 0.8 0.9
alter vs dc=$vs
dc vm 0.8 1.8 1m
meas dc trip when v(n1)=1.65 fall=1
end
quit
.endc
.end
