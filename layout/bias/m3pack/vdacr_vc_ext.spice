* NGSPICE file created from vdacr_vc.ext - technology: gf180mcuD

.subckt r_w2_l1p315 a_n200_n254# a_n200_132# VSUBS
X0 a_n200_132# a_n200_n254# VSUBS ppolyf_u_1k r_width=2u r_length=1.32u
.ends

.subckt r_w2_l2p625 a_n200_n385# a_n200_263# VSUBS
X0 a_n200_263# a_n200_n385# VSUBS ppolyf_u_1k r_width=2u r_length=2.63u
.ends

.subckt r_w1_l5p175 a_n100_518# a_n100_n640# VSUBS
X0 a_n100_518# a_n100_n640# VSUBS ppolyf_u_1k r_width=1u r_length=5.18u
.ends

.subckt r_w1_l2p59 a_n100_n381# a_n100_259# VSUBS
X0 a_n100_259# a_n100_n381# VSUBS ppolyf_u_1k r_width=1u r_length=2.59u
.ends

.subckt r_w1_l10p35 a_n100_n1157# a_n100_1035# VSUBS
X0 a_n100_1035# a_n100_n1157# VSUBS ppolyf_u_1k r_width=1u r_length=10.35u
.ends

.subckt n_w0p5_l1 a_100_n50# a_n100_n94# a_n188_n50# VSUBS
X0 a_100_n50# a_n100_n94# a_n188_n50# VSUBS nfet_03v3 ad=0.22p pd=1.88u as=0.22p ps=1.88u w=0.5u l=1u
.ends

.subckt p_w1_l1 a_n188_n100# a_100_n100# a_n100_n144# w_n274_n230#
X0 a_100_n100# a_n100_n144# a_n188_n100# w_n274_n230# pfet_03v3 ad=0.44p pd=2.88u as=0.44p ps=2.88u w=1u l=1u
.ends

.subckt r_w1_l12p86 a_n100_n1408# a_n100_1286# VSUBS
X0 a_n100_1286# a_n100_n1408# VSUBS ppolyf_u_1k r_width=1u r_length=12.86u
.ends

.subckt n_w4_l0p28_f2 a_n52_n400# a_52_n444# a_108_n400# a_n108_n444# a_n196_n400#
+ VSUBS
X0 a_108_n400# a_52_n444# a_n52_n400# VSUBS nfet_03v3 ad=1.76p pd=8.88u as=1.04p ps=4.52u w=4u l=0.28u
X1 a_n52_n400# a_n108_n444# a_n196_n400# VSUBS nfet_03v3 ad=1.04p pd=4.52u as=1.76p ps=8.88u w=4u l=0.28u
.ends

.subckt vdacr_vc b0 b1 b2 b3 b4 vdd out vss
XXRS0 m1_756_2640# m1_596_3240# vss r_w2_l1p315
XXRS1 m1_1663_4920# m1_756_2640# vss r_w2_l2p625
XXRS3 m1_2382_2650# m1_2964_2640# vss r_w1_l5p175
XXRS2 m1_2382_2650# m1_1663_4920# vss r_w1_l2p59
XXRS4 vss m1_2964_2640# vss r_w1_l10p35
XIB4n a_3048_3416# b4 vss vss n_w0p5_l1
XIB3n a_2456_3416# b3 vss vss n_w0p5_l1
XIB4p vdd a_3048_3416# b4 vdd p_w1_l1
XIB2n a_1864_3416# b2 vss vss n_w0p5_l1
XIB3p vdd a_2456_3416# b3 vdd p_w1_l1
XIB2p vdd a_1864_3416# b2 vdd p_w1_l1
XIB1n a_1272_3416# b1 vss vss n_w0p5_l1
XIB0n a_680_3416# b0 vss vss n_w0p5_l1
XIB1p vdd a_1272_3416# b1 vdd p_w1_l1
XIB0p vdd a_680_3416# b0 vdd p_w1_l1
XXRB0 m1_240_4046# out vss r_w1_l12p86
XSW0 m1_756_2640# a_680_3416# m1_596_3240# a_680_3416# m1_596_3240# vss n_w4_l0p28_f2
XXRB1 m1_902_4048# m1_240_4046# vss r_w1_l12p86
XSW2 m1_2382_2650# a_1864_3416# m1_1663_4920# a_1864_3416# m1_1663_4920# vss n_w4_l0p28_f2
XSW1 m1_1663_4920# a_1272_3416# m1_756_2640# a_1272_3416# m1_756_2640# vss n_w4_l0p28_f2
XXRB3 m1_596_3240# m1_1342_4048# vss r_w1_l12p86
XXRB2 m1_1342_4048# m1_902_4048# vss r_w1_l12p86
XSW3 m1_2964_2640# a_2456_3416# m1_2382_2650# a_2456_3416# m1_2382_2650# vss n_w4_l0p28_f2
XSW4 vss a_3048_3416# m1_2964_2640# a_3048_3416# m1_2964_2640# vss n_w4_l0p28_f2
.ends
