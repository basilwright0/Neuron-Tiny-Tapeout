* NGSPICE file created from vdacr_el_vdac.ext - technology: gf180mcuD

.subckt r_w1_l7p765 a_n100_n899# a_n100_777# VSUBS
X0 a_n100_777# a_n100_n899# VSUBS ppolyf_u_1k r_width=1u r_length=7.77u
C0 a_n100_n899# VSUBS 0.27003f
C1 a_n100_777# VSUBS 0.27003f
.ends

.subckt r_w2_l1p97 a_n200_n319# a_n200_197# VSUBS
X0 a_n200_197# a_n200_n319# VSUBS ppolyf_u_1k r_width=2u r_length=1.97u
C0 a_n200_197# a_n200_n319# 0.02096f
C1 a_n200_n319# VSUBS 0.42971f
C2 a_n200_197# VSUBS 0.42971f
.ends

.subckt r_w1_l1p94 a_n100_n316# a_n100_194# VSUBS
X0 a_n100_194# a_n100_n316# VSUBS ppolyf_u_1k r_width=1u r_length=1.94u
C0 a_n100_194# a_n100_n316# 0.01052f
C1 a_n100_n316# VSUBS 0.2541f
C2 a_n100_194# VSUBS 0.2541f
.ends

.subckt r_w1_l3p88 a_n100_n510# a_n100_388# VSUBS
X0 a_n100_388# a_n100_n510# VSUBS ppolyf_u_1k r_width=1u r_length=3.88u
C0 a_n100_388# a_n100_n510# 0.00535f
C1 a_n100_n510# VSUBS 0.26053f
C2 a_n100_388# VSUBS 0.26053f
.ends

.subckt n_w0p5_l1 a_100_n50# a_n100_n94# a_n188_n50# VSUBS
X0 a_100_n50# a_n100_n94# a_n188_n50# VSUBS nfet_03v3 ad=0.22p pd=1.88u as=0.22p ps=1.88u w=0.5u l=1u
C0 a_n100_n94# a_n188_n50# 0.01026f
C1 a_n188_n50# a_100_n50# 0.00935f
C2 a_n100_n94# a_100_n50# 0.01026f
C3 a_100_n50# VSUBS 0.13392f
C4 a_n188_n50# VSUBS 0.13392f
.ends

.subckt p_w1_l1 a_n188_n100# a_100_n100# a_n100_n144# w_n274_n230# VSUBS
X0 a_100_n100# a_n100_n144# a_n188_n100# w_n274_n230# pfet_03v3 ad=0.44p pd=2.88u as=0.44p ps=2.88u w=1u l=1u
C0 a_100_n100# a_n188_n100# 0.0191f
C1 w_n274_n230# a_n100_n144# 0.12884f
C2 a_100_n100# a_n100_n144# 0.02094f
C3 w_n274_n230# a_100_n100# 0.02517f
C4 a_n100_n144# a_n188_n100# 0.02094f
C5 w_n274_n230# a_n188_n100# 0.02517f
C6 a_100_n100# VSUBS 0.07854f
C7 a_n188_n100# VSUBS 0.07854f
C8 w_n274_n230# VSUBS 0.75624f
.ends

.subckt r_w1_l11p645 a_n100_1165# a_n100_n1287# VSUBS
X0 a_n100_1165# a_n100_n1287# VSUBS ppolyf_u_1k r_width=1u r_length=11.65u
C0 a_n100_n1287# VSUBS 0.27003f
C1 a_n100_1165# VSUBS 0.27003f
.ends

.subckt n_w4_l0p28_f2 a_n52_n400# a_52_n444# a_108_n400# a_n108_n444# a_n196_n400#
+ VSUBS
X0 a_108_n400# a_52_n444# a_n52_n400# VSUBS nfet_03v3 ad=1.76p pd=8.88u as=1.04p ps=4.52u w=4u l=0.28u
X1 a_n52_n400# a_n108_n444# a_n196_n400# VSUBS nfet_03v3 ad=1.04p pd=4.52u as=1.76p ps=8.88u w=4u l=0.28u
C0 a_n52_n400# a_n196_n400# 0.17284f
C1 a_108_n400# a_52_n444# 0.03125f
C2 a_n52_n400# a_108_n400# 0.17284f
C3 a_n108_n444# a_52_n444# 0.00519f
C4 a_n52_n400# a_52_n444# 0.03125f
C5 a_n108_n444# a_n52_n400# 0.03125f
C6 a_n108_n444# a_n196_n400# 0.03125f
C7 a_108_n400# VSUBS 0.20946f
C8 a_n52_n400# VSUBS 0.09458f
C9 a_n196_n400# VSUBS 0.20946f
.ends

.subckt vdacr_el_vdac b0 b1 b2 b3 b4 vdd out vss
XXRS4_0 m1_3662_4048# m1_3310_2880# vss r_w1_l7p765
XXRS4_1 vss m1_3662_4048# vss r_w1_l7p765
XXRS0 m1_617_3840# m1_956_3000# vss r_w2_l1p97
XXRS1 m1_2242_4966# m1_617_3840# vss r_w1_l1p94
XXRS3 m1_3310_2880# m1_2742_3250# vss r_w1_l7p765
XXRS2 m1_2742_3250# m1_2242_4966# vss r_w1_l3p88
XIB4n a_3408_3416# b4 vss vss n_w0p5_l1
XIB3n a_2816_3416# b3 vss vss n_w0p5_l1
XIB4p vdd a_3408_3416# b4 vdd vss p_w1_l1
XIB2n a_2224_3416# b2 vss vss n_w0p5_l1
XIB3p vdd a_2816_3416# b3 vdd vss p_w1_l1
XIB2p vdd a_2224_3416# b2 vdd vss p_w1_l1
XIB1n a_1632_3416# b1 vss vss n_w0p5_l1
XIB0n a_1040_3416# b0 vss vss n_w0p5_l1
XIB1p vdd a_1632_3416# b1 vdd vss p_w1_l1
XIB0p vdd a_1040_3416# b0 vdd vss p_w1_l1
XXRB0 out m1_382_4048# vss r_w1_l11p645
XSW0 m1_617_3840# a_1040_3416# m1_956_3000# a_1040_3416# m1_956_3000# vss n_w4_l0p28_f2
XXRB1 m1_382_4048# m1_822_4048# vss r_w1_l11p645
XSW2 m1_2742_3250# a_2224_3416# m1_2242_4966# a_2224_3416# m1_2242_4966# vss n_w4_l0p28_f2
XSW1 m1_2242_4966# a_1632_3416# m1_617_3840# a_1632_3416# m1_617_3840# vss n_w4_l0p28_f2
XXRB3 m1_1262_4048# m1_956_3000# vss r_w1_l11p645
XXRB2 m1_822_4048# m1_1262_4048# vss r_w1_l11p645
XSW3 m1_3310_2880# a_2816_3416# m1_2742_3250# a_2816_3416# m1_2742_3250# vss n_w4_l0p28_f2
XSW4 vss a_3408_3416# m1_3310_2880# a_3408_3416# m1_3310_2880# vss n_w4_l0p28_f2
C0 m1_2242_4966# a_2816_3416# 0
C1 m1_382_4048# m1_617_3840# 0.32274f
C2 vdd b1 0.48179f
C3 m1_2742_3250# m1_3310_2880# 0.31172f
C4 vdd a_2816_3416# 0.1469f
C5 m1_617_3840# m1_1262_4048# 0.13358f
C6 m1_2242_4966# b2 0.00331f
C7 m1_382_4048# out 0.02694f
C8 a_3408_3416# b3 0
C9 vdd b2 0.46487f
C10 out m1_1262_4048# 0.01147f
C11 m1_956_3000# m1_3662_4048# 0
C12 b0 m1_617_3840# 0
C13 m1_2242_4966# vdd 0.0033f
C14 b4 m1_3310_2880# 0.01127f
C15 m1_822_4048# m1_617_3840# 0.123f
C16 m1_1262_4048# m1_2742_3250# 0.009f
C17 out m1_822_4048# 0.02257f
C18 b3 m1_2742_3250# 0.00105f
C19 m1_382_4048# a_1040_3416# 0
C20 m1_956_3000# m1_3310_2880# 0
C21 m1_2242_4966# m1_3662_4048# 0
C22 m1_1262_4048# a_1040_3416# 0
C23 b0 a_1040_3416# 0.2598f
C24 a_2816_3416# m1_3310_2880# 0.20114f
C25 b4 b3 0.04052f
C26 m1_822_4048# a_1040_3416# 0
C27 m1_956_3000# m1_382_4048# 0.00423f
C28 m1_2242_4966# m1_3310_2880# 0
C29 m1_956_3000# m1_1262_4048# 0.07066f
C30 vdd m1_3310_2880# 0.00483f
C31 m1_956_3000# b0 0.00622f
C32 b1 b3 0
C33 a_2816_3416# b3 0.2249f
C34 m1_382_4048# m1_2242_4966# 0
C35 m1_956_3000# m1_822_4048# 0.03636f
C36 b0 b1 0.02882f
C37 b2 b3 0.04135f
C38 m1_3662_4048# m1_3310_2880# 0.3114f
C39 m1_2242_4966# m1_1262_4048# 0.01042f
C40 vdd b3 0.44294f
C41 a_1632_3416# a_2224_3416# 0.03245f
C42 b0 b2 0.00416f
C43 b0 vdd 0.49326f
C44 a_1632_3416# m1_617_3840# 0.15378f
C45 m1_822_4048# m1_2242_4966# 0
C46 a_1632_3416# m1_2742_3250# 0.00921f
C47 a_1632_3416# a_1040_3416# 0.0443f
C48 b3 m1_3310_2880# 0.02434f
C49 a_1632_3416# m1_956_3000# 0.03269f
C50 m1_617_3840# a_2224_3416# 0.03861f
C51 a_1632_3416# b1 0.35929f
C52 a_3408_3416# a_2224_3416# 0
C53 a_1632_3416# a_2816_3416# 0.00123f
C54 a_1632_3416# b2 0.02431f
C55 m1_382_4048# m1_822_4048# 0.39941f
C56 a_1632_3416# m1_2242_4966# 0.15001f
C57 out m1_617_3840# 0.00314f
C58 m1_822_4048# m1_1262_4048# 0.18781f
C59 a_1632_3416# vdd 0.17222f
C60 a_2224_3416# m1_2742_3250# 0.23293f
C61 a_2224_3416# a_1040_3416# 0
C62 m1_617_3840# m1_2742_3250# 0.01845f
C63 a_3408_3416# m1_2742_3250# 0.01258f
C64 m1_617_3840# a_1040_3416# 0.2193f
C65 a_2224_3416# b4 0
C66 m1_956_3000# a_2224_3416# 0
C67 a_3408_3416# b4 0.21422f
C68 a_1632_3416# m1_3310_2880# 0
C69 m1_956_3000# m1_617_3840# 0.75011f
C70 a_2224_3416# b1 0
C71 a_2224_3416# a_2816_3416# 0.17309f
C72 a_2224_3416# b2 0.22771f
C73 m1_617_3840# b1 0.00533f
C74 m1_2242_4966# a_2224_3416# 0.17274f
C75 m1_617_3840# a_2816_3416# 0
C76 a_2224_3416# vdd 0.20102f
C77 a_3408_3416# a_2816_3416# 0.03415f
C78 m1_2242_4966# m1_617_3840# 0.32683f
C79 a_1632_3416# m1_1262_4048# 0.00132f
C80 a_1632_3416# b3 0.00127f
C81 m1_956_3000# m1_2742_3250# 0.00197f
C82 m1_617_3840# vdd 0
C83 a_3408_3416# vdd 0.22664f
C84 m1_956_3000# a_1040_3416# 0.11081f
C85 a_1632_3416# b0 0.00371f
C86 a_2816_3416# m1_2742_3250# 0.2733f
C87 a_1040_3416# b1 0.03315f
C88 b2 m1_2742_3250# 0.01093f
C89 m1_2242_4966# m1_2742_3250# 0.46801f
C90 m1_617_3840# m1_3662_4048# 0
C91 a_1040_3416# b2 0.00223f
C92 vdd m1_2742_3250# 0.00512f
C93 a_3408_3416# m1_3662_4048# 0
C94 b4 b1 0.00115f
C95 a_1040_3416# vdd 0.27317f
C96 b4 a_2816_3416# 0.05297f
C97 a_2224_3416# m1_3310_2880# 0.05997f
C98 b4 b2 0
C99 m1_956_3000# b1 0
C100 vdd b4 0.59499f
C101 m1_617_3840# m1_3310_2880# 0.00278f
C102 m1_3662_4048# m1_2742_3250# 0.03614f
C103 a_3408_3416# m1_3310_2880# 0.07699f
C104 m1_956_3000# b2 0
C105 m1_956_3000# m1_2242_4966# 0.15942f
C106 m1_956_3000# vdd 0.00146f
C107 a_2816_3416# b1 0
C108 b2 b1 0.04707f
C109 a_2224_3416# b3 0.05038f
C110 m1_2242_4966# b1 0.00209f
C111 m1_3310_2880# vss 1.09895f
C112 m1_1262_4048# vss 0.55221f
C113 m1_2242_4966# vss 0.19454f
C114 m1_2742_3250# vss 0.65139f
C115 m1_822_4048# vss 0.24942f
C116 m1_617_3840# vss 2.00651f
C117 m1_956_3000# vss 0.55486f
C118 m1_382_4048# vss 0.33796f
C119 out vss 0.8541f
C120 a_1040_3416# vss 1.07104f
C121 b0 vss 0.4933f
C122 vdd vss 10.07211f
C123 a_1632_3416# vss 0.5138f
C124 b1 vss 0.49625f
C125 a_2224_3416# vss 0.54715f
C126 b2 vss 0.3102f
C127 a_2816_3416# vss 0.43096f
C128 b3 vss 0.35598f
C129 a_3408_3416# vss 1.10802f
C130 b4 vss 0.34471f
C131 m1_3662_4048# vss 0.38401f
.ends
