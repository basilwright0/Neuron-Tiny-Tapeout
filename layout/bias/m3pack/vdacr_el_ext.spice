* NGSPICE file created from vdacr_el.ext - technology: gf180mcuD

.subckt r_w1_l7p765 a_n100_n899# a_n100_777# VSUBS
X0 a_n100_777# a_n100_n899# VSUBS ppolyf_u_1k r_width=1u r_length=7.77u
.ends

.subckt r_w2_l1p97 a_n200_n319# a_n200_197# VSUBS
X0 a_n200_197# a_n200_n319# VSUBS ppolyf_u_1k r_width=2u r_length=1.97u
.ends

.subckt r_w1_l1p94 a_n100_n316# a_n100_194# VSUBS
X0 a_n100_194# a_n100_n316# VSUBS ppolyf_u_1k r_width=1u r_length=1.94u
.ends

.subckt r_w1_l3p88 a_n100_n510# a_n100_388# VSUBS
X0 a_n100_388# a_n100_n510# VSUBS ppolyf_u_1k r_width=1u r_length=3.88u
.ends

.subckt n_w0p5_l1 a_100_n50# a_n100_n94# a_n188_n50# VSUBS
X0 a_100_n50# a_n100_n94# a_n188_n50# VSUBS nfet_03v3 ad=0.22p pd=1.88u as=0.22p ps=1.88u w=0.5u l=1u
.ends

.subckt p_w1_l1 a_n188_n100# a_100_n100# a_n100_n144# w_n274_n230#
X0 a_100_n100# a_n100_n144# a_n188_n100# w_n274_n230# pfet_03v3 ad=0.44p pd=2.88u as=0.44p ps=2.88u w=1u l=1u
.ends

.subckt r_w1_l11p645 a_n100_1165# a_n100_n1287# VSUBS
X0 a_n100_1165# a_n100_n1287# VSUBS ppolyf_u_1k r_width=1u r_length=11.65u
.ends

.subckt n_w4_l0p28_f2 a_n52_n400# a_52_n444# a_108_n400# a_n108_n444# a_n196_n400#
+ VSUBS
X0 a_108_n400# a_52_n444# a_n52_n400# VSUBS nfet_03v3 ad=1.76p pd=8.88u as=1.04p ps=4.52u w=4u l=0.28u
X1 a_n52_n400# a_n108_n444# a_n196_n400# VSUBS nfet_03v3 ad=1.04p pd=4.52u as=1.76p ps=8.88u w=4u l=0.28u
.ends

.subckt vdacr_el b0 b1 b2 b3 b4 vdd out vss
XXRS4_0 m1_3662_4048# m1_3310_2880# vss r_w1_l7p765
XXRS4_1 vss m1_3662_4048# vss r_w1_l7p765
XXRS0 m1_617_3840# m1_956_3000# vss r_w2_l1p97
XXRS1 m1_2242_4966# m1_617_3840# vss r_w1_l1p94
XXRS3 m1_3310_2880# m1_2742_3250# vss r_w1_l7p765
XXRS2 m1_2742_3250# m1_2242_4966# vss r_w1_l3p88
XIB4n a_3408_3416# b4 vss vss n_w0p5_l1
XIB3n a_2816_3416# b3 vss vss n_w0p5_l1
XIB4p vdd a_3408_3416# b4 vdd p_w1_l1
XIB2n a_2224_3416# b2 vss vss n_w0p5_l1
XIB3p vdd a_2816_3416# b3 vdd p_w1_l1
XIB2p vdd a_2224_3416# b2 vdd p_w1_l1
XIB1n a_1632_3416# b1 vss vss n_w0p5_l1
XIB0n a_1040_3416# b0 vss vss n_w0p5_l1
XIB1p vdd a_1632_3416# b1 vdd p_w1_l1
XIB0p vdd a_1040_3416# b0 vdd p_w1_l1
XXRB0 out m1_382_4048# vss r_w1_l11p645
XSW0 m1_617_3840# a_1040_3416# m1_956_3000# a_1040_3416# m1_956_3000# vss n_w4_l0p28_f2
XXRB1 m1_382_4048# m1_822_4048# vss r_w1_l11p645
XSW2 m1_2742_3250# a_2224_3416# m1_2242_4966# a_2224_3416# m1_2242_4966# vss n_w4_l0p28_f2
XSW1 m1_2242_4966# a_1632_3416# m1_617_3840# a_1632_3416# m1_617_3840# vss n_w4_l0p28_f2
XXRB3 m1_1262_4048# m1_956_3000# vss r_w1_l11p645
XXRB2 m1_822_4048# m1_1262_4048# vss r_w1_l11p645
XSW3 m1_3310_2880# a_2816_3416# m1_2742_3250# a_2816_3416# m1_2742_3250# vss n_w4_l0p28_f2
XSW4 vss a_3408_3416# m1_3310_2880# a_3408_3416# m1_3310_2880# vss n_w4_l0p28_f2
.ends
