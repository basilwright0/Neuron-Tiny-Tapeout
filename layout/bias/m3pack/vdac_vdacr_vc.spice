* NGSPICE file created from vdacr_vc_vdac.ext - technology: gf180mcuD

.subckt r_w2_l1p315 a_n200_n254# a_n200_132# VSUBS
X0 a_n200_132# a_n200_n254# VSUBS ppolyf_u_1k r_width=2u r_length=1.32u
C0 a_n200_132# a_n200_n254# 0.02982f
C1 a_n200_n254# VSUBS 0.42149f
C2 a_n200_132# VSUBS 0.42149f
.ends

.subckt r_w2_l2p625 a_n200_n385# a_n200_263# VSUBS
X0 a_n200_263# a_n200_n385# VSUBS ppolyf_u_1k r_width=2u r_length=2.63u
C0 a_n200_263# a_n200_n385# 0.01591f
C1 a_n200_n385# VSUBS 0.43549f
C2 a_n200_263# VSUBS 0.43549f
.ends

.subckt r_w1_l5p175 a_n100_518# a_n100_n640# VSUBS
X0 a_n100_518# a_n100_n640# VSUBS ppolyf_u_1k r_width=1u r_length=5.18u
C0 a_n100_518# a_n100_n640# 0.00399f
C1 a_n100_n640# VSUBS 0.26263f
C2 a_n100_518# VSUBS 0.26263f
.ends

.subckt r_w1_l2p59 a_n100_n381# a_n100_259# VSUBS
X0 a_n100_259# a_n100_n381# VSUBS ppolyf_u_1k r_width=1u r_length=2.59u
C0 a_n100_259# a_n100_n381# 0.00799f
C1 a_n100_n381# VSUBS 0.25697f
C2 a_n100_259# VSUBS 0.25697f
.ends

.subckt r_w1_l10p35 a_n100_n1157# a_n100_1035# VSUBS
X0 a_n100_1035# a_n100_n1157# VSUBS ppolyf_u_1k r_width=1u r_length=10.35u
C0 a_n100_n1157# VSUBS 0.27003f
C1 a_n100_1035# VSUBS 0.27003f
.ends

.subckt n_w0p5_l1 a_100_n50# a_n100_n94# a_n188_n50# VSUBS
X0 a_100_n50# a_n100_n94# a_n188_n50# VSUBS nfet_03v3 ad=0.22p pd=1.88u as=0.22p ps=1.88u w=0.5u l=1u
C0 a_n100_n94# a_n188_n50# 0.01026f
C1 a_n100_n94# a_100_n50# 0.01026f
C2 a_n188_n50# a_100_n50# 0.00935f
C3 a_100_n50# VSUBS 0.13392f
C4 a_n188_n50# VSUBS 0.13392f
.ends

.subckt p_w1_l1 a_n188_n100# a_100_n100# a_n100_n144# w_n274_n230# VSUBS
X0 a_100_n100# a_n100_n144# a_n188_n100# w_n274_n230# pfet_03v3 ad=0.44p pd=2.88u as=0.44p ps=2.88u w=1u l=1u
C0 w_n274_n230# a_n100_n144# 0.12884f
C1 w_n274_n230# a_100_n100# 0.02517f
C2 a_100_n100# a_n100_n144# 0.02094f
C3 w_n274_n230# a_n188_n100# 0.02517f
C4 a_n100_n144# a_n188_n100# 0.02094f
C5 a_100_n100# a_n188_n100# 0.0191f
C6 a_100_n100# VSUBS 0.07854f
C7 a_n188_n100# VSUBS 0.07854f
C8 w_n274_n230# VSUBS 0.75624f
.ends

.subckt r_w1_l14p555 a_n100_1456# a_n100_n1578# VSUBS
X0 a_n100_1456# a_n100_n1578# VSUBS ppolyf_u_1k r_width=1u r_length=14.56u
C0 a_n100_n1578# VSUBS 0.27003f
C1 a_n100_1456# VSUBS 0.27003f
.ends

.subckt n_w4_l0p28_f2 a_n52_n400# a_52_n444# a_108_n400# a_n108_n444# a_n196_n400#
+ VSUBS
X0 a_108_n400# a_52_n444# a_n52_n400# VSUBS nfet_03v3 ad=1.76p pd=8.88u as=1.04p ps=4.52u w=4u l=0.28u
X1 a_n52_n400# a_n108_n444# a_n196_n400# VSUBS nfet_03v3 ad=1.04p pd=4.52u as=1.76p ps=8.88u w=4u l=0.28u
C0 a_n108_n444# a_52_n444# 0.00519f
C1 a_n108_n444# a_n52_n400# 0.03125f
C2 a_n52_n400# a_52_n444# 0.03125f
C3 a_52_n444# a_108_n400# 0.03125f
C4 a_n108_n444# a_n196_n400# 0.03125f
C5 a_n52_n400# a_108_n400# 0.17284f
C6 a_n52_n400# a_n196_n400# 0.17284f
C7 a_108_n400# VSUBS 0.20946f
C8 a_n52_n400# VSUBS 0.09458f
C9 a_n196_n400# VSUBS 0.20946f
.ends

.subckt vdacr_vc_vdac b0 b1 b2 b3 b4 vdd out vss
XXRS0 m1_756_3240# m1_596_2880# vss r_w2_l1p315
XXRS1 m1_1780_2760# m1_756_3240# vss r_w2_l2p625
XXRS3 m1_2382_2650# m1_2964_2640# vss r_w1_l5p175
XXRS2 m1_2382_2650# m1_1780_2760# vss r_w1_l2p59
XXRS4 vss m1_2964_2640# vss r_w1_l10p35
XIB4n a_3048_3416# b4 vss vss n_w0p5_l1
XIB3n a_2456_3416# b3 vss vss n_w0p5_l1
XIB4p vdd a_3048_3416# b4 vdd vss p_w1_l1
XIB2n a_1864_3416# b2 vss vss n_w0p5_l1
XIB3p vdd a_2456_3416# b3 vdd vss p_w1_l1
XIB2p vdd a_1864_3416# b2 vdd vss p_w1_l1
XIB1n a_1272_3416# b1 vss vss n_w0p5_l1
XIB0n a_680_3416# b0 vss vss n_w0p5_l1
XIB1p vdd a_1272_3416# b1 vdd vss p_w1_l1
XIB0p vdd a_680_3416# b0 vdd vss p_w1_l1
XXRB0 out m1_462_4048# vss r_w1_l14p555
XSW0 m1_756_3240# a_680_3416# m1_596_2880# a_680_3416# m1_596_2880# vss n_w4_l0p28_f2
XXRB1 m1_462_4048# m1_902_4048# vss r_w1_l14p555
XSW2 m1_2382_2650# a_1864_3416# m1_1780_2760# a_1864_3416# m1_1780_2760# vss n_w4_l0p28_f2
XSW1 m1_1780_2760# a_1272_3416# m1_756_3240# a_1272_3416# m1_756_3240# vss n_w4_l0p28_f2
XXRB3 m1_1342_4048# m1_596_2880# vss r_w1_l14p555
XXRB2 m1_902_4048# m1_1342_4048# vss r_w1_l14p555
XSW3 m1_2964_2640# a_2456_3416# m1_2382_2650# a_2456_3416# m1_2382_2650# vss n_w4_l0p28_f2
XSW4 vss a_3048_3416# m1_2964_2640# a_3048_3416# m1_2964_2640# vss n_w4_l0p28_f2
C0 b3 b2 0.05389f
C1 a_1864_3416# a_2456_3416# 0.02091f
C2 m1_2382_2650# m1_1780_2760# 0.57773f
C3 m1_1780_2760# vdd 0.0024f
C4 m1_1342_4048# m1_2382_2650# 0.00106f
C5 b3 b4 0.05196f
C6 b1 vdd 0.42955f
C7 a_1864_3416# m1_2382_2650# 0.08407f
C8 b3 m1_2964_2640# 0
C9 m1_1780_2760# a_680_3416# 0
C10 m1_902_4048# m1_2964_2640# 0
C11 a_2456_3416# m1_756_3240# 0.00946f
C12 b1 a_680_3416# 0.0311f
C13 m1_902_4048# out 0.00898f
C14 b4 a_3048_3416# 0.28941f
C15 a_1864_3416# vdd 0.25499f
C16 m1_2964_2640# a_3048_3416# 0.09007f
C17 m1_2382_2650# m1_462_4048# 0
C18 a_1864_3416# a_680_3416# 0.00213f
C19 m1_2382_2650# m1_756_3240# 0.18929f
C20 m1_902_4048# m1_1780_2760# 0.0028f
C21 b2 a_1272_3416# 0.04376f
C22 m1_596_2880# b0 0.00542f
C23 b0 a_1272_3416# 0
C24 m1_756_3240# vdd 0.00935f
C25 m1_462_4048# a_680_3416# 0.00344f
C26 m1_902_4048# m1_1342_4048# 0.59267f
C27 m1_756_3240# a_680_3416# 0.09138f
C28 b3 a_1864_3416# 0.03231f
C29 m1_2964_2640# m1_596_2880# 0
C30 m1_2964_2640# a_1272_3416# 0
C31 a_1864_3416# a_3048_3416# 0
C32 m1_902_4048# m1_462_4048# 0.1067f
C33 m1_902_4048# m1_756_3240# 0.15859f
C34 m1_1780_2760# m1_596_2880# 0.13932f
C35 m1_2382_2650# a_2456_3416# 0.29833f
C36 m1_1780_2760# a_1272_3416# 0.20372f
C37 b1 a_1272_3416# 0.24461f
C38 m1_1342_4048# m1_596_2880# 0.05175f
C39 a_2456_3416# vdd 0.22632f
C40 a_1864_3416# m1_596_2880# 0.00298f
C41 m1_1342_4048# a_1272_3416# 0.00125f
C42 a_1864_3416# a_1272_3416# 0.13668f
C43 m1_2382_2650# vdd 0.00156f
C44 m1_596_2880# m1_462_4048# 0.10991f
C45 m1_596_2880# m1_756_3240# 0.63405f
C46 m1_2382_2650# a_680_3416# 0
C47 m1_756_3240# a_1272_3416# 0.25178f
C48 b3 a_2456_3416# 0.20171f
C49 m1_2964_2640# b4 0.01478f
C50 vdd a_680_3416# 0.29783f
C51 a_2456_3416# a_3048_3416# 0.03483f
C52 b2 m1_1780_2760# 0.01235f
C53 b2 b1 0.03672f
C54 b3 m1_2382_2650# 0.02078f
C55 m1_902_4048# m1_2382_2650# 0
C56 b1 b0 0.03223f
C57 m1_2382_2650# a_3048_3416# 0.00307f
C58 a_1864_3416# b2 0.30281f
C59 b3 vdd 0.45495f
C60 m1_2964_2640# m1_1780_2760# 0.00209f
C61 m1_902_4048# a_680_3416# 0
C62 m1_1780_2760# out 0.00408f
C63 a_3048_3416# vdd 0.1443f
C64 a_2456_3416# m1_596_2880# 0
C65 a_1864_3416# b4 0
C66 m1_2964_2640# m1_1342_4048# 0
C67 a_2456_3416# a_1272_3416# 0.01817f
C68 m1_2964_2640# a_1864_3416# 0
C69 m1_1342_4048# out 0.02845f
C70 m1_756_3240# b0 0
C71 b1 m1_1780_2760# 0
C72 m1_2382_2650# m1_596_2880# 0.12127f
C73 m1_2382_2650# a_1272_3416# 0.00845f
C74 b3 a_3048_3416# 0
C75 m1_1342_4048# m1_1780_2760# 0.36407f
C76 m1_2964_2640# m1_756_3240# 0.03724f
C77 a_1864_3416# m1_1780_2760# 0.45815f
C78 out m1_462_4048# 0.08186f
C79 m1_596_2880# vdd 0
C80 a_1864_3416# b1 0.01341f
C81 vdd a_1272_3416# 0.16599f
C82 m1_596_2880# a_680_3416# 0.18443f
C83 a_680_3416# a_1272_3416# 0.0323f
C84 m1_1780_2760# m1_462_4048# 0
C85 m1_1780_2760# m1_756_3240# 0.31426f
C86 b1 m1_756_3240# 0.02481f
C87 b2 a_2456_3416# 0.00423f
C88 m1_902_4048# m1_596_2880# 0.04254f
C89 b3 a_1272_3416# 0
C90 m1_902_4048# a_1272_3416# 0.00535f
C91 m1_1342_4048# m1_756_3240# 0.02959f
C92 a_1864_3416# m1_756_3240# 0.21894f
C93 b4 a_2456_3416# 0.08415f
C94 m1_2382_2650# b2 0.00779f
C95 m1_2964_2640# a_2456_3416# 0.19022f
C96 m1_756_3240# m1_462_4048# 0.07243f
C97 b2 vdd 0.48541f
C98 vdd b0 0.4728f
C99 m1_2964_2640# m1_2382_2650# 0.25078f
C100 b0 a_680_3416# 0.36752f
C101 m1_1780_2760# a_2456_3416# 0.02311f
C102 b4 vdd 0.64298f
C103 m1_596_2880# a_1272_3416# 0.01859f
C104 m1_2964_2640# vdd 0.00309f
C105 m1_2382_2650# vss 0.88559f
C106 m1_2964_2640# vss 1.71738f
C107 m1_1342_4048# vss 0.20629f
C108 m1_1780_2760# vss 0.55176f
C109 m1_902_4048# vss 0.29458f
C110 m1_756_3240# vss 0.82268f
C111 m1_596_2880# vss 0.7575f
C112 m1_462_4048# vss 0.72606f
C113 out vss 0.62102f
C114 a_680_3416# vss 1.18414f
C115 b0 vss 0.36638f
C116 vdd vss 7.67233f
C117 a_1272_3416# vss 0.4405f
C118 b1 vss 0.28315f
C119 a_1864_3416# vss 0.73889f
C120 b2 vss 0.31706f
C121 a_2456_3416# vss 0.60405f
C122 b3 vss 0.35144f
C123 a_3048_3416# vss 1.11524f
C124 b4 vss 0.35606f
.ends
