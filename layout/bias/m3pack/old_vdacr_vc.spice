* NGSPICE file created from vdacr_vc_old.ext - technology: gf180mcuD

.subckt r_w2_l1p315 a_n200_n254# a_n200_132# VSUBS
X0 a_n200_132# a_n200_n254# VSUBS ppolyf_u_1k r_width=2u r_length=1.32u
C0 a_n200_132# a_n200_n254# 0.02982f
C1 a_n200_n254# VSUBS 0.42149f
C2 a_n200_132# VSUBS 0.42149f
.ends

.subckt r_w2_l2p625 a_n200_n385# a_n200_263# VSUBS
X0 a_n200_263# a_n200_n385# VSUBS ppolyf_u_1k r_width=2u r_length=2.63u
C0 a_n200_263# a_n200_n385# 0.01591f
C1 a_n200_n385# VSUBS 0.43549f
C2 a_n200_263# VSUBS 0.43549f
.ends

.subckt r_w1_l5p175 a_n100_518# a_n100_n640# VSUBS
X0 a_n100_518# a_n100_n640# VSUBS ppolyf_u_1k r_width=1u r_length=5.18u
C0 a_n100_518# a_n100_n640# 0.00399f
C1 a_n100_n640# VSUBS 0.26263f
C2 a_n100_518# VSUBS 0.26263f
.ends

.subckt r_w1_l2p59 a_n100_n381# a_n100_259# VSUBS
X0 a_n100_259# a_n100_n381# VSUBS ppolyf_u_1k r_width=1u r_length=2.59u
C0 a_n100_259# a_n100_n381# 0.00799f
C1 a_n100_n381# VSUBS 0.25697f
C2 a_n100_259# VSUBS 0.25697f
.ends

.subckt r_w1_l10p35 a_n100_n1157# a_n100_1035# VSUBS
X0 a_n100_1035# a_n100_n1157# VSUBS ppolyf_u_1k r_width=1u r_length=10.35u
C0 a_n100_n1157# VSUBS 0.27003f
C1 a_n100_1035# VSUBS 0.27003f
.ends

.subckt n_w0p5_l1 a_100_n50# a_n100_n94# a_n188_n50# VSUBS
X0 a_100_n50# a_n100_n94# a_n188_n50# VSUBS nfet_03v3 ad=0.22p pd=1.88u as=0.22p ps=1.88u w=0.5u l=1u
C0 a_n100_n94# a_100_n50# 0.01026f
C1 a_n188_n50# a_n100_n94# 0.01026f
C2 a_n188_n50# a_100_n50# 0.00935f
C3 a_100_n50# VSUBS 0.13392f
C4 a_n188_n50# VSUBS 0.13392f
.ends

.subckt p_w1_l1 a_n188_n100# a_100_n100# a_n100_n144# w_n274_n230# VSUBS
X0 a_100_n100# a_n100_n144# a_n188_n100# w_n274_n230# pfet_03v3 ad=0.44p pd=2.88u as=0.44p ps=2.88u w=1u l=1u
C0 w_n274_n230# a_n188_n100# 0.02517f
C1 a_n100_n144# w_n274_n230# 0.12884f
C2 a_100_n100# a_n188_n100# 0.0191f
C3 a_100_n100# a_n100_n144# 0.02094f
C4 a_100_n100# w_n274_n230# 0.02517f
C5 a_n100_n144# a_n188_n100# 0.02094f
C6 a_100_n100# VSUBS 0.07854f
C7 a_n188_n100# VSUBS 0.07854f
C8 w_n274_n230# VSUBS 0.75624f
.ends

.subckt r_w1_l12p86 a_n100_n1408# a_n100_1286# VSUBS
X0 a_n100_1286# a_n100_n1408# VSUBS ppolyf_u_1k r_width=1u r_length=12.86u
C0 a_n100_n1408# VSUBS 0.27003f
C1 a_n100_1286# VSUBS 0.27003f
.ends

.subckt n_w4_l0p28_f2 a_n52_n400# a_52_n444# a_108_n400# a_n108_n444# a_n196_n400#
+ VSUBS
X0 a_108_n400# a_52_n444# a_n52_n400# VSUBS nfet_03v3 ad=1.76p pd=8.88u as=1.04p ps=4.52u w=4u l=0.28u
X1 a_n52_n400# a_n108_n444# a_n196_n400# VSUBS nfet_03v3 ad=1.04p pd=4.52u as=1.76p ps=8.88u w=4u l=0.28u
C0 a_n108_n444# a_n196_n400# 0.03125f
C1 a_52_n444# a_n108_n444# 0.00519f
C2 a_n52_n400# a_n196_n400# 0.17284f
C3 a_n52_n400# a_52_n444# 0.03125f
C4 a_n52_n400# a_n108_n444# 0.03125f
C5 a_52_n444# a_108_n400# 0.03125f
C6 a_n52_n400# a_108_n400# 0.17284f
C7 a_108_n400# VSUBS 0.20946f
C8 a_n52_n400# VSUBS 0.09458f
C9 a_n196_n400# VSUBS 0.20946f
.ends

.subckt vdacr_vc_old b0 b1 b2 b3 b4 vdd out vss
XXRS0 m1_2156_3240# m1_1822_4048# vss r_w2_l1p315
XXRS1 m1_2900_3120# m1_2156_3240# vss r_w2_l2p625
XXRS3 m1_3542_4048# m1_3982_4048# vss r_w1_l5p175
XXRS2 m1_3542_4048# m1_2900_3120# vss r_w1_l2p59
XXRS4 vss m1_3982_4048# vss r_w1_l10p35
XIB4n a_4168_3416# b4 vss vss n_w0p5_l1
XIB3n a_3576_3416# b3 vss vss n_w0p5_l1
XIB4p vdd a_4168_3416# b4 vdd vss p_w1_l1
XIB2n a_2984_3416# b2 vss vss n_w0p5_l1
XIB3p vdd a_3576_3416# b3 vdd vss p_w1_l1
XIB2p vdd a_2984_3416# b2 vdd vss p_w1_l1
XIB1n a_2392_3416# b1 vss vss n_w0p5_l1
XIB0n a_1800_3416# b0 vss vss n_w0p5_l1
XIB1p vdd a_2392_3416# b1 vdd vss p_w1_l1
XIB0p vdd a_1800_3416# b0 vdd vss p_w1_l1
XXRB0 m1_502_4048# out vss r_w1_l12p86
XSW0 m1_2156_3240# a_1800_3416# m1_1822_4048# a_1800_3416# m1_1822_4048# vss n_w4_l0p28_f2
XXRB1 m1_942_4048# m1_502_4048# vss r_w1_l12p86
XSW2 m1_3542_4048# a_2984_3416# m1_2900_3120# a_2984_3416# m1_2900_3120# vss n_w4_l0p28_f2
XSW1 m1_2900_3120# a_2392_3416# m1_2156_3240# a_2392_3416# m1_2156_3240# vss n_w4_l0p28_f2
XXRB3 m1_1822_4048# m1_1382_4048# vss r_w1_l12p86
XXRB2 m1_1382_4048# m1_942_4048# vss r_w1_l12p86
XSW3 m1_3982_4048# a_3576_3416# m1_3542_4048# a_3576_3416# m1_3542_4048# vss n_w4_l0p28_f2
XSW4 vss a_4168_3416# m1_3982_4048# a_4168_3416# m1_3982_4048# vss n_w4_l0p28_f2
C0 vdd a_1800_3416# 0.16313f
C1 m1_1822_4048# vdd 0.00249f
C2 m1_1822_4048# m1_3982_4048# 0
C3 m1_2156_3240# m1_3542_4048# 0.00287f
C4 a_1800_3416# b1 0.02676f
C5 a_2392_3416# b3 0
C6 b2 a_2984_3416# 0.19562f
C7 m1_1822_4048# b1 0.0085f
C8 b3 a_3576_3416# 0.31847f
C9 vdd a_2392_3416# 0.23488f
C10 vdd b3 0.69411f
C11 a_2392_3416# m1_3982_4048# 0
C12 vdd a_3576_3416# 0.17218f
C13 m1_3982_4048# b3 0.05346f
C14 m1_3542_4048# a_2984_3416# 0.13514f
C15 m1_1382_4048# m1_2156_3240# 0.00556f
C16 m1_3982_4048# a_3576_3416# 0.26669f
C17 vdd m1_3982_4048# 0.00734f
C18 a_2392_3416# b1 0.1487f
C19 m1_2156_3240# a_2984_3416# 0.08949f
C20 vdd b1 0.60145f
C21 a_1800_3416# m1_2900_3120# 0
C22 m1_1382_4048# m1_942_4048# 0.11722f
C23 m1_1822_4048# m1_2900_3120# 0
C24 a_2392_3416# m1_2900_3120# 0.12579f
C25 m1_2900_3120# a_3576_3416# 0.02458f
C26 vdd m1_2900_3120# 0.00446f
C27 m1_2900_3120# m1_3982_4048# 0.0302f
C28 m1_1822_4048# m1_502_4048# 0
C29 b3 b4 0.13917f
C30 a_3576_3416# b4 0.03989f
C31 vdd b4 0.96713f
C32 a_4168_3416# b3 0.02366f
C33 a_4168_3416# a_3576_3416# 0.04025f
C34 vdd a_4168_3416# 0.22626f
C35 m1_3982_4048# a_4168_3416# 0.09009f
C36 m1_1822_4048# m1_3542_4048# 0
C37 a_2392_3416# b2 0.02304f
C38 b2 b3 0.02623f
C39 a_1800_3416# m1_2156_3240# 0.05712f
C40 b2 a_3576_3416# 0.00239f
C41 m1_1822_4048# m1_2156_3240# 0.46064f
C42 vdd b2 0.51583f
C43 a_1800_3416# m1_1382_4048# 0.01707f
C44 a_2392_3416# m1_3542_4048# 0
C45 m1_3542_4048# b3 0
C46 m1_1822_4048# m1_1382_4048# 0.09954f
C47 m1_3542_4048# a_3576_3416# 0.21685f
C48 vdd m1_3542_4048# 0
C49 m1_3542_4048# m1_3982_4048# 0.57866f
C50 a_1800_3416# a_2984_3416# 0
C51 b2 b1 0.02443f
C52 m1_1822_4048# a_2984_3416# 0
C53 a_2392_3416# m1_2156_3240# 0.25323f
C54 m1_1822_4048# m1_942_4048# 0
C55 m1_2156_3240# a_3576_3416# 0
C56 vdd m1_2156_3240# 0
C57 m1_2156_3240# m1_3982_4048# 0.00173f
C58 a_2392_3416# a_2984_3416# 0.06364f
C59 a_2984_3416# b3 0.00998f
C60 m1_2156_3240# b1 0.03127f
C61 a_2984_3416# a_3576_3416# 0.04562f
C62 vdd a_2984_3416# 0.22246f
C63 a_2984_3416# m1_3982_4048# 0.00685f
C64 m1_2900_3120# b2 0.00112f
C65 out m1_502_4048# 0.06298f
C66 a_4168_3416# b4 0.27982f
C67 m1_2900_3120# m1_3542_4048# 0.23213f
C68 b1 a_2984_3416# 0
C69 a_1800_3416# b0 0.19361f
C70 m1_2900_3120# m1_2156_3240# 0.35505f
C71 b2 b4 0
C72 m1_2900_3120# a_2984_3416# 0.33054f
C73 vdd b0 0.48837f
C74 m1_3542_4048# a_4168_3416# 0.00878f
C75 out m1_1382_4048# 0.02522f
C76 b0 b1 0.02243f
C77 m1_1822_4048# a_1800_3416# 0.11392f
C78 out m1_942_4048# 0.07036f
C79 b2 m1_3542_4048# 0.00783f
C80 m1_942_4048# m1_502_4048# 0.31498f
C81 a_1800_3416# a_2392_3416# 0.03539f
C82 m1_1822_4048# a_2392_3416# 0.02442f
C83 m1_3982_4048# vss 1.03972f
C84 m1_1382_4048# vss 0.71003f
C85 m1_2900_3120# vss 0.25398f
C86 m1_3542_4048# vss 0.91811f
C87 m1_942_4048# vss 0.38112f
C88 m1_2156_3240# vss 0.45166f
C89 m1_1822_4048# vss 0.22977f
C90 m1_502_4048# vss 0.67554f
C91 out vss 0.78918f
C92 a_1800_3416# vss 0.80682f
C93 b0 vss 0.64361f
C94 vdd vss 14.93496f
C95 a_2392_3416# vss 0.54774f
C96 b1 vss 0.49635f
C97 a_2984_3416# vss 0.60284f
C98 b2 vss 0.58464f
C99 a_3576_3416# vss 0.53451f
C100 b3 vss 0.61339f
C101 a_4168_3416# vss 1.17112f
C102 b4 vss 0.57954f
.ends
