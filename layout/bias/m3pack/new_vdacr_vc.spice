* NGSPICE file created from vdacr_vc_new.ext - technology: gf180mcuD

.subckt r_w2_l1p315 a_n200_n254# a_n200_132# VSUBS
X0 a_n200_132# a_n200_n254# VSUBS ppolyf_u_1k r_width=2u r_length=1.32u
C0 a_n200_n254# a_n200_132# 0.02982f
C1 a_n200_n254# VSUBS 0.42149f
C2 a_n200_132# VSUBS 0.42149f
.ends

.subckt r_w2_l2p625 a_n200_n385# a_n200_263# VSUBS
X0 a_n200_263# a_n200_n385# VSUBS ppolyf_u_1k r_width=2u r_length=2.63u
C0 a_n200_n385# a_n200_263# 0.01591f
C1 a_n200_n385# VSUBS 0.43549f
C2 a_n200_263# VSUBS 0.43549f
.ends

.subckt r_w1_l5p175 a_n100_518# a_n100_n640# VSUBS
X0 a_n100_518# a_n100_n640# VSUBS ppolyf_u_1k r_width=1u r_length=5.18u
C0 a_n100_n640# a_n100_518# 0.00399f
C1 a_n100_n640# VSUBS 0.26263f
C2 a_n100_518# VSUBS 0.26263f
.ends

.subckt r_w1_l2p59 a_n100_n381# a_n100_259# VSUBS
X0 a_n100_259# a_n100_n381# VSUBS ppolyf_u_1k r_width=1u r_length=2.59u
C0 a_n100_n381# a_n100_259# 0.00799f
C1 a_n100_n381# VSUBS 0.25697f
C2 a_n100_259# VSUBS 0.25697f
.ends

.subckt r_w1_l10p35 a_n100_n1157# a_n100_1035# VSUBS
X0 a_n100_1035# a_n100_n1157# VSUBS ppolyf_u_1k r_width=1u r_length=10.35u
C0 a_n100_n1157# VSUBS 0.27003f
C1 a_n100_1035# VSUBS 0.27003f
.ends

.subckt n_w0p5_l1 a_100_n50# a_n100_n94# a_n188_n50# VSUBS
X0 a_100_n50# a_n100_n94# a_n188_n50# VSUBS nfet_03v3 ad=0.22p pd=1.88u as=0.22p ps=1.88u w=0.5u l=1u
C0 a_100_n50# a_n100_n94# 0.01026f
C1 a_n188_n50# a_n100_n94# 0.01026f
C2 a_100_n50# a_n188_n50# 0.00935f
C3 a_100_n50# VSUBS 0.13392f
C4 a_n188_n50# VSUBS 0.13392f
.ends

.subckt p_w1_l1 a_n188_n100# a_100_n100# a_n100_n144# w_n274_n230# VSUBS
X0 a_100_n100# a_n100_n144# a_n188_n100# w_n274_n230# pfet_03v3 ad=0.44p pd=2.88u as=0.44p ps=2.88u w=1u l=1u
C0 a_n188_n100# w_n274_n230# 0.02517f
C1 a_n100_n144# a_100_n100# 0.02094f
C2 w_n274_n230# a_100_n100# 0.02517f
C3 a_n188_n100# a_100_n100# 0.0191f
C4 a_n100_n144# w_n274_n230# 0.12884f
C5 a_n188_n100# a_n100_n144# 0.02094f
C6 a_100_n100# VSUBS 0.07854f
C7 a_n188_n100# VSUBS 0.07854f
C8 w_n274_n230# VSUBS 0.75624f
.ends

.subckt r_w1_l12p86 a_n100_n1408# a_n100_1286# VSUBS
X0 a_n100_1286# a_n100_n1408# VSUBS ppolyf_u_1k r_width=1u r_length=12.86u
C0 a_n100_n1408# VSUBS 0.27003f
C1 a_n100_1286# VSUBS 0.27003f
.ends

.subckt n_w4_l0p28_f2 a_n52_n400# a_52_n444# a_108_n400# a_n108_n444# a_n196_n400#
+ VSUBS
X0 a_108_n400# a_52_n444# a_n52_n400# VSUBS nfet_03v3 ad=1.76p pd=8.88u as=1.04p ps=4.52u w=4u l=0.28u
X1 a_n52_n400# a_n108_n444# a_n196_n400# VSUBS nfet_03v3 ad=1.04p pd=4.52u as=1.76p ps=8.88u w=4u l=0.28u
C0 a_52_n444# a_108_n400# 0.03125f
C1 a_n196_n400# a_n108_n444# 0.03125f
C2 a_52_n444# a_n52_n400# 0.03125f
C3 a_n108_n444# a_n52_n400# 0.03125f
C4 a_n196_n400# a_n52_n400# 0.17284f
C5 a_108_n400# a_n52_n400# 0.17284f
C6 a_52_n444# a_n108_n444# 0.00519f
C7 a_108_n400# VSUBS 0.20946f
C8 a_n52_n400# VSUBS 0.09458f
C9 a_n196_n400# VSUBS 0.20946f
.ends

.subckt vdacr_vc_new b0 b1 b2 b3 b4 vdd out vss
XXRS0 m1_756_2640# m1_596_3240# vss r_w2_l1p315
XXRS1 m1_1663_4920# m1_756_2640# vss r_w2_l2p625
XXRS3 m1_2382_2650# m1_2964_2640# vss r_w1_l5p175
XXRS2 m1_2382_2650# m1_1663_4920# vss r_w1_l2p59
XXRS4 vss m1_2964_2640# vss r_w1_l10p35
XIB4n a_3048_3416# b4 vss vss n_w0p5_l1
XIB3n a_2456_3416# b3 vss vss n_w0p5_l1
XIB4p vdd a_3048_3416# b4 vdd vss p_w1_l1
XIB2n a_1864_3416# b2 vss vss n_w0p5_l1
XIB3p vdd a_2456_3416# b3 vdd vss p_w1_l1
XIB2p vdd a_1864_3416# b2 vdd vss p_w1_l1
XIB1n a_1272_3416# b1 vss vss n_w0p5_l1
XIB0n a_680_3416# b0 vss vss n_w0p5_l1
XIB1p vdd a_1272_3416# b1 vdd vss p_w1_l1
XIB0p vdd a_680_3416# b0 vdd vss p_w1_l1
XXRB0 m1_240_4046# out vss r_w1_l12p86
XSW0 m1_756_2640# a_680_3416# m1_596_3240# a_680_3416# m1_596_3240# vss n_w4_l0p28_f2
XXRB1 m1_902_4048# m1_240_4046# vss r_w1_l12p86
XSW2 m1_2382_2650# a_1864_3416# m1_1663_4920# a_1864_3416# m1_1663_4920# vss n_w4_l0p28_f2
XSW1 m1_1663_4920# a_1272_3416# m1_756_2640# a_1272_3416# m1_756_2640# vss n_w4_l0p28_f2
XXRB3 m1_596_3240# m1_1342_4048# vss r_w1_l12p86
XXRB2 m1_1342_4048# m1_902_4048# vss r_w1_l12p86
XSW3 m1_2964_2640# a_2456_3416# m1_2382_2650# a_2456_3416# m1_2382_2650# vss n_w4_l0p28_f2
XSW4 vss a_3048_3416# m1_2964_2640# a_3048_3416# m1_2964_2640# vss n_w4_l0p28_f2
C0 m1_2382_2650# b2 0.00779f
C1 m1_902_4048# m1_596_3240# 0.17167f
C2 m1_240_4046# out 0.07214f
C3 a_1272_3416# a_1864_3416# 0.13781f
C4 m1_2964_2640# m1_596_3240# 0
C5 b2 m1_756_2640# 0
C6 m1_2382_2650# a_2456_3416# 0.29266f
C7 b1 m1_756_2640# 0.02521f
C8 a_680_3416# a_1864_3416# 0.00212f
C9 m1_2382_2650# m1_1342_4048# 0.01723f
C10 m1_2964_2640# b3 0
C11 vdd m1_596_3240# 0
C12 a_1272_3416# a_680_3416# 0.03382f
C13 a_2456_3416# m1_756_2640# 0.0082f
C14 b3 b4 0.05196f
C15 m1_1663_4920# m1_240_4046# 0.00215f
C16 m1_1342_4048# out 0.06792f
C17 m1_1342_4048# m1_756_2640# 0.00252f
C18 m1_756_2640# b0 0
C19 vdd b3 0.45495f
C20 m1_240_4046# m1_902_4048# 0.07637f
C21 m1_1663_4920# b2 0.01235f
C22 m1_1663_4920# b1 0
C23 a_3048_3416# b3 0
C24 a_1864_3416# m1_596_3240# 0.00107f
C25 m1_2382_2650# m1_756_2640# 0.20497f
C26 a_1272_3416# m1_596_3240# 0.02856f
C27 m1_1663_4920# a_2456_3416# 0.07447f
C28 b3 a_1864_3416# 0.03231f
C29 m1_1663_4920# m1_1342_4048# 0.26306f
C30 a_1272_3416# b3 0
C31 m1_1342_4048# m1_902_4048# 0.53671f
C32 a_680_3416# m1_596_3240# 0.14182f
C33 vdd b2 0.48541f
C34 m1_2964_2640# a_2456_3416# 0.19022f
C35 m1_2964_2640# m1_1342_4048# 0
C36 vdd b1 0.42955f
C37 a_2456_3416# b4 0.08415f
C38 m1_2382_2650# m1_1663_4920# 0.69587f
C39 vdd a_2456_3416# 0.22632f
C40 m1_2382_2650# m1_902_4048# 0
C41 m1_1663_4920# out 0.00973f
C42 m1_1663_4920# m1_756_2640# 0.35225f
C43 vdd b0 0.4728f
C44 b2 a_1864_3416# 0.30281f
C45 m1_2382_2650# m1_2964_2640# 0.23693f
C46 a_3048_3416# a_2456_3416# 0.03483f
C47 m1_902_4048# out 0.02561f
C48 m1_756_2640# m1_902_4048# 0.00238f
C49 a_1272_3416# b2 0.04376f
C50 b1 a_1864_3416# 0.01341f
C51 a_680_3416# m1_240_4046# 0.01577f
C52 a_1272_3416# b1 0.2443f
C53 m1_2964_2640# m1_756_2640# 0.04178f
C54 a_1864_3416# a_2456_3416# 0.01449f
C55 m1_2382_2650# vdd 0.00156f
C56 a_1272_3416# a_2456_3416# 0.01813f
C57 a_680_3416# b1 0.0311f
C58 a_1272_3416# m1_1342_4048# 0.00204f
C59 m1_2382_2650# a_3048_3416# 0.00307f
C60 vdd m1_756_2640# 0.01026f
C61 a_1272_3416# b0 0
C62 m1_1663_4920# m1_902_4048# 0.00281f
C63 m1_240_4046# m1_596_3240# 0.03917f
C64 m1_2382_2650# a_1864_3416# 0.08393f
C65 m1_1663_4920# m1_2964_2640# 0.01984f
C66 a_680_3416# b0 0.36757f
C67 a_1272_3416# m1_2382_2650# 0.00845f
C68 m1_2964_2640# m1_902_4048# 0
C69 a_1864_3416# m1_756_2640# 0.29457f
C70 vdd m1_1663_4920# 0.00412f
C71 a_1272_3416# m1_756_2640# 0.26733f
C72 b2 b3 0.05389f
C73 a_2456_3416# m1_596_3240# 0
C74 m1_2964_2640# b4 0.01478f
C75 a_3048_3416# m1_1663_4920# 0
C76 m1_1342_4048# m1_596_3240# 0.09677f
C77 b0 m1_596_3240# 0.00377f
C78 vdd m1_2964_2640# 0.00309f
C79 a_680_3416# m1_756_2640# 0.04344f
C80 b3 a_2456_3416# 0.20171f
C81 vdd b4 0.64298f
C82 m1_1663_4920# a_1864_3416# 0.42793f
C83 a_3048_3416# m1_2964_2640# 0.09007f
C84 a_1272_3416# m1_1663_4920# 0.13237f
C85 m1_2382_2650# m1_596_3240# 0.118f
C86 a_3048_3416# b4 0.28941f
C87 a_1272_3416# m1_902_4048# 0.00536f
C88 m1_2964_2640# a_1864_3416# 0
C89 a_3048_3416# vdd 0.1443f
C90 a_680_3416# m1_1663_4920# 0
C91 b1 b2 0.03672f
C92 m1_2382_2650# b3 0.02078f
C93 m1_756_2640# m1_596_3240# 0.31403f
C94 a_1272_3416# m1_2964_2640# 0
C95 a_1864_3416# b4 0
C96 m1_1342_4048# m1_240_4046# 0.00103f
C97 a_680_3416# m1_902_4048# 0
C98 b2 a_2456_3416# 0.00423f
C99 vdd a_1864_3416# 0.25499f
C100 a_1272_3416# vdd 0.16599f
C101 a_3048_3416# a_1864_3416# 0
C102 b1 b0 0.03223f
C103 m1_1663_4920# m1_596_3240# 0.1127f
C104 vdd a_680_3416# 0.29773f
C105 m1_2382_2650# vss 0.81449f
C106 m1_2964_2640# vss 1.70309f
C107 m1_1342_4048# vss 0.15563f
C108 m1_1663_4920# vss 0.55315f
C109 m1_902_4048# vss 0.3341f
C110 m1_756_2640# vss 0.62171f
C111 m1_596_3240# vss 0.55289f
C112 m1_240_4046# vss 1.23966f
C113 out vss 0.55586f
C114 a_680_3416# vss 1.22922f
C115 b0 vss 0.37052f
C116 vdd vss 7.67257f
C117 a_1272_3416# vss 0.44211f
C118 b1 vss 0.28315f
C119 a_1864_3416# vss 0.73162f
C120 b2 vss 0.31706f
C121 a_2456_3416# vss 0.59836f
C122 b3 vss 0.35144f
C123 a_3048_3416# vss 1.11524f
C124 b4 vss 0.35606f
.ends
