* NGSPICE file created from vdacr_vr_vdac.ext - technology: gf180mcuD

.subckt r_w1_l7p765 a_n100_n899# a_n100_777# VSUBS
X0 a_n100_777# a_n100_n899# VSUBS ppolyf_u_1k r_width=1u r_length=7.77u
C0 a_n100_n899# VSUBS 0.27003f
C1 a_n100_777# VSUBS 0.27003f
.ends

.subckt r_w2_l1p97 a_n200_n319# a_n200_197# VSUBS
X0 a_n200_197# a_n200_n319# VSUBS ppolyf_u_1k r_width=2u r_length=1.97u
C0 a_n200_n319# a_n200_197# 0.02096f
C1 a_n200_n319# VSUBS 0.42971f
C2 a_n200_197# VSUBS 0.42971f
.ends

.subckt r_w1_l1p94 a_n100_n316# a_n100_194# VSUBS
X0 a_n100_194# a_n100_n316# VSUBS ppolyf_u_1k r_width=1u r_length=1.94u
C0 a_n100_n316# a_n100_194# 0.01052f
C1 a_n100_n316# VSUBS 0.2541f
C2 a_n100_194# VSUBS 0.2541f
.ends

.subckt r_w1_l3p88 a_n100_n510# a_n100_388# VSUBS
X0 a_n100_388# a_n100_n510# VSUBS ppolyf_u_1k r_width=1u r_length=3.88u
C0 a_n100_n510# a_n100_388# 0.00535f
C1 a_n100_n510# VSUBS 0.26053f
C2 a_n100_388# VSUBS 0.26053f
.ends

.subckt n_w0p5_l1 a_100_n50# a_n100_n94# a_n188_n50# VSUBS
X0 a_100_n50# a_n100_n94# a_n188_n50# VSUBS nfet_03v3 ad=0.22p pd=1.88u as=0.22p ps=1.88u w=0.5u l=1u
C0 a_n188_n50# a_n100_n94# 0.01026f
C1 a_100_n50# a_n100_n94# 0.01026f
C2 a_100_n50# a_n188_n50# 0.00935f
C3 a_100_n50# VSUBS 0.13392f
C4 a_n188_n50# VSUBS 0.13392f
.ends

.subckt p_w1_l1 a_n188_n100# a_100_n100# a_n100_n144# w_n274_n230# VSUBS
X0 a_100_n100# a_n100_n144# a_n188_n100# w_n274_n230# pfet_03v3 ad=0.44p pd=2.88u as=0.44p ps=2.88u w=1u l=1u
C0 a_n100_n144# w_n274_n230# 0.12884f
C1 a_n188_n100# w_n274_n230# 0.02517f
C2 a_100_n100# w_n274_n230# 0.02517f
C3 a_n188_n100# a_n100_n144# 0.02094f
C4 a_100_n100# a_n100_n144# 0.02094f
C5 a_100_n100# a_n188_n100# 0.0191f
C6 a_100_n100# VSUBS 0.07854f
C7 a_n188_n100# VSUBS 0.07854f
C8 w_n274_n230# VSUBS 0.75624f
.ends

.subckt r_w1_l13p91 a_n100_n1513# a_n100_1391# VSUBS
X0 a_n100_1391# a_n100_n1513# VSUBS ppolyf_u_1k r_width=1u r_length=13.91u
C0 a_n100_n1513# VSUBS 0.27003f
C1 a_n100_1391# VSUBS 0.27003f
.ends

.subckt n_w4_l0p28_f2 a_n52_n400# a_52_n444# a_108_n400# a_n108_n444# a_n196_n400#
+ VSUBS
X0 a_108_n400# a_52_n444# a_n52_n400# VSUBS nfet_03v3 ad=1.76p pd=8.88u as=1.04p ps=4.52u w=4u l=0.28u
X1 a_n52_n400# a_n108_n444# a_n196_n400# VSUBS nfet_03v3 ad=1.04p pd=4.52u as=1.76p ps=8.88u w=4u l=0.28u
C0 a_52_n444# a_108_n400# 0.03125f
C1 a_52_n444# a_n108_n444# 0.00519f
C2 a_n196_n400# a_n108_n444# 0.03125f
C3 a_n52_n400# a_108_n400# 0.17284f
C4 a_n52_n400# a_n108_n444# 0.03125f
C5 a_n52_n400# a_52_n444# 0.03125f
C6 a_n52_n400# a_n196_n400# 0.17284f
C7 a_108_n400# VSUBS 0.20946f
C8 a_n52_n400# VSUBS 0.09458f
C9 a_n196_n400# VSUBS 0.20946f
.ends

.subckt vdacr_vr_vdac b0 b1 b2 b3 b4 vdd out vss
XXRS4_0 m1_2862_4048# m1_2974_2650# vss r_w1_l7p765
XXRS4_1 vss m1_2862_4048# vss r_w1_l7p765
XXRS0 m1_756_3120# m1_606_2410# vss r_w2_l1p97
XXRS1 m1_1780_5040# m1_756_3120# vss r_w1_l1p94
XXRS3 m1_2974_2650# m1_2372_2520# vss r_w1_l7p765
XXRS2 m1_2372_2520# m1_1780_5040# vss r_w1_l3p88
XIB4n a_3048_3416# b4 vss vss n_w0p5_l1
XIB3n a_2456_3416# b3 vss vss n_w0p5_l1
XIB4p vdd a_3048_3416# b4 vdd vss p_w1_l1
XIB2n a_1864_3416# b2 vss vss n_w0p5_l1
XIB3p vdd a_2456_3416# b3 vdd vss p_w1_l1
XIB2p vdd a_1864_3416# b2 vdd vss p_w1_l1
XIB1n a_1272_3416# b1 vss vss n_w0p5_l1
XIB0n a_680_3416# b0 vss vss n_w0p5_l1
XIB1p vdd a_1272_3416# b1 vdd vss p_w1_l1
XIB0p vdd a_680_3416# b0 vdd vss p_w1_l1
XXRB0 m1_462_4048# out vss r_w1_l13p91
XSW0 m1_756_3120# a_680_3416# m1_606_2410# a_680_3416# m1_606_2410# vss n_w4_l0p28_f2
XXRB1 m1_860_4046# m1_462_4048# vss r_w1_l13p91
XSW2 m1_2372_2520# a_1864_3416# m1_1780_5040# a_1864_3416# m1_1780_5040# vss n_w4_l0p28_f2
XSW1 m1_1780_5040# a_1272_3416# m1_756_3120# a_1272_3416# m1_756_3120# vss n_w4_l0p28_f2
XXRB2 m1_606_2410# m1_860_4046# vss r_w1_l13p91
XSW3 m1_2974_2650# a_2456_3416# m1_2372_2520# a_2456_3416# m1_2372_2520# vss n_w4_l0p28_f2
XSW4 vss a_3048_3416# m1_2974_2650# a_3048_3416# m1_2974_2650# vss n_w4_l0p28_f2
C0 a_2456_3416# b4 0.09406f
C1 a_1272_3416# a_1864_3416# 0.02555f
C2 m1_2372_2520# m1_2974_2650# 0.5557f
C3 b1 b2 0.05461f
C4 vdd a_2456_3416# 0.20273f
C5 m1_462_4048# m1_1780_5040# 0
C6 m1_2862_4048# m1_1780_5040# 0.00262f
C7 m1_2862_4048# a_3048_3416# 0.00491f
C8 m1_2372_2520# m1_860_4046# 0
C9 a_2456_3416# m1_1780_5040# 0.00741f
C10 a_2456_3416# a_3048_3416# 0.11912f
C11 m1_2372_2520# m1_606_2410# 0
C12 a_1272_3416# vdd 0.13505f
C13 m1_2372_2520# b3 0.02027f
C14 m1_1780_5040# out 0.00646f
C15 a_1272_3416# m1_1780_5040# 0.152f
C16 b2 a_2456_3416# 0
C17 m1_2974_2650# m1_756_3120# 0.0665f
C18 vdd a_1864_3416# 0.23259f
C19 b2 a_1272_3416# 0.04419f
C20 m1_860_4046# m1_756_3120# 0.01696f
C21 a_1864_3416# m1_1780_5040# 0.42554f
C22 a_1864_3416# a_3048_3416# 0
C23 m1_606_2410# m1_756_3120# 0.30895f
C24 b0 vdd 0.43014f
C25 vdd b4 0.55146f
C26 m1_2372_2520# m1_462_4048# 0
C27 m1_2372_2520# m1_2862_4048# 0.02957f
C28 a_680_3416# m1_756_3120# 0.10755f
C29 b4 a_3048_3416# 0.26257f
C30 b2 a_1864_3416# 0.16397f
C31 m1_2372_2520# a_2456_3416# 0.13462f
C32 b1 m1_756_3120# 0.00539f
C33 vdd m1_1780_5040# 0.0026f
C34 vdd a_3048_3416# 0.14688f
C35 m1_2974_2650# m1_606_2410# 0
C36 m1_2372_2520# out 0
C37 b2 b0 0
C38 b2 b4 0
C39 m1_2372_2520# a_1272_3416# 0.01394f
C40 b3 m1_2974_2650# 0.00379f
C41 m1_860_4046# m1_606_2410# 0.08949f
C42 b2 vdd 0.57544f
C43 m1_462_4048# m1_756_3120# 0
C44 m1_2862_4048# m1_756_3120# 0
C45 b2 m1_1780_5040# 0
C46 b2 a_3048_3416# 0
C47 a_2456_3416# m1_756_3120# 0
C48 m1_860_4046# a_680_3416# 0
C49 m1_2372_2520# a_1864_3416# 0.27866f
C50 a_680_3416# m1_606_2410# 0.28826f
C51 a_1272_3416# m1_756_3120# 0.2354f
C52 b1 m1_606_2410# 0
C53 m1_2862_4048# m1_2974_2650# 0.17897f
C54 b1 b3 0.00301f
C55 a_2456_3416# m1_2974_2650# 0.30479f
C56 m1_2372_2520# vdd 0.00451f
C57 b1 a_680_3416# 0.03391f
C58 m1_462_4048# m1_860_4046# 0.19198f
C59 m1_2372_2520# m1_1780_5040# 0.17871f
C60 m1_2372_2520# a_3048_3416# 0
C61 a_1864_3416# m1_756_3120# 0.0068f
C62 m1_462_4048# m1_606_2410# 0.01332f
C63 a_1272_3416# m1_2974_2650# 0
C64 m1_2862_4048# m1_606_2410# 0
C65 m1_860_4046# out 0.01202f
C66 b0 m1_756_3120# 0
C67 m1_462_4048# a_680_3416# 0.00361f
C68 b3 a_2456_3416# 0.21262f
C69 m1_2372_2520# b2 0.00692f
C70 m1_860_4046# a_1272_3416# 0
C71 a_1272_3416# m1_606_2410# 0.01865f
C72 vdd m1_756_3120# 0.00214f
C73 a_1864_3416# m1_2974_2650# 0.00495f
C74 a_1272_3416# b3 0
C75 m1_1780_5040# m1_756_3120# 0.43379f
C76 a_1272_3416# a_680_3416# 0.04759f
C77 m1_2974_2650# b4 0.03331f
C78 b1 a_1272_3416# 0.24882f
C79 a_1864_3416# m1_606_2410# 0.0027f
C80 b2 m1_756_3120# 0
C81 vdd m1_2974_2650# 0.01155f
C82 b3 a_1864_3416# 0.04632f
C83 m1_2862_4048# a_2456_3416# 0.00561f
C84 a_1864_3416# a_680_3416# 0
C85 b0 m1_606_2410# 0.01272f
C86 m1_2974_2650# m1_1780_5040# 0.08507f
C87 m1_2974_2650# a_3048_3416# 0.1083f
C88 m1_462_4048# out 0.08166f
C89 b3 b4 0.04752f
C90 b1 a_1864_3416# 0
C91 b0 a_680_3416# 0.24565f
C92 m1_860_4046# m1_1780_5040# 0.08602f
C93 a_1272_3416# a_2456_3416# 0.00297f
C94 vdd b3 0.45194f
C95 b1 b0 0.0391f
C96 m1_1780_5040# m1_606_2410# 0.12918f
C97 vdd a_680_3416# 0.1904f
C98 m1_2372_2520# m1_756_3120# 0.13736f
C99 b1 vdd 0.41268f
C100 a_1864_3416# a_2456_3416# 0.02335f
C101 b1 m1_1780_5040# 0.00216f
C102 b2 b3 0.03777f
C103 b2 a_680_3416# 0
C104 m1_2974_2650# vss 0.65248f
C105 m1_2372_2520# vss 0.45945f
C106 m1_1780_5040# vss 0.79973f
C107 m1_860_4046# vss 0.58374f
C108 m1_756_3120# vss 0.79001f
C109 m1_606_2410# vss 0.54107f
C110 m1_462_4048# vss 0.74869f
C111 out vss 0.66703f
C112 a_680_3416# vss 0.76469f
C113 b0 vss 0.46453f
C114 vdd vss 7.78061f
C115 a_1272_3416# vss 0.41953f
C116 b1 vss 0.31842f
C117 a_1864_3416# vss 0.56004f
C118 b2 vss 0.2832f
C119 a_2456_3416# vss 0.64752f
C120 b3 vss 0.32156f
C121 a_3048_3416# vss 1.09158f
C122 b4 vss 0.38639f
C123 m1_2862_4048# vss 0.49249f
.ends
