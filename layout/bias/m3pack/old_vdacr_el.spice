* NGSPICE file created from vdacr_el_old.ext - technology: gf180mcuD

.subckt r_w1_l7p765 a_n100_n899# a_n100_777# VSUBS
X0 a_n100_777# a_n100_n899# VSUBS ppolyf_u_1k r_width=1u r_length=7.77u
C0 a_n100_n899# VSUBS 0.27003f
C1 a_n100_777# VSUBS 0.27003f
.ends

.subckt r_w2_l1p97 a_n200_n319# a_n200_197# VSUBS
X0 a_n200_197# a_n200_n319# VSUBS ppolyf_u_1k r_width=2u r_length=1.97u
C0 a_n200_n319# a_n200_197# 0.02096f
C1 a_n200_n319# VSUBS 0.42971f
C2 a_n200_197# VSUBS 0.42971f
.ends

.subckt r_w1_l1p94 a_n100_n316# a_n100_194# VSUBS
X0 a_n100_194# a_n100_n316# VSUBS ppolyf_u_1k r_width=1u r_length=1.94u
C0 a_n100_n316# a_n100_194# 0.01052f
C1 a_n100_n316# VSUBS 0.2541f
C2 a_n100_194# VSUBS 0.2541f
.ends

.subckt r_w1_l3p88 a_n100_n510# a_n100_388# VSUBS
X0 a_n100_388# a_n100_n510# VSUBS ppolyf_u_1k r_width=1u r_length=3.88u
C0 a_n100_n510# a_n100_388# 0.00535f
C1 a_n100_n510# VSUBS 0.26053f
C2 a_n100_388# VSUBS 0.26053f
.ends

.subckt n_w0p5_l1 a_100_n50# a_n100_n94# a_n188_n50# VSUBS
X0 a_100_n50# a_n100_n94# a_n188_n50# VSUBS nfet_03v3 ad=0.22p pd=1.88u as=0.22p ps=1.88u w=0.5u l=1u
C0 a_n100_n94# a_n188_n50# 0.01026f
C1 a_100_n50# a_n100_n94# 0.01026f
C2 a_100_n50# a_n188_n50# 0.00935f
C3 a_100_n50# VSUBS 0.13392f
C4 a_n188_n50# VSUBS 0.13392f
.ends

.subckt p_w1_l1 a_n188_n100# a_100_n100# a_n100_n144# w_n274_n230# VSUBS
X0 a_100_n100# a_n100_n144# a_n188_n100# w_n274_n230# pfet_03v3 ad=0.44p pd=2.88u as=0.44p ps=2.88u w=1u l=1u
C0 w_n274_n230# a_n100_n144# 0.12884f
C1 a_n188_n100# w_n274_n230# 0.02517f
C2 a_n188_n100# a_n100_n144# 0.02094f
C3 a_100_n100# w_n274_n230# 0.02517f
C4 a_100_n100# a_n100_n144# 0.02094f
C5 a_100_n100# a_n188_n100# 0.0191f
C6 a_100_n100# VSUBS 0.07854f
C7 a_n188_n100# VSUBS 0.07854f
C8 w_n274_n230# VSUBS 0.75624f
.ends

.subckt r_w1_l11p645 a_n100_1165# a_n100_n1287# VSUBS
X0 a_n100_1165# a_n100_n1287# VSUBS ppolyf_u_1k r_width=1u r_length=11.65u
C0 a_n100_n1287# VSUBS 0.27003f
C1 a_n100_1165# VSUBS 0.27003f
.ends

.subckt n_w4_l0p28_f2 a_n52_n400# a_52_n444# a_108_n400# a_n108_n444# a_n196_n400#
+ VSUBS
X0 a_108_n400# a_52_n444# a_n52_n400# VSUBS nfet_03v3 ad=1.76p pd=8.88u as=1.04p ps=4.52u w=4u l=0.28u
X1 a_n52_n400# a_n108_n444# a_n196_n400# VSUBS nfet_03v3 ad=1.04p pd=4.52u as=1.76p ps=8.88u w=4u l=0.28u
C0 a_n52_n400# a_108_n400# 0.17284f
C1 a_n108_n444# a_52_n444# 0.00519f
C2 a_n196_n400# a_n108_n444# 0.03125f
C3 a_n52_n400# a_n108_n444# 0.03125f
C4 a_n52_n400# a_52_n444# 0.03125f
C5 a_n52_n400# a_n196_n400# 0.17284f
C6 a_108_n400# a_52_n444# 0.03125f
C7 a_108_n400# VSUBS 0.20946f
C8 a_n52_n400# VSUBS 0.09458f
C9 a_n196_n400# VSUBS 0.20946f
.ends

.subckt vdacr_el_old b0 b1 b2 b3 b4 vdd out vss
XXRS4_0 m1_4222_4048# m1_4094_3010# vss r_w1_l7p765
XXRS4_1 vss m1_4222_4048# vss r_w1_l7p765
XXRS0 m1_2262_4048# m1_1822_4048# vss r_w2_l1p97
XXRS1 m1_2760_3412# m1_2262_4048# vss r_w1_l1p94
XXRS3 m1_4094_3010# m1_3342_4048# vss r_w1_l7p765
XXRS2 m1_3342_4048# m1_2760_3412# vss r_w1_l3p88
XIB4n a_4168_3416# b4 vss vss n_w0p5_l1
XIB3n a_3576_3416# b3 vss vss n_w0p5_l1
XIB4p vdd a_4168_3416# b4 vdd vss p_w1_l1
XIB2n a_2984_3416# b2 vss vss n_w0p5_l1
XIB3p vdd a_3576_3416# b3 vdd vss p_w1_l1
XIB2p vdd a_2984_3416# b2 vdd vss p_w1_l1
XIB1n a_2392_3416# b1 vss vss n_w0p5_l1
XIB0n a_1800_3416# b0 vss vss n_w0p5_l1
XIB1p vdd a_2392_3416# b1 vdd vss p_w1_l1
XIB0p vdd a_1800_3416# b0 vdd vss p_w1_l1
XXRB0 out m1_502_4048# vss r_w1_l11p645
XSW0 m1_2262_4048# a_1800_3416# m1_1822_4048# a_1800_3416# m1_1822_4048# vss n_w4_l0p28_f2
XXRB1 m1_502_4048# m1_942_4048# vss r_w1_l11p645
XSW2 m1_3342_4048# a_2984_3416# m1_2760_3412# a_2984_3416# m1_2760_3412# vss n_w4_l0p28_f2
XSW1 m1_2760_3412# a_2392_3416# m1_2262_4048# a_2392_3416# m1_2262_4048# vss n_w4_l0p28_f2
XXRB3 m1_1382_4048# m1_1822_4048# vss r_w1_l11p645
XXRB2 m1_942_4048# m1_1382_4048# vss r_w1_l11p645
XSW3 m1_4094_3010# a_3576_3416# m1_3342_4048# a_3576_3416# m1_3342_4048# vss n_w4_l0p28_f2
XSW4 vss a_4168_3416# m1_4094_3010# a_4168_3416# m1_4094_3010# vss n_w4_l0p28_f2
C0 m1_3342_4048# m1_4222_4048# 0.06437f
C1 m1_3342_4048# a_4168_3416# 0
C2 m1_942_4048# m1_502_4048# 0.29397f
C3 m1_1822_4048# m1_502_4048# 0
C4 m1_4094_3010# a_2984_3416# 0.00843f
C5 m1_3342_4048# m1_1822_4048# 0
C6 b4 b2 0
C7 m1_942_4048# m1_1382_4048# 0.11001f
C8 m1_1822_4048# m1_1382_4048# 0.11431f
C9 m1_3342_4048# a_2984_3416# 0.13071f
C10 a_4168_3416# b4 0.08723f
C11 a_1800_3416# m1_1822_4048# 0.09997f
C12 b4 a_2984_3416# 0
C13 m1_2262_4048# m1_4222_4048# 0
C14 m1_2262_4048# a_4168_3416# 0
C15 m1_2262_4048# m1_1822_4048# 0.2724f
C16 b1 b3 0
C17 vdd b2 0.54911f
C18 m1_4222_4048# m1_2760_3412# 0
C19 a_4168_3416# m1_2760_3412# 0
C20 m1_2262_4048# a_2984_3416# 0.03635f
C21 m1_1822_4048# m1_2760_3412# 0
C22 a_4168_3416# vdd 0.27917f
C23 m1_1822_4048# vdd 0.00239f
C24 a_2984_3416# m1_2760_3412# 0.28127f
C25 vdd a_2984_3416# 0.11011f
C26 a_1800_3416# b1 0.02378f
C27 m1_4094_3010# b3 0.06497f
C28 a_3576_3416# b2 0
C29 m1_3342_4048# b3 0.0067f
C30 m1_2262_4048# b1 0.01445f
C31 m1_4222_4048# a_3576_3416# 0
C32 a_2392_3416# b2 0.01373f
C33 a_4168_3416# a_3576_3416# 0.05563f
C34 m1_4094_3010# m1_3342_4048# 0.26112f
C35 b4 b3 0.03476f
C36 a_2392_3416# m1_1822_4048# 0.06921f
C37 a_3576_3416# a_2984_3416# 0.03485f
C38 vdd b1 0.60011f
C39 b0 b1 0.02048f
C40 a_2392_3416# a_2984_3416# 0.04802f
C41 m1_4094_3010# b4 0
C42 a_1800_3416# m1_1382_4048# 0.01706f
C43 m1_2262_4048# m1_4094_3010# 0.00343f
C44 vdd b3 0.75321f
C45 m1_2262_4048# m1_3342_4048# 0
C46 m1_4094_3010# m1_2760_3412# 0.00462f
C47 m1_2262_4048# m1_1382_4048# 0
C48 m1_4094_3010# vdd 0.00117f
C49 m1_3342_4048# m1_2760_3412# 0.31317f
C50 m1_2262_4048# a_1800_3416# 0.04031f
C51 m1_942_4048# out 0.06958f
C52 m1_3342_4048# vdd 0.00477f
C53 m1_1382_4048# m1_2760_3412# 0.00312f
C54 a_2392_3416# b1 0.26752f
C55 a_1800_3416# m1_2760_3412# 0
C56 a_1800_3416# vdd 0.17226f
C57 vdd b4 0.72875f
C58 a_1800_3416# b0 0.2037f
C59 a_3576_3416# b3 0.12657f
C60 m1_2262_4048# m1_2760_3412# 0.4402f
C61 a_2392_3416# b3 0
C62 m1_2262_4048# vdd 0.01298f
C63 m1_4094_3010# a_3576_3416# 0.20164f
C64 vdd m1_2760_3412# 0.00478f
C65 m1_3342_4048# a_3576_3416# 0.19263f
C66 a_4168_3416# m1_4222_4048# 0.00345f
C67 b2 a_2984_3416# 0.25515f
C68 b0 vdd 0.49782f
C69 m1_3342_4048# a_2392_3416# -0
C70 m1_942_4048# m1_1822_4048# 0
C71 a_4168_3416# a_2984_3416# 0
C72 a_3576_3416# b4 0.06652f
C73 a_1800_3416# a_2392_3416# 0.01991f
C74 m1_2262_4048# a_3576_3416# 0
C75 m1_2262_4048# a_2392_3416# 0.32464f
C76 a_3576_3416# m1_2760_3412# 0.00689f
C77 vdd a_3576_3416# 0.16485f
C78 a_2392_3416# m1_2760_3412# 0.1015f
C79 b1 b2 0.03015f
C80 a_2392_3416# vdd 0.19015f
C81 out m1_502_4048# 0.06293f
C82 b0 a_2392_3416# 0
C83 out m1_1382_4048# 0.02493f
C84 m1_1822_4048# b1 0.00833f
C85 b2 b3 0.0858f
C86 a_4168_3416# b3 0.00279f
C87 a_2984_3416# b3 0.11129f
C88 m1_4094_3010# m1_4222_4048# 0.32763f
C89 m1_4094_3010# a_4168_3416# 0.11823f
C90 m1_3342_4048# b2 0.0068f
C91 m1_4094_3010# vss 1.24421f
C92 m1_1382_4048# vss 0.63563f
C93 m1_2760_3412# vss 0.51839f
C94 m1_3342_4048# vss 0.51288f
C95 m1_942_4048# vss 0.35136f
C96 m1_2262_4048# vss 0.29456f
C97 m1_1822_4048# vss 0.33864f
C98 m1_502_4048# vss 0.6194f
C99 out vss 0.79041f
C100 a_1800_3416# vss 0.84103f
C101 b0 vss 0.53222f
C102 vdd vss 15.08764f
C103 a_2392_3416# vss 0.56569f
C104 b1 vss 0.44836f
C105 a_2984_3416# vss 0.44317f
C106 b2 vss 0.55514f
C107 a_3576_3416# vss 0.65055f
C108 b3 vss 0.54803f
C109 a_4168_3416# vss 1.35234f
C110 b4 vss 0.62555f
C111 m1_4222_4048# vss 0.2956f
.ends
