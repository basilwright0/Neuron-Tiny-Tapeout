* NGSPICE file created from vdacr_vr_old.ext - technology: gf180mcuD

.subckt r_w1_l7p765 a_n100_n899# a_n100_777# VSUBS
X0 a_n100_777# a_n100_n899# VSUBS ppolyf_u_1k r_width=1u r_length=7.77u
C0 a_n100_n899# VSUBS 0.27003f
C1 a_n100_777# VSUBS 0.27003f
.ends

.subckt r_w2_l1p97 a_n200_n319# a_n200_197# VSUBS
X0 a_n200_197# a_n200_n319# VSUBS ppolyf_u_1k r_width=2u r_length=1.97u
C0 a_n200_197# a_n200_n319# 0.02096f
C1 a_n200_n319# VSUBS 0.42971f
C2 a_n200_197# VSUBS 0.42971f
.ends

.subckt r_w1_l1p94 a_n100_n316# a_n100_194# VSUBS
X0 a_n100_194# a_n100_n316# VSUBS ppolyf_u_1k r_width=1u r_length=1.94u
C0 a_n100_194# a_n100_n316# 0.01052f
C1 a_n100_n316# VSUBS 0.2541f
C2 a_n100_194# VSUBS 0.2541f
.ends

.subckt r_w1_l3p88 a_n100_n510# a_n100_388# VSUBS
X0 a_n100_388# a_n100_n510# VSUBS ppolyf_u_1k r_width=1u r_length=3.88u
C0 a_n100_388# a_n100_n510# 0.00535f
C1 a_n100_n510# VSUBS 0.26053f
C2 a_n100_388# VSUBS 0.26053f
.ends

.subckt n_w0p5_l1 a_100_n50# a_n100_n94# a_n188_n50# VSUBS
X0 a_100_n50# a_n100_n94# a_n188_n50# VSUBS nfet_03v3 ad=0.22p pd=1.88u as=0.22p ps=1.88u w=0.5u l=1u
C0 a_100_n50# a_n188_n50# 0.00935f
C1 a_n100_n94# a_100_n50# 0.01026f
C2 a_n100_n94# a_n188_n50# 0.01026f
C3 a_100_n50# VSUBS 0.13392f
C4 a_n188_n50# VSUBS 0.13392f
.ends

.subckt p_w1_l1 a_n188_n100# a_100_n100# a_n100_n144# w_n274_n230# VSUBS
X0 a_100_n100# a_n100_n144# a_n188_n100# w_n274_n230# pfet_03v3 ad=0.44p pd=2.88u as=0.44p ps=2.88u w=1u l=1u
C0 w_n274_n230# a_100_n100# 0.02517f
C1 a_n188_n100# a_n100_n144# 0.02094f
C2 w_n274_n230# a_n188_n100# 0.02517f
C3 a_100_n100# a_n188_n100# 0.0191f
C4 w_n274_n230# a_n100_n144# 0.12884f
C5 a_100_n100# a_n100_n144# 0.02094f
C6 a_100_n100# VSUBS 0.07854f
C7 a_n188_n100# VSUBS 0.07854f
C8 w_n274_n230# VSUBS 0.75624f
.ends

.subckt r_w1_l13p91 a_n100_n1513# a_n100_1391# VSUBS
X0 a_n100_1391# a_n100_n1513# VSUBS ppolyf_u_1k r_width=1u r_length=13.91u
C0 a_n100_n1513# VSUBS 0.27003f
C1 a_n100_1391# VSUBS 0.27003f
.ends

.subckt n_w4_l0p28_f2 a_n52_n400# a_52_n444# a_108_n400# a_n108_n444# a_n196_n400#
+ VSUBS
X0 a_108_n400# a_52_n444# a_n52_n400# VSUBS nfet_03v3 ad=1.76p pd=8.88u as=1.04p ps=4.52u w=4u l=0.28u
X1 a_n52_n400# a_n108_n444# a_n196_n400# VSUBS nfet_03v3 ad=1.04p pd=4.52u as=1.76p ps=8.88u w=4u l=0.28u
C0 a_52_n444# a_108_n400# 0.03125f
C1 a_n108_n444# a_n52_n400# 0.03125f
C2 a_n52_n400# a_108_n400# 0.17284f
C3 a_n108_n444# a_n196_n400# 0.03125f
C4 a_n52_n400# a_n196_n400# 0.17284f
C5 a_n108_n444# a_52_n444# 0.00519f
C6 a_n52_n400# a_52_n444# 0.03125f
C7 a_108_n400# VSUBS 0.20946f
C8 a_n52_n400# VSUBS 0.09458f
C9 a_n196_n400# VSUBS 0.20946f
.ends

.subckt vdacr_vr_old b0 b1 b2 b3 b4 vdd out vss
XXRS4_0 m1_3782_4048# m1_3662_2290# vss r_w1_l7p765
XXRS4_1 vss m1_3782_4048# vss r_w1_l7p765
XXRS0 m1_2318_2410# m1_1716_2640# vss r_w2_l1p97
XXRS1 m1_2910_2650# m1_2318_2410# vss r_w1_l1p94
XXRS3 m1_3662_2290# m1_3492_2640# vss r_w1_l7p765
XXRS2 m1_3492_2640# m1_2910_2650# vss r_w1_l3p88
XIB4n a_4168_3416# b4 vss vss n_w0p5_l1
XIB3n a_3576_3416# b3 vss vss n_w0p5_l1
XIB4p vdd a_4168_3416# b4 vdd vss p_w1_l1
XIB2n a_2984_3416# b2 vss vss n_w0p5_l1
XIB3p vdd a_3576_3416# b3 vdd vss p_w1_l1
XIB2p vdd a_2984_3416# b2 vdd vss p_w1_l1
XIB1n a_2392_3416# b1 vss vss n_w0p5_l1
XIB0n a_1800_3416# b0 vss vss n_w0p5_l1
XIB1p vdd a_2392_3416# b1 vdd vss p_w1_l1
XIB0p vdd a_1800_3416# b0 vdd vss p_w1_l1
XXRB0 m1_502_4048# out vss r_w1_l13p91
XSW0 m1_2318_2410# a_1800_3416# m1_1716_2640# a_1800_3416# m1_1716_2640# vss n_w4_l0p28_f2
XXRB1 m1_942_4048# m1_502_4048# vss r_w1_l13p91
XSW2 m1_3492_2640# a_2984_3416# m1_2910_2650# a_2984_3416# m1_2910_2650# vss n_w4_l0p28_f2
XSW1 m1_2910_2650# a_2392_3416# m1_2318_2410# a_2392_3416# m1_2318_2410# vss n_w4_l0p28_f2
XXRB2 m1_1716_2640# m1_942_4048# vss r_w1_l13p91
XSW3 m1_3662_2290# a_3576_3416# m1_3492_2640# a_3576_3416# m1_3492_2640# vss n_w4_l0p28_f2
XSW4 vss a_4168_3416# m1_3662_2290# a_4168_3416# m1_3662_2290# vss n_w4_l0p28_f2
C0 m1_942_4048# m1_2318_2410# 0
C1 vdd m1_3492_2640# 0.00698f
C2 m1_2318_2410# m1_3782_4048# 0
C3 m1_942_4048# m1_502_4048# 0.22901f
C4 m1_2910_2650# m1_3492_2640# 0.4255f
C5 vdd a_3576_3416# 0.23034f
C6 b2 a_1800_3416# 0
C7 m1_2910_2650# a_3576_3416# 0.00192f
C8 vdd m1_3662_2290# 0
C9 out m1_502_4048# 0.0905f
C10 m1_2910_2650# m1_3662_2290# 0.01509f
C11 m1_1716_2640# m1_3492_2640# 0
C12 out m1_942_4048# 0.03171f
C13 a_3576_3416# b3 0.23396f
C14 m1_2318_2410# a_1800_3416# 0.10972f
C15 b2 a_2392_3416# 0.09705f
C16 b3 m1_3662_2290# 0.03077f
C17 a_2984_3416# a_2392_3416# 0.06043f
C18 a_4168_3416# m1_3492_2640# 0.00141f
C19 m1_942_4048# a_1800_3416# 0
C20 m1_2318_2410# a_2392_3416# 0.24082f
C21 b0 vdd 0.56802f
C22 m1_2910_2650# vdd 0.0023f
C23 a_4168_3416# a_3576_3416# 0.09216f
C24 vdd b1 0.64727f
C25 a_4168_3416# m1_3662_2290# 0.09446f
C26 m1_3492_2640# b2 0.00107f
C27 b0 b1 0.03005f
C28 vdd b3 0.49099f
C29 m1_3492_2640# a_2984_3416# 0.19145f
C30 m1_1716_2640# vdd 0.00575f
C31 b2 a_3576_3416# 0
C32 a_2984_3416# a_3576_3416# 0.01854f
C33 m1_1716_2640# m1_2910_2650# 0.04159f
C34 m1_2318_2410# m1_3492_2640# 0
C35 m1_1716_2640# b1 0.02654f
C36 a_2984_3416# m1_3662_2290# 0.02389f
C37 a_4168_3416# vdd 0.2173f
C38 m1_2318_2410# m1_3662_2290# 0
C39 a_1800_3416# a_2392_3416# 0.03101f
C40 m1_2910_2650# a_4168_3416# 0
C41 a_3576_3416# b4 0.03753f
C42 m1_3782_4048# m1_3492_2640# 0.01069f
C43 a_4168_3416# b3 0.00455f
C44 vdd b2 0.70269f
C45 m1_3782_4048# a_3576_3416# 0.0078f
C46 vdd a_2984_3416# 0.30382f
C47 m1_2910_2650# b2 0.04099f
C48 m1_3782_4048# m1_3662_2290# 0.3267f
C49 m1_2910_2650# a_2984_3416# 0.33905f
C50 b1 b2 0.02658f
C51 m1_2318_2410# vdd 0.0012f
C52 b1 a_2984_3416# 0
C53 b2 b3 0.03632f
C54 a_2984_3416# b3 0.04137f
C55 m1_2910_2650# m1_2318_2410# 0.21981f
C56 vdd b4 0.7855f
C57 m1_2318_2410# b1 0.01095f
C58 m1_1716_2640# m1_2318_2410# 0.65049f
C59 b4 b3 0.03565f
C60 m1_2910_2650# m1_3782_4048# 0
C61 a_4168_3416# a_2984_3416# 0.00142f
C62 m1_1716_2640# m1_502_4048# 0
C63 a_2392_3416# m1_3662_2290# 0
C64 m1_1716_2640# m1_942_4048# 0.0409f
C65 vdd a_1800_3416# 0.17745f
C66 b2 a_2984_3416# 0.1241f
C67 b0 a_1800_3416# 0.19236f
C68 a_4168_3416# b4 0.14638f
C69 m1_2910_2650# a_1800_3416# 0.00203f
C70 m1_3492_2640# a_3576_3416# 0.14935f
C71 b1 a_1800_3416# 0.06437f
C72 vdd a_2392_3416# 0.27248f
C73 m1_2318_2410# a_2984_3416# 0.02082f
C74 m1_3782_4048# a_4168_3416# 0.00195f
C75 m1_3492_2640# m1_3662_2290# 0.29405f
C76 m1_1716_2640# a_1800_3416# 0.06997f
C77 m1_2910_2650# a_2392_3416# 0.10575f
C78 a_3576_3416# m1_3662_2290# 0.30182f
C79 a_2984_3416# b4 0
C80 b1 a_2392_3416# 0.06781f
C81 m1_2318_2410# m1_502_4048# 0
C82 m1_1716_2640# a_2392_3416# 0.04631f
C83 m1_3662_2290# vss 1.32246f
C84 m1_2910_2650# vss 0.57102f
C85 m1_3492_2640# vss 0.58918f
C86 m1_942_4048# vss 0.68475f
C87 m1_2318_2410# vss 0.33445f
C88 m1_1716_2640# vss 0.27476f
C89 m1_502_4048# vss 0.74307f
C90 out vss 0.95167f
C91 a_1800_3416# vss 0.95743f
C92 b0 vss 0.57434f
C93 vdd vss 15.01984f
C94 a_2392_3416# vss 0.55472f
C95 b1 vss 0.60104f
C96 a_2984_3416# vss 0.73623f
C97 b2 vss 0.77591f
C98 a_3576_3416# vss 0.68085f
C99 b3 vss 0.47349f
C100 a_4168_3416# vss 1.18373f
C101 b4 vss 0.4195f
C102 m1_3782_4048# vss 0.43439f
.ends
