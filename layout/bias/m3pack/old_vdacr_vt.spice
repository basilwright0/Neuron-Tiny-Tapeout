* NGSPICE file created from vdacr_vt_old.ext - technology: gf180mcuD

.subckt r_w1_l9p86 a_n100_n1108# a_n100_986# VSUBS
X0 a_n100_986# a_n100_n1108# VSUBS ppolyf_u_1k r_width=1u r_length=9.86u
C0 a_n100_n1108# VSUBS 0.27003f
C1 a_n100_986# VSUBS 0.27003f
.ends

.subckt r_w2_l2p5 a_n200_250# a_n200_n372# VSUBS
X0 a_n200_250# a_n200_n372# VSUBS ppolyf_u_1k r_width=2u r_length=2.5u
C0 a_n200_250# a_n200_n372# 0.01672f
C1 a_n200_n372# VSUBS 0.4345f
C2 a_n200_250# VSUBS 0.4345f
.ends

.subckt r_w1_l2p465 a_n100_n369# a_n100_247# VSUBS
X0 a_n100_247# a_n100_n369# VSUBS ppolyf_u_1k r_width=1u r_length=2.47u
C0 a_n100_247# a_n100_n369# 0.00837f
C1 a_n100_n369# VSUBS 0.25651f
C2 a_n100_247# VSUBS 0.25651f
.ends

.subckt r_w1_l4p93 a_n100_n615# a_n100_493# VSUBS
X0 a_n100_493# a_n100_n615# VSUBS ppolyf_u_1k r_width=1u r_length=4.93u
C0 a_n100_493# a_n100_n615# 0.0042f
C1 a_n100_n615# VSUBS 0.2623f
C2 a_n100_493# VSUBS 0.2623f
.ends

.subckt n_w0p5_l1 a_100_n50# a_n100_n94# a_n188_n50# VSUBS
X0 a_100_n50# a_n100_n94# a_n188_n50# VSUBS nfet_03v3 ad=0.22p pd=1.88u as=0.22p ps=1.88u w=0.5u l=1u
C0 a_n188_n50# a_n100_n94# 0.01026f
C1 a_n188_n50# a_100_n50# 0.00935f
C2 a_n100_n94# a_100_n50# 0.01026f
C3 a_100_n50# VSUBS 0.13392f
C4 a_n188_n50# VSUBS 0.13392f
.ends

.subckt p_w1_l1 a_n188_n100# a_100_n100# a_n100_n144# w_n274_n230# VSUBS
X0 a_100_n100# a_n100_n144# a_n188_n100# w_n274_n230# pfet_03v3 ad=0.44p pd=2.88u as=0.44p ps=2.88u w=1u l=1u
C0 a_n100_n144# w_n274_n230# 0.12884f
C1 a_100_n100# a_n100_n144# 0.02094f
C2 a_n100_n144# a_n188_n100# 0.02094f
C3 a_100_n100# w_n274_n230# 0.02517f
C4 w_n274_n230# a_n188_n100# 0.02517f
C5 a_100_n100# a_n188_n100# 0.0191f
C6 a_100_n100# VSUBS 0.07854f
C7 a_n188_n100# VSUBS 0.07854f
C8 w_n274_n230# VSUBS 0.75624f
.ends

.subckt r_w1_l13p145 a_n100_1315# a_n100_n1437# VSUBS
X0 a_n100_1315# a_n100_n1437# VSUBS ppolyf_u_1k r_width=1u r_length=13.15u
C0 a_n100_n1437# VSUBS 0.27003f
C1 a_n100_1315# VSUBS 0.27003f
.ends

.subckt r_w1_l13p39 a_n100_n1461# a_n100_1339# VSUBS
X0 a_n100_1339# a_n100_n1461# VSUBS ppolyf_u_1k r_width=1u r_length=13.39u
C0 a_n100_n1461# VSUBS 0.27003f
C1 a_n100_1339# VSUBS 0.27003f
.ends

.subckt n_w6_l0p28_f2 a_52_n644# a_108_n600# a_n108_n644# a_n196_n600# a_n52_n600#
+ VSUBS
X0 a_108_n600# a_52_n644# a_n52_n600# VSUBS nfet_03v3 ad=2.64p pd=12.88u as=1.56p ps=6.52u w=6u l=0.28u
X1 a_n52_n600# a_n108_n644# a_n196_n600# VSUBS nfet_03v3 ad=1.56p pd=6.52u as=2.64p ps=12.88u w=6u l=0.28u
C0 a_52_n644# a_n108_n644# 0.00519f
C1 a_n52_n600# a_108_n600# 0.2597f
C2 a_n52_n600# a_52_n644# 0.04695f
C3 a_n52_n600# a_n108_n644# 0.04695f
C4 a_52_n644# a_108_n600# 0.04695f
C5 a_n108_n644# a_n196_n600# 0.04695f
C6 a_n52_n600# a_n196_n600# 0.2597f
C7 a_108_n600# VSUBS 0.28641f
C8 a_n52_n600# VSUBS 0.09458f
C9 a_n196_n600# VSUBS 0.28641f
.ends

.subckt vdacr_vt_old b0 b1 b2 b3 b4 b5 vdd out vss
XXRS4_0 m1_4648_4446# m1_4328_3000# vss r_w1_l9p86
XXRS4_1 m1_4488_3600# m1_4648_4446# vss r_w1_l9p86
XXRS0 m1_1970_3610# m1_2702_4448# vss r_w2_l2p5
XXRS1 m1_3342_4448# m1_2702_4448# vss r_w1_l2p465
XXRS3 m1_4328_3000# m1_3600_4920# vss r_w1_l9p86
XXRS2 m1_3600_4920# m1_3342_4448# vss r_w1_l4p93
XIB5n a_5004_3816# b5 vss vss n_w0p5_l1
XIB4n a_4412_3816# b4 vss vss n_w0p5_l1
XIB5p vdd a_5004_3816# b5 vdd vss p_w1_l1
XIB3n a_3820_3816# b3 vss vss n_w0p5_l1
XIB4p vdd a_4412_3816# b4 vdd vss p_w1_l1
XIB2n a_3228_3816# b2 vss vss n_w0p5_l1
XIB3p vdd a_3820_3816# b3 vdd vss p_w1_l1
XIB2p vdd a_3228_3816# b2 vdd vss p_w1_l1
XIB1n a_2636_3816# b1 vss vss n_w0p5_l1
XIB0n a_2044_3816# b0 vss vss n_w0p5_l1
XIB1p vdd a_2636_3816# b1 vdd vss p_w1_l1
XIB0p vdd a_2044_3816# b0 vdd vss p_w1_l1
XXRS5_0 m1_4488_3600# m1_5542_4448# vss r_w1_l13p145
XXRS5_1 m1_5542_4448# m1_5982_4448# vss r_w1_l13p145
XXRB0 m1_502_4448# out vss r_w1_l13p39
XSW0 a_2044_3816# m1_1970_3610# a_2044_3816# m1_1970_3610# m1_2702_4448# vss n_w6_l0p28_f2
XXRS5_2 m1_5982_4448# vss vss r_w1_l13p145
XXRB1 m1_942_4448# m1_502_4448# vss r_w1_l13p39
XSW2 a_3228_3816# m1_3342_4448# a_3228_3816# m1_3342_4448# m1_3600_4920# vss n_w6_l0p28_f2
XSW1 a_2636_3816# m1_2702_4448# a_2636_3816# m1_2702_4448# m1_3342_4448# vss n_w6_l0p28_f2
XXRB3 m1_1822_4448# m1_1382_4448# vss r_w1_l13p39
XXRB2 m1_1382_4448# m1_942_4448# vss r_w1_l13p39
XSW3 a_3820_3816# m1_3600_4920# a_3820_3816# m1_3600_4920# m1_4328_3000# vss n_w6_l0p28_f2
XXRB4 m1_1970_3610# m1_1822_4448# vss r_w1_l13p39
XSW4 a_4412_3816# m1_4328_3000# a_4412_3816# m1_4328_3000# m1_4488_3600# vss n_w6_l0p28_f2
XSW5 a_5004_3816# m1_4488_3600# a_5004_3816# m1_4488_3600# vss vss n_w6_l0p28_f2
C0 b1 b2 0.04123f
C1 m1_1970_3610# a_2044_3816# 0.10153f
C2 a_3820_3816# vdd 0.29721f
C3 vdd b5 0.77239f
C4 a_2636_3816# m1_2702_4448# 0.1678f
C5 m1_3342_4448# a_2636_3816# 0.03732f
C6 a_5004_3816# m1_4328_3000# 0.00328f
C7 b1 a_3228_3816# 0.02319f
C8 a_3820_3816# m1_3600_4920# 0.31917f
C9 m1_2702_4448# m1_4648_4446# 0
C10 m1_3342_4448# m1_4648_4446# 0.00357f
C11 m1_1970_3610# m1_1382_4448# 0
C12 m1_1970_3610# b1 0.00571f
C13 b3 vdd 0.68874f
C14 a_3820_3816# b5 0
C15 m1_2702_4448# a_4412_3816# -0
C16 m1_1970_3610# m1_1822_4448# 0.05422f
C17 a_2636_3816# vdd 0.3449f
C18 b3 m1_3600_4920# 0.0043f
C19 m1_3342_4448# b2 0.02073f
C20 b4 vdd 0.68174f
C21 b0 vdd 0.59561f
C22 a_2636_3816# m1_3600_4920# 0
C23 m1_2702_4448# a_3228_3816# 0.24753f
C24 a_5004_3816# m1_5542_4448# 0.00614f
C25 m1_3342_4448# a_3228_3816# 0.2721f
C26 a_3820_3816# b3 0.24966f
C27 m1_3600_4920# m1_4648_4446# 0.00845f
C28 m1_1382_4448# m1_502_4448# 0
C29 m1_1970_3610# m1_2702_4448# 0.34169f
C30 m1_1382_4448# out 0.04481f
C31 m1_3342_4448# m1_1970_3610# 0.00116f
C32 a_3820_3816# a_2636_3816# 0.00239f
C33 vdd a_4412_3816# 0.37257f
C34 vdd b2 0.49822f
C35 m1_5982_4448# m1_4488_3600# 0
C36 m1_502_4448# m1_1822_4448# 0
C37 b4 a_3820_3816# 0.02144f
C38 out m1_1822_4448# 0.01716f
C39 b4 b5 0.06082f
C40 m1_3600_4920# a_4412_3816# 0.06544f
C41 vdd a_3228_3816# 0.27287f
C42 b3 a_2636_3816# 0
C43 m1_3600_4920# a_3228_3816# 0.08395f
C44 a_3820_3816# a_4412_3816# 0.13807f
C45 a_4412_3816# b5 0.02149f
C46 a_3820_3816# b2 0.01081f
C47 b4 b3 0.03428f
C48 m1_1970_3610# m1_3600_4920# 0.01105f
C49 m1_4328_3000# m1_4488_3600# 0.37579f
C50 a_3820_3816# a_3228_3816# 0.095f
C51 b0 a_2636_3816# 0.00455f
C52 a_5004_3816# vdd 0.24276f
C53 b3 a_4412_3816# 0.02259f
C54 b3 b2 0.04726f
C55 m1_1970_3610# m1_942_4448# 0
C56 a_2636_3816# b2 0.00158f
C57 b3 a_3228_3816# 0.04175f
C58 m1_4648_4446# a_4412_3816# 0
C59 b4 a_4412_3816# 0.35348f
C60 a_5004_3816# b5 0.15238f
C61 a_2636_3816# a_3228_3816# 0.11112f
C62 m1_3600_4920# out 0.00168f
C63 m1_5542_4448# m1_4488_3600# 0.43146f
C64 m1_4328_3000# m1_5982_4448# 0
C65 m1_1970_3610# a_2636_3816# 0.26038f
C66 m1_502_4448# m1_942_4448# 0.32053f
C67 out m1_942_4448# 0.04568f
C68 a_3228_3816# b2 0.28704f
C69 m1_3342_4448# m1_4488_3600# 0
C70 a_5004_3816# m1_4648_4446# 0
C71 b4 a_5004_3816# 0.00821f
C72 m1_5982_4448# m1_5542_4448# 0.20108f
C73 m1_1970_3610# a_3228_3816# 0.05212f
C74 a_5004_3816# a_4412_3816# 0.02705f
C75 vdd m1_4488_3600# 0.00711f
C76 m1_3600_4920# m1_4488_3600# 0.00423f
C77 m1_4328_3000# m1_5542_4448# 0.00102f
C78 m1_1382_4448# a_2044_3816# 0.00399f
C79 a_3820_3816# m1_4488_3600# 0
C80 a_2044_3816# b1 0.01431f
C81 a_2044_3816# m1_1822_4448# 0.00152f
C82 m1_4328_3000# m1_2702_4448# 0
C83 m1_4328_3000# m1_3342_4448# 0.04776f
C84 m1_1382_4448# m1_1822_4448# 0.13617f
C85 a_2044_3816# m1_2702_4448# 0.0396f
C86 m1_3342_4448# a_2044_3816# 0
C87 m1_4648_4446# m1_4488_3600# 0.19057f
C88 b4 m1_4488_3600# 0.01234f
C89 m1_502_4448# out 0.05317f
C90 m1_2702_4448# b1 0.01432f
C91 m1_4488_3600# a_4412_3816# 0.24379f
C92 m1_4328_3000# m1_3600_4920# 0.29676f
C93 a_2044_3816# vdd 0.21896f
C94 m1_2702_4448# m1_1822_4448# 0.01365f
C95 m1_3342_4448# m1_1822_4448# 0
C96 m1_4328_3000# a_3820_3816# 0.13623f
C97 m1_5982_4448# m1_4648_4446# 0
C98 vdd b1 0.42773f
C99 m1_3342_4448# m1_2702_4448# 0.32043f
C100 m1_4328_3000# b3 0.04902f
C101 m1_5542_4448# m1_3600_4920# 0
C102 a_5004_3816# m1_4488_3600# 0.08054f
C103 m1_3600_4920# m1_1822_4448# 0.02531f
C104 m1_1382_4448# m1_942_4448# 0.22008f
C105 m1_4328_3000# m1_4648_4446# 0.34307f
C106 vdd m1_2702_4448# 0
C107 b4 m1_4328_3000# 0
C108 m1_3342_4448# vdd 0.00387f
C109 a_2044_3816# a_2636_3816# 0.24666f
C110 m1_1822_4448# m1_942_4448# 0
C111 m1_2702_4448# m1_3600_4920# 0.03473f
C112 a_2044_3816# b0 0.1542f
C113 m1_3342_4448# m1_3600_4920# 0.50642f
C114 m1_4328_3000# a_4412_3816# 0.33612f
C115 a_2636_3816# b1 0.52429f
C116 a_3820_3816# m1_2702_4448# 0.00476f
C117 m1_3342_4448# a_3820_3816# 0.13866f
C118 a_5004_3816# m1_5982_4448# 0.00304f
C119 a_2636_3816# m1_1822_4448# 0.0315f
C120 b0 b1 0.01967f
C121 m1_5542_4448# m1_4648_4446# 0.00178f
C122 vdd m1_3600_4920# 0.01058f
C123 a_2044_3816# a_3228_3816# 0.01538f
C124 m1_4488_3600# vss 0.8538f
C125 m1_4328_3000# vss 0.53806f
C126 m1_1382_4448# vss 0.44029f
C127 m1_1822_4448# vss 0.69694f
C128 m1_3342_4448# vss 0.37026f
C129 m1_2702_4448# vss 0.1525f
C130 m1_3600_4920# vss 0.84217f
C131 m1_942_4448# vss 0.30669f
C132 m1_1970_3610# vss 0.29471f
C133 m1_502_4448# vss 0.71325f
C134 out vss 0.81653f
C135 m1_5982_4448# vss 0.81009f
C136 m1_5542_4448# vss 0.39604f
C137 a_2044_3816# vss 1.10805f
C138 b0 vss 0.62622f
C139 vdd vss 17.44801f
C140 a_2636_3816# vss 1.19693f
C141 b1 vss 0.43137f
C142 a_3228_3816# vss 1.02137f
C143 b2 vss 0.41637f
C144 a_3820_3816# vss 0.80739f
C145 b3 vss 0.46252f
C146 a_4412_3816# vss 0.93204f
C147 b4 vss 0.43507f
C148 a_5004_3816# vss 1.4333f
C149 b5 vss 0.5235f
C150 m1_4648_4446# vss 0.32911f
.ends
