* NGSPICE file created from vdacr_vt_vdac.ext - technology: gf180mcuD

.subckt r_w1_l9p86 a_n100_n1108# a_n100_986# VSUBS
X0 a_n100_986# a_n100_n1108# VSUBS ppolyf_u_1k r_width=1u r_length=9.86u
C0 a_n100_n1108# VSUBS 0.27003f
C1 a_n100_986# VSUBS 0.27003f
.ends

.subckt r_w2_l2p5 a_n200_250# a_n200_n372# VSUBS
X0 a_n200_250# a_n200_n372# VSUBS ppolyf_u_1k r_width=2u r_length=2.5u
C0 a_n200_n372# a_n200_250# 0.01672f
C1 a_n200_n372# VSUBS 0.4345f
C2 a_n200_250# VSUBS 0.4345f
.ends

.subckt r_w1_l2p465 a_n100_n369# a_n100_247# VSUBS
X0 a_n100_247# a_n100_n369# VSUBS ppolyf_u_1k r_width=1u r_length=2.47u
C0 a_n100_n369# a_n100_247# 0.00837f
C1 a_n100_n369# VSUBS 0.25651f
C2 a_n100_247# VSUBS 0.25651f
.ends

.subckt r_w1_l4p93 a_n100_n615# a_n100_493# VSUBS
X0 a_n100_493# a_n100_n615# VSUBS ppolyf_u_1k r_width=1u r_length=4.93u
C0 a_n100_n615# a_n100_493# 0.0042f
C1 a_n100_n615# VSUBS 0.2623f
C2 a_n100_493# VSUBS 0.2623f
.ends

.subckt n_w0p5_l1 a_100_n50# a_n100_n94# a_n188_n50# VSUBS
X0 a_100_n50# a_n100_n94# a_n188_n50# VSUBS nfet_03v3 ad=0.22p pd=1.88u as=0.22p ps=1.88u w=0.5u l=1u
C0 a_100_n50# a_n188_n50# 0.00935f
C1 a_100_n50# a_n100_n94# 0.01026f
C2 a_n100_n94# a_n188_n50# 0.01026f
C3 a_100_n50# VSUBS 0.13392f
C4 a_n188_n50# VSUBS 0.13392f
.ends

.subckt p_w1_l1 a_n188_n100# a_100_n100# a_n100_n144# w_n274_n230# VSUBS
X0 a_100_n100# a_n100_n144# a_n188_n100# w_n274_n230# pfet_03v3 ad=0.44p pd=2.88u as=0.44p ps=2.88u w=1u l=1u
C0 a_n188_n100# a_100_n100# 0.0191f
C1 a_n100_n144# a_100_n100# 0.02094f
C2 w_n274_n230# a_100_n100# 0.02517f
C3 a_n188_n100# a_n100_n144# 0.02094f
C4 a_n188_n100# w_n274_n230# 0.02517f
C5 w_n274_n230# a_n100_n144# 0.12884f
C6 a_100_n100# VSUBS 0.07854f
C7 a_n188_n100# VSUBS 0.07854f
C8 w_n274_n230# VSUBS 0.75624f
.ends

.subckt r_w1_l13p145 a_n100_1315# a_n100_n1437# VSUBS
X0 a_n100_1315# a_n100_n1437# VSUBS ppolyf_u_1k r_width=1u r_length=13.15u
C0 a_n100_n1437# VSUBS 0.27003f
C1 a_n100_1315# VSUBS 0.27003f
.ends

.subckt r_w1_l13p39 a_n100_n1461# a_n100_1339# VSUBS
X0 a_n100_1339# a_n100_n1461# VSUBS ppolyf_u_1k r_width=1u r_length=13.39u
C0 a_n100_n1461# VSUBS 0.27003f
C1 a_n100_1339# VSUBS 0.27003f
.ends

.subckt n_w6_l0p28_f2 a_52_n644# a_108_n600# a_n108_n644# a_n196_n600# a_n52_n600#
+ VSUBS
X0 a_108_n600# a_52_n644# a_n52_n600# VSUBS nfet_03v3 ad=2.64p pd=12.88u as=1.56p ps=6.52u w=6u l=0.28u
X1 a_n52_n600# a_n108_n644# a_n196_n600# VSUBS nfet_03v3 ad=1.56p pd=6.52u as=2.64p ps=12.88u w=6u l=0.28u
C0 a_108_n600# a_52_n644# 0.04695f
C1 a_n196_n600# a_n52_n600# 0.2597f
C2 a_52_n644# a_n52_n600# 0.04695f
C3 a_n108_n644# a_n52_n600# 0.04695f
C4 a_108_n600# a_n52_n600# 0.2597f
C5 a_n196_n600# a_n108_n644# 0.04695f
C6 a_n108_n644# a_52_n644# 0.00519f
C7 a_108_n600# VSUBS 0.28641f
C8 a_n52_n600# VSUBS 0.09458f
C9 a_n196_n600# VSUBS 0.28641f
.ends

.subckt vdacr_vt_vdac b0 b1 b2 b3 b4 b5 vdd out vss
XXRS4_0 m1_4102_4448# m1_3908_2760# vss r_w1_l9p86
XXRS4_1 m1_4078_3250# m1_4102_4448# vss r_w1_l9p86
XXRS0 m1_1523_3480# m1_2408_3600# vss r_w2_l2p5
XXRS1 m1_2720_2760# m1_2408_3600# vss r_w1_l2p465
XXRS3 m1_3908_2760# m1_3222_4448# vss r_w1_l9p86
XXRS2 m1_3222_4448# m1_2720_2760# vss r_w1_l4p93
XIB5n a_4584_3816# b5 vss vss n_w0p5_l1
XIB4n a_3992_3816# b4 vss vss n_w0p5_l1
XIB5p vdd a_4584_3816# b5 vdd vss p_w1_l1
XIB3n a_3400_3816# b3 vss vss n_w0p5_l1
XIB4p vdd a_3992_3816# b4 vdd vss p_w1_l1
XIB2n a_2808_3816# b2 vss vss n_w0p5_l1
XIB3p vdd a_3400_3816# b3 vdd vss p_w1_l1
XIB2p vdd a_2808_3816# b2 vdd vss p_w1_l1
XIB1n a_2216_3816# b1 vss vss n_w0p5_l1
XIB0n a_1624_3816# b0 vss vss n_w0p5_l1
XIB1p vdd a_2216_3816# b1 vdd vss p_w1_l1
XIB0p vdd a_1624_3816# b0 vdd vss p_w1_l1
XXRS5_0 m1_4078_3250# m1_4982_4448# vss r_w1_l13p145
XXRS5_1 m1_4982_4448# m1_5422_4448# vss r_w1_l13p145
XXRB0 m1_382_4448# out vss r_w1_l13p39
XSW0 a_1624_3816# m1_1523_3480# a_1624_3816# m1_1523_3480# m1_2408_3600# vss n_w6_l0p28_f2
XXRS5_2 m1_5422_4448# vss vss r_w1_l13p145
XXRB1 m1_822_4448# m1_382_4448# vss r_w1_l13p39
XSW2 a_2808_3816# m1_2720_2760# a_2808_3816# m1_2720_2760# m1_3222_4448# vss n_w6_l0p28_f2
XSW1 a_2216_3816# m1_2408_3600# a_2216_3816# m1_2408_3600# m1_2720_2760# vss n_w6_l0p28_f2
XXRB3 m1_1702_4448# m1_1262_4448# vss r_w1_l13p39
XXRB2 m1_1262_4448# m1_822_4448# vss r_w1_l13p39
XSW3 a_3400_3816# m1_3222_4448# a_3400_3816# m1_3222_4448# m1_3908_2760# vss n_w6_l0p28_f2
XXRB4 m1_1523_3480# m1_1702_4448# vss r_w1_l13p39
XSW4 a_3992_3816# m1_3908_2760# a_3992_3816# m1_3908_2760# m1_4078_3250# vss n_w6_l0p28_f2
XSW5 a_4584_3816# m1_4078_3250# a_4584_3816# m1_4078_3250# vss vss n_w6_l0p28_f2
C0 a_3992_3816# m1_3908_2760# 0.28733f
C1 b3 a_3400_3816# 0.22216f
C2 m1_3222_4448# m1_4078_3250# 0.00268f
C3 vdd a_2808_3816# 0.27798f
C4 b1 a_1624_3816# 0.07746f
C5 m1_2720_2760# m1_4078_3250# 0
C6 m1_4982_4448# m1_3908_2760# 0
C7 a_2216_3816# m1_3222_4448# 0.00993f
C8 m1_4102_4448# m1_2408_3600# 0
C9 m1_822_4448# m1_2408_3600# 0
C10 m1_4102_4448# m1_1523_3480# 0
C11 m1_822_4448# m1_1523_3480# 0
C12 a_3992_3816# a_2808_3816# 0
C13 a_4584_3816# m1_4078_3250# 0.111f
C14 m1_2720_2760# a_2216_3816# 0.18569f
C15 vdd a_3400_3816# 0.23735f
C16 b5 m1_4078_3250# 0.00647f
C17 m1_1262_4448# m1_1702_4448# 0.26271f
C18 m1_822_4448# m1_382_4448# 0.24532f
C19 b5 b4 0.04472f
C20 a_1624_3816# a_2808_3816# 0
C21 m1_3222_4448# m1_3908_2760# 0.79372f
C22 a_3992_3816# a_3400_3816# 0.06572f
C23 m1_2720_2760# b1 0
C24 m1_3222_4448# b2 0.02027f
C25 m1_4102_4448# m1_4078_3250# 0.24673f
C26 m1_2720_2760# m1_3908_2760# 0.00425f
C27 m1_4102_4448# m1_5422_4448# 0
C28 b3 vdd 0.48325f
C29 m1_2720_2760# b2 0.00703f
C30 a_4584_3816# m1_3908_2760# 0.00224f
C31 m1_1523_3480# m1_2408_3600# 0.469f
C32 m1_3222_4448# a_2808_3816# 0.33661f
C33 b0 m1_2408_3600# 0
C34 m1_1523_3480# b0 0.00106f
C35 m1_2720_2760# a_2808_3816# 0.18059f
C36 m1_1262_4448# a_1624_3816# 0.01883f
C37 m1_382_4448# m1_1523_3480# 0
C38 m1_4102_4448# m1_3908_2760# 0.13034f
C39 m1_3222_4448# a_3400_3816# 0.21689f
C40 m1_822_4448# out 0.03993f
C41 m1_2720_2760# a_3400_3816# 0.00201f
C42 a_3992_3816# vdd 0.2529f
C43 a_1624_3816# m1_1702_4448# 0.00126f
C44 a_2216_3816# m1_2408_3600# 0.39348f
C45 a_2216_3816# m1_1523_3480# 0.06767f
C46 a_4584_3816# a_3400_3816# 0.00726f
C47 a_2216_3816# b0 0
C48 vdd a_1624_3816# 0.18717f
C49 b3 m1_3222_4448# 0.02397f
C50 m1_2720_2760# m1_1262_4448# 0
C51 b1 m1_2408_3600# 0.03027f
C52 b1 b0 0.07045f
C53 m1_2408_3600# m1_3908_2760# 0.00121f
C54 b4 m1_4078_3250# 0.00389f
C55 m1_3222_4448# m1_1702_4448# 0.01015f
C56 m1_5422_4448# m1_4078_3250# 0.00347f
C57 m1_1523_3480# m1_3908_2760# 0
C58 out m1_2408_3600# 0.00379f
C59 m1_2720_2760# m1_1702_4448# 0
C60 b0 b2 0
C61 vdd m1_3222_4448# 0
C62 m1_2720_2760# vdd 0.00518f
C63 m1_822_4448# m1_1262_4448# 0.1481f
C64 m1_2408_3600# a_2808_3816# 0.00831f
C65 m1_382_4448# out 0.05592f
C66 m1_1523_3480# a_2808_3816# 0
C67 a_3992_3816# m1_3222_4448# 0.00131f
C68 b0 a_2808_3816# 0
C69 m1_4078_3250# m1_3908_2760# 0.30336f
C70 a_4584_3816# vdd 0.20323f
C71 a_2216_3816# b1 0.2531f
C72 b4 m1_3908_2760# 0.01955f
C73 m1_5422_4448# m1_3908_2760# 0
C74 m1_2720_2760# a_3992_3816# 0
C75 b5 vdd 0.43768f
C76 b4 b2 0
C77 a_2216_3816# b2 0.05886f
C78 a_4584_3816# a_3992_3816# 0.07047f
C79 b5 a_3992_3816# 0.04355f
C80 m1_2720_2760# a_1624_3816# 0
C81 b1 b2 0.03795f
C82 a_2216_3816# a_2808_3816# 0.04827f
C83 m1_1262_4448# m1_2408_3600# 0
C84 a_4584_3816# m1_4982_4448# 0.00404f
C85 m1_1262_4448# m1_1523_3480# 0
C86 a_3992_3816# m1_4102_4448# 0.00406f
C87 m1_4078_3250# a_3400_3816# 0.02137f
C88 b4 a_3400_3816# 0.05013f
C89 m1_2720_2760# m1_3222_4448# 0.29322f
C90 b1 a_2808_3816# 0
C91 m1_1262_4448# m1_382_4448# 0
C92 a_2216_3816# a_3400_3816# 0
C93 m1_2408_3600# m1_1702_4448# 0.06983f
C94 m1_1523_3480# m1_1702_4448# 0.11064f
C95 m1_4102_4448# m1_4982_4448# 0
C96 a_2808_3816# m1_3908_2760# 0.05146f
C97 a_4584_3816# m1_3222_4448# 0
C98 b2 a_2808_3816# 0.15545f
C99 vdd m1_2408_3600# 0.00431f
C100 vdd m1_1523_3480# 0.00181f
C101 vdd b0 0.93369f
C102 m1_382_4448# m1_1702_4448# 0
C103 a_3400_3816# m1_3908_2760# 0.22332f
C104 b3 b4 0.0464f
C105 m1_4102_4448# m1_3222_4448# 0.00515f
C106 a_2216_3816# b3 0
C107 b2 a_3400_3816# 0.0044f
C108 b5 a_4584_3816# 0.25028f
C109 m1_2720_2760# m1_4102_4448# 0
C110 vdd m1_4078_3250# 0
C111 a_1624_3816# m1_2408_3600# 0.06776f
C112 b1 b3 0
C113 a_1624_3816# m1_1523_3480# 0.24354f
C114 vdd b4 0.42881f
C115 a_2808_3816# a_3400_3816# 0.12718f
C116 a_1624_3816# b0 0.15697f
C117 m1_1262_4448# out 0.01815f
C118 a_2216_3816# vdd 0.16862f
C119 b3 m1_3908_2760# 0.00485f
C120 a_3992_3816# m1_4078_3250# 0.46129f
C121 b3 b2 0.04625f
C122 a_3992_3816# b4 0.14825f
C123 m1_3908_2760# m1_1702_4448# 0
C124 b1 vdd 0.57997f
C125 m1_3222_4448# m1_2408_3600# 0.04242f
C126 out m1_1702_4448# 0.0205f
C127 m1_1523_3480# m1_3222_4448# 0.00589f
C128 m1_4982_4448# m1_4078_3250# 0.28435f
C129 vdd m1_3908_2760# 0.00273f
C130 b3 a_2808_3816# 0.06713f
C131 m1_2720_2760# m1_2408_3600# 0.46666f
C132 m1_2720_2760# m1_1523_3480# 0.1053f
C133 m1_5422_4448# m1_4982_4448# 0.22446f
C134 vdd b2 0.50217f
C135 a_2216_3816# a_1624_3816# 0.04096f
C136 m1_4078_3250# vss 1.0193f
C137 m1_3908_2760# vss 0.6176f
C138 m1_1262_4448# vss 0.46622f
C139 m1_1702_4448# vss 0.50469f
C140 m1_3222_4448# vss 0.36281f
C141 m1_2720_2760# vss 0.22391f
C142 m1_822_4448# vss 0.40669f
C143 m1_2408_3600# vss 0.34795f
C144 m1_1523_3480# vss 0.30041f
C145 m1_382_4448# vss 0.76813f
C146 out vss 0.89235f
C147 m1_5422_4448# vss 0.76804f
C148 m1_4982_4448# vss 0.40392f
C149 a_1624_3816# vss 1.18395f
C150 b0 vss 0.66386f
C151 vdd vss 15.03409f
C152 a_2216_3816# vss 0.49587f
C153 b1 vss 0.50743f
C154 a_2808_3816# vss 0.53292f
C155 b2 vss 0.53627f
C156 a_3400_3816# vss 0.52169f
C157 b3 vss 0.32078f
C158 a_3992_3816# vss 0.54027f
C159 b4 vss 0.29907f
C160 a_4584_3816# vss 0.98136f
C161 b5 vss 0.41509f
C162 m1_4102_4448# vss 0.36138f
.ends
