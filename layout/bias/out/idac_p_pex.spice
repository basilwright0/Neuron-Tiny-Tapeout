* NGSPICE file created from idac_p.ext - technology: gf180mcuD

.subckt p_w2_l2_f8 a_n52_n200# a_n1060_n200# a_452_n200# a_1564_n244# a_n452_n244#
+ w_n2138_n330# a_n556_n200# a_n1460_n244# a_1460_n200# a_52_n244# a_n1564_n200# a_956_n200#
+ a_n2052_n200# a_n956_n244# a_1060_n244# a_n1964_n244# a_556_n244# a_1964_n200# VSUBS
X0 a_1964_n200# a_1564_n244# a_1460_n200# w_n2138_n330# pfet_03v3 ad=0.88p pd=4.88u as=0.52p ps=2.52u w=2u l=2u
X1 a_452_n200# a_52_n244# a_n52_n200# w_n2138_n330# pfet_03v3 ad=0.52p pd=2.52u as=0.52p ps=2.52u w=2u l=2u
X2 a_956_n200# a_556_n244# a_452_n200# w_n2138_n330# pfet_03v3 ad=0.52p pd=2.52u as=0.52p ps=2.52u w=2u l=2u
X3 a_1460_n200# a_1060_n244# a_956_n200# w_n2138_n330# pfet_03v3 ad=0.52p pd=2.52u as=0.52p ps=2.52u w=2u l=2u
X4 a_n1564_n200# a_n1964_n244# a_n2052_n200# w_n2138_n330# pfet_03v3 ad=0.52p pd=2.52u as=0.88p ps=4.88u w=2u l=2u
X5 a_n1060_n200# a_n1460_n244# a_n1564_n200# w_n2138_n330# pfet_03v3 ad=0.52p pd=2.52u as=0.52p ps=2.52u w=2u l=2u
X6 a_n556_n200# a_n956_n244# a_n1060_n200# w_n2138_n330# pfet_03v3 ad=0.52p pd=2.52u as=0.52p ps=2.52u w=2u l=2u
X7 a_n52_n200# a_n452_n244# a_n556_n200# w_n2138_n330# pfet_03v3 ad=0.52p pd=2.52u as=0.52p ps=2.52u w=2u l=2u
C0 a_1060_n244# a_556_n244# 0.00519f
C1 a_956_n200# w_n2138_n330# 0.09155f
C2 a_452_n200# a_556_n244# 0.0587f
C3 a_n956_n244# a_n1460_n244# 0.00519f
C4 w_n2138_n330# a_n2052_n200# 0.0618f
C5 a_n956_n244# a_n452_n244# 0.00519f
C6 a_52_n244# a_556_n244# 0.00519f
C7 w_n2138_n330# a_n556_n200# 0.09155f
C8 a_n1564_n200# a_n1460_n244# 0.0587f
C9 a_452_n200# a_n52_n200# 0.02133f
C10 a_452_n200# a_52_n244# 0.0587f
C11 a_n52_n200# a_52_n244# 0.0587f
C12 a_n1564_n200# a_n1964_n244# 0.0587f
C13 a_1060_n244# a_1460_n200# 0.0587f
C14 a_n52_n200# a_n452_n244# 0.0587f
C15 a_n1060_n200# a_n556_n200# 0.02133f
C16 a_n452_n244# a_52_n244# 0.00519f
C17 a_n1964_n244# a_n1460_n244# 0.00519f
C18 a_1060_n244# a_1564_n244# 0.00519f
C19 a_n956_n244# w_n2138_n330# 0.21994f
C20 w_n2138_n330# a_1060_n244# 0.21994f
C21 w_n2138_n330# a_556_n244# 0.21994f
C22 a_n1564_n200# w_n2138_n330# 0.09155f
C23 a_452_n200# w_n2138_n330# 0.09155f
C24 a_n956_n244# a_n1060_n200# 0.0587f
C25 w_n2138_n330# a_n52_n200# 0.09155f
C26 w_n2138_n330# a_n1460_n244# 0.21994f
C27 w_n2138_n330# a_52_n244# 0.21994f
C28 w_n2138_n330# a_n452_n244# 0.21994f
C29 a_n1564_n200# a_n1060_n200# 0.02133f
C30 a_1460_n200# a_1564_n244# 0.0587f
C31 w_n2138_n330# a_n1964_n244# 0.2233f
C32 a_956_n200# a_1060_n244# 0.0587f
C33 a_956_n200# a_556_n244# 0.0587f
C34 a_n1060_n200# a_n1460_n244# 0.0587f
C35 w_n2138_n330# a_1460_n200# 0.09155f
C36 a_1460_n200# a_1964_n200# 0.02133f
C37 a_956_n200# a_452_n200# 0.02133f
C38 a_n956_n244# a_n556_n200# 0.0587f
C39 a_n1564_n200# a_n2052_n200# 0.02133f
C40 w_n2138_n330# a_1564_n244# 0.2233f
C41 a_1964_n200# a_1564_n244# 0.0587f
C42 a_n52_n200# a_n556_n200# 0.02133f
C43 w_n2138_n330# a_1964_n200# 0.0618f
C44 a_956_n200# a_1460_n200# 0.02133f
C45 a_n1964_n244# a_n2052_n200# 0.0587f
C46 a_n452_n244# a_n556_n200# 0.0587f
C47 w_n2138_n330# a_n1060_n200# 0.09155f
C48 a_1964_n200# VSUBS 0.13364f
C49 a_1460_n200# VSUBS 0.12191f
C50 a_956_n200# VSUBS 0.11851f
C51 a_452_n200# VSUBS 0.11851f
C52 a_n52_n200# VSUBS 0.11851f
C53 a_n556_n200# VSUBS 0.11851f
C54 a_n1060_n200# VSUBS 0.11851f
C55 a_n1564_n200# VSUBS 0.12191f
C56 a_n2052_n200# VSUBS 0.13364f
C57 w_n2138_n330# VSUBS 8.46648f
.ends

.subckt p_w0p5_l1_f2 a_n52_n50# w_n426_n180# a_52_n94# a_n340_n50# a_252_n50# a_n252_n94#
+ VSUBS
X0 a_n52_n50# a_n252_n94# a_n340_n50# w_n426_n180# pfet_03v3 ad=0.13p pd=1.02u as=0.22p ps=1.88u w=0.5u l=1u
X1 a_252_n50# a_52_n94# a_n52_n50# w_n426_n180# pfet_03v3 ad=0.22p pd=1.88u as=0.13p ps=1.02u w=0.5u l=1u
C0 a_252_n50# w_n426_n180# 0.0135f
C1 a_52_n94# a_n252_n94# 0.00519f
C2 a_52_n94# a_n52_n50# 0.01026f
C3 a_n252_n94# a_n52_n50# 0.01026f
C4 a_n340_n50# w_n426_n180# 0.0135f
C5 a_52_n94# a_252_n50# 0.01026f
C6 a_n52_n50# a_252_n50# 0.00935f
C7 a_n340_n50# a_n252_n94# 0.01026f
C8 a_52_n94# w_n426_n180# 0.12548f
C9 a_n252_n94# w_n426_n180# 0.12548f
C10 a_n340_n50# a_n52_n50# 0.00935f
C11 a_n52_n50# w_n426_n180# 0.01622f
C12 a_252_n50# VSUBS 0.05896f
C13 a_n52_n50# VSUBS 0.073f
C14 a_n340_n50# VSUBS 0.05896f
C15 w_n426_n180# VSUBS 0.92016f
.ends

.subckt p_w0p5_l1 a_100_n50# a_n100_n94# a_n188_n50# w_n274_n180# VSUBS
X0 a_100_n50# a_n100_n94# a_n188_n50# w_n274_n180# pfet_03v3 ad=0.22p pd=1.88u as=0.22p ps=1.88u w=0.5u l=1u
C0 a_n188_n50# a_n100_n94# 0.01026f
C1 a_100_n50# w_n274_n180# 0.0135f
C2 a_100_n50# a_n188_n50# 0.00935f
C3 a_100_n50# a_n100_n94# 0.01026f
C4 a_n188_n50# w_n274_n180# 0.0135f
C5 a_n100_n94# w_n274_n180# 0.12884f
C6 a_100_n50# VSUBS 0.06237f
C7 a_n188_n50# VSUBS 0.06237f
C8 w_n274_n180# VSUBS 0.59184f
.ends

.subckt p_w1_l0p28_f2 a_n196_n100# a_n52_n100# w_n282_n230# a_108_n100# a_52_n144#
+ a_n108_n144# VSUBS
X0 a_n52_n100# a_n108_n144# a_n196_n100# w_n282_n230# pfet_03v3 ad=0.26p pd=1.52u as=0.44p ps=2.88u w=1u l=0.28u
X1 a_108_n100# a_52_n144# a_n52_n100# w_n282_n230# pfet_03v3 ad=0.44p pd=2.88u as=0.26p ps=1.52u w=1u l=0.28u
C0 a_108_n100# w_n282_n230# 0.01808f
C1 a_52_n144# a_n108_n144# 0.00519f
C2 a_52_n144# a_n52_n100# 0.00769f
C3 a_n108_n144# a_n52_n100# 0.00769f
C4 a_n196_n100# w_n282_n230# 0.01808f
C5 a_52_n144# a_108_n100# 0.00769f
C6 a_n52_n100# a_108_n100# 0.04256f
C7 a_n196_n100# a_n108_n144# 0.00769f
C8 a_52_n144# w_n282_n230# 0.05505f
C9 a_n108_n144# w_n282_n230# 0.05505f
C10 a_n196_n100# a_n52_n100# 0.04256f
C11 a_n52_n100# w_n282_n230# 0.01828f
C12 a_108_n100# VSUBS 0.0563f
C13 a_n52_n100# VSUBS 0.03533f
C14 a_n196_n100# VSUBS 0.0563f
C15 w_n282_n230# VSUBS 0.77832f
.ends

.subckt n_w0p5_l0p28_f2 a_n52_n50# a_n196_n50# a_52_n94# a_108_n50# a_n108_n94# VSUBS
X0 a_108_n50# a_52_n94# a_n52_n50# VSUBS nfet_03v3 ad=0.22p pd=1.88u as=0.13p ps=1.02u w=0.5u l=0.28u
X1 a_n52_n50# a_n108_n94# a_n196_n50# VSUBS nfet_03v3 ad=0.13p pd=1.02u as=0.22p ps=1.88u w=0.5u l=0.28u
C0 a_52_n94# a_108_n50# 0.00377f
C1 a_n52_n50# a_n108_n94# 0.00377f
C2 a_n52_n50# a_n196_n50# 0.02085f
C3 a_n52_n50# a_52_n94# 0.00377f
C4 a_n196_n50# a_n108_n94# 0.00377f
C5 a_52_n94# a_n108_n94# 0.00519f
C6 a_n52_n50# a_108_n50# 0.02085f
C7 a_108_n50# VSUBS 0.07479f
C8 a_n52_n50# VSUBS 0.09458f
C9 a_n196_n50# VSUBS 0.07479f
.ends

.subckt p_w2_l2_f7 a_n704_n244# a_n808_n200# a_304_n244# a_n1712_n244# a_1712_n200#
+ a_n1800_n200# a_n1208_n244# a_1208_n200# a_200_n200# a_1312_n244# a_808_n244# a_n200_n244#
+ a_n304_n200# w_n1886_n330# a_n1312_n200# a_704_n200# VSUBS
X0 a_n1312_n200# a_n1712_n244# a_n1800_n200# w_n1886_n330# pfet_03v3 ad=0.52p pd=2.52u as=0.88p ps=4.88u w=2u l=2u
X1 a_n304_n200# a_n704_n244# a_n808_n200# w_n1886_n330# pfet_03v3 ad=0.52p pd=2.52u as=0.52p ps=2.52u w=2u l=2u
X2 a_200_n200# a_n200_n244# a_n304_n200# w_n1886_n330# pfet_03v3 ad=0.52p pd=2.52u as=0.52p ps=2.52u w=2u l=2u
X3 a_1712_n200# a_1312_n244# a_1208_n200# w_n1886_n330# pfet_03v3 ad=0.88p pd=4.88u as=0.52p ps=2.52u w=2u l=2u
X4 a_1208_n200# a_808_n244# a_704_n200# w_n1886_n330# pfet_03v3 ad=0.52p pd=2.52u as=0.52p ps=2.52u w=2u l=2u
X5 a_n808_n200# a_n1208_n244# a_n1312_n200# w_n1886_n330# pfet_03v3 ad=0.52p pd=2.52u as=0.52p ps=2.52u w=2u l=2u
X6 a_704_n200# a_304_n244# a_200_n200# w_n1886_n330# pfet_03v3 ad=0.52p pd=2.52u as=0.52p ps=2.52u w=2u l=2u
C0 a_1208_n200# a_1312_n244# 0.0587f
C1 a_1712_n200# a_1312_n244# 0.0587f
C2 a_n1312_n200# w_n1886_n330# 0.09155f
C3 a_704_n200# a_200_n200# 0.02133f
C4 a_704_n200# a_808_n244# 0.0587f
C5 a_n1312_n200# a_n1800_n200# 0.02133f
C6 a_1208_n200# w_n1886_n330# 0.09155f
C7 a_1712_n200# w_n1886_n330# 0.0618f
C8 a_304_n244# w_n1886_n330# 0.21994f
C9 a_n1208_n244# a_n1712_n244# 0.00519f
C10 a_n704_n244# a_n304_n200# 0.0587f
C11 a_n200_n244# a_200_n200# 0.0587f
C12 a_n1208_n244# a_n808_n200# 0.0587f
C13 a_1208_n200# a_704_n200# 0.02133f
C14 a_n704_n244# w_n1886_n330# 0.21994f
C15 a_n1312_n200# a_n1208_n244# 0.0587f
C16 a_n304_n200# w_n1886_n330# 0.09155f
C17 w_n1886_n330# a_1312_n244# 0.2233f
C18 a_n1312_n200# a_n1712_n244# 0.0587f
C19 a_704_n200# a_304_n244# 0.0587f
C20 a_1208_n200# a_808_n244# 0.0587f
C21 a_304_n244# a_200_n200# 0.0587f
C22 a_808_n244# a_304_n244# 0.00519f
C23 a_n1800_n200# w_n1886_n330# 0.0618f
C24 a_n1312_n200# a_n808_n200# 0.02133f
C25 a_n200_n244# a_304_n244# 0.00519f
C26 a_n704_n244# a_n1208_n244# 0.00519f
C27 a_n304_n200# a_200_n200# 0.02133f
C28 a_1208_n200# a_1712_n200# 0.02133f
C29 a_704_n200# w_n1886_n330# 0.09155f
C30 a_808_n244# a_1312_n244# 0.00519f
C31 a_200_n200# w_n1886_n330# 0.09155f
C32 a_n1208_n244# w_n1886_n330# 0.21994f
C33 a_808_n244# w_n1886_n330# 0.21994f
C34 a_n1712_n244# w_n1886_n330# 0.2233f
C35 a_n704_n244# a_n200_n244# 0.00519f
C36 a_n704_n244# a_n808_n200# 0.0587f
C37 a_n304_n200# a_n200_n244# 0.0587f
C38 a_n1712_n244# a_n1800_n200# 0.0587f
C39 a_n304_n200# a_n808_n200# 0.02133f
C40 a_n200_n244# w_n1886_n330# 0.21994f
C41 a_n808_n200# w_n1886_n330# 0.09155f
C42 a_1712_n200# VSUBS 0.13364f
C43 a_1208_n200# VSUBS 0.12191f
C44 a_704_n200# VSUBS 0.11851f
C45 a_200_n200# VSUBS 0.11851f
C46 a_n304_n200# VSUBS 0.11851f
C47 a_n808_n200# VSUBS 0.11851f
C48 a_n1312_n200# VSUBS 0.12191f
C49 a_n1800_n200# VSUBS 0.13364f
C50 w_n1886_n330# VSUBS 7.46856f
.ends

.subckt p_w0p5_l0p5_f2 a_n52_n50# w_n326_n180# a_52_n94# a_152_n50# a_n240_n50# a_n152_n94#
+ VSUBS
X0 a_152_n50# a_52_n94# a_n52_n50# w_n326_n180# pfet_03v3 ad=0.22p pd=1.88u as=0.13p ps=1.02u w=0.5u l=0.5u
X1 a_n52_n50# a_n152_n94# a_n240_n50# w_n326_n180# pfet_03v3 ad=0.13p pd=1.02u as=0.22p ps=1.88u w=0.5u l=0.5u
C0 a_n52_n50# a_n152_n94# 0.00625f
C1 a_n240_n50# w_n326_n180# 0.01152f
C2 w_n326_n180# a_52_n94# 0.07657f
C3 a_n52_n50# a_n240_n50# 0.01511f
C4 a_n52_n50# a_52_n94# 0.00625f
C5 a_152_n50# a_52_n94# 0.00625f
C6 a_n52_n50# w_n326_n180# 0.01225f
C7 w_n326_n180# a_152_n50# 0.01152f
C8 a_n240_n50# a_n152_n94# 0.00625f
C9 a_n152_n94# a_52_n94# 0.00519f
C10 a_n52_n50# a_152_n50# 0.01511f
C11 a_n152_n94# w_n326_n180# 0.07657f
C12 a_152_n50# VSUBS 0.04588f
C13 a_n52_n50# VSUBS 0.04684f
C14 a_n240_n50# VSUBS 0.04588f
C15 w_n326_n180# VSUBS 0.70416f
.ends

.subckt idac_p g0 g1 g2 g3 g4 g5 vsp rb0 rb1 rb2 rb3 rb4 rb5 rboff b0 b1 b2 b3 b4
+ out dump vcas vdd vss
XU4b vsp vsp m1_1148_2006# a_736_1720# a_736_1720# vdd m1_1148_2006# a_736_1720# m1_1148_2006#
+ a_736_1720# m1_1148_2006# vsp vsp a_736_1720# a_736_1720# a_736_1720# a_736_1720#
+ vsp vss p_w2_l2_f8
XMX1 a_736_1720# vdd rb3 g2 g3 rb2 vss p_w0p5_l1_f2
XU3 vsp vsp m1_1148_3882# a_736_1720# a_736_1720# vdd m1_1148_3882# a_736_1720# m1_1148_3882#
+ a_736_1720# m1_1148_3882# vsp vsp a_736_1720# a_736_1720# a_736_1720# a_736_1720#
+ vsp vss p_w2_l2_f8
XMX2 a_736_1720# vdd rb5 g4 g5 rb4 vss p_w0p5_l1_f2
XMXOFF a_736_1720# rboff vsp vdd vss p_w0p5_l1
XIP0 a_568_5470# vdd vdd a_772_5470# a_568_5470# b0 vss p_w1_l0p28_f2
XIP1 a_1518_5470# vdd vdd a_1722_5470# a_1518_5470# b1 vss p_w1_l0p28_f2
XIN0 vcas a_568_5470# a_568_5470# a_772_5470# b0 vss n_w0p5_l0p28_f2
XIP2 a_2468_5470# vdd vdd a_2672_5470# a_2468_5470# b2 vss p_w1_l0p28_f2
XIN1 vcas a_1518_5470# a_1518_5470# a_1722_5470# b1 vss n_w0p5_l0p28_f2
XIP3 a_3418_5470# vdd vdd a_3622_5470# a_3418_5470# b3 vss p_w1_l0p28_f2
XIN3 vcas a_3418_5470# a_3418_5470# a_3622_5470# b3 vss n_w0p5_l0p28_f2
XIN2 vcas a_2468_5470# a_2468_5470# a_2672_5470# b2 vss n_w0p5_l0p28_f2
XIP4 a_4368_5470# vdd vdd a_4572_5470# a_4368_5470# b4 vss p_w1_l0p28_f2
XIN4 vcas a_4368_5470# a_4368_5470# a_4572_5470# b4 vss n_w0p5_l0p28_f2
XU210 a_736_1720# vsp a_736_1720# a_736_1720# m1_636_5380# vsp a_736_1720# vsp vsp
+ a_736_1720# a_736_1720# a_736_1720# m1_1148_4542# vdd m1_1148_4542# m1_1640_5000#
+ vss p_w2_l2_f7
XSW0 m1_636_5380# vdd a_772_5470# dump out a_568_5470# vss p_w0p5_l0p5_f2
XSW2 m1_1148_4542# vdd a_2672_5470# dump out a_2468_5470# vss p_w0p5_l0p5_f2
XSW1 m1_1640_5000# vdd a_1722_5470# dump out a_1518_5470# vss p_w0p5_l0p5_f2
XSW3 m1_1148_3882# vdd a_3622_5470# dump out a_3418_5470# vss p_w0p5_l0p5_f2
XSW4 m1_1148_2006# vdd a_4572_5470# dump out a_4368_5470# vss p_w0p5_l0p5_f2
XU4a vsp vsp m1_1148_2006# a_736_1720# a_736_1720# vdd m1_1148_2006# a_736_1720# m1_1148_2006#
+ a_736_1720# m1_1148_2006# vsp vsp a_736_1720# a_736_1720# a_736_1720# a_736_1720#
+ vsp vss p_w2_l2_f8
XMX0 a_736_1720# vdd rb1 g0 g1 rb0 vss p_w0p5_l1_f2
C0 g4 rb3 0.03679f
C1 dump vsp 0.00362f
C2 b4 a_4572_5470# 0.01409f
C3 rb2 rb1 0.00525f
C4 a_1518_5470# b2 0.00271f
C5 m1_1640_5000# b2 0
C6 b1 dump 0.02687f
C7 rb2 g5 0
C8 vcas a_1518_5470# 0.22593f
C9 a_736_1720# vsp 4.25043f
C10 vcas a_4368_5470# 0.22478f
C11 m1_1148_3882# m1_636_5380# 0.22224f
C12 a_1518_5470# out 0.03719f
C13 m1_1640_5000# out 0.36967f
C14 a_736_1720# b1 0.00204f
C15 b2 vdd 0.4544f
C16 rb4 rb5 0.04982f
C17 a_4368_5470# out 0.01378f
C18 vcas vdd 0.80535f
C19 rb1 vdd 0.26304f
C20 a_1518_5470# a_1722_5470# 0.12726f
C21 a_1518_5470# a_772_5470# 0.0542f
C22 m1_1640_5000# a_1722_5470# 0.00344f
C23 m1_1148_3882# b3 0.00208f
C24 a_1518_5470# a_568_5470# 0.00953f
C25 b1 a_2468_5470# 0
C26 g5 vdd 0.16304f
C27 vdd out 1.14199f
C28 b2 dump 0.26141f
C29 rboff vdd 0.36431f
C30 b0 a_1518_5470# 0
C31 a_3418_5470# m1_1148_3882# 0.01433f
C32 vcas dump 0.03219f
C33 a_1722_5470# vdd 0.34946f
C34 a_772_5470# vdd 0.41756f
C35 m1_1148_2006# rb2 0.00937f
C36 a_568_5470# vdd 0.57221f
C37 a_736_1720# b2 0
C38 dump out 0.75771f
C39 rb5 vsp 0.0016f
C40 a_4368_5470# a_3622_5470# 0.05054f
C41 g1 rb0 0.07305f
C42 b0 vdd 0.27737f
C43 a_3418_5470# b3 0.32008f
C44 rb4 rb3 0.00452f
C45 a_736_1720# rb1 0.01747f
C46 a_4368_5470# m1_1148_2006# 0.0166f
C47 g3 g2 0.02233f
C48 b2 a_2468_5470# 0.26923f
C49 rb3 g3 0.13699f
C50 dump a_1722_5470# 0.33317f
C51 a_736_1720# g5 0.02732f
C52 dump a_772_5470# 0.04964f
C53 a_736_1720# out 0.47701f
C54 dump a_568_5470# 0.00247f
C55 vcas a_2468_5470# 0.25391f
C56 a_3622_5470# vdd 0.60417f
C57 rboff a_736_1720# 0.00347f
C58 b3 a_2672_5470# 0
C59 m1_1148_2006# vdd 0.92917f
C60 b2 b4 0
C61 a_736_1720# a_1722_5470# 0.00183f
C62 a_736_1720# a_772_5470# 0.00511f
C63 a_2468_5470# out 0.01473f
C64 a_736_1720# a_568_5470# 0
C65 vcas b4 0.05574f
C66 a_1518_5470# m1_1148_4542# 0.001f
C67 m1_1148_4542# m1_1640_5000# 0.12627f
C68 a_3418_5470# a_2672_5470# 0.15063f
C69 g1 g0 0.01801f
C70 dump a_3622_5470# 0.05048f
C71 b0 a_736_1720# 0
C72 b4 out 0.00403f
C73 a_1722_5470# a_2468_5470# 0.01919f
C74 a_772_5470# a_2468_5470# 0
C75 rb4 g4 0.08418f
C76 a_568_5470# a_2468_5470# 0
C77 m1_1148_2006# dump 0.08062f
C78 b3 a_4572_5470# 0
C79 g4 g3 0.02125f
C80 m1_1148_4542# vdd 0.17281f
C81 a_736_1720# a_3622_5470# 0.00228f
C82 a_736_1720# m1_1148_2006# 2.67633f
C83 rb5 g5 0.13825f
C84 a_3418_5470# a_4572_5470# 0
C85 a_3622_5470# a_2468_5470# 0
C86 vsp m1_636_5380# 0.50709f
C87 g1 vsp 0
C88 rboff rb5 0.00658f
C89 m1_1148_3882# vsp 0.26086f
C90 m1_1148_4542# dump 0.04321f
C91 b4 a_3622_5470# 0.13276f
C92 m1_1148_2006# b4 0.00109f
C93 g0 rb0 0.07276f
C94 m1_1148_4542# a_736_1720# 0.36914f
C95 g2 rb1 0.05061f
C96 m1_1148_4542# a_2468_5470# 0.03183f
C97 g2 g5 0
C98 rb3 g5 0
C99 rb5 m1_1148_2006# 0.0049f
C100 a_1518_5470# m1_1640_5000# 0.00859f
C101 rb0 vsp 0
C102 vcas m1_1148_3882# 0
C103 rb2 vdd 0.25065f
C104 g1 rb1 0.1451f
C105 m1_636_5380# out 0.17624f
C106 a_1518_5470# vdd 0.62384f
C107 m1_1640_5000# vdd 0.24749f
C108 m1_1148_3882# out 0.15737f
C109 b2 b3 0.00553f
C110 a_4368_5470# vdd 0.59418f
C111 vcas b3 0.16407f
C112 g4 g5 0.01312f
C113 a_772_5470# m1_636_5380# 0.00329f
C114 a_568_5470# m1_636_5380# 0.06818f
C115 m1_1148_2006# g2 0.0175f
C116 vsp a_4572_5470# 0
C117 m1_1148_2006# rb3 0.00266f
C118 a_3418_5470# b2 0
C119 b3 out 0.00137f
C120 g0 vsp 0.0044f
C121 vcas a_3418_5470# 0.21835f
C122 a_1518_5470# dump 0.0472f
C123 m1_1640_5000# dump 0.06493f
C124 b0 m1_636_5380# 0
C125 a_736_1720# rb2 0.01714f
C126 a_4368_5470# dump 0.02585f
C127 b3 a_1722_5470# 0
C128 a_3418_5470# out 0.06416f
C129 b2 a_2672_5470# 0.00731f
C130 a_1518_5470# a_736_1720# 0.0086f
C131 m1_1640_5000# a_736_1720# 0.41505f
C132 vcas a_2672_5470# 0.10114f
C133 m1_1148_3882# a_3622_5470# 0.03267f
C134 a_4368_5470# a_736_1720# 0.00116f
C135 dump vdd 1.14344f
C136 rb0 rb1 0.01589f
C137 m1_1148_2006# m1_636_5380# 0.08216f
C138 g1 m1_1148_2006# 0.01018f
C139 a_3418_5470# a_1722_5470# 0
C140 m1_1148_2006# m1_1148_3882# 0.35347f
C141 a_2672_5470# out 0.01037f
C142 a_1518_5470# a_2468_5470# 0.00841f
C143 m1_1640_5000# a_2468_5470# 0
C144 m1_1148_2006# g4 0.01273f
C145 a_4368_5470# a_2468_5470# 0
C146 a_736_1720# vdd 10.20311f
C147 b3 a_3622_5470# 0.00924f
C148 vcas a_4572_5470# 0.04876f
C149 a_4368_5470# b4 0.33273f
C150 vdd a_2468_5470# 0.51283f
C151 a_3418_5470# a_3622_5470# 0.1039f
C152 m1_1148_4542# m1_636_5380# 0.14814f
C153 g0 rb1 0.00148f
C154 rb4 g5 0.01336f
C155 a_736_1720# dump 0.08556f
C156 a_4572_5470# out 0.00118f
C157 b4 vdd 0.35809f
C158 g3 g5 0
C159 a_3622_5470# a_2672_5470# 0
C160 dump a_2468_5470# 0.19821f
C161 dump b4 0
C162 a_736_1720# a_2468_5470# 0.00197f
C163 rb5 vdd 0.22285f
C164 b1 b2 0.00669f
C165 rb2 g2 0.08755f
C166 g5 vsp 0.14695f
C167 vcas b1 0.03578f
C168 vsp out 0.01644f
C169 a_736_1720# b4 0
C170 a_3622_5470# a_4572_5470# 0.00289f
C171 rb3 rb2 0.01574f
C172 m1_1148_2006# a_4572_5470# 0.01953f
C173 rb4 m1_1148_2006# 0.01457f
C174 rboff vsp 0.26035f
C175 m1_1148_4542# a_2672_5470# 0.02241f
C176 b1 out 0.00482f
C177 m1_1148_2006# g3 0.02076f
C178 a_568_5470# vsp 0
C179 b1 a_1722_5470# 0.00506f
C180 b1 a_772_5470# 0.07205f
C181 rb5 a_736_1720# 0.07175f
C182 b1 a_568_5470# 0.00277f
C183 g2 vdd 0.14524f
C184 rb3 vdd 0.24594f
C185 b0 b1 0.01999f
C186 vcas b2 0.0941f
C187 m1_1640_5000# m1_636_5380# 0.11398f
C188 m1_1640_5000# m1_1148_3882# 0.00791f
C189 m1_1148_2006# vsp 0.52475f
C190 a_4368_5470# m1_1148_3882# 0
C191 b2 out 0
C192 vcas out 0.00871f
C193 vdd m1_636_5380# 0.259f
C194 g1 vdd 0.12612f
C195 m1_1148_3882# vdd 0.36113f
C196 b2 a_772_5470# 0
C197 b2 a_1722_5470# 0.0024f
C198 a_4368_5470# b3 0
C199 a_736_1720# g2 0.0063f
C200 vcas a_1722_5470# 0.15296f
C201 vcas a_772_5470# 0.14504f
C202 a_736_1720# rb3 0.00944f
C203 vcas a_568_5470# 0.08607f
C204 g4 vdd 0.19166f
C205 rboff g5 0.00165f
C206 b0 b2 0
C207 m1_1148_4542# vsp 0.0582f
C208 b3 vdd 0.32014f
C209 a_3418_5470# a_4368_5470# 0.00883f
C210 a_1722_5470# out 0.00598f
C211 a_772_5470# out 0.02224f
C212 a_568_5470# out 0.17127f
C213 vcas b0 0.08138f
C214 dump m1_636_5380# 0.02731f
C215 dump m1_1148_3882# 0.09942f
C216 m1_1148_4542# b1 0
C217 b2 a_3622_5470# 0
C218 a_1518_5470# a_2672_5470# 0
C219 m1_1640_5000# a_2672_5470# 0.01621f
C220 a_772_5470# a_1722_5470# 0
C221 b0 out 0.0984f
C222 a_3418_5470# vdd 0.61911f
C223 a_568_5470# a_1722_5470# 0
C224 a_568_5470# a_772_5470# 0.1449f
C225 vcas a_3622_5470# 0.05911f
C226 a_4368_5470# a_2672_5470# 0
C227 a_736_1720# m1_636_5380# 0.97716f
C228 g1 a_736_1720# 0.02808f
C229 a_736_1720# m1_1148_3882# 1.15091f
C230 dump b3 0
C231 m1_1148_2006# rb1 0.00163f
C232 b0 a_1722_5470# 0
C233 b0 a_772_5470# 0.01175f
C234 a_3622_5470# out 0.00623f
C235 b0 a_568_5470# 0.31903f
C236 a_736_1720# g4 0.01459f
C237 m1_1148_2006# g5 0.00769f
C238 vdd a_2672_5470# 0.44517f
C239 m1_1148_2006# out 0.02244f
C240 rb0 vdd 0.22603f
C241 a_736_1720# b3 0
C242 a_3418_5470# dump 0.02797f
C243 rboff m1_1148_2006# 0.00217f
C244 rb2 g3 0.10803f
C245 b4 m1_636_5380# 0.00146f
C246 a_4368_5470# a_4572_5470# 0.1395f
C247 m1_1148_4542# b2 0
C248 b3 a_2468_5470# 0.00204f
C249 a_3418_5470# a_736_1720# 0.00279f
C250 dump a_2672_5470# 0.16669f
C251 vdd a_4572_5470# 0.57619f
C252 rb4 vdd 0.271f
C253 m1_1148_4542# out 0.30137f
C254 b4 b3 0.00758f
C255 a_3418_5470# a_2468_5470# 0.00607f
C256 g0 vdd 0.14712f
C257 a_736_1720# a_2672_5470# 0.00212f
C258 g3 vdd 0.14841f
C259 a_736_1720# rb0 0.06196f
C260 m1_1148_2006# a_3622_5470# 0
C261 m1_1148_4542# a_1722_5470# 0.0053f
C262 a_3418_5470# b4 0.00259f
C263 rb5 g4 0.00141f
C264 rb3 g2 0
C265 a_2468_5470# a_2672_5470# 0.15168f
C266 m1_1640_5000# vsp 0.03033f
C267 dump a_4572_5470# 0.02202f
C268 a_4368_5470# vsp 0
C269 a_1518_5470# b1 0.38085f
C270 m1_1640_5000# b1 0
C271 a_736_1720# a_4572_5470# 0.00117f
C272 rb4 a_736_1720# 0.01454f
C273 vdd vsp 2.78035f
C274 a_736_1720# g0 0.00453f
C275 a_736_1720# g3 0.04172f
C276 g1 g2 0.02733f
C277 b1 vdd 0.34801f
C278 g1 vss 0.06885f
C279 a_736_1720# vss -3.05552f
C280 g0 vss 0.18974f
C281 rb1 vss -0.02482f
C282 rb0 vss -0.00712f
C283 vdd vss 50.95037f
C284 m1_1148_2006# vss -0.04674f
C285 vsp vss -0.07003f
C286 a_4572_5470# vss 0.15802f
C287 a_4368_5470# vss 0.10031f
C288 a_3622_5470# vss 0.00152f
C289 a_3418_5470# vss 0.20335f
C290 m1_1640_5000# vss -0.01864f
C291 a_1722_5470# vss -0.04047f
C292 a_1518_5470# vss 0.07595f
C293 a_2672_5470# vss 0.04824f
C294 a_2468_5470# vss 0.06359f
C295 dump vss -0.06883f
C296 m1_636_5380# vss 0.02746f
C297 out vss 0.69335f
C298 a_772_5470# vss -0.03351f
C299 a_568_5470# vss 0.21556f
C300 m1_1148_4542# vss -0.02947f
C301 b4 vss 0.36077f
C302 b3 vss 0.23565f
C303 b2 vss 0.32646f
C304 vcas vss 1.27622f
C305 b1 vss 0.32064f
C306 b0 vss 0.24663f
C307 rboff vss -0
C308 g5 vss 0.20316f
C309 g4 vss 0.07616f
C310 rb5 vss -0.0287f
C311 rb4 vss 0.00699f
C312 m1_1148_3882# vss -0.04304f
C313 g3 vss 0.0787f
C314 g2 vss 0.05468f
C315 rb3 vss -0.02301f
C316 rb2 vss -0.01858f
.ends
