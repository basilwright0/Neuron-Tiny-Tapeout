* NGSPICE file created from idac_p.ext - technology: gf180mcuD

.subckt p_w2_l2_f8 a_n52_n200# a_n1060_n200# a_452_n200# a_1564_n244# a_n452_n244#
+ w_n2138_n330# a_n556_n200# a_n1460_n244# a_1460_n200# a_52_n244# a_n1564_n200# a_956_n200#
+ a_n2052_n200# a_n956_n244# a_1060_n244# a_n1964_n244# a_556_n244# a_1964_n200# VSUBS
X0 a_1964_n200# a_1564_n244# a_1460_n200# w_n2138_n330# pfet_03v3 ad=0.88p pd=4.88u as=0.52p ps=2.52u w=2u l=2u
X1 a_452_n200# a_52_n244# a_n52_n200# w_n2138_n330# pfet_03v3 ad=0.52p pd=2.52u as=0.52p ps=2.52u w=2u l=2u
X2 a_956_n200# a_556_n244# a_452_n200# w_n2138_n330# pfet_03v3 ad=0.52p pd=2.52u as=0.52p ps=2.52u w=2u l=2u
X3 a_1460_n200# a_1060_n244# a_956_n200# w_n2138_n330# pfet_03v3 ad=0.52p pd=2.52u as=0.52p ps=2.52u w=2u l=2u
X4 a_n1564_n200# a_n1964_n244# a_n2052_n200# w_n2138_n330# pfet_03v3 ad=0.52p pd=2.52u as=0.88p ps=4.88u w=2u l=2u
X5 a_n1060_n200# a_n1460_n244# a_n1564_n200# w_n2138_n330# pfet_03v3 ad=0.52p pd=2.52u as=0.52p ps=2.52u w=2u l=2u
X6 a_n556_n200# a_n956_n244# a_n1060_n200# w_n2138_n330# pfet_03v3 ad=0.52p pd=2.52u as=0.52p ps=2.52u w=2u l=2u
X7 a_n52_n200# a_n452_n244# a_n556_n200# w_n2138_n330# pfet_03v3 ad=0.52p pd=2.52u as=0.52p ps=2.52u w=2u l=2u
C0 a_n1564_n200# a_n1060_n200# 0.02133f
C1 a_52_n244# a_n452_n244# 0.00519f
C2 a_n556_n200# a_n1060_n200# 0.02133f
C3 a_n1964_n244# a_n1460_n244# 0.00519f
C4 a_1564_n244# a_1460_n200# 0.0587f
C5 a_n1964_n244# w_n2138_n330# 0.2233f
C6 a_n1564_n200# a_n1460_n244# 0.0587f
C7 a_452_n200# w_n2138_n330# 0.09155f
C8 a_956_n200# a_1060_n244# 0.0587f
C9 a_n52_n200# a_452_n200# 0.02133f
C10 a_556_n244# a_452_n200# 0.0587f
C11 a_n1564_n200# w_n2138_n330# 0.09155f
C12 a_1964_n200# a_1460_n200# 0.02133f
C13 a_956_n200# w_n2138_n330# 0.09155f
C14 a_556_n244# a_956_n200# 0.0587f
C15 a_n556_n200# a_n956_n244# 0.0587f
C16 a_n556_n200# w_n2138_n330# 0.09155f
C17 a_1564_n244# a_1964_n200# 0.0587f
C18 a_n52_n200# a_n556_n200# 0.02133f
C19 a_n956_n244# a_n452_n244# 0.00519f
C20 w_n2138_n330# a_n452_n244# 0.21994f
C21 a_n52_n200# a_n452_n244# 0.0587f
C22 a_1060_n244# a_1460_n200# 0.0587f
C23 w_n2138_n330# a_1460_n200# 0.09155f
C24 a_n1964_n244# a_n1564_n200# 0.0587f
C25 a_1564_n244# a_1060_n244# 0.00519f
C26 w_n2138_n330# a_n2052_n200# 0.0618f
C27 a_452_n200# a_956_n200# 0.02133f
C28 a_1564_n244# w_n2138_n330# 0.2233f
C29 a_1964_n200# w_n2138_n330# 0.0618f
C30 a_52_n244# w_n2138_n330# 0.21994f
C31 a_n1460_n244# a_n1060_n200# 0.0587f
C32 a_n52_n200# a_52_n244# 0.0587f
C33 a_556_n244# a_52_n244# 0.00519f
C34 a_n956_n244# a_n1060_n200# 0.0587f
C35 w_n2138_n330# a_n1060_n200# 0.09155f
C36 a_n556_n200# a_n452_n244# 0.0587f
C37 a_n1964_n244# a_n2052_n200# 0.0587f
C38 a_956_n200# a_1460_n200# 0.02133f
C39 a_n1460_n244# a_n956_n244# 0.00519f
C40 a_n1564_n200# a_n2052_n200# 0.02133f
C41 a_1060_n244# w_n2138_n330# 0.21994f
C42 a_n1460_n244# w_n2138_n330# 0.21994f
C43 a_556_n244# a_1060_n244# 0.00519f
C44 a_n956_n244# w_n2138_n330# 0.21994f
C45 a_n52_n200# w_n2138_n330# 0.09155f
C46 a_556_n244# w_n2138_n330# 0.21994f
C47 a_452_n200# a_52_n244# 0.0587f
C48 a_1964_n200# VSUBS 0.13364f
C49 a_1460_n200# VSUBS 0.12191f
C50 a_956_n200# VSUBS 0.11851f
C51 a_452_n200# VSUBS 0.11851f
C52 a_n52_n200# VSUBS 0.11851f
C53 a_n556_n200# VSUBS 0.11851f
C54 a_n1060_n200# VSUBS 0.11851f
C55 a_n1564_n200# VSUBS 0.12191f
C56 a_n2052_n200# VSUBS 0.13364f
C57 w_n2138_n330# VSUBS 8.46648f
.ends

.subckt p_w1_l0p28_f2 a_n196_n100# a_n52_n100# w_n282_n230# a_108_n100# a_52_n144#
+ a_n108_n144# VSUBS
X0 a_n52_n100# a_n108_n144# a_n196_n100# w_n282_n230# pfet_03v3 ad=0.26p pd=1.52u as=0.44p ps=2.88u w=1u l=0.28u
X1 a_108_n100# a_52_n144# a_n52_n100# w_n282_n230# pfet_03v3 ad=0.44p pd=2.88u as=0.26p ps=1.52u w=1u l=0.28u
C0 w_n282_n230# a_108_n100# 0.01808f
C1 a_n108_n144# a_52_n144# 0.00519f
C2 a_108_n100# a_n52_n100# 0.04256f
C3 a_n108_n144# a_n196_n100# 0.00769f
C4 a_n108_n144# w_n282_n230# 0.05505f
C5 a_n108_n144# a_n52_n100# 0.00769f
C6 w_n282_n230# a_52_n144# 0.05505f
C7 w_n282_n230# a_n196_n100# 0.01808f
C8 a_52_n144# a_n52_n100# 0.00769f
C9 a_n196_n100# a_n52_n100# 0.04256f
C10 w_n282_n230# a_n52_n100# 0.01828f
C11 a_52_n144# a_108_n100# 0.00769f
C12 a_108_n100# VSUBS 0.0563f
C13 a_n52_n100# VSUBS 0.03533f
C14 a_n196_n100# VSUBS 0.0563f
C15 w_n282_n230# VSUBS 0.77832f
.ends

.subckt n_w0p5_l0p28_f2 a_n52_n50# a_n196_n50# a_52_n94# a_108_n50# a_n108_n94# VSUBS
X0 a_108_n50# a_52_n94# a_n52_n50# VSUBS nfet_03v3 ad=0.22p pd=1.88u as=0.13p ps=1.02u w=0.5u l=0.28u
X1 a_n52_n50# a_n108_n94# a_n196_n50# VSUBS nfet_03v3 ad=0.13p pd=1.02u as=0.22p ps=1.88u w=0.5u l=0.28u
C0 a_52_n94# a_n52_n50# 0.00377f
C1 a_52_n94# a_n108_n94# 0.00519f
C2 a_52_n94# a_108_n50# 0.00377f
C3 a_n196_n50# a_n52_n50# 0.02085f
C4 a_n108_n94# a_n196_n50# 0.00377f
C5 a_n108_n94# a_n52_n50# 0.00377f
C6 a_n52_n50# a_108_n50# 0.02085f
C7 a_108_n50# VSUBS 0.07479f
C8 a_n52_n50# VSUBS 0.09458f
C9 a_n196_n50# VSUBS 0.07479f
.ends

.subckt p_w2_l2_f7 a_n704_n244# a_n808_n200# a_304_n244# a_n1712_n244# a_1712_n200#
+ a_n1800_n200# a_n1208_n244# a_1208_n200# a_200_n200# a_1312_n244# a_808_n244# a_n200_n244#
+ a_n304_n200# w_n1886_n330# a_n1312_n200# a_704_n200# VSUBS
X0 a_n1312_n200# a_n1712_n244# a_n1800_n200# w_n1886_n330# pfet_03v3 ad=0.52p pd=2.52u as=0.88p ps=4.88u w=2u l=2u
X1 a_n304_n200# a_n704_n244# a_n808_n200# w_n1886_n330# pfet_03v3 ad=0.52p pd=2.52u as=0.52p ps=2.52u w=2u l=2u
X2 a_200_n200# a_n200_n244# a_n304_n200# w_n1886_n330# pfet_03v3 ad=0.52p pd=2.52u as=0.52p ps=2.52u w=2u l=2u
X3 a_1712_n200# a_1312_n244# a_1208_n200# w_n1886_n330# pfet_03v3 ad=0.88p pd=4.88u as=0.52p ps=2.52u w=2u l=2u
X4 a_1208_n200# a_808_n244# a_704_n200# w_n1886_n330# pfet_03v3 ad=0.52p pd=2.52u as=0.52p ps=2.52u w=2u l=2u
X5 a_n808_n200# a_n1208_n244# a_n1312_n200# w_n1886_n330# pfet_03v3 ad=0.52p pd=2.52u as=0.52p ps=2.52u w=2u l=2u
X6 a_704_n200# a_304_n244# a_200_n200# w_n1886_n330# pfet_03v3 ad=0.52p pd=2.52u as=0.52p ps=2.52u w=2u l=2u
C0 a_n304_n200# w_n1886_n330# 0.09155f
C1 a_808_n244# a_1312_n244# 0.00519f
C2 w_n1886_n330# a_304_n244# 0.21994f
C3 w_n1886_n330# a_n1800_n200# 0.0618f
C4 w_n1886_n330# a_704_n200# 0.09155f
C5 a_n1312_n200# a_n1800_n200# 0.02133f
C6 w_n1886_n330# a_1208_n200# 0.09155f
C7 a_n304_n200# a_n200_n244# 0.0587f
C8 a_n1712_n244# a_n1208_n244# 0.00519f
C9 a_304_n244# a_n200_n244# 0.00519f
C10 a_200_n200# w_n1886_n330# 0.09155f
C11 w_n1886_n330# a_1312_n244# 0.2233f
C12 a_n1712_n244# w_n1886_n330# 0.2233f
C13 a_n1712_n244# a_n1312_n200# 0.0587f
C14 a_1712_n200# a_1208_n200# 0.02133f
C15 a_200_n200# a_n200_n244# 0.0587f
C16 a_704_n200# a_304_n244# 0.0587f
C17 w_n1886_n330# a_808_n244# 0.21994f
C18 a_1312_n244# a_1712_n200# 0.0587f
C19 a_n1208_n244# a_n704_n244# 0.00519f
C20 a_n1208_n244# a_n808_n200# 0.0587f
C21 a_n304_n200# a_200_n200# 0.02133f
C22 a_704_n200# a_1208_n200# 0.02133f
C23 w_n1886_n330# a_n1208_n244# 0.21994f
C24 a_200_n200# a_304_n244# 0.0587f
C25 a_n704_n244# a_n808_n200# 0.0587f
C26 a_n1208_n244# a_n1312_n200# 0.0587f
C27 w_n1886_n330# a_n704_n244# 0.21994f
C28 a_200_n200# a_704_n200# 0.02133f
C29 w_n1886_n330# a_n808_n200# 0.09155f
C30 a_n1312_n200# a_n808_n200# 0.02133f
C31 a_n1712_n244# a_n1800_n200# 0.0587f
C32 a_1312_n244# a_1208_n200# 0.0587f
C33 w_n1886_n330# a_n1312_n200# 0.09155f
C34 a_808_n244# a_304_n244# 0.00519f
C35 a_n704_n244# a_n200_n244# 0.00519f
C36 a_808_n244# a_704_n200# 0.0587f
C37 w_n1886_n330# a_n200_n244# 0.21994f
C38 w_n1886_n330# a_1712_n200# 0.0618f
C39 a_808_n244# a_1208_n200# 0.0587f
C40 a_n304_n200# a_n704_n244# 0.0587f
C41 a_n304_n200# a_n808_n200# 0.02133f
C42 a_1712_n200# VSUBS 0.13364f
C43 a_1208_n200# VSUBS 0.12191f
C44 a_704_n200# VSUBS 0.11851f
C45 a_200_n200# VSUBS 0.11851f
C46 a_n304_n200# VSUBS 0.11851f
C47 a_n808_n200# VSUBS 0.11851f
C48 a_n1312_n200# VSUBS 0.12191f
C49 a_n1800_n200# VSUBS 0.13364f
C50 w_n1886_n330# VSUBS 7.46856f
.ends

.subckt p_w0p5_l0p5_f2 a_n52_n50# w_n326_n180# a_52_n94# a_152_n50# a_n240_n50# a_n152_n94#
+ VSUBS
X0 a_152_n50# a_52_n94# a_n52_n50# w_n326_n180# pfet_03v3 ad=0.22p pd=1.88u as=0.13p ps=1.02u w=0.5u l=0.5u
X1 a_n52_n50# a_n152_n94# a_n240_n50# w_n326_n180# pfet_03v3 ad=0.13p pd=1.02u as=0.22p ps=1.88u w=0.5u l=0.5u
C0 a_n240_n50# w_n326_n180# 0.01152f
C1 w_n326_n180# a_n52_n50# 0.01225f
C2 a_52_n94# w_n326_n180# 0.07657f
C3 a_152_n50# a_n52_n50# 0.01511f
C4 a_n152_n94# a_n240_n50# 0.00625f
C5 a_52_n94# a_152_n50# 0.00625f
C6 a_n152_n94# a_n52_n50# 0.00625f
C7 a_n152_n94# a_52_n94# 0.00519f
C8 a_n240_n50# a_n52_n50# 0.01511f
C9 a_52_n94# a_n52_n50# 0.00625f
C10 w_n326_n180# a_152_n50# 0.01152f
C11 a_n152_n94# w_n326_n180# 0.07657f
C12 a_152_n50# VSUBS 0.04588f
C13 a_n52_n50# VSUBS 0.04684f
C14 a_n240_n50# VSUBS 0.04588f
C15 w_n326_n180# VSUBS 0.70416f
.ends

.subckt idac_p g vsp b0 b1 b2 b3 b4 out dump vcas vdd vss
XU4b vsp vsp m1_988_888# g g vdd m1_988_888# g m1_988_888# g m1_988_888# vsp vsp g
+ g g g vsp vss p_w2_l2_f8
XU3 vsp vsp m1_988_2804# g g vdd m1_988_2804# g m1_988_2804# g m1_988_2804# vsp vsp
+ g g g g vsp vss p_w2_l2_f8
XIP0 a_528_4392# vdd vdd a_732_4392# a_528_4392# b0 vss p_w1_l0p28_f2
XIP1 a_1378_4392# vdd vdd a_1582_4392# a_1378_4392# b1 vss p_w1_l0p28_f2
XIN0 vcas a_528_4392# a_528_4392# a_732_4392# b0 vss n_w0p5_l0p28_f2
XIP2 a_2228_4392# vdd vdd a_2432_4392# a_2228_4392# b2 vss p_w1_l0p28_f2
XIN1 vcas a_1378_4392# a_1378_4392# a_1582_4392# b1 vss n_w0p5_l0p28_f2
XIP3 a_3078_4392# vdd vdd a_3282_4392# a_3078_4392# b3 vss p_w1_l0p28_f2
XIN3 vcas a_3078_4392# a_3078_4392# a_3282_4392# b3 vss n_w0p5_l0p28_f2
XIN2 vcas a_2228_4392# a_2228_4392# a_2432_4392# b2 vss n_w0p5_l0p28_f2
XIP4 a_3928_4392# vdd vdd a_4132_4392# a_3928_4392# b4 vss p_w1_l0p28_f2
XIN4 vcas a_3928_4392# a_3928_4392# a_4132_4392# b4 vss n_w0p5_l0p28_f2
XU210 g vsp g g m1_240_3480# vsp g vsp vsp g g g m1_988_3464# vdd m1_988_3464# m1_1500_4312#
+ vss p_w2_l2_f7
XSW0 m1_240_3480# vdd a_732_4392# dump out a_528_4392# vss p_w0p5_l0p5_f2
XSW2 m1_988_3464# vdd a_2432_4392# dump out a_2228_4392# vss p_w0p5_l0p5_f2
XSW1 m1_1500_4312# vdd a_1582_4392# dump out a_1378_4392# vss p_w0p5_l0p5_f2
XSW3 m1_988_2804# vdd a_3282_4392# dump out a_3078_4392# vss p_w0p5_l0p5_f2
XSW4 m1_988_888# vdd a_4132_4392# dump out a_3928_4392# vss p_w0p5_l0p5_f2
XU4a vsp vsp m1_988_888# g g vdd m1_988_888# g m1_988_888# g m1_988_888# vsp vsp g
+ g g g vsp vss p_w2_l2_f8
C0 dump g 0.05176f
C1 a_2432_4392# vcas 0.00805f
C2 b3 a_2228_4392# 0.00173f
C3 b2 b1 0.00341f
C4 dump m1_240_3480# 0.01325f
C5 m1_988_2804# a_2228_4392# 0
C6 a_1582_4392# m1_988_2804# 0
C7 a_3928_4392# dump 0.02728f
C8 a_2228_4392# g 0.00218f
C9 a_1582_4392# g 0.00236f
C10 b3 b4 0.00351f
C11 vcas dump 0.09162f
C12 a_528_4392# vsp 0
C13 b1 a_528_4392# 0.00327f
C14 b2 b3 0.09189f
C15 a_1378_4392# a_732_4392# 0.07957f
C16 vcas a_2228_4392# 0.02559f
C17 a_1582_4392# vcas 0.01431f
C18 a_3078_4392# vdd 0.51762f
C19 b4 m1_240_3480# 0
C20 b2 g 0
C21 m1_1500_4312# a_1378_4392# 0.01574f
C22 a_3078_4392# a_3282_4392# 0.17009f
C23 a_3928_4392# b4 0.20796f
C24 a_3078_4392# out 0.01364f
C25 vsp m1_988_888# 0.84877f
C26 vcas b4 0.21592f
C27 b2 vcas 0.29794f
C28 a_528_4392# g 0.0015f
C29 a_528_4392# m1_240_3480# 0.0165f
C30 a_4132_4392# vdd 0.5253f
C31 m1_988_2804# m1_988_888# 0.20776f
C32 vcas a_528_4392# 0.05572f
C33 dump a_1378_4392# 0.12224f
C34 g m1_988_888# 2.54331f
C35 m1_1500_4312# a_732_4392# 0
C36 m1_240_3480# m1_988_888# 0.04999f
C37 a_1378_4392# a_2228_4392# 0.0019f
C38 a_1582_4392# a_1378_4392# 0.20351f
C39 a_3928_4392# m1_988_888# 0.01013f
C40 b2 a_1378_4392# 0.00157f
C41 dump a_732_4392# 0.11406f
C42 a_2432_4392# m1_1500_4312# 0.0018f
C43 a_1582_4392# a_732_4392# 0
C44 m1_1500_4312# dump 0.07029f
C45 a_1378_4392# a_528_4392# 0.00968f
C46 b3 a_3078_4392# 0.27358f
C47 a_3282_4392# vdd 0.51129f
C48 vdd out 1.27153f
C49 m1_988_2804# a_3078_4392# 0.00631f
C50 a_4132_4392# vsp 0
C51 a_2432_4392# dump 0.12878f
C52 m1_1500_4312# a_2228_4392# 0
C53 a_1582_4392# m1_1500_4312# 0.0222f
C54 a_3282_4392# out 0.01304f
C55 a_3078_4392# g 0.00203f
C56 a_2432_4392# a_2228_4392# 0.18456f
C57 a_3928_4392# a_3078_4392# 0.01001f
C58 b0 vdd 0.15292f
C59 vcas a_3078_4392# 0.04594f
C60 a_528_4392# a_732_4392# 0.11371f
C61 m1_988_2804# a_4132_4392# 0
C62 b0 out 0.34956f
C63 a_4132_4392# g 0
C64 dump a_2228_4392# 0.22128f
C65 a_1582_4392# dump 0.29887f
C66 b2 a_2432_4392# 0.25812f
C67 a_4132_4392# m1_240_3480# 0
C68 a_3928_4392# a_4132_4392# 0.1229f
C69 dump b4 0
C70 a_1582_4392# a_2228_4392# 0.06282f
C71 vcas a_4132_4392# 0.00535f
C72 m1_988_3464# vdd 0.12699f
C73 b2 dump 0.03612f
C74 vsp vdd 1.94491f
C75 b1 vdd 0.16268f
C76 m1_988_3464# out 0.21869f
C77 m1_1500_4312# m1_988_888# 0
C78 b2 a_2228_4392# 0.1815f
C79 a_1582_4392# b2 0
C80 vsp out 0
C81 b1 out 0.01042f
C82 dump a_528_4392# 0.01755f
C83 b3 vdd 0.18861f
C84 b2 b4 0
C85 m1_988_2804# vdd 0.36066f
C86 b3 a_3282_4392# 0.02628f
C87 b3 out 0
C88 g vdd 8.74367f
C89 dump m1_988_888# 0.05324f
C90 m1_988_2804# a_3282_4392# 0.00333f
C91 b1 b0 0.00796f
C92 m1_988_2804# out 0.06468f
C93 m1_240_3480# vdd 1.54226f
C94 a_3282_4392# g 0.00215f
C95 g out 0.69731f
C96 a_3928_4392# vdd 0.65032f
C97 m1_240_3480# out 0.20558f
C98 vcas vdd 0.12325f
C99 a_3928_4392# a_3282_4392# 0.05112f
C100 a_3928_4392# out 0.0039f
C101 vcas a_3282_4392# 0.02198f
C102 vcas out 0.13451f
C103 b4 m1_988_888# 0
C104 m1_988_3464# vsp 0.09235f
C105 b0 g 0
C106 m1_1500_4312# a_3078_4392# 0
C107 b0 m1_240_3480# 0.0015f
C108 a_2432_4392# a_3078_4392# 0.16749f
C109 vcas b0 0.06096f
C110 m1_988_3464# m1_988_2804# 0.03356f
C111 m1_988_3464# g 0.69646f
C112 dump a_3078_4392# 0.11788f
C113 m1_988_2804# vsp 0.24604f
C114 a_1378_4392# vdd 0.49318f
C115 m1_988_3464# m1_240_3480# 0.00676f
C116 g vsp 4.05384f
C117 b1 g 0
C118 m1_240_3480# vsp 0.29136f
C119 a_1378_4392# out 0.01469f
C120 a_3078_4392# a_2228_4392# 0.00233f
C121 b3 m1_988_2804# 0.0024f
C122 a_3928_4392# vsp 0
C123 b1 vcas 0.16455f
C124 b3 g 0
C125 dump a_4132_4392# 0.04726f
C126 a_3078_4392# b4 0.00186f
C127 m1_988_2804# g 1.11336f
C128 b2 a_3078_4392# 0.00848f
C129 a_732_4392# vdd 0.42048f
C130 m1_988_2804# m1_240_3480# 0.46309f
C131 a_1378_4392# b0 0.01025f
C132 b3 a_3928_4392# 0.00713f
C133 b3 vcas 0.13187f
C134 m1_240_3480# g 1.39137f
C135 m1_988_2804# a_3928_4392# 0
C136 a_732_4392# out 0.05477f
C137 a_3928_4392# g 0.00474f
C138 m1_1500_4312# vdd 0.16576f
C139 b4 a_4132_4392# 0.14194f
C140 a_3928_4392# m1_240_3480# 0.00167f
C141 m1_1500_4312# out 0.15763f
C142 a_2432_4392# vdd 0.43511f
C143 vcas a_3928_4392# 0.02838f
C144 m1_988_3464# a_1378_4392# 0.00387f
C145 b0 a_732_4392# 0.02072f
C146 a_2432_4392# a_3282_4392# 0
C147 a_2432_4392# out 0.03176f
C148 b1 a_1378_4392# 0.276f
C149 dump vdd 1.00627f
C150 dump a_3282_4392# 0.08877f
C151 dump out 0.14997f
C152 a_2228_4392# vdd 0.45461f
C153 a_1582_4392# vdd 0.31851f
C154 a_4132_4392# m1_988_888# 0.03507f
C155 m1_988_3464# a_732_4392# 0.00112f
C156 a_2228_4392# a_3282_4392# 0
C157 a_1378_4392# g 0.00206f
C158 a_2228_4392# out 0.01362f
C159 a_1582_4392# out 0.01339f
C160 b4 vdd 0.36351f
C161 b1 a_732_4392# 0.0505f
C162 a_1378_4392# m1_240_3480# 0
C163 b2 vdd 0.206f
C164 dump b0 0
C165 b4 a_3282_4392# 0
C166 m1_988_3464# m1_1500_4312# 0.46191f
C167 vcas a_1378_4392# 0.02974f
C168 b2 a_3282_4392# 0
C169 m1_1500_4312# vsp 0.21814f
C170 b2 out 0
C171 b1 m1_1500_4312# 0
C172 a_2432_4392# m1_988_3464# 0.0039f
C173 a_1582_4392# b0 0
C174 a_528_4392# vdd 0.44354f
C175 g a_732_4392# 0.00258f
C176 a_528_4392# out 0.16739f
C177 m1_240_3480# a_732_4392# 0.00483f
C178 m1_988_3464# dump 0.03151f
C179 m1_988_2804# m1_1500_4312# 0.11128f
C180 vdd m1_988_888# 1.79894f
C181 dump vsp 0.00712f
C182 b1 dump 0.03413f
C183 m1_1500_4312# g 0.40807f
C184 vcas a_732_4392# 0.07256f
C185 b3 a_2432_4392# 0
C186 a_3078_4392# a_4132_4392# 0
C187 m1_1500_4312# m1_240_3480# 0.0068f
C188 m1_988_3464# a_2228_4392# 0.01383f
C189 a_2432_4392# m1_988_2804# 0
C190 m1_988_888# out 0.03269f
C191 a_2432_4392# g 0.00264f
C192 b0 a_528_4392# 0.35816f
C193 b1 a_2228_4392# 0
C194 a_1582_4392# b1 0.02085f
C195 b3 dump 0
C196 b2 m1_988_3464# 0
C197 m1_988_2804# dump 0.02557f
C198 b4 vsp 0
C199 m1_988_888# vss 1.02294f
C200 vsp vss 0.2353f
C201 g vss -2.45698f
C202 vdd vss 23.98689f
C203 a_4132_4392# vss 0.12907f
C204 a_3928_4392# vss 0.16119f
C205 a_3282_4392# vss 0.00178f
C206 a_3078_4392# vss 0.11146f
C207 m1_1500_4312# vss -0.02333f
C208 a_1582_4392# vss 0.0096f
C209 a_1378_4392# vss 0.1291f
C210 a_2432_4392# vss 0.06008f
C211 a_2228_4392# vss 0.1444f
C212 dump vss 0.07406f
C213 m1_240_3480# vss 0.32442f
C214 out vss 0.5531f
C215 a_732_4392# vss -0.00313f
C216 a_528_4392# vss 0.1515f
C217 m1_988_3464# vss -0.03952f
C218 b4 vss 0.44872f
C219 b3 vss 0.20878f
C220 b2 vss 0.37183f
C221 vcas vss 1.54593f
C222 b1 vss 0.2684f
C223 b0 vss 0.41869f
C224 m1_988_2804# vss -0.01016f
.ends
