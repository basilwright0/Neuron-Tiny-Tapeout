* NGSPICE file created from bias_b1.ext - technology: gf180mcuD

.subckt n_w2_l4_f4 a_n52_n200# a_852_n200# a_n852_n244# a_n956_n200# a_52_n244# a_n1756_n244#
+ a_1756_n200# a_n1844_n200# a_956_n244# VSUBS
X0 a_852_n200# a_52_n244# a_n52_n200# VSUBS nfet_03v3 ad=0.52p pd=2.52u as=0.52p ps=2.52u w=2u l=4u
X1 a_1756_n200# a_956_n244# a_852_n200# VSUBS nfet_03v3 ad=0.88p pd=4.88u as=0.52p ps=2.52u w=2u l=4u
X2 a_n956_n200# a_n1756_n244# a_n1844_n200# VSUBS nfet_03v3 ad=0.52p pd=2.52u as=0.88p ps=4.88u w=2u l=4u
X3 a_n52_n200# a_n852_n244# a_n956_n200# VSUBS nfet_03v3 ad=0.52p pd=2.52u as=0.52p ps=2.52u w=2u l=4u
.ends

.subckt rx_n4 line vdd vss
XD vss line line line line line vss vss line vss n_w2_l4_f4
.ends

.subckt n_w2_l4_f2 a_n52_n200# a_852_n200# a_n852_n244# a_n940_n200# a_52_n244# VSUBS
X0 a_852_n200# a_52_n244# a_n52_n200# VSUBS nfet_03v3 ad=0.88p pd=4.88u as=0.52p ps=2.52u w=2u l=4u
X1 a_n52_n200# a_n852_n244# a_n940_n200# VSUBS nfet_03v3 ad=0.52p pd=2.52u as=0.88p ps=4.88u w=2u l=4u
.ends

.subckt rx_n2 line vdd vss
XD line vss line vss line vss n_w2_l4_f2
.ends

.subckt p_w2_l4 a_400_n200# a_n400_n244# w_n574_n330# a_n488_n200#
X0 a_400_n200# a_n400_n244# a_n488_n200# w_n574_n330# pfet_03v3 ad=0.88p pd=4.88u as=0.88p ps=4.88u w=2u l=4u
.ends

.subckt rx_p24 line vdd vss
XD line line vdd vdd p_w2_l4
.ends

.subckt n_w2_l4 a_400_n200# a_n400_n244# a_n488_n200# VSUBS
X0 a_400_n200# a_n400_n244# a_n488_n200# VSUBS nfet_03v3 ad=0.88p pd=4.88u as=0.88p ps=4.88u w=2u l=4u
.ends

.subckt rx_n1 line vdd vss
XD line line vss vss n_w2_l4
.ends

.subckt p_w1_l4 a_n488_n100# a_400_n100# a_n400_n144# w_n574_n230#
X0 a_400_n100# a_n400_n144# a_n488_n100# w_n574_n230# pfet_03v3 ad=0.44p pd=2.88u as=0.44p ps=2.88u w=1u l=4u
.ends

.subckt rx_p05 line vdd vss
XD vdd line line vdd p_w1_l4
.ends

.subckt p_w4_l2_f5 a_n304_n400# a_704_n400# a_n704_n444# a_n808_n400# a_304_n444#
+ a_n1208_n444# a_n1296_n400# a_1208_n400# w_n1382_n530# a_200_n400# a_808_n444# a_n200_n444#
X0 a_1208_n400# a_808_n444# a_704_n400# w_n1382_n530# pfet_03v3 ad=1.76p pd=8.88u as=1.04p ps=4.52u w=4u l=2u
X1 a_704_n400# a_304_n444# a_200_n400# w_n1382_n530# pfet_03v3 ad=1.04p pd=4.52u as=1.04p ps=4.52u w=4u l=2u
X2 a_n808_n400# a_n1208_n444# a_n1296_n400# w_n1382_n530# pfet_03v3 ad=1.04p pd=4.52u as=1.76p ps=8.88u w=4u l=2u
X3 a_n304_n400# a_n704_n444# a_n808_n400# w_n1382_n530# pfet_03v3 ad=1.04p pd=4.52u as=1.04p ps=4.52u w=4u l=2u
X4 a_200_n400# a_n200_n444# a_n304_n400# w_n1382_n530# pfet_03v3 ad=1.04p pd=4.52u as=1.04p ps=4.52u w=4u l=2u
.ends

.subckt p_w2_l1 a_100_n200# a_n100_n244# w_n274_n330# a_n188_n200#
X0 a_100_n200# a_n100_n244# a_n188_n200# w_n274_n330# pfet_03v3 ad=0.88p pd=4.88u as=0.88p ps=4.88u w=2u l=1u
.ends

.subckt n_w4_l2_f6 a_n956_n444# a_1060_n444# a_556_n444# a_n52_n400# a_n1548_n400#
+ a_n1060_n400# a_452_n400# a_n452_n444# a_n556_n400# a_n1460_n444# a_1460_n400# a_52_n444#
+ a_956_n400# VSUBS
X0 a_n556_n400# a_n956_n444# a_n1060_n400# VSUBS nfet_03v3 ad=1.04p pd=4.52u as=1.04p ps=4.52u w=4u l=2u
X1 a_n52_n400# a_n452_n444# a_n556_n400# VSUBS nfet_03v3 ad=1.04p pd=4.52u as=1.04p ps=4.52u w=4u l=2u
X2 a_452_n400# a_52_n444# a_n52_n400# VSUBS nfet_03v3 ad=1.04p pd=4.52u as=1.04p ps=4.52u w=4u l=2u
X3 a_n1060_n400# a_n1460_n444# a_n1548_n400# VSUBS nfet_03v3 ad=1.04p pd=4.52u as=1.76p ps=8.88u w=4u l=2u
X4 a_956_n400# a_556_n444# a_452_n400# VSUBS nfet_03v3 ad=1.04p pd=4.52u as=1.04p ps=4.52u w=4u l=2u
X5 a_1460_n400# a_1060_n444# a_956_n400# VSUBS nfet_03v3 ad=1.76p pd=8.88u as=1.04p ps=4.52u w=4u l=2u
.ends

.subckt n_w2_l2_f2 a_n52_n200# a_452_n200# a_n452_n244# a_n540_n200# a_52_n244# VSUBS
X0 a_452_n200# a_52_n244# a_n52_n200# VSUBS nfet_03v3 ad=0.88p pd=4.88u as=0.52p ps=2.52u w=2u l=2u
X1 a_n52_n200# a_n452_n244# a_n540_n200# VSUBS nfet_03v3 ad=0.52p pd=2.52u as=0.88p ps=4.88u w=2u l=2u
.ends

.subckt n_w2_l1 a_100_n200# a_n100_n244# a_n188_n200# VSUBS
X0 a_100_n200# a_n100_n244# a_n188_n200# VSUBS nfet_03v3 ad=0.88p pd=4.88u as=0.88p ps=4.88u w=2u l=1u
.ends

.subckt p_w2_l2_f8 a_n52_n200# a_n1060_n200# a_452_n200# a_1564_n244# a_n452_n244#
+ w_n2138_n330# a_n556_n200# a_n1460_n244# a_1460_n200# a_52_n244# a_n1564_n200# a_956_n200#
+ a_n2052_n200# a_n956_n244# a_1060_n244# a_n1964_n244# a_556_n244# a_1964_n200#
X0 a_1964_n200# a_1564_n244# a_1460_n200# w_n2138_n330# pfet_03v3 ad=0.88p pd=4.88u as=0.52p ps=2.52u w=2u l=2u
X1 a_452_n200# a_52_n244# a_n52_n200# w_n2138_n330# pfet_03v3 ad=0.52p pd=2.52u as=0.52p ps=2.52u w=2u l=2u
X2 a_956_n200# a_556_n244# a_452_n200# w_n2138_n330# pfet_03v3 ad=0.52p pd=2.52u as=0.52p ps=2.52u w=2u l=2u
X3 a_1460_n200# a_1060_n244# a_956_n200# w_n2138_n330# pfet_03v3 ad=0.52p pd=2.52u as=0.52p ps=2.52u w=2u l=2u
X4 a_n1564_n200# a_n1964_n244# a_n2052_n200# w_n2138_n330# pfet_03v3 ad=0.52p pd=2.52u as=0.88p ps=4.88u w=2u l=2u
X5 a_n1060_n200# a_n1460_n244# a_n1564_n200# w_n2138_n330# pfet_03v3 ad=0.52p pd=2.52u as=0.52p ps=2.52u w=2u l=2u
X6 a_n556_n200# a_n956_n244# a_n1060_n200# w_n2138_n330# pfet_03v3 ad=0.52p pd=2.52u as=0.52p ps=2.52u w=2u l=2u
X7 a_n52_n200# a_n452_n244# a_n556_n200# w_n2138_n330# pfet_03v3 ad=0.52p pd=2.52u as=0.52p ps=2.52u w=2u l=2u
.ends

.subckt n_w2_l2_f8 a_n52_n200# a_n1060_n200# a_452_n200# a_1564_n244# a_n452_n244#
+ a_n556_n200# a_n1460_n244# a_1460_n200# a_52_n244# a_n1564_n200# a_956_n200# a_n2052_n200#
+ a_n956_n244# a_1060_n244# a_n1964_n244# a_556_n244# a_1964_n200# VSUBS
X0 a_1964_n200# a_1564_n244# a_1460_n200# VSUBS nfet_03v3 ad=0.88p pd=4.88u as=0.52p ps=2.52u w=2u l=2u
X1 a_452_n200# a_52_n244# a_n52_n200# VSUBS nfet_03v3 ad=0.52p pd=2.52u as=0.52p ps=2.52u w=2u l=2u
X2 a_956_n200# a_556_n244# a_452_n200# VSUBS nfet_03v3 ad=0.52p pd=2.52u as=0.52p ps=2.52u w=2u l=2u
X3 a_1460_n200# a_1060_n244# a_956_n200# VSUBS nfet_03v3 ad=0.52p pd=2.52u as=0.52p ps=2.52u w=2u l=2u
X4 a_n1564_n200# a_n1964_n244# a_n2052_n200# VSUBS nfet_03v3 ad=0.52p pd=2.52u as=0.88p ps=4.88u w=2u l=2u
X5 a_n1060_n200# a_n1460_n244# a_n1564_n200# VSUBS nfet_03v3 ad=0.52p pd=2.52u as=0.52p ps=2.52u w=2u l=2u
X6 a_n556_n200# a_n956_n244# a_n1060_n200# VSUBS nfet_03v3 ad=0.52p pd=2.52u as=0.52p ps=2.52u w=2u l=2u
X7 a_n52_n200# a_n452_n244# a_n556_n200# VSUBS nfet_03v3 ad=0.52p pd=2.52u as=0.52p ps=2.52u w=2u l=2u
.ends

.subckt p_w2_l2 a_n288_n200# a_200_n200# a_n200_n244# w_n374_n330#
X0 a_200_n200# a_n200_n244# a_n288_n200# w_n374_n330# pfet_03v3 ad=0.88p pd=4.88u as=0.88p ps=4.88u w=2u l=2u
.ends

.subckt n_w2_l2 a_n288_n200# a_200_n200# a_n200_n244# VSUBS
X0 a_200_n200# a_n200_n244# a_n288_n200# VSUBS nfet_03v3 ad=0.88p pd=4.88u as=0.88p ps=4.88u w=2u l=2u
.ends

.subckt p_w2_l2_f2 a_n52_n200# a_452_n200# a_n452_n244# a_n540_n200# w_n626_n330#
+ a_52_n244#
X0 a_452_n200# a_52_n244# a_n52_n200# w_n626_n330# pfet_03v3 ad=0.88p pd=4.88u as=0.52p ps=2.52u w=2u l=2u
X1 a_n52_n200# a_n452_n244# a_n540_n200# w_n626_n330# pfet_03v3 ad=0.52p pd=2.52u as=0.88p ps=4.88u w=2u l=2u
.ends

.subckt bias_ladder in_n vgln vsn vgn3 vgn5 in_p vglp vsp vdd vgp3 vgp5 vgp6 vss
XnpSE m1_3898_9610# m1_4906_9490# vglp m1_3666_9610# vglp vglp in_p m1_6020_10200#
+ vdd m1_5022_10210# vglp vglp p_w4_l2_f5
XFP3 vgp3 a_1580_5314# vgp3 vss p_w2_l1
XnnSE vgln vgln vgln m1_4760_1320# in_n m1_3298_2050# m1_4538_1930# vgln m1_3530_1930#
+ vgln m1_6282_1450# vgln m1_5516_1920# vss n_w4_l2_f6
XnnSH6T m1_6282_1450# vdd vgln a_7580_5314# vgln vss n_w2_l2_f2
XFP5 vgp5 a_4580_5314# vgp5 vss p_w2_l1
XFN3 vgn3 a_3036_4156# vdd vss n_w2_l1
XDP3 vsp vsp a_1580_5314# vgp3 vgp3 vdd a_1580_5314# vgp3 a_1580_5314# vgp3 a_1580_5314#
+ vsp vsp vgp3 vgp3 vgp3 vgp3 vsp p_w2_l2_f8
XFP6 vgp6 a_7580_5314# vgp6 vss p_w2_l1
XFN5 vgn5 a_5188_4156# vdd vss n_w2_l1
XDP5 vsp vsp a_4580_5314# vgp5 vgp5 vdd a_4580_5314# vgp5 a_4580_5314# vgp5 a_4580_5314#
+ vsp vsp vgp5 vgp5 vgp5 vgp5 vsp p_w2_l2_f8
XDN3 vsn vsn a_3036_4156# vgn3 vgn3 a_3036_4156# vgn3 a_3036_4156# vgn3 a_3036_4156#
+ vsn vsn vgn3 vgn3 vgn3 vgn3 vsn vss n_w2_l2_f8
XDP6 vsp vsp a_7580_5314# vgp6 vgp6 vdd a_7580_5314# vgp6 a_7580_5314# vgp6 a_7580_5314#
+ vsp vsp vgp6 vgp6 vgp6 vgp6 vsp p_w2_l2_f8
XBP3 vsp vgp3 vgp6 vdd p_w2_l2
XDN5 vsn vsn a_5188_4156# vgn5 vgn5 a_5188_4156# vgn5 a_5188_4156# vgn5 a_5188_4156#
+ vsn vsn vgn5 vgn5 vgn5 vgn5 vsn vss n_w2_l2_f8
XBP5 vsp vgp5 vgp6 vdd p_w2_l2
XBN3 vgn3 vsn vgn5 vss n_w2_l2
XnnSH01 vdd m1_3298_2050# vgln in_n vgln vss n_w2_l2_f2
XBP6 vsp vgp6 vgp6 vdd p_w2_l2
XnnSH24 vdd m1_4538_1930# vgln m1_3530_1930# vgln vss n_w2_l2_f2
XBN5 vgn5 vsn vgn5 vss n_w2_l2
XnpSH3 m1_5022_10210# a_3036_4156# vglp vdd p_w2_l2
XnpSH5T m1_6020_10200# vss vglp a_5188_4156# vdd vglp p_w2_l2_f2
XnpSH01 vss m1_3666_9610# vglp in_p vdd vglp p_w2_l2_f2
XnpSH24 vss m1_4906_9490# vglp m1_3898_9610# vdd vglp p_w2_l2_f2
XnnSH3 m1_4760_1320# a_1580_5314# vgln vss n_w2_l2
XnnSH5 m1_5516_1920# a_4580_5314# vgln vss n_w2_l2
.ends

.subckt p_w1_l0p28_f2 a_n196_n100# a_n52_n100# w_n282_n230# a_108_n100# a_52_n144#
+ a_n108_n144#
X0 a_n52_n100# a_n108_n144# a_n196_n100# w_n282_n230# pfet_03v3 ad=0.26p pd=1.52u as=0.44p ps=2.88u w=1u l=0.28u
X1 a_108_n100# a_52_n144# a_n52_n100# w_n282_n230# pfet_03v3 ad=0.44p pd=2.88u as=0.26p ps=1.52u w=1u l=0.28u
.ends

.subckt n_w0p5_l0p28_f2 a_n52_n50# a_n196_n50# a_52_n94# a_108_n50# a_n108_n94# VSUBS
X0 a_108_n50# a_52_n94# a_n52_n50# VSUBS nfet_03v3 ad=0.22p pd=1.88u as=0.13p ps=1.02u w=0.5u l=0.28u
X1 a_n52_n50# a_n108_n94# a_n196_n50# VSUBS nfet_03v3 ad=0.13p pd=1.02u as=0.22p ps=1.88u w=0.5u l=0.28u
.ends

.subckt p_w2_l2_f7 a_n704_n244# a_n808_n200# a_304_n244# a_n1712_n244# a_1712_n200#
+ a_n1800_n200# a_n1208_n244# a_1208_n200# a_200_n200# a_1312_n244# a_808_n244# a_n200_n244#
+ a_n304_n200# w_n1886_n330# a_n1312_n200# a_704_n200#
X0 a_n1312_n200# a_n1712_n244# a_n1800_n200# w_n1886_n330# pfet_03v3 ad=0.52p pd=2.52u as=0.88p ps=4.88u w=2u l=2u
X1 a_n304_n200# a_n704_n244# a_n808_n200# w_n1886_n330# pfet_03v3 ad=0.52p pd=2.52u as=0.52p ps=2.52u w=2u l=2u
X2 a_200_n200# a_n200_n244# a_n304_n200# w_n1886_n330# pfet_03v3 ad=0.52p pd=2.52u as=0.52p ps=2.52u w=2u l=2u
X3 a_1712_n200# a_1312_n244# a_1208_n200# w_n1886_n330# pfet_03v3 ad=0.88p pd=4.88u as=0.52p ps=2.52u w=2u l=2u
X4 a_1208_n200# a_808_n244# a_704_n200# w_n1886_n330# pfet_03v3 ad=0.52p pd=2.52u as=0.52p ps=2.52u w=2u l=2u
X5 a_n808_n200# a_n1208_n244# a_n1312_n200# w_n1886_n330# pfet_03v3 ad=0.52p pd=2.52u as=0.52p ps=2.52u w=2u l=2u
X6 a_704_n200# a_304_n244# a_200_n200# w_n1886_n330# pfet_03v3 ad=0.52p pd=2.52u as=0.52p ps=2.52u w=2u l=2u
.ends

.subckt p_w0p5_l0p5_f2 a_n52_n50# w_n326_n180# a_52_n94# a_152_n50# a_n240_n50# a_n152_n94#
X0 a_152_n50# a_52_n94# a_n52_n50# w_n326_n180# pfet_03v3 ad=0.22p pd=1.88u as=0.13p ps=1.02u w=0.5u l=0.5u
X1 a_n52_n50# a_n152_n94# a_n240_n50# w_n326_n180# pfet_03v3 ad=0.13p pd=1.02u as=0.22p ps=1.88u w=0.5u l=0.5u
.ends

.subckt idac_p g vsp b0 b1 b2 b3 b4 out dump vcas vdd vss
XU4b vsp vsp m1_988_1168# g g vdd m1_988_1168# g m1_988_1168# g m1_988_1168# vsp vsp
+ g g g g vsp p_w2_l2_f8
XU3 vsp vsp m1_988_2984# g g vdd m1_988_2984# g m1_988_2984# g m1_988_2984# vsp vsp
+ g g g g vsp p_w2_l2_f8
XIP0 a_528_4572# vdd vdd a_732_4572# a_528_4572# b0 p_w1_l0p28_f2
XIP1 a_1378_4572# vdd vdd a_1582_4572# a_1378_4572# b1 p_w1_l0p28_f2
XIN0 vcas a_528_4572# a_528_4572# a_732_4572# b0 vss n_w0p5_l0p28_f2
XIP2 a_2228_4572# vdd vdd a_2432_4572# a_2228_4572# b2 p_w1_l0p28_f2
XIN1 vcas a_1378_4572# a_1378_4572# a_1582_4572# b1 vss n_w0p5_l0p28_f2
XIP3 a_3078_4572# vdd vdd a_3282_4572# a_3078_4572# b3 p_w1_l0p28_f2
XIN3 vcas a_3078_4572# a_3078_4572# a_3282_4572# b3 vss n_w0p5_l0p28_f2
XIN2 vcas a_2228_4572# a_2228_4572# a_2432_4572# b2 vss n_w0p5_l0p28_f2
XIP4 a_3928_4572# vdd vdd a_4132_4572# a_3928_4572# b4 p_w1_l0p28_f2
XIN4 vcas a_3928_4572# a_3928_4572# a_4132_4572# b4 vss n_w0p5_l0p28_f2
XU210 g vsp g g m1_650_4492# vsp g vsp vsp g g g m1_988_3644# vdd m1_988_3644# m1_1460_4102#
+ p_w2_l2_f7
XSW0 m1_650_4492# vdd a_732_4572# dump out a_528_4572# p_w0p5_l0p5_f2
XSW2 m1_988_3644# vdd a_2432_4572# dump out a_2228_4572# p_w0p5_l0p5_f2
XSW1 m1_1460_4102# vdd a_1582_4572# dump out a_1378_4572# p_w0p5_l0p5_f2
XSW3 m1_988_2984# vdd a_3282_4572# dump out a_3078_4572# p_w0p5_l0p5_f2
XSW4 m1_988_1168# vdd a_4132_4572# dump out a_3928_4572# p_w0p5_l0p5_f2
XU4a vsp vsp m1_988_1168# g g vdd m1_988_1168# g m1_988_1168# g m1_988_1168# vsp vsp
+ g g g g vsp p_w2_l2_f8
.ends

.subckt r_w4_l3p97 a_n400_n519# a_n400_397# VSUBS
X0 a_n400_397# a_n400_n519# VSUBS ppolyf_u_1k r_width=4u r_length=3.97u
.ends

.subckt n_w8_l0p5 a_50_n800# a_n50_n844# a_n138_n800# VSUBS
X0 a_50_n800# a_n50_n844# a_n138_n800# VSUBS nfet_03v3 ad=3.52p pd=16.88u as=3.52p ps=16.88u w=8u l=0.5u
.ends

.subckt n_w4_l0p5 a_n138_n400# a_50_n400# a_n50_n444# VSUBS
X0 a_50_n400# a_n50_n444# a_n138_n400# VSUBS nfet_03v3 ad=1.76p pd=8.88u as=1.76p ps=8.88u w=4u l=0.5u
.ends

.subckt n_w0p5_l0p28 a_n28_n94# a_n116_n50# a_28_n50# VSUBS
X0 a_28_n50# a_n28_n94# a_n116_n50# VSUBS nfet_03v3 ad=0.22p pd=1.88u as=0.22p ps=1.88u w=0.5u l=0.28u
.ends

.subckt p_w1_l0p28 w_n202_n230# a_28_n100# a_n28_n144# a_n116_n100#
X0 a_28_n100# a_n28_n144# a_n116_n100# w_n202_n230# pfet_03v3 ad=0.44p pd=2.88u as=0.44p ps=2.88u w=1u l=0.28u
.ends

.subckt p_w2_l2_f4 a_n52_n200# a_452_n200# a_n452_n244# a_n556_n200# a_52_n244# a_956_n200#
+ a_n1044_n200# w_n1130_n330# a_n956_n244# a_556_n244#
X0 a_452_n200# a_52_n244# a_n52_n200# w_n1130_n330# pfet_03v3 ad=0.52p pd=2.52u as=0.52p ps=2.52u w=2u l=2u
X1 a_956_n200# a_556_n244# a_452_n200# w_n1130_n330# pfet_03v3 ad=0.88p pd=4.88u as=0.52p ps=2.52u w=2u l=2u
X2 a_n556_n200# a_n956_n244# a_n1044_n200# w_n1130_n330# pfet_03v3 ad=0.52p pd=2.52u as=0.88p ps=4.88u w=2u l=2u
X3 a_n52_n200# a_n452_n244# a_n556_n200# w_n1130_n330# pfet_03v3 ad=0.52p pd=2.52u as=0.52p ps=2.52u w=2u l=2u
.ends

.subckt p_w2_l0p5 a_50_n200# a_n50_n244# w_n224_n330# a_n138_n200#
X0 a_50_n200# a_n50_n244# a_n138_n200# w_n224_n330# pfet_03v3 ad=0.88p pd=4.88u as=0.88p ps=4.88u w=2u l=0.5u
.ends

.subckt n_w2_l0p5 a_50_n200# a_n50_n244# a_n138_n200# VSUBS
X0 a_50_n200# a_n50_n244# a_n138_n200# VSUBS nfet_03v3 ad=0.88p pd=4.88u as=0.88p ps=4.88u w=2u l=0.5u
.ends

.subckt p_w4_l0p5 a_n138_n400# a_50_n400# a_n50_n444# w_n224_n530#
X0 a_50_n400# a_n50_n444# a_n138_n400# w_n224_n530# pfet_03v3 ad=1.76p pd=8.88u as=1.76p ps=8.88u w=4u l=0.5u
.ends

.subckt bias_master pad s0 s1 stim intref en in_n in_p vbp_st iint ua0_stim en_b vdd
+ vss
XOP vss a_1744_10100# a_736_7228# vss n_w2_l2
XRS pad a_420_700# vss r_w4_l3p97
XS1 a_736_5516# s1 a_420_700# vss n_w8_l0p5
XS0 a_420_700# a_736_7228# s0 vss n_w4_l0p5
XOS vss vbp_st a_736_7228# vss n_w2_l2
XIENn en vss en_b vss n_w0p5_l0p28
XIENp vdd en_b en vdd p_w1_l0p28
XQX a_1744_9182# vdd a_1744_9182# vdd a_1744_9182# a_736_7228# a_736_7228# vdd a_1744_9182#
+ a_1744_9182# p_w2_l2_f4
XDXa vss vss a_736_5516# a_736_5516# a_736_5516# a_736_5516# a_736_5516# a_736_5516#
+ a_736_5516# a_736_5516# vss vss a_736_5516# a_736_5516# a_736_5516# a_736_5516#
+ vss vss n_w2_l2_f8
XOX vss a_1744_9182# a_736_5516# vss n_w2_l2
XDXb vss vss a_736_5516# a_736_5516# a_736_5516# a_736_5516# a_736_5516# a_736_5516#
+ a_736_5516# a_736_5516# vss vss a_736_5516# a_736_5516# a_736_5516# a_736_5516#
+ vss vss n_w2_l2_f8
XISTn stim vss a_1764_11418# vss n_w0p5_l0p28
XISTp vdd a_1764_11418# stim vdd p_w1_l0p28
XSWI a_736_7228# a_2240_11218# vdd iint p_w2_l0p5
XPD vdd a_1744_10100# a_1744_10100# in_p a_1744_10100# vdd vdd vdd a_1744_10100# a_1744_10100#
+ p_w2_l2_f4
XSTN ua0_stim stim a_420_700# vss n_w2_l0p5
XSTP a_420_700# ua0_stim a_1764_11418# vdd p_w4_l0p5
XPDN a_736_7228# vss en_b vss n_w4_l0p5
XDa vss vss a_736_7228# a_736_7228# a_736_7228# a_736_7228# a_736_7228# a_736_7228#
+ a_736_7228# a_736_7228# vss vss a_736_7228# a_736_7228# a_736_7228# a_736_7228#
+ vss vss n_w2_l2_f8
XDb vss vss a_736_7228# a_736_7228# a_736_7228# a_736_7228# a_736_7228# a_736_7228#
+ a_736_7228# a_736_7228# vss vss a_736_7228# a_736_7228# a_736_7228# a_736_7228#
+ vss vss n_w2_l2_f8
XIIRn intref vss a_2240_11218# vss n_w0p5_l0p28
XIIRp vdd a_2240_11218# intref vdd p_w1_l0p28
XON vss in_n a_736_7228# vss n_w2_l2
D0 vss a_420_700# diode_nd2ps_03v3 pj=22u area=10p
D1 a_420_700# vdd diode_pd2nw_03v3 pj=22u area=10p
.ends

.subckt n_w2_l2_f7 a_n704_n244# a_n808_n200# a_304_n244# a_n1712_n244# a_1712_n200#
+ a_n1800_n200# a_n1208_n244# a_1208_n200# a_200_n200# a_1312_n244# a_808_n244# a_n200_n244#
+ a_n304_n200# a_n1312_n200# a_704_n200# VSUBS
X0 a_n304_n200# a_n704_n244# a_n808_n200# VSUBS nfet_03v3 ad=0.52p pd=2.52u as=0.52p ps=2.52u w=2u l=2u
X1 a_200_n200# a_n200_n244# a_n304_n200# VSUBS nfet_03v3 ad=0.52p pd=2.52u as=0.52p ps=2.52u w=2u l=2u
X2 a_1712_n200# a_1312_n244# a_1208_n200# VSUBS nfet_03v3 ad=0.88p pd=4.88u as=0.52p ps=2.52u w=2u l=2u
X3 a_1208_n200# a_808_n244# a_704_n200# VSUBS nfet_03v3 ad=0.52p pd=2.52u as=0.52p ps=2.52u w=2u l=2u
X4 a_704_n200# a_304_n244# a_200_n200# VSUBS nfet_03v3 ad=0.52p pd=2.52u as=0.52p ps=2.52u w=2u l=2u
X5 a_n1312_n200# a_n1712_n244# a_n1800_n200# VSUBS nfet_03v3 ad=0.52p pd=2.52u as=0.88p ps=4.88u w=2u l=2u
X6 a_n808_n200# a_n1208_n244# a_n1312_n200# VSUBS nfet_03v3 ad=0.52p pd=2.52u as=0.52p ps=2.52u w=2u l=2u
.ends

.subckt n_w0p5_l0p5_f2 a_n52_n50# a_52_n94# a_152_n50# a_n240_n50# a_n152_n94# VSUBS
X0 a_152_n50# a_52_n94# a_n52_n50# VSUBS nfet_03v3 ad=0.22p pd=1.88u as=0.13p ps=1.02u w=0.5u l=0.5u
X1 a_n52_n50# a_n152_n94# a_n240_n50# VSUBS nfet_03v3 ad=0.13p pd=1.02u as=0.22p ps=1.88u w=0.5u l=0.5u
.ends

.subckt idac_n g vsn b0 b1 b2 b3 b4 out dump vcas vdd vss
XU4b vsn vsn m1_988_1168# g g m1_988_1168# g m1_988_1168# g m1_988_1168# vsn vsn g
+ g g g vsn vss n_w2_l2_f8
XU3 vsn vsn m1_988_2984# g g m1_988_2984# g m1_988_2984# g m1_988_2984# vsn vsn g
+ g g g vsn vss n_w2_l2_f8
XIP0 a_732_4510# vcas vcas a_528_4510# a_732_4510# b0 p_w1_l0p28_f2
XIP1 a_1582_4510# vcas vcas a_1378_4510# a_1582_4510# b1 p_w1_l0p28_f2
XIP2 a_2432_4510# vcas vcas a_2228_4510# a_2432_4510# b2 p_w1_l0p28_f2
XIN0 vss a_732_4510# a_732_4510# a_528_4510# b0 vss n_w0p5_l0p28_f2
XIP3 a_3282_4510# vcas vcas a_3078_4510# a_3282_4510# b3 p_w1_l0p28_f2
XIN1 vss a_1582_4510# a_1582_4510# a_1378_4510# b1 vss n_w0p5_l0p28_f2
XIP4 a_4132_4510# vcas vcas a_3928_4510# a_4132_4510# b4 p_w1_l0p28_f2
XIN3 vss a_3282_4510# a_3282_4510# a_3078_4510# b3 vss n_w0p5_l0p28_f2
XIN2 vss a_2432_4510# a_2432_4510# a_2228_4510# b2 vss n_w0p5_l0p28_f2
XIN4 vss a_4132_4510# a_4132_4510# a_3928_4510# b4 vss n_w0p5_l0p28_f2
XU210 g vsn g g m1_640_4420# vsn g vsn vsn g g g m1_988_3644# m1_988_3644# m1_1500_4102#
+ vss n_w2_l2_f7
XSW0 m1_640_4420# a_732_4510# dump out a_528_4510# vss n_w0p5_l0p5_f2
XSW2 m1_988_3644# a_2432_4510# dump out a_2228_4510# vss n_w0p5_l0p5_f2
XSW1 m1_1500_4102# a_1582_4510# dump out a_1378_4510# vss n_w0p5_l0p5_f2
XSW3 m1_988_2984# a_3282_4510# dump out a_3078_4510# vss n_w0p5_l0p5_f2
XSW4 m1_988_1168# a_4132_4510# dump out a_3928_4510# vss n_w0p5_l0p5_f2
XU4a vsn vsn m1_988_1168# g g m1_988_1168# g m1_988_1168# g m1_988_1168# vsn vsn g
+ g g g vsn vss n_w2_l2_f8
.ends

.subckt r_w1_l7p765 a_n100_n899# a_n100_777# VSUBS
X0 a_n100_777# a_n100_n899# VSUBS ppolyf_u_1k r_width=1u r_length=7.77u
.ends

.subckt r_w2_l1p97 a_n200_n319# a_n200_197# VSUBS
X0 a_n200_197# a_n200_n319# VSUBS ppolyf_u_1k r_width=2u r_length=1.97u
.ends

.subckt r_w1_l1p94 a_n100_n316# a_n100_194# VSUBS
X0 a_n100_194# a_n100_n316# VSUBS ppolyf_u_1k r_width=1u r_length=1.94u
.ends

.subckt r_w1_l3p88 a_n100_n510# a_n100_388# VSUBS
X0 a_n100_388# a_n100_n510# VSUBS ppolyf_u_1k r_width=1u r_length=3.88u
.ends

.subckt n_w0p5_l1 a_100_n50# a_n100_n94# a_n188_n50# VSUBS
X0 a_100_n50# a_n100_n94# a_n188_n50# VSUBS nfet_03v3 ad=0.22p pd=1.88u as=0.22p ps=1.88u w=0.5u l=1u
.ends

.subckt p_w1_l1 a_n188_n100# a_100_n100# a_n100_n144# w_n274_n230#
X0 a_100_n100# a_n100_n144# a_n188_n100# w_n274_n230# pfet_03v3 ad=0.44p pd=2.88u as=0.44p ps=2.88u w=1u l=1u
.ends

.subckt r_w1_l11p645 a_n100_1165# a_n100_n1287# VSUBS
X0 a_n100_1165# a_n100_n1287# VSUBS ppolyf_u_1k r_width=1u r_length=11.65u
.ends

.subckt n_w4_l0p28_f2 a_n52_n400# a_52_n444# a_108_n400# a_n108_n444# a_n196_n400#
+ VSUBS
X0 a_108_n400# a_52_n444# a_n52_n400# VSUBS nfet_03v3 ad=1.76p pd=8.88u as=1.04p ps=4.52u w=4u l=0.28u
X1 a_n52_n400# a_n108_n444# a_n196_n400# VSUBS nfet_03v3 ad=1.04p pd=4.52u as=1.76p ps=8.88u w=4u l=0.28u
.ends

.subckt vdacr_el b0 b1 b2 b3 b4 vdd out vss
XXRS4_0 m1_4222_4048# m1_4094_3010# vss r_w1_l7p765
XXRS4_1 vss m1_4222_4048# vss r_w1_l7p765
XXRS0 m1_2262_4048# m1_1822_4048# vss r_w2_l1p97
XXRS1 m1_2760_3412# m1_2262_4048# vss r_w1_l1p94
XXRS3 m1_4094_3010# m1_3342_4048# vss r_w1_l7p765
XXRS2 m1_3342_4048# m1_2760_3412# vss r_w1_l3p88
XIB4n a_4168_3416# b4 vss vss n_w0p5_l1
XIB3n a_3576_3416# b3 vss vss n_w0p5_l1
XIB4p vdd a_4168_3416# b4 vdd p_w1_l1
XIB2n a_2984_3416# b2 vss vss n_w0p5_l1
XIB3p vdd a_3576_3416# b3 vdd p_w1_l1
XIB2p vdd a_2984_3416# b2 vdd p_w1_l1
XIB1n a_2392_3416# b1 vss vss n_w0p5_l1
XIB0n a_1800_3416# b0 vss vss n_w0p5_l1
XIB1p vdd a_2392_3416# b1 vdd p_w1_l1
XIB0p vdd a_1800_3416# b0 vdd p_w1_l1
XXRB0 out m1_502_4048# vss r_w1_l11p645
XSW0 m1_2262_4048# a_1800_3416# m1_1822_4048# a_1800_3416# m1_1822_4048# vss n_w4_l0p28_f2
XXRB1 m1_502_4048# m1_942_4048# vss r_w1_l11p645
XSW2 m1_3342_4048# a_2984_3416# m1_2760_3412# a_2984_3416# m1_2760_3412# vss n_w4_l0p28_f2
XSW1 m1_2760_3412# a_2392_3416# m1_2262_4048# a_2392_3416# m1_2262_4048# vss n_w4_l0p28_f2
XXRB3 m1_1382_4048# m1_1822_4048# vss r_w1_l11p645
XXRB2 m1_942_4048# m1_1382_4048# vss r_w1_l11p645
XSW3 m1_4094_3010# a_3576_3416# m1_3342_4048# a_3576_3416# m1_3342_4048# vss n_w4_l0p28_f2
XSW4 vss a_4168_3416# m1_4094_3010# a_4168_3416# m1_4094_3010# vss n_w4_l0p28_f2
.ends

.subckt r_w1_l13p91 a_n100_n1513# a_n100_1391# VSUBS
X0 a_n100_1391# a_n100_n1513# VSUBS ppolyf_u_1k r_width=1u r_length=13.91u
.ends

.subckt vdacr_vr b0 b1 b2 b3 b4 vdd out vss
XXRS4_0 m1_3782_4048# m1_3662_2290# vss r_w1_l7p765
XXRS4_1 vss m1_3782_4048# vss r_w1_l7p765
XXRS0 m1_2318_2410# m1_1716_2640# vss r_w2_l1p97
XXRS1 m1_2910_2650# m1_2318_2410# vss r_w1_l1p94
XXRS3 m1_3662_2290# m1_3492_2640# vss r_w1_l7p765
XXRS2 m1_3492_2640# m1_2910_2650# vss r_w1_l3p88
XIB4n a_4168_3416# b4 vss vss n_w0p5_l1
XIB3n a_3576_3416# b3 vss vss n_w0p5_l1
XIB4p vdd a_4168_3416# b4 vdd p_w1_l1
XIB2n a_2984_3416# b2 vss vss n_w0p5_l1
XIB3p vdd a_3576_3416# b3 vdd p_w1_l1
XIB2p vdd a_2984_3416# b2 vdd p_w1_l1
XIB1n a_2392_3416# b1 vss vss n_w0p5_l1
XIB0n a_1800_3416# b0 vss vss n_w0p5_l1
XIB1p vdd a_2392_3416# b1 vdd p_w1_l1
XIB0p vdd a_1800_3416# b0 vdd p_w1_l1
XXRB0 m1_502_4048# out vss r_w1_l13p91
XSW0 m1_2318_2410# a_1800_3416# m1_1716_2640# a_1800_3416# m1_1716_2640# vss n_w4_l0p28_f2
XXRB1 m1_942_4048# m1_502_4048# vss r_w1_l13p91
XSW2 m1_3492_2640# a_2984_3416# m1_2910_2650# a_2984_3416# m1_2910_2650# vss n_w4_l0p28_f2
XSW1 m1_2910_2650# a_2392_3416# m1_2318_2410# a_2392_3416# m1_2318_2410# vss n_w4_l0p28_f2
XXRB2 m1_1716_2640# m1_942_4048# vss r_w1_l13p91
XSW3 m1_3662_2290# a_3576_3416# m1_3492_2640# a_3576_3416# m1_3492_2640# vss n_w4_l0p28_f2
XSW4 vss a_4168_3416# m1_3662_2290# a_4168_3416# m1_3662_2290# vss n_w4_l0p28_f2
.ends

.subckt r_w1_l14p555 a_n100_1456# a_n100_n1578# VSUBS
X0 a_n100_1456# a_n100_n1578# VSUBS ppolyf_u_1k r_width=1u r_length=14.56u
.ends

.subckt p_w10_l10 w_n1174_n1130# a_n1000_n1044# a_1000_n1000# a_n1088_n1000#
X0 a_1000_n1000# a_n1000_n1044# a_n1088_n1000# w_n1174_n1130# pfet_03v3 ad=4.4p pd=20.88u as=4.4p ps=20.88u w=10u l=10u
.ends

.subckt bias_rails vsn vsp vgln vglp en_b vdd vss
XR0 vsp m1_342_438# vss r_w1_l14p555
XR1 vsp m1_782_438# vss r_w1_l14p555
XR2 m1_1222_3522# m1_782_438# vss r_w1_l14p555
XR3 m1_1222_3522# m1_1662_438# vss r_w1_l14p555
XR4 vgln m1_1662_438# vss r_w1_l14p555
XHDR vdd m1_342_438# en_b vdd p_w4_l0p5
XR5 vgln m1_2542_438# vss r_w1_l14p555
XR6 vglp m1_2542_438# vss r_w1_l14p555
XR7 vglp m1_3422_438# vss r_w1_l14p555
XR9 m1_3862_3522# vsn vss r_w1_l14p555
XR8 m1_3862_3522# m1_3422_438# vss r_w1_l14p555
XR10 vss vsn vss r_w1_l14p555
XC2 vsp vdd vsp vsp p_w10_l10
XC1 vss vsn vss vss p_w10_l10
.ends

.subckt r_w2_l1p315 a_n200_n254# a_n200_132# VSUBS
X0 a_n200_132# a_n200_n254# VSUBS ppolyf_u_1k r_width=2u r_length=1.32u
.ends

.subckt r_w2_l2p625 a_n200_n385# a_n200_263# VSUBS
X0 a_n200_263# a_n200_n385# VSUBS ppolyf_u_1k r_width=2u r_length=2.63u
.ends

.subckt r_w1_l5p175 a_n100_518# a_n100_n640# VSUBS
X0 a_n100_518# a_n100_n640# VSUBS ppolyf_u_1k r_width=1u r_length=5.18u
.ends

.subckt r_w1_l2p59 a_n100_n381# a_n100_259# VSUBS
X0 a_n100_259# a_n100_n381# VSUBS ppolyf_u_1k r_width=1u r_length=2.59u
.ends

.subckt r_w1_l10p35 a_n100_n1157# a_n100_1035# VSUBS
X0 a_n100_1035# a_n100_n1157# VSUBS ppolyf_u_1k r_width=1u r_length=10.35u
.ends

.subckt r_w1_l12p86 a_n100_n1408# a_n100_1286# VSUBS
X0 a_n100_1286# a_n100_n1408# VSUBS ppolyf_u_1k r_width=1u r_length=12.86u
.ends

.subckt vdacr_vc b0 b1 b2 b3 b4 vdd out vss
XXRS0 m1_2156_3240# m1_1822_4048# vss r_w2_l1p315
XXRS1 m1_2900_3120# m1_2156_3240# vss r_w2_l2p625
XXRS3 m1_3542_4048# m1_3982_4048# vss r_w1_l5p175
XXRS2 m1_3542_4048# m1_2900_3120# vss r_w1_l2p59
XXRS4 vss m1_3982_4048# vss r_w1_l10p35
XIB4n a_4168_3416# b4 vss vss n_w0p5_l1
XIB3n a_3576_3416# b3 vss vss n_w0p5_l1
XIB4p vdd a_4168_3416# b4 vdd p_w1_l1
XIB2n a_2984_3416# b2 vss vss n_w0p5_l1
XIB3p vdd a_3576_3416# b3 vdd p_w1_l1
XIB2p vdd a_2984_3416# b2 vdd p_w1_l1
XIB1n a_2392_3416# b1 vss vss n_w0p5_l1
XIB0n a_1800_3416# b0 vss vss n_w0p5_l1
XIB1p vdd a_2392_3416# b1 vdd p_w1_l1
XIB0p vdd a_1800_3416# b0 vdd p_w1_l1
XXRB0 m1_502_4048# out vss r_w1_l12p86
XSW0 m1_2156_3240# a_1800_3416# m1_1822_4048# a_1800_3416# m1_1822_4048# vss n_w4_l0p28_f2
XXRB1 m1_942_4048# m1_502_4048# vss r_w1_l12p86
XSW2 m1_3542_4048# a_2984_3416# m1_2900_3120# a_2984_3416# m1_2900_3120# vss n_w4_l0p28_f2
XSW1 m1_2900_3120# a_2392_3416# m1_2156_3240# a_2392_3416# m1_2156_3240# vss n_w4_l0p28_f2
XXRB3 m1_1822_4048# m1_1382_4048# vss r_w1_l12p86
XXRB2 m1_1382_4048# m1_942_4048# vss r_w1_l12p86
XSW3 m1_3982_4048# a_3576_3416# m1_3542_4048# a_3576_3416# m1_3542_4048# vss n_w4_l0p28_f2
XSW4 vss a_4168_3416# m1_3982_4048# a_4168_3416# m1_3982_4048# vss n_w4_l0p28_f2
.ends

.subckt r_w1_l9p86 a_n100_n1108# a_n100_986# VSUBS
X0 a_n100_986# a_n100_n1108# VSUBS ppolyf_u_1k r_width=1u r_length=9.86u
.ends

.subckt r_w2_l2p5 a_n200_250# a_n200_n372# VSUBS
X0 a_n200_250# a_n200_n372# VSUBS ppolyf_u_1k r_width=2u r_length=2.5u
.ends

.subckt r_w1_l2p465 a_n100_n369# a_n100_247# VSUBS
X0 a_n100_247# a_n100_n369# VSUBS ppolyf_u_1k r_width=1u r_length=2.47u
.ends

.subckt r_w1_l4p93 a_n100_n615# a_n100_493# VSUBS
X0 a_n100_493# a_n100_n615# VSUBS ppolyf_u_1k r_width=1u r_length=4.93u
.ends

.subckt r_w1_l13p145 a_n100_1315# a_n100_n1437# VSUBS
X0 a_n100_1315# a_n100_n1437# VSUBS ppolyf_u_1k r_width=1u r_length=13.15u
.ends

.subckt r_w1_l13p39 a_n100_n1461# a_n100_1339# VSUBS
X0 a_n100_1339# a_n100_n1461# VSUBS ppolyf_u_1k r_width=1u r_length=13.39u
.ends

.subckt n_w6_l0p28_f2 a_52_n644# a_108_n600# a_n108_n644# a_n196_n600# a_n52_n600#
+ VSUBS
X0 a_108_n600# a_52_n644# a_n52_n600# VSUBS nfet_03v3 ad=2.64p pd=12.88u as=1.56p ps=6.52u w=6u l=0.28u
X1 a_n52_n600# a_n108_n644# a_n196_n600# VSUBS nfet_03v3 ad=1.56p pd=6.52u as=2.64p ps=12.88u w=6u l=0.28u
.ends

.subckt vdacr_vt b0 b1 b2 b3 b4 b5 vdd out vss
XXRS4_0 m1_4648_4446# m1_4328_3000# vss r_w1_l9p86
XXRS4_1 m1_4488_3600# m1_4648_4446# vss r_w1_l9p86
XXRS0 m1_1970_3610# m1_2702_4448# vss r_w2_l2p5
XXRS1 m1_3342_4448# m1_2702_4448# vss r_w1_l2p465
XXRS3 m1_4328_3000# m1_3600_4920# vss r_w1_l9p86
XXRS2 m1_3600_4920# m1_3342_4448# vss r_w1_l4p93
XIB5n a_5004_3816# b5 vss vss n_w0p5_l1
XIB4n a_4412_3816# b4 vss vss n_w0p5_l1
XIB5p vdd a_5004_3816# b5 vdd p_w1_l1
XIB3n a_3820_3816# b3 vss vss n_w0p5_l1
XIB4p vdd a_4412_3816# b4 vdd p_w1_l1
XIB2n a_3228_3816# b2 vss vss n_w0p5_l1
XIB3p vdd a_3820_3816# b3 vdd p_w1_l1
XIB2p vdd a_3228_3816# b2 vdd p_w1_l1
XIB1n a_2636_3816# b1 vss vss n_w0p5_l1
XIB0n a_2044_3816# b0 vss vss n_w0p5_l1
XIB1p vdd a_2636_3816# b1 vdd p_w1_l1
XIB0p vdd a_2044_3816# b0 vdd p_w1_l1
XXRS5_0 m1_4488_3600# m1_5542_4448# vss r_w1_l13p145
XXRS5_1 m1_5542_4448# m1_5982_4448# vss r_w1_l13p145
XXRB0 m1_502_4448# out vss r_w1_l13p39
XSW0 a_2044_3816# m1_1970_3610# a_2044_3816# m1_1970_3610# m1_2702_4448# vss n_w6_l0p28_f2
XXRS5_2 m1_5982_4448# vss vss r_w1_l13p145
XXRB1 m1_942_4448# m1_502_4448# vss r_w1_l13p39
XSW2 a_3228_3816# m1_3342_4448# a_3228_3816# m1_3342_4448# m1_3600_4920# vss n_w6_l0p28_f2
XSW1 a_2636_3816# m1_2702_4448# a_2636_3816# m1_2702_4448# m1_3342_4448# vss n_w6_l0p28_f2
XXRB3 m1_1822_4448# m1_1382_4448# vss r_w1_l13p39
XXRB2 m1_1382_4448# m1_942_4448# vss r_w1_l13p39
XSW3 a_3820_3816# m1_3600_4920# a_3820_3816# m1_3600_4920# m1_4328_3000# vss n_w6_l0p28_f2
XXRB4 m1_1970_3610# m1_1822_4448# vss r_w1_l13p39
XSW4 a_4412_3816# m1_4328_3000# a_4412_3816# m1_4328_3000# m1_4488_3600# vss n_w6_l0p28_f2
XSW5 a_5004_3816# m1_4488_3600# a_5004_3816# m1_4488_3600# vss vss n_w6_l0p28_f2
.ends

.subckt p_w0p8_l2 w_n374_n210# a_n288_n80# a_200_n80# a_n200_n124#
X0 a_200_n80# a_n200_n124# a_n288_n80# w_n374_n210# pfet_03v3 ad=0.352p pd=2.48u as=0.352p ps=2.48u w=0.8u l=2u
.ends

.subckt p_w4_l2_f4 w_n1130_n530# a_n956_n444# a_556_n444# a_n52_n400# a_452_n400#
+ a_n452_n444# a_n556_n400# a_52_n444# a_956_n400# a_n1044_n400#
X0 a_n556_n400# a_n956_n444# a_n1044_n400# w_n1130_n530# pfet_03v3 ad=1.04p pd=4.52u as=1.76p ps=8.88u w=4u l=2u
X1 a_n52_n400# a_n452_n444# a_n556_n400# w_n1130_n530# pfet_03v3 ad=1.04p pd=4.52u as=1.04p ps=4.52u w=4u l=2u
X2 a_452_n400# a_52_n444# a_n52_n400# w_n1130_n530# pfet_03v3 ad=1.04p pd=4.52u as=1.04p ps=4.52u w=4u l=2u
X3 a_956_n400# a_556_n444# a_452_n400# w_n1130_n530# pfet_03v3 ad=1.76p pd=8.88u as=1.04p ps=4.52u w=4u l=2u
.ends

.subckt p_w0p5_l10 a_n1088_n50# a_1000_n50# w_n1174_n180# a_n1000_n94#
X0 a_1000_n50# a_n1000_n94# a_n1088_n50# w_n1174_n180# pfet_03v3 ad=0.22p pd=1.88u as=0.22p ps=1.88u w=0.5u l=10u
.ends

.subckt n_w2_l2_f4 a_n52_n200# a_452_n200# a_n452_n244# a_n556_n200# a_52_n244# a_956_n200#
+ a_n1044_n200# a_n956_n244# a_556_n244# VSUBS
X0 a_452_n200# a_52_n244# a_n52_n200# VSUBS nfet_03v3 ad=0.52p pd=2.52u as=0.52p ps=2.52u w=2u l=2u
X1 a_956_n200# a_556_n244# a_452_n200# VSUBS nfet_03v3 ad=0.88p pd=4.88u as=0.52p ps=2.52u w=2u l=2u
X2 a_n556_n200# a_n956_n244# a_n1044_n200# VSUBS nfet_03v3 ad=0.52p pd=2.52u as=0.88p ps=4.88u w=2u l=2u
X3 a_n52_n200# a_n452_n244# a_n556_n200# VSUBS nfet_03v3 ad=0.52p pd=2.52u as=0.52p ps=2.52u w=2u l=2u
.ends

.subckt p_w4_l1_f4 a_252_n400# a_n556_n444# a_n644_n400# a_n252_n444# a_n356_n400#
+ a_n52_n400# a_356_n444# w_n730_n530# a_52_n444# a_556_n400#
X0 a_n356_n400# a_n556_n444# a_n644_n400# w_n730_n530# pfet_03v3 ad=1.04p pd=4.52u as=1.76p ps=8.88u w=4u l=1u
X1 a_556_n400# a_356_n444# a_252_n400# w_n730_n530# pfet_03v3 ad=1.76p pd=8.88u as=1.04p ps=4.52u w=4u l=1u
X2 a_n52_n400# a_n252_n444# a_n356_n400# w_n730_n530# pfet_03v3 ad=1.04p pd=4.52u as=1.04p ps=4.52u w=4u l=1u
X3 a_252_n400# a_52_n444# a_n52_n400# w_n730_n530# pfet_03v3 ad=1.04p pd=4.52u as=1.04p ps=4.52u w=4u l=1u
.ends

.subckt n_w4_l2_f2 a_n52_n400# a_452_n400# a_n452_n444# a_n540_n400# a_52_n444# VSUBS
X0 a_n52_n400# a_n452_n444# a_n540_n400# VSUBS nfet_03v3 ad=1.04p pd=4.52u as=1.76p ps=8.88u w=4u l=2u
X1 a_452_n400# a_52_n444# a_n52_n400# VSUBS nfet_03v3 ad=1.76p pd=8.88u as=1.04p ps=4.52u w=4u l=2u
.ends

.subckt p_w1_l0p5 a_n138_n100# a_50_n100# a_n50_n144# w_n224_n230#
X0 a_50_n100# a_n50_n144# a_n138_n100# w_n224_n230# pfet_03v3 ad=0.44p pd=2.88u as=0.44p ps=2.88u w=1u l=0.5u
.ends

.subckt p_w4_l2 w_n374_n530# a_n288_n400# a_200_n400# a_n200_n444#
X0 a_200_n400# a_n200_n444# a_n288_n400# w_n374_n530# pfet_03v3 ad=1.76p pd=8.88u as=1.76p ps=8.88u w=4u l=2u
.ends

.subckt n_w4_l2 a_n288_n400# a_200_n400# a_n200_n444# VSUBS
X0 a_200_n400# a_n200_n444# a_n288_n400# VSUBS nfet_03v3 ad=1.76p pd=8.88u as=1.76p ps=8.88u w=4u l=2u
.ends

.subckt p_w4_l1 a_n188_n400# a_100_n400# a_n100_n444# w_n274_n530#
X0 a_100_n400# a_n100_n444# a_n188_n400# w_n274_n530# pfet_03v3 ad=1.76p pd=8.88u as=1.76p ps=8.88u w=4u l=1u
.ends

.subckt r_w1_l14p19 a_n100_1419# a_n100_n1541# VSUBS
X0 a_n100_1419# a_n100_n1541# VSUBS ppolyf_u_1k r_width=1u r_length=14.19u
.ends

.subckt p_w0p5_l4 a_n488_n50# a_400_n50# a_n400_n94# w_n574_n180#
X0 a_400_n50# a_n400_n94# a_n488_n50# w_n574_n180# pfet_03v3 ad=0.22p pd=1.88u as=0.22p ps=1.88u w=0.5u l=4u
.ends

.subckt bias_vi en ib_x2 vbn_prb ib_r1 iint vglp vgln vdd el vreset_src vth_cmp vth_ref
+ vss
XPP vdd vdd vbn_prb a_864_6450# p_w0p8_l2
XMO vdd a_864_6450# a_864_6450# vdd m1_1276_6360# a_864_6450# m1_1276_6360# a_864_6450#
+ vdd vdd p_w4_l2_f4
XPS vdd m1_7102_850# vdd vgln p_w0p5_l10
XOR vss ib_r1 vbn_prb ib_r1 vbn_prb vss vss vbn_prb vbn_prb vss n_w2_l2_f4
XKO a_4976_1528# vglp m1_1276_6360# vglp a_4976_1528# m1_1276_6360# vglp vdd vglp
+ m1_1276_6360# p_w4_l1_f4
XMR vdd a_864_6450# a_864_6450# vdd m1_5388_6960# a_864_6450# m1_5388_6960# a_864_6450#
+ vdd vdd p_w4_l2_f4
XP1 vdd a_2102_5152# a_2102_5152# vdd p_w2_l2
XNS vss m1_7102_850# a_5712_1328# m1_7102_850# a_5712_1328# vss n_w4_l2_f2
XPOFF vdd a_864_6450# en vdd p_w1_l0p5
XP2 vdd a_864_6450# a_2102_5152# vdd p_w2_l2
XMS2 vss en m1_8646_1098# vss n_w0p5_l1
XMS1 m1_8646_1098# m1_7102_850# a_864_6450# vss n_w0p5_l1
XNT vss m1_4894_1238# a_5712_1328# vss n_w2_l2
XMT vdd vdd m1_8332_7080# a_864_6450# p_w4_l2
XKR vreset_src vglp m1_5388_6960# vglp vreset_src m1_5388_6960# vglp vdd vglp m1_5388_6960#
+ p_w4_l1_f4
XN1 m1_4894_1238# a_864_6450# vglp vss n_w4_l2
XN2 m1_4894_1238# a_2102_5152# a_4976_1528# vss n_w4_l2
XKT m1_8332_7080# vth_ref vglp vdd p_w4_l1
XOX vss m1_7440_2050# vbn_prb m1_7440_2050# vbn_prb vss vss vbn_prb vbn_prb vss n_w2_l2_f4
XXR00 a_4976_1528# m1_502_738# vss r_w1_l14p19
XXR01 m1_502_738# m1_942_738# vss r_w1_l14p19
XXR03 m1_1382_738# vss vss r_w1_l14p19
XXR02 m1_942_738# m1_1382_738# vss r_w1_l14p19
XPB vdd a_5712_1328# a_864_6450# vdd p_w0p5_l4
XNB vss a_5712_1328# a_5712_1328# vss n_w2_l2
XMC vdd a_864_6450# a_864_6450# vdd m1_8042_6360# a_864_6450# m1_8042_6360# a_864_6450#
+ vdd vdd p_w4_l2_f4
XKC vth_cmp vglp m1_8042_6360# vglp vth_cmp m1_8042_6360# vglp vdd vglp m1_8042_6360#
+ p_w4_l1_f4
XME vdd a_864_6450# a_864_6450# vdd m1_4546_7560# a_864_6450# m1_4546_7560# a_864_6450#
+ vdd vdd p_w4_l2_f4
XPI vdd vdd iint a_864_6450# p_w0p8_l2
XSX2 m1_7440_2050# ib_r1 ib_x2 vss n_w4_l0p5
XKE el vglp m1_4546_7560# vglp el m1_4546_7560# vglp vdd vglp m1_4546_7560# p_w4_l1_f4
XDB vss vbn_prb vbn_prb vss n_w2_l2
.ends

.subckt bias_b1 vth_ref vreset_src ib_r1 ua0 vbn_leak vbn_ref vbp_syn vbp_st vbn_prb
+ el vth_cmp vbn_ax vbp_w ua0_stim_out r0_b0 r0_b1 r0_b2 r0_b3 r0_b4 r2_b0 r2_b1 r2_b2
+ r2_b3 r2_b4 r1_b0 r1_b1 r1_b2 r1_b3 r1_b4 i2_b0 i4_b0 i2_b1 i4_b1 i2_b2 i4_b2 i2_b3
+ i4_b3 i2_b4 i4_b4 i0_b0 i1_b0 i3_b0 i0_b1 i1_b1 i3_b1 i0_b2 i1_b2 i3_b2 i0_b3 i1_b3
+ i3_b3 i0_b4 i1_b4 i3_b4 v0_c0 v0_c1 v0_c2 v0_c3 v0_c4 v0_c5 bias_en ib_x2 ua0_s0
+ ua0_s1 ua0_stim ua0_int vdd vss
XXx0 vbn_leak vdd vss rx_n4
XXx1 vbn_ref vdd vss rx_n2
XXx2 vbp_syn vdd vss rx_p24
XXx3 vbn_ax vdd vss rx_n1
XXx4 vbp_w vdd vss rx_p05
XXg Xm/in_n Xr/vgln Xr/vsn Xi4/g Xi2/g Xm/in_p Xr/vglp Xr/vsp vdd Xi1/g Xi0/g Xi3/g
+ vss bias_ladder
XXi0 Xi0/g Xr/vsp i0_b0 i0_b1 i0_b2 i0_b3 i0_b4 vbn_leak vss Xr/vgln vdd vss idac_p
XXi1 Xi1/g Xr/vsp i1_b0 i1_b1 i1_b2 i1_b3 i1_b4 vbn_ref vss Xr/vgln vdd vss idac_p
XXm ua0 ua0_s0 ua0_s1 ua0_stim ua0_int bias_en Xm/in_n Xm/in_p vbp_st Xm/iint ua0_stim_out
+ Xr/en_b vdd vss bias_master
XXi2 Xi2/g Xr/vsn i2_b0 i2_b1 i2_b2 i2_b3 i2_b4 vbp_syn vdd Xr/vgln vdd vss idac_n
XXi3 Xi3/g Xr/vsp i3_b0 i3_b1 i3_b2 i3_b3 i3_b4 vbn_ax vss Xr/vgln vdd vss idac_p
XXxst vbp_st vdd vss rx_p05
XXi4 Xi4/g Xr/vsn i4_b0 i4_b1 i4_b2 i4_b3 i4_b4 vbp_w vdd Xr/vgln vdd vss idac_n
XXd0 r0_b0 r0_b1 r0_b2 r0_b3 r0_b4 vdd el vss vdacr_el
XXd1 r1_b0 r1_b1 r1_b2 r1_b3 r1_b4 vdd vreset_src vss vdacr_vr
XXr Xr/vsn Xr/vsp Xr/vgln Xr/vglp Xr/en_b vdd vss bias_rails
XXd2 r2_b0 r2_b1 r2_b2 r2_b3 r2_b4 vdd vth_cmp vss vdacr_vc
XXd3 v0_c0 v0_c1 v0_c2 v0_c3 v0_c4 v0_c5 vdd vth_ref vss vdacr_vt
XXvi bias_en ib_x2 vbn_prb ib_r1 Xm/iint Xr/vglp Xr/vgln vdd el vreset_src vth_cmp
+ vth_ref vss bias_vi
.ends
