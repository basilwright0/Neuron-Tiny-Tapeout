* NGSPICE file created from bias_ladder.ext - technology: gf180mcuD

.subckt p_w4_l2_f5 a_n304_n400# a_704_n400# a_n704_n444# a_n808_n400# a_304_n444#
+ a_n1208_n444# a_n1296_n400# a_1208_n400# w_n1382_n530# a_200_n400# a_808_n444# a_n200_n444#
X0 a_1208_n400# a_808_n444# a_704_n400# w_n1382_n530# pfet_03v3 ad=1.76p pd=8.88u as=1.04p ps=4.52u w=4u l=2u
X1 a_704_n400# a_304_n444# a_200_n400# w_n1382_n530# pfet_03v3 ad=1.04p pd=4.52u as=1.04p ps=4.52u w=4u l=2u
X2 a_n808_n400# a_n1208_n444# a_n1296_n400# w_n1382_n530# pfet_03v3 ad=1.04p pd=4.52u as=1.76p ps=8.88u w=4u l=2u
X3 a_n304_n400# a_n704_n444# a_n808_n400# w_n1382_n530# pfet_03v3 ad=1.04p pd=4.52u as=1.04p ps=4.52u w=4u l=2u
X4 a_200_n400# a_n200_n444# a_n304_n400# w_n1382_n530# pfet_03v3 ad=1.04p pd=4.52u as=1.04p ps=4.52u w=4u l=2u
.ends

.subckt p_w2_l1 a_100_n200# a_n100_n244# w_n274_n330# a_n188_n200#
X0 a_100_n200# a_n100_n244# a_n188_n200# w_n274_n330# pfet_03v3 ad=0.88p pd=4.88u as=0.88p ps=4.88u w=2u l=1u
.ends

.subckt n_w4_l2_f6 a_n956_n444# a_1060_n444# a_556_n444# a_n52_n400# a_n1548_n400#
+ a_n1060_n400# a_452_n400# a_n452_n444# a_n556_n400# a_n1460_n444# a_1460_n400# a_52_n444#
+ a_956_n400# VSUBS
X0 a_n556_n400# a_n956_n444# a_n1060_n400# VSUBS nfet_03v3 ad=1.04p pd=4.52u as=1.04p ps=4.52u w=4u l=2u
X1 a_n52_n400# a_n452_n444# a_n556_n400# VSUBS nfet_03v3 ad=1.04p pd=4.52u as=1.04p ps=4.52u w=4u l=2u
X2 a_452_n400# a_52_n444# a_n52_n400# VSUBS nfet_03v3 ad=1.04p pd=4.52u as=1.04p ps=4.52u w=4u l=2u
X3 a_n1060_n400# a_n1460_n444# a_n1548_n400# VSUBS nfet_03v3 ad=1.04p pd=4.52u as=1.76p ps=8.88u w=4u l=2u
X4 a_956_n400# a_556_n444# a_452_n400# VSUBS nfet_03v3 ad=1.04p pd=4.52u as=1.04p ps=4.52u w=4u l=2u
X5 a_1460_n400# a_1060_n444# a_956_n400# VSUBS nfet_03v3 ad=1.76p pd=8.88u as=1.04p ps=4.52u w=4u l=2u
.ends

.subckt n_w2_l2_f2 a_n52_n200# a_452_n200# a_n452_n244# a_n540_n200# a_52_n244# VSUBS
X0 a_452_n200# a_52_n244# a_n52_n200# VSUBS nfet_03v3 ad=0.88p pd=4.88u as=0.52p ps=2.52u w=2u l=2u
X1 a_n52_n200# a_n452_n244# a_n540_n200# VSUBS nfet_03v3 ad=0.52p pd=2.52u as=0.88p ps=4.88u w=2u l=2u
.ends

.subckt n_w2_l1 a_100_n200# a_n100_n244# a_n188_n200# VSUBS
X0 a_100_n200# a_n100_n244# a_n188_n200# VSUBS nfet_03v3 ad=0.88p pd=4.88u as=0.88p ps=4.88u w=2u l=1u
.ends

.subckt p_w2_l2_f8 a_n52_n200# a_n1060_n200# a_452_n200# a_1564_n244# a_n452_n244#
+ w_n2138_n330# a_n556_n200# a_n1460_n244# a_1460_n200# a_52_n244# a_n1564_n200# a_956_n200#
+ a_n2052_n200# a_n956_n244# a_1060_n244# a_n1964_n244# a_556_n244# a_1964_n200#
X0 a_1964_n200# a_1564_n244# a_1460_n200# w_n2138_n330# pfet_03v3 ad=0.88p pd=4.88u as=0.52p ps=2.52u w=2u l=2u
X1 a_452_n200# a_52_n244# a_n52_n200# w_n2138_n330# pfet_03v3 ad=0.52p pd=2.52u as=0.52p ps=2.52u w=2u l=2u
X2 a_956_n200# a_556_n244# a_452_n200# w_n2138_n330# pfet_03v3 ad=0.52p pd=2.52u as=0.52p ps=2.52u w=2u l=2u
X3 a_1460_n200# a_1060_n244# a_956_n200# w_n2138_n330# pfet_03v3 ad=0.52p pd=2.52u as=0.52p ps=2.52u w=2u l=2u
X4 a_n1564_n200# a_n1964_n244# a_n2052_n200# w_n2138_n330# pfet_03v3 ad=0.52p pd=2.52u as=0.88p ps=4.88u w=2u l=2u
X5 a_n1060_n200# a_n1460_n244# a_n1564_n200# w_n2138_n330# pfet_03v3 ad=0.52p pd=2.52u as=0.52p ps=2.52u w=2u l=2u
X6 a_n556_n200# a_n956_n244# a_n1060_n200# w_n2138_n330# pfet_03v3 ad=0.52p pd=2.52u as=0.52p ps=2.52u w=2u l=2u
X7 a_n52_n200# a_n452_n244# a_n556_n200# w_n2138_n330# pfet_03v3 ad=0.52p pd=2.52u as=0.52p ps=2.52u w=2u l=2u
.ends

.subckt n_w2_l2_f8 a_n52_n200# a_n1060_n200# a_452_n200# a_1564_n244# a_n452_n244#
+ a_n556_n200# a_n1460_n244# a_1460_n200# a_52_n244# a_n1564_n200# a_956_n200# a_n2052_n200#
+ a_n956_n244# a_1060_n244# a_n1964_n244# a_556_n244# a_1964_n200# VSUBS
X0 a_1964_n200# a_1564_n244# a_1460_n200# VSUBS nfet_03v3 ad=0.88p pd=4.88u as=0.52p ps=2.52u w=2u l=2u
X1 a_452_n200# a_52_n244# a_n52_n200# VSUBS nfet_03v3 ad=0.52p pd=2.52u as=0.52p ps=2.52u w=2u l=2u
X2 a_956_n200# a_556_n244# a_452_n200# VSUBS nfet_03v3 ad=0.52p pd=2.52u as=0.52p ps=2.52u w=2u l=2u
X3 a_1460_n200# a_1060_n244# a_956_n200# VSUBS nfet_03v3 ad=0.52p pd=2.52u as=0.52p ps=2.52u w=2u l=2u
X4 a_n1564_n200# a_n1964_n244# a_n2052_n200# VSUBS nfet_03v3 ad=0.52p pd=2.52u as=0.88p ps=4.88u w=2u l=2u
X5 a_n1060_n200# a_n1460_n244# a_n1564_n200# VSUBS nfet_03v3 ad=0.52p pd=2.52u as=0.52p ps=2.52u w=2u l=2u
X6 a_n556_n200# a_n956_n244# a_n1060_n200# VSUBS nfet_03v3 ad=0.52p pd=2.52u as=0.52p ps=2.52u w=2u l=2u
X7 a_n52_n200# a_n452_n244# a_n556_n200# VSUBS nfet_03v3 ad=0.52p pd=2.52u as=0.52p ps=2.52u w=2u l=2u
.ends

.subckt p_w2_l2 a_n288_n200# a_200_n200# a_n200_n244# w_n374_n330#
X0 a_200_n200# a_n200_n244# a_n288_n200# w_n374_n330# pfet_03v3 ad=0.88p pd=4.88u as=0.88p ps=4.88u w=2u l=2u
.ends

.subckt n_w2_l2 a_n288_n200# a_200_n200# a_n200_n244# VSUBS
X0 a_200_n200# a_n200_n244# a_n288_n200# VSUBS nfet_03v3 ad=0.88p pd=4.88u as=0.88p ps=4.88u w=2u l=2u
.ends

.subckt p_w2_l2_f2 a_n52_n200# a_452_n200# a_n452_n244# a_n540_n200# w_n626_n330#
+ a_52_n244#
X0 a_452_n200# a_52_n244# a_n52_n200# w_n626_n330# pfet_03v3 ad=0.88p pd=4.88u as=0.52p ps=2.52u w=2u l=2u
X1 a_n52_n200# a_n452_n244# a_n540_n200# w_n626_n330# pfet_03v3 ad=0.52p pd=2.52u as=0.88p ps=4.88u w=2u l=2u
.ends

.subckt bias_ladder in_n vgln vsn vgn3 vgn5 in_p vglp vsp vdd vgp3 vgp5 vgp6 vss
XnpSE m1_3898_9610# m1_4906_9490# vglp m1_3666_9610# vglp vglp in_p m1_6020_10200#
+ vdd m1_5022_10210# vglp vglp p_w4_l2_f5
XFP3 vgp3 a_1580_5314# vgp3 vss p_w2_l1
XnnSE vgln vgln vgln m1_4760_1320# in_n m1_3298_2050# m1_4538_1930# vgln m1_3530_1930#
+ vgln m1_6282_1450# vgln m1_5516_1920# vss n_w4_l2_f6
XnnSH6T m1_6282_1450# vdd vgln a_7580_5314# vgln vss n_w2_l2_f2
XFP5 vgp5 a_4580_5314# vgp5 vss p_w2_l1
XFN3 vgn3 a_3036_4156# vdd vss n_w2_l1
XDP3 vsp vsp a_1580_5314# vgp3 vgp3 vdd a_1580_5314# vgp3 a_1580_5314# vgp3 a_1580_5314#
+ vsp vsp vgp3 vgp3 vgp3 vgp3 vsp p_w2_l2_f8
XFP6 vgp6 a_7580_5314# vgp6 vss p_w2_l1
XFN5 vgn5 a_5188_4156# vdd vss n_w2_l1
XDP5 vsp vsp a_4580_5314# vgp5 vgp5 vdd a_4580_5314# vgp5 a_4580_5314# vgp5 a_4580_5314#
+ vsp vsp vgp5 vgp5 vgp5 vgp5 vsp p_w2_l2_f8
XDN3 vsn vsn a_3036_4156# vgn3 vgn3 a_3036_4156# vgn3 a_3036_4156# vgn3 a_3036_4156#
+ vsn vsn vgn3 vgn3 vgn3 vgn3 vsn vss n_w2_l2_f8
XDP6 vsp vsp a_7580_5314# vgp6 vgp6 vdd a_7580_5314# vgp6 a_7580_5314# vgp6 a_7580_5314#
+ vsp vsp vgp6 vgp6 vgp6 vgp6 vsp p_w2_l2_f8
XBP3 vsp vgp3 vgp6 vdd p_w2_l2
XDN5 vsn vsn a_5188_4156# vgn5 vgn5 a_5188_4156# vgn5 a_5188_4156# vgn5 a_5188_4156#
+ vsn vsn vgn5 vgn5 vgn5 vgn5 vsn vss n_w2_l2_f8
XBP5 vsp vgp5 vgp6 vdd p_w2_l2
XBN3 vgn3 vsn vgn5 vss n_w2_l2
XnnSH01 vdd m1_3298_2050# vgln in_n vgln vss n_w2_l2_f2
XBP6 vsp vgp6 vgp6 vdd p_w2_l2
XnnSH24 vdd m1_4538_1930# vgln m1_3530_1930# vgln vss n_w2_l2_f2
XBN5 vgn5 vsn vgn5 vss n_w2_l2
XnpSH3 m1_5022_10210# a_3036_4156# vglp vdd p_w2_l2
XnpSH5T m1_6020_10200# vss vglp a_5188_4156# vdd vglp p_w2_l2_f2
XnpSH01 vss m1_3666_9610# vglp in_p vdd vglp p_w2_l2_f2
XnpSH24 vss m1_4906_9490# vglp m1_3898_9610# vdd vglp p_w2_l2_f2
XnnSH3 m1_4760_1320# a_1580_5314# vgln vss n_w2_l2
XnnSH5 m1_5516_1920# a_4580_5314# vgln vss n_w2_l2
.ends
