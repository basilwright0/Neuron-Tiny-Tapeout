* NGSPICE file created from vdacr_el.ext - technology: gf180mcuD

.subckt r_w1_l7p765 a_n100_n899# a_n100_777# VSUBS
X0 a_n100_777# a_n100_n899# VSUBS ppolyf_u_1k r_width=1u r_length=7.77u
C0 a_n100_n899# VSUBS 0.27003f
C1 a_n100_777# VSUBS 0.27003f
.ends

.subckt r_w2_l1p97 a_n200_n319# a_n200_197# VSUBS
X0 a_n200_197# a_n200_n319# VSUBS ppolyf_u_1k r_width=2u r_length=1.97u
C0 a_n200_n319# a_n200_197# 0.02096f
C1 a_n200_n319# VSUBS 0.42971f
C2 a_n200_197# VSUBS 0.42971f
.ends

.subckt r_w1_l1p94 a_n100_n316# a_n100_194# VSUBS
X0 a_n100_194# a_n100_n316# VSUBS ppolyf_u_1k r_width=1u r_length=1.94u
C0 a_n100_n316# a_n100_194# 0.01052f
C1 a_n100_n316# VSUBS 0.2541f
C2 a_n100_194# VSUBS 0.2541f
.ends

.subckt r_w1_l3p88 a_n100_n510# a_n100_388# VSUBS
X0 a_n100_388# a_n100_n510# VSUBS ppolyf_u_1k r_width=1u r_length=3.88u
C0 a_n100_n510# a_n100_388# 0.00535f
C1 a_n100_n510# VSUBS 0.26053f
C2 a_n100_388# VSUBS 0.26053f
.ends

.subckt n_w0p5_l0p28 a_n28_n94# a_n116_n50# a_28_n50# VSUBS
X0 a_28_n50# a_n28_n94# a_n116_n50# VSUBS nfet_03v3 ad=0.22p pd=1.88u as=0.22p ps=1.88u w=0.5u l=0.28u
C0 a_28_n50# a_n116_n50# 0.02085f
C1 a_n28_n94# a_n116_n50# 0.00377f
C2 a_28_n50# a_n28_n94# 0.00377f
C3 a_28_n50# VSUBS 0.07987f
C4 a_n116_n50# VSUBS 0.07987f
.ends

.subckt p_w1_l0p28 w_n202_n230# a_28_n100# a_n28_n144# a_n116_n100# VSUBS
X0 a_28_n100# a_n28_n144# a_n116_n100# w_n202_n230# pfet_03v3 ad=0.44p pd=2.88u as=0.44p ps=2.88u w=1u l=0.28u
C0 a_n116_n100# a_n28_n144# 0.00769f
C1 w_n202_n230# a_n28_n144# 0.05841f
C2 a_n116_n100# a_28_n100# 0.04256f
C3 a_28_n100# w_n202_n230# 0.01808f
C4 a_n116_n100# w_n202_n230# 0.01808f
C5 a_28_n100# a_n28_n144# 0.00769f
C6 a_28_n100# VSUBS 0.0597f
C7 a_n116_n100# VSUBS 0.0597f
C8 w_n202_n230# VSUBS 0.55752f
.ends

.subckt r_w1_l11p645 a_n100_1165# a_n100_n1287# VSUBS
X0 a_n100_1165# a_n100_n1287# VSUBS ppolyf_u_1k r_width=1u r_length=11.65u
C0 a_n100_n1287# VSUBS 0.27003f
C1 a_n100_1165# VSUBS 0.27003f
.ends

.subckt n_w4_l0p28_f2 a_n52_n400# a_52_n444# a_108_n400# a_n108_n444# a_n196_n400#
+ VSUBS
X0 a_108_n400# a_52_n444# a_n52_n400# VSUBS nfet_03v3 ad=1.76p pd=8.88u as=1.04p ps=4.52u w=4u l=0.28u
X1 a_n52_n400# a_n108_n444# a_n196_n400# VSUBS nfet_03v3 ad=1.04p pd=4.52u as=1.76p ps=8.88u w=4u l=0.28u
C0 a_n108_n444# a_52_n444# 0.00519f
C1 a_n52_n400# a_108_n400# 0.17284f
C2 a_n196_n400# a_n52_n400# 0.17284f
C3 a_n52_n400# a_n108_n444# 0.03125f
C4 a_n196_n400# a_n108_n444# 0.03125f
C5 a_108_n400# a_52_n444# 0.03125f
C6 a_n52_n400# a_52_n444# 0.03125f
C7 a_108_n400# VSUBS 0.20946f
C8 a_n52_n400# VSUBS 0.09458f
C9 a_n196_n400# VSUBS 0.20946f
.ends

.subckt vdacr_el b0 b1 b2 b3 b4 vdd out vss
XXRS4_0 m1_4222_4048# m1_3782_4048# vss r_w1_l7p765
XXRS4_1 vss m1_4222_4048# vss r_w1_l7p765
XXRS0 m1_2262_4048# m1_1822_4048# vss r_w2_l1p97
XXRS1 m1_2910_2890# m1_2262_4048# vss r_w1_l1p94
XXRS3 m1_3782_4048# m1_3342_4048# vss r_w1_l7p765
XXRS2 m1_3342_4048# m1_2910_2890# vss r_w1_l3p88
XIB4n b4 vss a_4168_3416# vss n_w0p5_l0p28
XIB3n b3 vss a_3576_3416# vss n_w0p5_l0p28
XIB4p vdd a_4168_3416# b4 vdd vss p_w1_l0p28
XIB2n b2 vss a_2984_3416# vss n_w0p5_l0p28
XIB3p vdd a_3576_3416# b3 vdd vss p_w1_l0p28
XIB2p vdd a_2984_3416# b2 vdd vss p_w1_l0p28
XIB1n b1 vss a_2392_3416# vss n_w0p5_l0p28
XIB0n b0 vss a_1800_3416# vss n_w0p5_l0p28
XIB1p vdd a_2392_3416# b1 vdd vss p_w1_l0p28
XIB0p vdd a_1800_3416# b0 vdd vss p_w1_l0p28
XXRB0 out m1_502_4048# vss r_w1_l11p645
XSW0 m1_2262_4048# a_1800_3416# m1_1822_4048# a_1800_3416# m1_1822_4048# vss n_w4_l0p28_f2
XXRB1 m1_502_4048# m1_942_4048# vss r_w1_l11p645
XSW2 m1_3342_4048# a_2984_3416# m1_2910_2890# a_2984_3416# m1_2910_2890# vss n_w4_l0p28_f2
XSW1 m1_2910_2890# a_2392_3416# m1_2262_4048# a_2392_3416# m1_2262_4048# vss n_w4_l0p28_f2
XXRB3 m1_1382_4048# m1_1822_4048# vss r_w1_l11p645
XXRB2 m1_942_4048# m1_1382_4048# vss r_w1_l11p645
XSW3 m1_3782_4048# a_3576_3416# m1_3342_4048# a_3576_3416# m1_3342_4048# vss n_w4_l0p28_f2
XSW4 vss a_4168_3416# m1_3782_4048# a_4168_3416# m1_3782_4048# vss n_w4_l0p28_f2
C0 vdd b0 0.67591f
C1 a_3576_3416# m1_2910_2890# 0.04048f
C2 m1_2910_2890# b2 0.01222f
C3 m1_3342_4048# m1_2910_2890# 0.65586f
C4 a_2392_3416# m1_1822_4048# 0.01627f
C5 m1_1382_4048# m1_1822_4048# 0.0409f
C6 m1_2262_4048# a_2984_3416# 0.0501f
C7 b4 a_3576_3416# 0.02041f
C8 a_1800_3416# m1_3342_4048# 0
C9 a_4168_3416# b3 0
C10 m1_2262_4048# b2 0
C11 m1_2262_4048# m1_3342_4048# 0.01354f
C12 m1_942_4048# m1_2910_2890# 0
C13 m1_3342_4048# m1_4222_4048# 0.05545f
C14 a_2392_3416# b1 0.07642f
C15 a_1800_3416# m1_942_4048# 0.00153f
C16 m1_502_4048# m1_1822_4048# 0
C17 a_4168_3416# m1_3782_4048# 0.1115f
C18 m1_3782_4048# m1_1822_4048# 0
C19 m1_2262_4048# m1_942_4048# 0
C20 a_2984_3416# vdd 0.24605f
C21 a_2392_3416# m1_2910_2890# 0.13412f
C22 m1_1382_4048# m1_2910_2890# 0
C23 vdd a_3576_3416# 0.31209f
C24 vdd b2 0.64084f
C25 a_1800_3416# a_2392_3416# 0.02129f
C26 a_1800_3416# m1_1382_4048# 0.00297f
C27 m1_3342_4048# vdd 0.00115f
C28 a_2392_3416# m1_2262_4048# 0.2705f
C29 m1_2262_4048# m1_1382_4048# 0.00298f
C30 b4 b3 0.03027f
C31 m1_3782_4048# m1_2910_2890# 0.04612f
C32 out m1_942_4048# 0.02271f
C33 a_2984_3416# a_3576_3416# 0.04709f
C34 a_2392_3416# b0 0
C35 a_2984_3416# b2 0.13154f
C36 m1_1822_4048# b1 0.00658f
C37 m1_3342_4048# a_2984_3416# 0.10532f
C38 m1_3782_4048# b4 0.00138f
C39 a_3576_3416# b2 0
C40 m1_3342_4048# a_3576_3416# 0.26129f
C41 a_2392_3416# vdd 0.24765f
C42 m1_2262_4048# m1_3782_4048# 0
C43 m1_3342_4048# b2 0.00104f
C44 m1_3782_4048# m1_4222_4048# 0.1056f
C45 a_4168_3416# m1_2910_2890# 0
C46 out m1_1382_4048# 0.05753f
C47 m1_1822_4048# m1_2910_2890# 0.06674f
C48 vdd b3 0.55376f
C49 a_1800_3416# m1_1822_4048# 0.13186f
C50 a_4168_3416# b4 0.16899f
C51 m1_2262_4048# m1_1822_4048# 0.27563f
C52 a_4168_3416# m1_4222_4048# 0.0024f
C53 m1_3782_4048# vdd 0.01051f
C54 out m1_502_4048# 0.07712f
C55 a_2392_3416# a_2984_3416# 0.09045f
C56 a_1800_3416# b1 0.05439f
C57 a_2392_3416# a_3576_3416# 0
C58 a_2392_3416# b2 0.07961f
C59 a_2392_3416# m1_3342_4048# 0
C60 m1_2262_4048# b1 0.02099f
C61 a_2984_3416# b3 0.0833f
C62 a_3576_3416# b3 0.13611f
C63 a_1800_3416# m1_2910_2890# 0.00164f
C64 a_4168_3416# vdd 0.27741f
C65 b2 b3 0.02937f
C66 vdd m1_1822_4048# 0.00212f
C67 m1_3342_4048# b3 0
C68 m1_2262_4048# m1_2910_2890# 0.54801f
C69 a_2984_3416# m1_3782_4048# 0
C70 m1_942_4048# m1_1382_4048# 0.46167f
C71 m1_4222_4048# m1_2910_2890# 0
C72 b0 b1 0.02689f
C73 a_1800_3416# m1_2262_4048# 0.06726f
C74 m1_3782_4048# a_3576_3416# 0.26629f
C75 m1_3342_4048# m1_3782_4048# 0.45403f
C76 vdd b1 0.64191f
C77 m1_2262_4048# m1_4222_4048# 0
C78 m1_502_4048# m1_942_4048# 0.13288f
C79 a_2984_3416# m1_1822_4048# 0
C80 a_1800_3416# b0 0.12038f
C81 a_4168_3416# a_3576_3416# 0.0465f
C82 vdd m1_2910_2890# 0.00167f
C83 a_2392_3416# b3 0
C84 m1_3342_4048# a_4168_3416# 0.01309f
C85 a_1800_3416# vdd 0.25095f
C86 m1_3342_4048# m1_1822_4048# 0
C87 vdd b4 0.89363f
C88 m1_2262_4048# vdd 0.01352f
C89 m1_502_4048# m1_1382_4048# 0
C90 b1 b2 0.0339f
C91 m1_942_4048# m1_1822_4048# 0
C92 a_2984_3416# m1_2910_2890# 0.29577f
C93 m1_3782_4048# b3 0.01236f
C94 m1_3782_4048# vss 1.0631f
C95 m1_1382_4048# vss 0.51707f
C96 m1_2910_2890# vss 0.62471f
C97 m1_3342_4048# vss 0.82318f
C98 m1_942_4048# vss 0.312f
C99 m1_2262_4048# vss 0.3151f
C100 m1_1822_4048# vss 0.51958f
C101 m1_502_4048# vss 0.76255f
C102 out vss 0.79155f
C103 a_1800_3416# vss 0.67571f
C104 b0 vss 0.65661f
C105 vdd vss 16.0906f
C106 a_2392_3416# vss 0.49566f
C107 b1 vss 0.50158f
C108 a_2984_3416# vss 0.41143f
C109 b2 vss 0.3841f
C110 a_3576_3416# vss 0.54929f
C111 b3 vss 0.52144f
C112 a_4168_3416# vss 1.11357f
C113 b4 vss 0.61886f
C114 m1_4222_4048# vss 0.57091f
.ends
