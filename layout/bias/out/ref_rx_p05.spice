.subckt rx_p05 line vdd vss
XD0 line line vdd vdd pfet_03v3 W=1u L=4u
.ends rx_p05
