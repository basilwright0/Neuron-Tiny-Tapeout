.subckt idac_n out dump b0 b1 b2 b3 b4 g vsn vcas vdd vss
XU0_0 d0 g vsn vss nfet_03v3 W=2u L=2u
XIC0p bd0 b0 vcas vcas pfet_03v3 W=1u L=0.28u
XIC0n bd0 b0 vss vss nfet_03v3 W=0.5u L=0.28u
XID0p bc0 bd0 vcas vcas pfet_03v3 W=1u L=0.28u
XID0n bc0 bd0 vss vss nfet_03v3 W=0.5u L=0.28u
XSO0 out bc0 d0 vss nfet_03v3 W=0.5u L=0.5u
XSD0 dump bd0 d0 vss nfet_03v3 W=0.5u L=0.5u
XU1_0 d1 g vsn vss nfet_03v3 W=2u L=2u
XU1_1 d1 g vsn vss nfet_03v3 W=2u L=2u
XIC1p bd1 b1 vcas vcas pfet_03v3 W=1u L=0.28u
XIC1n bd1 b1 vss vss nfet_03v3 W=0.5u L=0.28u
XID1p bc1 bd1 vcas vcas pfet_03v3 W=1u L=0.28u
XID1n bc1 bd1 vss vss nfet_03v3 W=0.5u L=0.28u
XSO1 out bc1 d1 vss nfet_03v3 W=0.5u L=0.5u
XSD1 dump bd1 d1 vss nfet_03v3 W=0.5u L=0.5u
XU2_0 d2 g vsn vss nfet_03v3 W=2u L=2u
XU2_1 d2 g vsn vss nfet_03v3 W=2u L=2u
XU2_2 d2 g vsn vss nfet_03v3 W=2u L=2u
XU2_3 d2 g vsn vss nfet_03v3 W=2u L=2u
XIC2p bd2 b2 vcas vcas pfet_03v3 W=1u L=0.28u
XIC2n bd2 b2 vss vss nfet_03v3 W=0.5u L=0.28u
XID2p bc2 bd2 vcas vcas pfet_03v3 W=1u L=0.28u
XID2n bc2 bd2 vss vss nfet_03v3 W=0.5u L=0.28u
XSO2 out bc2 d2 vss nfet_03v3 W=0.5u L=0.5u
XSD2 dump bd2 d2 vss nfet_03v3 W=0.5u L=0.5u
XU3_0 d3 g vsn vss nfet_03v3 W=2u L=2u
XU3_1 d3 g vsn vss nfet_03v3 W=2u L=2u
XU3_2 d3 g vsn vss nfet_03v3 W=2u L=2u
XU3_3 d3 g vsn vss nfet_03v3 W=2u L=2u
XU3_4 d3 g vsn vss nfet_03v3 W=2u L=2u
XU3_5 d3 g vsn vss nfet_03v3 W=2u L=2u
XU3_6 d3 g vsn vss nfet_03v3 W=2u L=2u
XU3_7 d3 g vsn vss nfet_03v3 W=2u L=2u
XIC3p bd3 b3 vcas vcas pfet_03v3 W=1u L=0.28u
XIC3n bd3 b3 vss vss nfet_03v3 W=0.5u L=0.28u
XID3p bc3 bd3 vcas vcas pfet_03v3 W=1u L=0.28u
XID3n bc3 bd3 vss vss nfet_03v3 W=0.5u L=0.28u
XSO3 out bc3 d3 vss nfet_03v3 W=0.5u L=0.5u
XSD3 dump bd3 d3 vss nfet_03v3 W=0.5u L=0.5u
XU4_0 d4 g vsn vss nfet_03v3 W=2u L=2u
XU4_1 d4 g vsn vss nfet_03v3 W=2u L=2u
XU4_2 d4 g vsn vss nfet_03v3 W=2u L=2u
XU4_3 d4 g vsn vss nfet_03v3 W=2u L=2u
XU4_4 d4 g vsn vss nfet_03v3 W=2u L=2u
XU4_5 d4 g vsn vss nfet_03v3 W=2u L=2u
XU4_6 d4 g vsn vss nfet_03v3 W=2u L=2u
XU4_7 d4 g vsn vss nfet_03v3 W=2u L=2u
XU4_8 d4 g vsn vss nfet_03v3 W=2u L=2u
XU4_9 d4 g vsn vss nfet_03v3 W=2u L=2u
XU4_10 d4 g vsn vss nfet_03v3 W=2u L=2u
XU4_11 d4 g vsn vss nfet_03v3 W=2u L=2u
XU4_12 d4 g vsn vss nfet_03v3 W=2u L=2u
XU4_13 d4 g vsn vss nfet_03v3 W=2u L=2u
XU4_14 d4 g vsn vss nfet_03v3 W=2u L=2u
XU4_15 d4 g vsn vss nfet_03v3 W=2u L=2u
XIC4p bd4 b4 vcas vcas pfet_03v3 W=1u L=0.28u
XIC4n bd4 b4 vss vss nfet_03v3 W=0.5u L=0.28u
XID4p bc4 bd4 vcas vcas pfet_03v3 W=1u L=0.28u
XID4n bc4 bd4 vss vss nfet_03v3 W=0.5u L=0.28u
XSO4 out bc4 d4 vss nfet_03v3 W=0.5u L=0.5u
XSD4 dump bd4 d4 vss nfet_03v3 W=0.5u L=0.5u
.ends idac_n
