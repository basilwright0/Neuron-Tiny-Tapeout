.subckt idac_p out dump b0 b1 b2 b3 b4 g vsp vcas vdd vss
XU0_0 d0 g vsp vdd pfet_03v3 W=2u L=2u
XIC0p bc0 b0 vdd vdd pfet_03v3 W=1u L=0.28u
XIC0n bc0 b0 vcas vss nfet_03v3 W=0.5u L=0.28u
XID0p bd0 bc0 vdd vdd pfet_03v3 W=1u L=0.28u
XID0n bd0 bc0 vcas vss nfet_03v3 W=0.5u L=0.28u
XSO0 out bc0 d0 vdd pfet_03v3 W=0.5u L=0.5u
XSD0 dump bd0 d0 vdd pfet_03v3 W=0.5u L=0.5u
XU1_0 d1 g vsp vdd pfet_03v3 W=2u L=2u
XU1_1 d1 g vsp vdd pfet_03v3 W=2u L=2u
XIC1p bc1 b1 vdd vdd pfet_03v3 W=1u L=0.28u
XIC1n bc1 b1 vcas vss nfet_03v3 W=0.5u L=0.28u
XID1p bd1 bc1 vdd vdd pfet_03v3 W=1u L=0.28u
XID1n bd1 bc1 vcas vss nfet_03v3 W=0.5u L=0.28u
XSO1 out bc1 d1 vdd pfet_03v3 W=0.5u L=0.5u
XSD1 dump bd1 d1 vdd pfet_03v3 W=0.5u L=0.5u
XU2_0 d2 g vsp vdd pfet_03v3 W=2u L=2u
XU2_1 d2 g vsp vdd pfet_03v3 W=2u L=2u
XU2_2 d2 g vsp vdd pfet_03v3 W=2u L=2u
XU2_3 d2 g vsp vdd pfet_03v3 W=2u L=2u
XIC2p bc2 b2 vdd vdd pfet_03v3 W=1u L=0.28u
XIC2n bc2 b2 vcas vss nfet_03v3 W=0.5u L=0.28u
XID2p bd2 bc2 vdd vdd pfet_03v3 W=1u L=0.28u
XID2n bd2 bc2 vcas vss nfet_03v3 W=0.5u L=0.28u
XSO2 out bc2 d2 vdd pfet_03v3 W=0.5u L=0.5u
XSD2 dump bd2 d2 vdd pfet_03v3 W=0.5u L=0.5u
XU3_0 d3 g vsp vdd pfet_03v3 W=2u L=2u
XU3_1 d3 g vsp vdd pfet_03v3 W=2u L=2u
XU3_2 d3 g vsp vdd pfet_03v3 W=2u L=2u
XU3_3 d3 g vsp vdd pfet_03v3 W=2u L=2u
XU3_4 d3 g vsp vdd pfet_03v3 W=2u L=2u
XU3_5 d3 g vsp vdd pfet_03v3 W=2u L=2u
XU3_6 d3 g vsp vdd pfet_03v3 W=2u L=2u
XU3_7 d3 g vsp vdd pfet_03v3 W=2u L=2u
XIC3p bc3 b3 vdd vdd pfet_03v3 W=1u L=0.28u
XIC3n bc3 b3 vcas vss nfet_03v3 W=0.5u L=0.28u
XID3p bd3 bc3 vdd vdd pfet_03v3 W=1u L=0.28u
XID3n bd3 bc3 vcas vss nfet_03v3 W=0.5u L=0.28u
XSO3 out bc3 d3 vdd pfet_03v3 W=0.5u L=0.5u
XSD3 dump bd3 d3 vdd pfet_03v3 W=0.5u L=0.5u
XU4_0 d4 g vsp vdd pfet_03v3 W=2u L=2u
XU4_1 d4 g vsp vdd pfet_03v3 W=2u L=2u
XU4_2 d4 g vsp vdd pfet_03v3 W=2u L=2u
XU4_3 d4 g vsp vdd pfet_03v3 W=2u L=2u
XU4_4 d4 g vsp vdd pfet_03v3 W=2u L=2u
XU4_5 d4 g vsp vdd pfet_03v3 W=2u L=2u
XU4_6 d4 g vsp vdd pfet_03v3 W=2u L=2u
XU4_7 d4 g vsp vdd pfet_03v3 W=2u L=2u
XU4_8 d4 g vsp vdd pfet_03v3 W=2u L=2u
XU4_9 d4 g vsp vdd pfet_03v3 W=2u L=2u
XU4_10 d4 g vsp vdd pfet_03v3 W=2u L=2u
XU4_11 d4 g vsp vdd pfet_03v3 W=2u L=2u
XU4_12 d4 g vsp vdd pfet_03v3 W=2u L=2u
XU4_13 d4 g vsp vdd pfet_03v3 W=2u L=2u
XU4_14 d4 g vsp vdd pfet_03v3 W=2u L=2u
XU4_15 d4 g vsp vdd pfet_03v3 W=2u L=2u
XIC4p bc4 b4 vdd vdd pfet_03v3 W=1u L=0.28u
XIC4n bc4 b4 vcas vss nfet_03v3 W=0.5u L=0.28u
XID4p bd4 bc4 vdd vdd pfet_03v3 W=1u L=0.28u
XID4n bd4 bc4 vcas vss nfet_03v3 W=0.5u L=0.28u
XSO4 out bc4 d4 vdd pfet_03v3 W=0.5u L=0.5u
XSD4 dump bd4 d4 vdd pfet_03v3 W=0.5u L=0.5u
.ends idac_p
