* NGSPICE file created from idac_n.ext - technology: gf180mcuD

.subckt n_w2_l2_f8 a_n52_n200# a_n1060_n200# a_452_n200# a_1564_n244# a_n452_n244#
+ a_n556_n200# a_n1460_n244# a_1460_n200# a_52_n244# a_n1564_n200# a_956_n200# a_n2052_n200#
+ a_n956_n244# a_1060_n244# a_n1964_n244# a_556_n244# a_1964_n200# VSUBS
X0 a_1964_n200# a_1564_n244# a_1460_n200# VSUBS nfet_03v3 ad=0.88p pd=4.88u as=0.52p ps=2.52u w=2u l=2u
X1 a_452_n200# a_52_n244# a_n52_n200# VSUBS nfet_03v3 ad=0.52p pd=2.52u as=0.52p ps=2.52u w=2u l=2u
X2 a_956_n200# a_556_n244# a_452_n200# VSUBS nfet_03v3 ad=0.52p pd=2.52u as=0.52p ps=2.52u w=2u l=2u
X3 a_1460_n200# a_1060_n244# a_956_n200# VSUBS nfet_03v3 ad=0.52p pd=2.52u as=0.52p ps=2.52u w=2u l=2u
X4 a_n1564_n200# a_n1964_n244# a_n2052_n200# VSUBS nfet_03v3 ad=0.52p pd=2.52u as=0.88p ps=4.88u w=2u l=2u
X5 a_n1060_n200# a_n1460_n244# a_n1564_n200# VSUBS nfet_03v3 ad=0.52p pd=2.52u as=0.52p ps=2.52u w=2u l=2u
X6 a_n556_n200# a_n956_n244# a_n1060_n200# VSUBS nfet_03v3 ad=0.52p pd=2.52u as=0.52p ps=2.52u w=2u l=2u
X7 a_n52_n200# a_n452_n244# a_n556_n200# VSUBS nfet_03v3 ad=0.52p pd=2.52u as=0.52p ps=2.52u w=2u l=2u
C0 a_n1964_n244# a_n1564_n200# 0.0587f
C1 a_n956_n244# a_n556_n200# 0.0587f
C2 a_n956_n244# a_n452_n244# 0.00519f
C3 a_n1460_n244# a_n1964_n244# 0.00519f
C4 a_1460_n200# a_1964_n200# 0.02133f
C5 a_452_n200# a_956_n200# 0.02133f
C6 a_n1460_n244# a_n956_n244# 0.00519f
C7 a_1060_n244# a_956_n200# 0.0587f
C8 a_n1060_n200# a_n556_n200# 0.02133f
C9 a_n1564_n200# a_n1060_n200# 0.02133f
C10 a_1060_n244# a_1564_n244# 0.00519f
C11 a_n52_n200# a_n556_n200# 0.02133f
C12 a_n52_n200# a_52_n244# 0.0587f
C13 a_n52_n200# a_n452_n244# 0.0587f
C14 a_n1460_n244# a_n1060_n200# 0.0587f
C15 a_n2052_n200# a_n1564_n200# 0.02133f
C16 a_n52_n200# a_452_n200# 0.02133f
C17 a_1460_n200# a_1060_n244# 0.0587f
C18 a_1460_n200# a_956_n200# 0.02133f
C19 a_n956_n244# a_n1060_n200# 0.0587f
C20 a_556_n244# a_52_n244# 0.00519f
C21 a_1460_n200# a_1564_n244# 0.0587f
C22 a_n2052_n200# a_n1964_n244# 0.0587f
C23 a_556_n244# a_452_n200# 0.0587f
C24 a_n452_n244# a_n556_n200# 0.0587f
C25 a_n452_n244# a_52_n244# 0.00519f
C26 a_452_n200# a_52_n244# 0.0587f
C27 a_n1460_n244# a_n1564_n200# 0.0587f
C28 a_556_n244# a_1060_n244# 0.00519f
C29 a_556_n244# a_956_n200# 0.0587f
C30 a_1564_n244# a_1964_n200# 0.0587f
C31 a_1964_n200# VSUBS 0.26162f
C32 a_1460_n200# VSUBS 0.34773f
C33 a_956_n200# VSUBS 0.34265f
C34 a_452_n200# VSUBS 0.34265f
C35 a_n52_n200# VSUBS 0.34265f
C36 a_n556_n200# VSUBS 0.34265f
C37 a_n1060_n200# VSUBS 0.34265f
C38 a_n1564_n200# VSUBS 0.34773f
C39 a_n2052_n200# VSUBS 0.26162f
.ends

.subckt n_w0p5_l1_f2 a_n52_n50# a_52_n94# a_n340_n50# a_252_n50# a_n252_n94# VSUBS
X0 a_252_n50# a_52_n94# a_n52_n50# VSUBS nfet_03v3 ad=0.22p pd=1.88u as=0.13p ps=1.02u w=0.5u l=1u
X1 a_n52_n50# a_n252_n94# a_n340_n50# VSUBS nfet_03v3 ad=0.13p pd=1.02u as=0.22p ps=1.88u w=0.5u l=1u
C0 a_52_n94# a_252_n50# 0.01026f
C1 a_n52_n50# a_n252_n94# 0.01026f
C2 a_n340_n50# a_n52_n50# 0.00935f
C3 a_52_n94# a_n252_n94# 0.00519f
C4 a_252_n50# a_n52_n50# 0.00935f
C5 a_52_n94# a_n52_n50# 0.01026f
C6 a_n340_n50# a_n252_n94# 0.01026f
C7 a_252_n50# VSUBS 0.12884f
C8 a_n52_n50# VSUBS 0.20268f
C9 a_n340_n50# VSUBS 0.12884f
.ends

.subckt n_w0p5_l1 a_100_n50# a_n100_n94# a_n188_n50# VSUBS
X0 a_100_n50# a_n100_n94# a_n188_n50# VSUBS nfet_03v3 ad=0.22p pd=1.88u as=0.22p ps=1.88u w=0.5u l=1u
C0 a_n188_n50# a_n100_n94# 0.01026f
C1 a_n188_n50# a_100_n50# 0.00935f
C2 a_100_n50# a_n100_n94# 0.01026f
C3 a_100_n50# VSUBS 0.13392f
C4 a_n188_n50# VSUBS 0.13392f
.ends

.subckt p_w1_l0p28_f2 a_n196_n100# a_n52_n100# w_n282_n230# a_108_n100# a_52_n144#
+ a_n108_n144# VSUBS
X0 a_n52_n100# a_n108_n144# a_n196_n100# w_n282_n230# pfet_03v3 ad=0.26p pd=1.52u as=0.44p ps=2.88u w=1u l=0.28u
X1 a_108_n100# a_52_n144# a_n52_n100# w_n282_n230# pfet_03v3 ad=0.44p pd=2.88u as=0.26p ps=1.52u w=1u l=0.28u
C0 a_n108_n144# a_n52_n100# 0.00769f
C1 a_n196_n100# w_n282_n230# 0.01808f
C2 a_n52_n100# a_108_n100# 0.04256f
C3 a_n52_n100# w_n282_n230# 0.01828f
C4 a_n52_n100# a_52_n144# 0.00769f
C5 a_n108_n144# w_n282_n230# 0.05505f
C6 a_108_n100# w_n282_n230# 0.01808f
C7 a_n108_n144# a_52_n144# 0.00519f
C8 a_n52_n100# a_n196_n100# 0.04256f
C9 a_52_n144# a_108_n100# 0.00769f
C10 a_n108_n144# a_n196_n100# 0.00769f
C11 a_52_n144# w_n282_n230# 0.05505f
C12 a_108_n100# VSUBS 0.0563f
C13 a_n52_n100# VSUBS 0.03533f
C14 a_n196_n100# VSUBS 0.0563f
C15 w_n282_n230# VSUBS 0.77832f
.ends

.subckt n_w0p5_l0p28_f2 a_n52_n50# a_n196_n50# a_52_n94# a_108_n50# a_n108_n94# VSUBS
X0 a_108_n50# a_52_n94# a_n52_n50# VSUBS nfet_03v3 ad=0.22p pd=1.88u as=0.13p ps=1.02u w=0.5u l=0.28u
X1 a_n52_n50# a_n108_n94# a_n196_n50# VSUBS nfet_03v3 ad=0.13p pd=1.02u as=0.22p ps=1.88u w=0.5u l=0.28u
C0 a_52_n94# a_108_n50# 0.00377f
C1 a_n52_n50# a_n108_n94# 0.00377f
C2 a_n196_n50# a_n52_n50# 0.02085f
C3 a_52_n94# a_n108_n94# 0.00519f
C4 a_108_n50# a_n52_n50# 0.02085f
C5 a_52_n94# a_n52_n50# 0.00377f
C6 a_n196_n50# a_n108_n94# 0.00377f
C7 a_108_n50# VSUBS 0.07479f
C8 a_n52_n50# VSUBS 0.09458f
C9 a_n196_n50# VSUBS 0.07479f
.ends

.subckt n_w2_l2_f7 a_n704_n244# a_n808_n200# a_304_n244# a_n1712_n244# a_1712_n200#
+ a_n1800_n200# a_n1208_n244# a_1208_n200# a_200_n200# a_1312_n244# a_808_n244# a_n200_n244#
+ a_n304_n200# a_n1312_n200# a_704_n200# VSUBS
X0 a_n304_n200# a_n704_n244# a_n808_n200# VSUBS nfet_03v3 ad=0.52p pd=2.52u as=0.52p ps=2.52u w=2u l=2u
X1 a_200_n200# a_n200_n244# a_n304_n200# VSUBS nfet_03v3 ad=0.52p pd=2.52u as=0.52p ps=2.52u w=2u l=2u
X2 a_1712_n200# a_1312_n244# a_1208_n200# VSUBS nfet_03v3 ad=0.88p pd=4.88u as=0.52p ps=2.52u w=2u l=2u
X3 a_1208_n200# a_808_n244# a_704_n200# VSUBS nfet_03v3 ad=0.52p pd=2.52u as=0.52p ps=2.52u w=2u l=2u
X4 a_704_n200# a_304_n244# a_200_n200# VSUBS nfet_03v3 ad=0.52p pd=2.52u as=0.52p ps=2.52u w=2u l=2u
X5 a_n1312_n200# a_n1712_n244# a_n1800_n200# VSUBS nfet_03v3 ad=0.52p pd=2.52u as=0.88p ps=4.88u w=2u l=2u
X6 a_n808_n200# a_n1208_n244# a_n1312_n200# VSUBS nfet_03v3 ad=0.52p pd=2.52u as=0.52p ps=2.52u w=2u l=2u
C0 a_n304_n200# a_n200_n244# 0.0587f
C1 a_n200_n244# a_200_n200# 0.0587f
C2 a_1208_n200# a_1712_n200# 0.02133f
C3 a_304_n244# a_808_n244# 0.00519f
C4 a_1208_n200# a_808_n244# 0.0587f
C5 a_704_n200# a_200_n200# 0.02133f
C6 a_n704_n244# a_n200_n244# 0.00519f
C7 a_n808_n200# a_n304_n200# 0.02133f
C8 a_n808_n200# a_n1312_n200# 0.02133f
C9 a_n808_n200# a_n704_n244# 0.0587f
C10 a_304_n244# a_200_n200# 0.0587f
C11 a_n1208_n244# a_n1312_n200# 0.0587f
C12 a_n1208_n244# a_n1712_n244# 0.00519f
C13 a_1312_n244# a_1208_n200# 0.0587f
C14 a_n1208_n244# a_n704_n244# 0.00519f
C15 a_304_n244# a_n200_n244# 0.00519f
C16 a_704_n200# a_304_n244# 0.0587f
C17 a_704_n200# a_1208_n200# 0.02133f
C18 a_1312_n244# a_1712_n200# 0.0587f
C19 a_n1312_n200# a_n1712_n244# 0.0587f
C20 a_1312_n244# a_808_n244# 0.00519f
C21 a_n304_n200# a_200_n200# 0.02133f
C22 a_n304_n200# a_n704_n244# 0.0587f
C23 a_704_n200# a_808_n244# 0.0587f
C24 a_n808_n200# a_n1208_n244# 0.0587f
C25 a_n1800_n200# a_n1312_n200# 0.02133f
C26 a_n1800_n200# a_n1712_n244# 0.0587f
C27 a_1712_n200# VSUBS 0.26162f
C28 a_1208_n200# VSUBS 0.34773f
C29 a_704_n200# VSUBS 0.34265f
C30 a_200_n200# VSUBS 0.34265f
C31 a_n304_n200# VSUBS 0.34265f
C32 a_n808_n200# VSUBS 0.34265f
C33 a_n1312_n200# VSUBS 0.34773f
C34 a_n1800_n200# VSUBS 0.26162f
.ends

.subckt n_w0p5_l0p5_f2 a_n52_n50# a_52_n94# a_152_n50# a_n240_n50# a_n152_n94# VSUBS
X0 a_152_n50# a_52_n94# a_n52_n50# VSUBS nfet_03v3 ad=0.22p pd=1.88u as=0.13p ps=1.02u w=0.5u l=0.5u
X1 a_n52_n50# a_n152_n94# a_n240_n50# VSUBS nfet_03v3 ad=0.13p pd=1.02u as=0.22p ps=1.88u w=0.5u l=0.5u
C0 a_n52_n50# a_52_n94# 0.00625f
C1 a_n52_n50# a_n240_n50# 0.01511f
C2 a_n152_n94# a_52_n94# 0.00519f
C3 a_n152_n94# a_n240_n50# 0.00625f
C4 a_52_n94# a_152_n50# 0.00625f
C5 a_n152_n94# a_n52_n50# 0.00625f
C6 a_n52_n50# a_152_n50# 0.01511f
C7 a_152_n50# VSUBS 0.09131f
C8 a_n52_n50# VSUBS 0.12761f
C9 a_n240_n50# VSUBS 0.09131f
.ends

.subckt idac_n g0 g1 g2 g3 g4 g5 vsn r0 r1 r2 r3 r4 r5 roff b0 b1 b2 b3 b4 out dump
+ vcas vdd vss
XU4b vsn vsn m1_1148_1944# a_736_1658# a_736_1658# m1_1148_1944# a_736_1658# m1_1148_1944#
+ a_736_1658# m1_1148_1944# vsn vsn a_736_1658# a_736_1658# a_736_1658# a_736_1658#
+ vsn vss n_w2_l2_f8
XMX1 a_736_1658# r3 g2 g3 r2 vss n_w0p5_l1_f2
XU3 vsn vsn m1_1148_3820# a_736_1658# a_736_1658# m1_1148_3820# a_736_1658# m1_1148_3820#
+ a_736_1658# m1_1148_3820# vsn vsn a_736_1658# a_736_1658# a_736_1658# a_736_1658#
+ vsn vss n_w2_l2_f8
XMX2 a_736_1658# r5 g4 g5 r4 vss n_w0p5_l1_f2
XMXOFF a_736_1658# roff vsn vss n_w0p5_l1
XIP0 a_772_5346# vcas vcas a_568_5346# a_772_5346# b0 vss p_w1_l0p28_f2
XIP1 a_1722_5346# vcas vcas a_1518_5346# a_1722_5346# b1 vss p_w1_l0p28_f2
XIP2 a_2672_5346# vcas vcas a_2468_5346# a_2672_5346# b2 vss p_w1_l0p28_f2
XIN0 vss a_772_5346# a_772_5346# a_568_5346# b0 vss n_w0p5_l0p28_f2
XIP3 a_3622_5346# vcas vcas a_3418_5346# a_3622_5346# b3 vss p_w1_l0p28_f2
XIN1 vss a_1722_5346# a_1722_5346# a_1518_5346# b1 vss n_w0p5_l0p28_f2
XIP4 a_4572_5346# vcas vcas a_4368_5346# a_4572_5346# b4 vss p_w1_l0p28_f2
XIN3 vss a_3622_5346# a_3622_5346# a_3418_5346# b3 vss n_w0p5_l0p28_f2
XIN2 vss a_2672_5346# a_2672_5346# a_2468_5346# b2 vss n_w0p5_l0p28_f2
XIN4 vss a_4572_5346# a_4572_5346# a_4368_5346# b4 vss n_w0p5_l0p28_f2
XU210 a_736_1658# vsn a_736_1658# a_736_1658# m1_240_3372# vsn a_736_1658# vsn vsn
+ a_736_1658# a_736_1658# a_736_1658# m1_1148_4480# m1_1148_4480# m1_1640_5266# vss
+ n_w2_l2_f7
XSW0 m1_240_3372# a_772_5346# dump out a_568_5346# vss n_w0p5_l0p5_f2
XSW2 m1_1148_4480# a_2672_5346# dump out a_2468_5346# vss n_w0p5_l0p5_f2
XSW1 m1_1640_5266# a_1722_5346# dump out a_1518_5346# vss n_w0p5_l0p5_f2
XSW3 m1_1148_3820# a_3622_5346# dump out a_3418_5346# vss n_w0p5_l0p5_f2
XSW4 m1_1148_1944# a_4572_5346# dump out a_4368_5346# vss n_w0p5_l0p5_f2
XU4a vsn vsn m1_1148_1944# a_736_1658# a_736_1658# m1_1148_1944# a_736_1658# m1_1148_1944#
+ a_736_1658# m1_1148_1944# vsn vsn a_736_1658# a_736_1658# a_736_1658# a_736_1658#
+ vsn vss n_w2_l2_f8
XMX0 a_736_1658# r1 g0 g1 r0 vss n_w0p5_l1_f2
C0 m1_1148_1944# g1 0.01186f
C1 m1_1148_1944# vsn 0.53145f
C2 m1_1640_5266# m1_1148_4480# 0.16058f
C3 g2 r3 0
C4 vcas a_4572_5346# 0.38884f
C5 a_736_1658# g3 0.04436f
C6 r1 g1 0.1451f
C7 a_736_1658# b0 0
C8 m1_1148_1944# r4 0.00455f
C9 b3 m1_1148_3820# 0.00114f
C10 vsn a_4368_5346# 0
C11 b4 b3 0.00973f
C12 vsn a_568_5346# 0
C13 a_3418_5346# a_4572_5346# 0.10985f
C14 g2 g1 0.02733f
C15 a_2672_5346# m1_1148_3820# 0
C16 a_1722_5346# vcas 0.33933f
C17 a_736_1658# m1_1148_3820# 1.1462f
C18 a_2672_5346# b4 0
C19 vsn out 0.45916f
C20 a_3622_5346# a_4368_5346# 0.0433f
C21 m1_1640_5266# b1 0
C22 g5 r5 0.14401f
C23 vsn dump 0.01724f
C24 vsn m1_240_3372# 0.35679f
C25 r2 r3 0.01581f
C26 vdd b4 0.00425f
C27 g5 r3 0
C28 a_3622_5346# a_2468_5346# 0.04768f
C29 a_772_5346# b1 0.00148f
C30 m1_1148_4480# b1 0
C31 roff r5 0.00658f
C32 m1_1640_5266# a_2468_5346# 0.01328f
C33 a_3622_5346# out 0.03674f
C34 a_3622_5346# b2 0
C35 a_3622_5346# dump 0.11655f
C36 a_772_5346# a_568_5346# 0.18972f
C37 m1_1640_5266# out 0.20794f
C38 m1_1640_5266# dump 0.08078f
C39 m1_1640_5266# b2 0
C40 m1_1640_5266# m1_240_3372# 0
C41 b4 a_4572_5346# 0.21252f
C42 vsn g5 0.14695f
C43 b0 a_1722_5346# 0.00484f
C44 g0 r1 0
C45 m1_1148_4480# a_2468_5346# 0.0326f
C46 r4 g5 0.00955f
C47 a_772_5346# out 0.18857f
C48 m1_1148_4480# out 0.16448f
C49 a_736_1658# g4 0.03542f
C50 a_772_5346# dump 0.13788f
C51 m1_1148_4480# b2 0.00213f
C52 a_772_5346# m1_240_3372# 0.00655f
C53 dump m1_1148_4480# 0.058f
C54 r0 g1 0.07036f
C55 m1_1148_1944# a_4368_5346# 0.00881f
C56 vsn roff 0.26035f
C57 m1_1148_1944# r1 0.00188f
C58 vsn r0 0
C59 a_1518_5346# a_2672_5346# 0
C60 a_736_1658# a_1518_5346# 0.00839f
C61 a_568_5346# b1 0
C62 g3 r3 0.1594f
C63 a_2672_5346# b3 0.00301f
C64 a_736_1658# b3 0
C65 m1_1148_1944# g2 0.02023f
C66 a_3622_5346# vcas 0.30994f
C67 m1_1148_1944# out 0.00988f
C68 vdd b3 0.00415f
C69 b1 a_2468_5346# 0.00106f
C70 m1_1148_1944# dump 0.12418f
C71 m1_1640_5266# vcas 0
C72 m1_1148_1944# m1_240_3372# 0.32394f
C73 r1 g2 0.05061f
C74 b1 out 0.07807f
C75 a_736_1658# a_2672_5346# 0.00561f
C76 b1 b2 0.00398f
C77 dump b1 0.13103f
C78 out a_4368_5346# 0.04158f
C79 a_3622_5346# a_3418_5346# 0.20566f
C80 dump a_4368_5346# 0.11623f
C81 a_568_5346# out 0.04902f
C82 m1_240_3372# a_4368_5346# 0.00282f
C83 dump a_568_5346# 0.08071f
C84 b0 vsn 0
C85 a_568_5346# m1_240_3372# 0.03407f
C86 a_772_5346# vcas 0.3246f
C87 m1_1148_4480# vcas 0
C88 b3 a_4572_5346# 0
C89 a_2468_5346# out 0.23811f
C90 a_2468_5346# b2 0.15778f
C91 dump a_2468_5346# 0.05129f
C92 m1_1148_1944# r2 0.00871f
C93 m1_1148_1944# g5 0.00869f
C94 out b2 0.05517f
C95 dump out 0.45697f
C96 out m1_240_3372# 0.175f
C97 g0 r0 0.07049f
C98 a_3418_5346# m1_1148_4480# 0
C99 vsn m1_1148_3820# 0.282f
C100 dump b2 0.08015f
C101 dump m1_240_3372# 0.0896f
C102 b4 vsn 0
C103 a_2672_5346# a_4572_5346# 0
C104 a_736_1658# a_4572_5346# 0
C105 r1 r2 0.00525f
C106 a_1518_5346# a_1722_5346# 0.36933f
C107 m1_1148_1944# roff 0.00251f
C108 b1 vcas 0.38575f
C109 g2 r2 0.08474f
C110 g4 r5 0
C111 g2 g5 0
C112 a_3622_5346# m1_1148_3820# 0.01497f
C113 a_4368_5346# vcas 0.18155f
C114 a_772_5346# b0 0.20784f
C115 b4 a_3622_5346# 0.00224f
C116 g4 r3 0.08023f
C117 m1_1640_5266# m1_1148_3820# 0
C118 a_568_5346# vcas 0.11292f
C119 r1 r0 0.01589f
C120 a_2672_5346# a_1722_5346# 0.0018f
C121 a_736_1658# a_1722_5346# 0.00262f
C122 a_3418_5346# a_4368_5346# 0.00345f
C123 a_2468_5346# vcas 0.20943f
C124 out vcas 0.68428f
C125 m1_1148_4480# m1_1148_3820# 0.00189f
C126 b2 vcas 0.39235f
C127 dump vcas 0.981f
C128 m1_1148_1944# g3 0.02043f
C129 m1_240_3372# vcas 0
C130 a_3418_5346# a_2468_5346# 0
C131 a_736_1658# r5 0.01419f
C132 r2 g5 0
C133 b0 b1 0.00317f
C134 a_3418_5346# out 0.07448f
C135 r4 g4 0.1198f
C136 a_736_1658# r3 0.01622f
C137 a_3418_5346# b2 0
C138 a_3418_5346# dump 0.13154f
C139 b0 a_568_5346# 0.11266f
C140 m1_1148_1944# m1_1148_3820# 0.33859f
C141 g2 g3 0.01305f
C142 m1_1148_1944# b4 0
C143 roff g5 0.00165f
C144 a_736_1658# g1 0.03743f
C145 a_4368_5346# m1_1148_3820# 0
C146 b0 out 0.1395f
C147 a_736_1658# vsn 4.29741f
C148 b4 a_4368_5346# 0.14127f
C149 b0 dump 0.01777f
C150 a_1518_5346# m1_1640_5266# 0.00319f
C151 a_3622_5346# b3 0.27921f
C152 b0 m1_240_3372# 0
C153 a_736_1658# r4 0.07911f
C154 out m1_1148_3820# 0.24284f
C155 a_1518_5346# a_772_5346# 0.00731f
C156 a_2672_5346# a_3622_5346# 0.02357f
C157 a_1518_5346# m1_1148_4480# 0.00217f
C158 dump m1_1148_3820# 0.07535f
C159 a_736_1658# a_3622_5346# 0.00343f
C160 a_3418_5346# vcas 0.16787f
C161 m1_240_3372# m1_1148_3820# 0.37838f
C162 b4 dump 0.07895f
C163 a_2672_5346# m1_1640_5266# 0.01964f
C164 g3 r2 0.08025f
C165 a_736_1658# m1_1640_5266# 0.36306f
C166 b4 m1_240_3372# 0
C167 g3 g5 0
C168 vsn a_4572_5346# 0
C169 m1_1148_1944# g4 0.02538f
C170 a_736_1658# a_772_5346# 0.00293f
C171 a_2672_5346# m1_1148_4480# 0.00498f
C172 a_736_1658# m1_1148_4480# 0.42886f
C173 b0 vcas 0.37859f
C174 a_1518_5346# b1 0.16007f
C175 a_3622_5346# a_4572_5346# 0.01353f
C176 a_736_1658# g0 0.01242f
C177 b1 b3 0
C178 a_1518_5346# a_568_5346# 0
C179 a_4368_5346# b3 0
C180 a_736_1658# m1_1148_1944# 2.43963f
C181 b4 vcas 0.41006f
C182 a_1518_5346# a_2468_5346# 0.03626f
C183 a_736_1658# b1 0
C184 a_1518_5346# out 0.20977f
C185 a_2468_5346# b3 0.00126f
C186 a_1518_5346# b2 0.01682f
C187 a_3418_5346# m1_1148_3820# 0.00718f
C188 a_1518_5346# dump 0.14559f
C189 a_736_1658# a_4368_5346# 0.00126f
C190 a_736_1658# r1 0.01629f
C191 a_1518_5346# m1_240_3372# 0
C192 vsn r5 0.00191f
C193 m1_1640_5266# a_1722_5346# 0.02383f
C194 out b3 0
C195 b4 a_3418_5346# 0.02552f
C196 a_736_1658# a_568_5346# 0.00119f
C197 b2 b3 0.00413f
C198 dump b3 0.22071f
C199 r4 r5 0.04264f
C200 a_2672_5346# a_2468_5346# 0.38268f
C201 a_736_1658# g2 0.01994f
C202 a_736_1658# a_2468_5346# 0.00269f
C203 r4 r3 0.00663f
C204 g4 g5 0.01076f
C205 a_772_5346# a_1722_5346# 0.01435f
C206 a_2672_5346# out 0.04289f
C207 a_736_1658# out 0.8158f
C208 m1_1148_1944# a_4572_5346# 0.06885f
C209 m1_1148_4480# a_1722_5346# 0.00172f
C210 a_2672_5346# b2 0.14044f
C211 a_2672_5346# dump 0.22087f
C212 a_736_1658# b2 0
C213 a_736_1658# dump 0.10845f
C214 a_736_1658# m1_240_3372# 1.4903f
C215 vsn g1 0
C216 vdd dump 0.01206f
C217 a_4368_5346# a_4572_5346# 0.52697f
C218 vsn r4 0
C219 a_1518_5346# vcas 0.16189f
C220 a_2468_5346# a_4572_5346# 0
C221 a_736_1658# r2 0.03425f
C222 b3 vcas 0.41461f
C223 a_736_1658# g5 0.01462f
C224 b1 a_1722_5346# 0.14843f
C225 out a_4572_5346# 0.00158f
C226 dump a_4572_5346# 0.03488f
C227 m1_1640_5266# vsn 0.02547f
C228 m1_240_3372# a_4572_5346# 0.00218f
C229 a_568_5346# a_1722_5346# 0.03105f
C230 a_3418_5346# b3 0.08939f
C231 a_2672_5346# vcas 0.28235f
C232 a_736_1658# vcas 0.00145f
C233 g3 g4 0.03721f
C234 a_736_1658# roff 0.00429f
C235 m1_1148_1944# r5 0.01153f
C236 a_736_1658# r0 0.03164f
C237 a_2468_5346# a_1722_5346# 0.00298f
C238 m1_1148_1944# r3 0.00463f
C239 vsn m1_1148_4480# 0.06278f
C240 vdd vcas 0
C241 out a_1722_5346# 0.0468f
C242 g0 g1 0.01371f
C243 a_1722_5346# b2 0.00214f
C244 dump a_1722_5346# 0.10049f
C245 a_2672_5346# a_3418_5346# 0.003f
C246 a_736_1658# a_3418_5346# 0.00489f
C247 m1_240_3372# a_1722_5346# 0
C248 a_1518_5346# b0 0
C249 g0 vsn 0.00607f
C250 vdd vss 0.03095f
C251 g1 vss 0.19747f
C252 a_736_1658# vss 6.28774f
C253 g0 vss 0.34393f
C254 r1 vss 0.23616f
C255 r0 vss 0.23543f
C256 m1_1148_1944# vss 1.01294f
C257 vsn vss 2.29789f
C258 a_4572_5346# vss 0.58061f
C259 a_4368_5346# vss 0.66354f
C260 a_3622_5346# vss 0.76226f
C261 a_3418_5346# vss 0.37781f
C262 m1_1640_5266# vss 0.37869f
C263 a_1722_5346# vss 0.50594f
C264 a_1518_5346# vss 0.33309f
C265 a_2672_5346# vss 0.55137f
C266 a_2468_5346# vss 0.3839f
C267 dump vss 2.19784f
C268 out vss 2.04626f
C269 a_772_5346# vss 0.75258f
C270 a_568_5346# vss 0.38645f
C271 m1_240_3372# vss 1.91379f
C272 m1_1148_4480# vss 0.23081f
C273 b4 vss 0.29974f
C274 b2 vss 0.18995f
C275 b3 vss 0.24236f
C276 b1 vss 0.16668f
C277 b0 vss 0.27007f
C278 vcas vss 11.62043f
C279 roff vss 0.3604f
C280 g5 vss 0.37442f
C281 g4 vss 0.19089f
C282 r5 vss 0.20702f
C283 r4 vss 0.27021f
C284 m1_1148_3820# vss 0.3165f
C285 g3 vss 0.1803f
C286 g2 vss 0.20497f
C287 r3 vss 0.25988f
C288 r2 vss 0.23435f
.ends
