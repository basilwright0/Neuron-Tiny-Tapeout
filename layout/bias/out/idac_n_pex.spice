* NGSPICE file created from idac_n.ext - technology: gf180mcuD

.subckt n_w2_l2_f8 a_n52_n200# a_n1060_n200# a_452_n200# a_1564_n244# a_n452_n244#
+ a_n556_n200# a_n1460_n244# a_1460_n200# a_52_n244# a_n1564_n200# a_956_n200# a_n2052_n200#
+ a_n956_n244# a_1060_n244# a_n1964_n244# a_556_n244# a_1964_n200# VSUBS
X0 a_1964_n200# a_1564_n244# a_1460_n200# VSUBS nfet_03v3 ad=0.88p pd=4.88u as=0.52p ps=2.52u w=2u l=2u
X1 a_452_n200# a_52_n244# a_n52_n200# VSUBS nfet_03v3 ad=0.52p pd=2.52u as=0.52p ps=2.52u w=2u l=2u
X2 a_956_n200# a_556_n244# a_452_n200# VSUBS nfet_03v3 ad=0.52p pd=2.52u as=0.52p ps=2.52u w=2u l=2u
X3 a_1460_n200# a_1060_n244# a_956_n200# VSUBS nfet_03v3 ad=0.52p pd=2.52u as=0.52p ps=2.52u w=2u l=2u
X4 a_n1564_n200# a_n1964_n244# a_n2052_n200# VSUBS nfet_03v3 ad=0.52p pd=2.52u as=0.88p ps=4.88u w=2u l=2u
X5 a_n1060_n200# a_n1460_n244# a_n1564_n200# VSUBS nfet_03v3 ad=0.52p pd=2.52u as=0.52p ps=2.52u w=2u l=2u
X6 a_n556_n200# a_n956_n244# a_n1060_n200# VSUBS nfet_03v3 ad=0.52p pd=2.52u as=0.52p ps=2.52u w=2u l=2u
X7 a_n52_n200# a_n452_n244# a_n556_n200# VSUBS nfet_03v3 ad=0.52p pd=2.52u as=0.52p ps=2.52u w=2u l=2u
C0 a_n1964_n244# a_n1460_n244# 0.00519f
C1 a_n1460_n244# a_n1060_n200# 0.0587f
C2 a_956_n200# a_452_n200# 0.02133f
C3 a_n556_n200# a_n956_n244# 0.0587f
C4 a_n452_n244# a_n556_n200# 0.0587f
C5 a_1060_n244# a_1460_n200# 0.0587f
C6 a_1060_n244# a_556_n244# 0.00519f
C7 a_n1964_n244# a_n2052_n200# 0.0587f
C8 a_1460_n200# a_1564_n244# 0.0587f
C9 a_n1060_n200# a_n956_n244# 0.0587f
C10 a_1964_n200# a_1564_n244# 0.0587f
C11 a_n1964_n244# a_n1564_n200# 0.0587f
C12 a_n1564_n200# a_n1060_n200# 0.02133f
C13 a_1060_n244# a_956_n200# 0.0587f
C14 a_n556_n200# a_n1060_n200# 0.02133f
C15 a_52_n244# a_556_n244# 0.00519f
C16 a_1460_n200# a_1964_n200# 0.02133f
C17 a_n52_n200# a_52_n244# 0.0587f
C18 a_n1460_n244# a_n956_n244# 0.00519f
C19 a_956_n200# a_1460_n200# 0.02133f
C20 a_956_n200# a_556_n244# 0.0587f
C21 a_n452_n244# a_52_n244# 0.00519f
C22 a_n1564_n200# a_n1460_n244# 0.0587f
C23 a_n52_n200# a_n452_n244# 0.0587f
C24 a_556_n244# a_452_n200# 0.0587f
C25 a_52_n244# a_452_n200# 0.0587f
C26 a_n52_n200# a_452_n200# 0.02133f
C27 a_1060_n244# a_1564_n244# 0.00519f
C28 a_n1564_n200# a_n2052_n200# 0.02133f
C29 a_n52_n200# a_n556_n200# 0.02133f
C30 a_n452_n244# a_n956_n244# 0.00519f
C31 a_1964_n200# VSUBS 0.26162f
C32 a_1460_n200# VSUBS 0.34773f
C33 a_956_n200# VSUBS 0.34265f
C34 a_452_n200# VSUBS 0.34265f
C35 a_n52_n200# VSUBS 0.34265f
C36 a_n556_n200# VSUBS 0.34265f
C37 a_n1060_n200# VSUBS 0.34265f
C38 a_n1564_n200# VSUBS 0.34773f
C39 a_n2052_n200# VSUBS 0.26162f
.ends

.subckt p_w1_l0p28_f2 a_n196_n100# a_n52_n100# w_n282_n230# a_108_n100# a_52_n144#
+ a_n108_n144# VSUBS
X0 a_n52_n100# a_n108_n144# a_n196_n100# w_n282_n230# pfet_03v3 ad=0.26p pd=1.52u as=0.44p ps=2.88u w=1u l=0.28u
X1 a_108_n100# a_52_n144# a_n52_n100# w_n282_n230# pfet_03v3 ad=0.44p pd=2.88u as=0.26p ps=1.52u w=1u l=0.28u
C0 a_n196_n100# w_n282_n230# 0.01808f
C1 w_n282_n230# a_52_n144# 0.05505f
C2 a_n108_n144# a_n52_n100# 0.00769f
C3 a_n52_n100# a_108_n100# 0.04256f
C4 a_n196_n100# a_n52_n100# 0.04256f
C5 a_n108_n144# a_n196_n100# 0.00769f
C6 a_n52_n100# a_52_n144# 0.00769f
C7 w_n282_n230# a_n52_n100# 0.01828f
C8 a_n108_n144# a_52_n144# 0.00519f
C9 a_n108_n144# w_n282_n230# 0.05505f
C10 a_108_n100# a_52_n144# 0.00769f
C11 w_n282_n230# a_108_n100# 0.01808f
C12 a_108_n100# VSUBS 0.0563f
C13 a_n52_n100# VSUBS 0.03533f
C14 a_n196_n100# VSUBS 0.0563f
C15 w_n282_n230# VSUBS 0.77832f
.ends

.subckt n_w0p5_l0p28_f2 a_n52_n50# a_n196_n50# a_52_n94# a_108_n50# a_n108_n94# VSUBS
X0 a_108_n50# a_52_n94# a_n52_n50# VSUBS nfet_03v3 ad=0.22p pd=1.88u as=0.13p ps=1.02u w=0.5u l=0.28u
X1 a_n52_n50# a_n108_n94# a_n196_n50# VSUBS nfet_03v3 ad=0.13p pd=1.02u as=0.22p ps=1.88u w=0.5u l=0.28u
C0 a_n52_n50# a_n196_n50# 0.02085f
C1 a_n52_n50# a_n108_n94# 0.00377f
C2 a_n108_n94# a_n196_n50# 0.00377f
C3 a_52_n94# a_108_n50# 0.00377f
C4 a_n52_n50# a_108_n50# 0.02085f
C5 a_52_n94# a_n52_n50# 0.00377f
C6 a_52_n94# a_n108_n94# 0.00519f
C7 a_108_n50# VSUBS 0.07479f
C8 a_n52_n50# VSUBS 0.09458f
C9 a_n196_n50# VSUBS 0.07479f
.ends

.subckt n_w2_l2_f7 a_n704_n244# a_n808_n200# a_304_n244# a_n1712_n244# a_1712_n200#
+ a_n1800_n200# a_n1208_n244# a_1208_n200# a_200_n200# a_1312_n244# a_808_n244# a_n200_n244#
+ a_n304_n200# a_n1312_n200# a_704_n200# VSUBS
X0 a_n304_n200# a_n704_n244# a_n808_n200# VSUBS nfet_03v3 ad=0.52p pd=2.52u as=0.52p ps=2.52u w=2u l=2u
X1 a_200_n200# a_n200_n244# a_n304_n200# VSUBS nfet_03v3 ad=0.52p pd=2.52u as=0.52p ps=2.52u w=2u l=2u
X2 a_1712_n200# a_1312_n244# a_1208_n200# VSUBS nfet_03v3 ad=0.88p pd=4.88u as=0.52p ps=2.52u w=2u l=2u
X3 a_1208_n200# a_808_n244# a_704_n200# VSUBS nfet_03v3 ad=0.52p pd=2.52u as=0.52p ps=2.52u w=2u l=2u
X4 a_704_n200# a_304_n244# a_200_n200# VSUBS nfet_03v3 ad=0.52p pd=2.52u as=0.52p ps=2.52u w=2u l=2u
X5 a_n1312_n200# a_n1712_n244# a_n1800_n200# VSUBS nfet_03v3 ad=0.52p pd=2.52u as=0.88p ps=4.88u w=2u l=2u
X6 a_n808_n200# a_n1208_n244# a_n1312_n200# VSUBS nfet_03v3 ad=0.52p pd=2.52u as=0.52p ps=2.52u w=2u l=2u
C0 a_1312_n244# a_808_n244# 0.00519f
C1 a_1712_n200# a_1208_n200# 0.02133f
C2 a_n200_n244# a_n704_n244# 0.00519f
C3 a_200_n200# a_n304_n200# 0.02133f
C4 a_n200_n244# a_n304_n200# 0.0587f
C5 a_n1312_n200# a_n808_n200# 0.02133f
C6 a_704_n200# a_1208_n200# 0.02133f
C7 a_n1800_n200# a_n1712_n244# 0.0587f
C8 a_n704_n244# a_n304_n200# 0.0587f
C9 a_704_n200# a_304_n244# 0.0587f
C10 a_n1208_n244# a_n1312_n200# 0.0587f
C11 a_1208_n200# a_808_n244# 0.0587f
C12 a_n1208_n244# a_n808_n200# 0.0587f
C13 a_304_n244# a_808_n244# 0.00519f
C14 a_704_n200# a_808_n244# 0.0587f
C15 a_200_n200# a_304_n244# 0.0587f
C16 a_1712_n200# a_1312_n244# 0.0587f
C17 a_200_n200# a_704_n200# 0.02133f
C18 a_n200_n244# a_304_n244# 0.00519f
C19 a_n1712_n244# a_n1312_n200# 0.0587f
C20 a_n808_n200# a_n704_n244# 0.0587f
C21 a_1312_n244# a_1208_n200# 0.0587f
C22 a_200_n200# a_n200_n244# 0.0587f
C23 a_n1800_n200# a_n1312_n200# 0.02133f
C24 a_n1208_n244# a_n704_n244# 0.00519f
C25 a_n1208_n244# a_n1712_n244# 0.00519f
C26 a_n808_n200# a_n304_n200# 0.02133f
C27 a_1712_n200# VSUBS 0.26162f
C28 a_1208_n200# VSUBS 0.34773f
C29 a_704_n200# VSUBS 0.34265f
C30 a_200_n200# VSUBS 0.34265f
C31 a_n304_n200# VSUBS 0.34265f
C32 a_n808_n200# VSUBS 0.34265f
C33 a_n1312_n200# VSUBS 0.34773f
C34 a_n1800_n200# VSUBS 0.26162f
.ends

.subckt n_w0p5_l0p5_f2 a_n52_n50# a_52_n94# a_152_n50# a_n240_n50# a_n152_n94# VSUBS
X0 a_152_n50# a_52_n94# a_n52_n50# VSUBS nfet_03v3 ad=0.22p pd=1.88u as=0.13p ps=1.02u w=0.5u l=0.5u
X1 a_n52_n50# a_n152_n94# a_n240_n50# VSUBS nfet_03v3 ad=0.13p pd=1.02u as=0.22p ps=1.88u w=0.5u l=0.5u
C0 a_n52_n50# a_52_n94# 0.00625f
C1 a_n52_n50# a_152_n50# 0.01511f
C2 a_n52_n50# a_n152_n94# 0.00625f
C3 a_n240_n50# a_n152_n94# 0.00625f
C4 a_n240_n50# a_n52_n50# 0.01511f
C5 a_152_n50# a_52_n94# 0.00625f
C6 a_n152_n94# a_52_n94# 0.00519f
C7 a_152_n50# VSUBS 0.09131f
C8 a_n52_n50# VSUBS 0.12761f
C9 a_n240_n50# VSUBS 0.09131f
.ends

.subckt idac_n g vsn b0 b1 b2 b3 b4 out dump vcas vdd vss
XU4b vsn vsn m1_988_888# g g m1_988_888# g m1_988_888# g m1_988_888# vsn vsn g g g
+ g vsn vss n_w2_l2_f8
XU3 vsn vsn m1_988_2644# g g m1_988_2644# g m1_988_2644# g m1_988_2644# vsn vsn g
+ g g g vsn vss n_w2_l2_f8
XIP0 a_732_4170# vcas vcas a_528_4170# a_732_4170# b0 vss p_w1_l0p28_f2
XIP1 a_1582_4170# vcas vcas a_1378_4170# a_1582_4170# b1 vss p_w1_l0p28_f2
XIP2 a_2432_4170# vcas vcas a_2228_4170# a_2432_4170# b2 vss p_w1_l0p28_f2
XIN0 vss a_732_4170# a_732_4170# a_528_4170# b0 vss n_w0p5_l0p28_f2
XIP3 a_3282_4170# vcas vcas a_3078_4170# a_3282_4170# b3 vss p_w1_l0p28_f2
XIN1 vss a_1582_4170# a_1582_4170# a_1378_4170# b1 vss n_w0p5_l0p28_f2
XIP4 a_4132_4170# vcas vcas a_3928_4170# a_4132_4170# b4 vss p_w1_l0p28_f2
XIN3 vss a_3282_4170# a_3282_4170# a_3078_4170# b3 vss n_w0p5_l0p28_f2
XIN2 vss a_2432_4170# a_2432_4170# a_2228_4170# b2 vss n_w0p5_l0p28_f2
XIN4 vss a_4132_4170# a_4132_4170# a_3928_4170# b4 vss n_w0p5_l0p28_f2
XU210 g vsn g g m1_260_2080# vsn g vsn vsn g g g m1_988_3304# m1_988_3304# m1_1500_3762#
+ vss n_w2_l2_f7
XSW0 m1_260_2080# a_732_4170# dump out a_528_4170# vss n_w0p5_l0p5_f2
XSW2 m1_988_3304# a_2432_4170# dump out a_2228_4170# vss n_w0p5_l0p5_f2
XSW1 m1_1500_3762# a_1582_4170# dump out a_1378_4170# vss n_w0p5_l0p5_f2
XSW3 m1_988_2644# a_3282_4170# dump out a_3078_4170# vss n_w0p5_l0p5_f2
XSW4 m1_988_888# a_4132_4170# dump out a_3928_4170# vss n_w0p5_l0p5_f2
XU4a vsn vsn m1_988_888# g g m1_988_888# g m1_988_888# g m1_988_888# vsn vsn g g g
+ g vsn vss n_w2_l2_f8
C0 vdd dump 0.01049f
C1 vcas a_2432_4170# 0.31499f
C2 a_2228_4170# vcas 0.08842f
C3 vsn m1_1500_3762# 0.02504f
C4 a_3928_4170# m1_988_2644# 0
C5 a_3282_4170# a_2228_4170# 0.01488f
C6 vcas b0 0.36918f
C7 a_3282_4170# a_2432_4170# 0.01327f
C8 a_3078_4170# a_2228_4170# 0.00113f
C9 a_3078_4170# a_2432_4170# 0.0066f
C10 vcas dump 1.35686f
C11 a_3282_4170# dump 0.04973f
C12 out vcas 0.27597f
C13 a_3078_4170# dump 0.52465f
C14 a_3282_4170# out 0.02704f
C15 a_1582_4170# m1_1500_3762# 0.02077f
C16 vdd b3 0.00415f
C17 a_2228_4170# m1_988_3304# 0.06446f
C18 a_2432_4170# m1_988_3304# 0.00578f
C19 m1_260_2080# a_3078_4170# 0.20065f
C20 out a_3078_4170# 0.08761f
C21 a_1378_4170# m1_1500_3762# 0.00998f
C22 vcas a_732_4170# 0.26007f
C23 a_1378_4170# a_1582_4170# 0.12904f
C24 dump m1_988_3304# 0.34162f
C25 m1_988_888# m1_988_2644# 0.44143f
C26 vcas b3 0.48197f
C27 out m1_988_3304# 0.25145f
C28 a_3282_4170# b3 0.14389f
C29 a_528_4170# vcas 0.09144f
C30 a_3078_4170# b3 0.09671f
C31 vsn a_2228_4170# 0
C32 a_3928_4170# g 0.00223f
C33 a_4132_4170# g 0.00123f
C34 b1 vcas 0.89272f
C35 b1 a_3282_4170# 0
C36 vsn dump 0.45688f
C37 m1_1500_3762# a_2228_4170# 0.00184f
C38 m1_1500_3762# a_2432_4170# 0
C39 g b4 0
C40 vsn m1_260_2080# 0.30933f
C41 vsn out 0.01026f
C42 a_1582_4170# a_2228_4170# 0.00492f
C43 a_1582_4170# a_2432_4170# 0.01867f
C44 a_1582_4170# b0 0.00914f
C45 m1_1500_3762# dump 0.09882f
C46 a_1378_4170# a_2228_4170# 0.00673f
C47 a_1378_4170# a_2432_4170# 0.06027f
C48 a_1582_4170# dump 0.01837f
C49 a_3282_4170# m1_988_2644# 0.00988f
C50 m1_260_2080# m1_1500_3762# 0
C51 out m1_1500_3762# 0.38998f
C52 m1_988_888# g 2.42837f
C53 a_3078_4170# m1_988_2644# 0.08059f
C54 a_1378_4170# dump 0.07506f
C55 a_1582_4170# out 0.17521f
C56 a_1378_4170# out 0.04703f
C57 vsn a_528_4170# 0
C58 a_1582_4170# a_732_4170# 0.00288f
C59 m1_988_2644# m1_988_3304# 0.00259f
C60 b2 vcas 0.3849f
C61 a_1378_4170# a_732_4170# 0.00239f
C62 m1_1500_3762# b3 0
C63 a_3282_4170# b2 0
C64 b2 a_3078_4170# 0
C65 a_2228_4170# a_2432_4170# 0.14213f
C66 a_1378_4170# b3 0.00218f
C67 a_1582_4170# a_528_4170# 0.0056f
C68 a_3928_4170# a_4132_4170# 0.12544f
C69 b1 m1_1500_3762# 0
C70 vcas g 0.00531f
C71 a_2228_4170# dump 0.15915f
C72 a_1378_4170# a_528_4170# 0.00677f
C73 b1 a_1582_4170# 0.27926f
C74 a_2432_4170# dump 0.04021f
C75 vsn m1_988_2644# 0.25449f
C76 a_3282_4170# g 0.00339f
C77 b2 m1_988_3304# 0
C78 b1 a_1378_4170# 0.03605f
C79 out a_2432_4170# 0.02507f
C80 out a_2228_4170# 0.02717f
C81 a_3078_4170# g 0.13262f
C82 a_4132_4170# b4 0.25674f
C83 a_3928_4170# b4 0.02632f
C84 m1_260_2080# b0 0
C85 out b0 0.01654f
C86 m1_260_2080# dump 0.05465f
C87 out dump 0.4373f
C88 m1_1500_3762# m1_988_2644# 0.09258f
C89 out m1_260_2080# 0.07116f
C90 g m1_988_3304# 0.39585f
C91 b0 a_732_4170# 0.2484f
C92 a_4132_4170# m1_988_888# 0.02826f
C93 a_3928_4170# m1_988_888# 0.0651f
C94 dump a_732_4170# 0.02697f
C95 a_2228_4170# b3 0.00226f
C96 a_2432_4170# b3 0.00238f
C97 m1_260_2080# a_732_4170# 0.00987f
C98 out a_732_4170# 0.01797f
C99 dump b3 0.14989f
C100 m1_988_888# b4 0
C101 a_528_4170# b0 0.02165f
C102 b1 a_2228_4170# 0
C103 b1 a_2432_4170# 0
C104 b2 m1_1500_3762# 0
C105 out b3 0
C106 a_528_4170# dump 0.07429f
C107 vsn g 4.12488f
C108 a_1582_4170# b2 0.00172f
C109 b1 b0 0.02437f
C110 a_528_4170# m1_260_2080# 0.05346f
C111 b1 dump 0.0143f
C112 a_528_4170# out 0.25397f
C113 a_1378_4170# b2 0.00837f
C114 b1 out 0.39281f
C115 vdd b4 0.0055f
C116 m1_1500_3762# g 0.51943f
C117 a_4132_4170# vcas 0.27886f
C118 a_3928_4170# vcas 0.08407f
C119 a_528_4170# a_732_4170# 0.1853f
C120 a_1582_4170# g 0.0036f
C121 a_3928_4170# a_3282_4170# 0.0068f
C122 a_3282_4170# a_4132_4170# 0.128f
C123 b1 a_732_4170# 0.00568f
C124 a_1378_4170# g 0.00374f
C125 a_4132_4170# a_3078_4170# 0.06615f
C126 a_3928_4170# a_3078_4170# 0.27629f
C127 dump m1_988_2644# 0.07098f
C128 vcas b4 0.34586f
C129 m1_260_2080# m1_988_2644# 0.24844f
C130 out m1_988_2644# 0.06032f
C131 a_3282_4170# b4 0.0031f
C132 a_3078_4170# b4 0.14552f
C133 b1 a_528_4170# 0.04801f
C134 b2 a_2228_4170# 0.04686f
C135 b2 a_2432_4170# 0.24144f
C136 b2 dump 0.07018f
C137 b3 m1_988_2644# 0
C138 m1_988_888# a_3078_4170# 0.08147f
C139 out b2 0.01329f
C140 a_2228_4170# g 0.00553f
C141 g a_2432_4170# 0.00286f
C142 a_3928_4170# vsn 0
C143 vsn a_4132_4170# 0
C144 g b0 0
C145 vdd vcas 0.00626f
C146 g dump 0.62788f
C147 a_3282_4170# vdd 0
C148 m1_260_2080# g 1.12515f
C149 out g 0.30711f
C150 a_3078_4170# vdd 0
C151 vsn b4 0
C152 b2 b3 0.01263f
C153 a_3282_4170# vcas 0.29204f
C154 g a_732_4170# 0.00276f
C155 a_3078_4170# vcas 0.73187f
C156 vsn m1_988_888# 0.75155f
C157 b1 b2 0.0021f
C158 a_3282_4170# a_3078_4170# 0.27925f
C159 g b3 0
C160 a_528_4170# g 0.00771f
C161 b1 g 0
C162 g m1_988_2644# 1.19317f
C163 a_4132_4170# dump 0.04826f
C164 a_3928_4170# dump 0.03528f
C165 m1_260_2080# a_4132_4170# 0
C166 vsn a_3078_4170# 0.01097f
C167 a_3928_4170# m1_260_2080# 0
C168 out a_4132_4170# 0.00472f
C169 a_3928_4170# out 0.00435f
C170 m1_1500_3762# vcas 0.00146f
C171 b4 dump 0.05108f
C172 a_1582_4170# vcas 0.27006f
C173 m1_260_2080# b4 0
C174 vsn m1_988_3304# 0.0562f
C175 a_1582_4170# a_3282_4170# 0
C176 m1_1500_3762# a_3078_4170# 0.00387f
C177 a_1378_4170# vcas 0.15514f
C178 b2 g 0
C179 a_1378_4170# a_3282_4170# 0
C180 a_4132_4170# b3 0.00478f
C181 a_3928_4170# b3 0
C182 m1_988_888# dump 0.1173f
C183 a_1378_4170# a_3078_4170# 0
C184 m1_1500_3762# m1_988_3304# 0.11176f
C185 m1_260_2080# m1_988_888# 0.55941f
C186 out m1_988_888# 0.00355f
C187 a_1582_4170# m1_988_3304# 0
C188 b4 b3 0.0097f
C189 a_1378_4170# m1_988_3304# 0
C190 vdd vss 0.03123f
C191 m1_988_888# vss 1.06123f
C192 vsn vss 1.84736f
C193 g vss 5.72892f
C194 a_4132_4170# vss 0.41879f
C195 a_3928_4170# vss 0.33427f
C196 a_3282_4170# vss 0.41623f
C197 a_3078_4170# vss 0.59741f
C198 m1_1500_3762# vss 0.27797f
C199 a_1582_4170# vss 0.4013f
C200 a_1378_4170# vss 0.34562f
C201 a_2432_4170# vss 0.40441f
C202 a_2228_4170# vss 0.17252f
C203 dump vss 1.82894f
C204 m1_260_2080# vss 2.17739f
C205 out vss 1.05553f
C206 a_732_4170# vss 0.39599f
C207 a_528_4170# vss 0.28429f
C208 m1_988_3304# vss 0.09089f
C209 b4 vss 0.21281f
C210 b2 vss 0.19167f
C211 b3 vss 0.18821f
C212 b1 vss 0.38616f
C213 b0 vss 0.34676f
C214 vcas vss 10.83517f
C215 m1_988_2644# vss 0.29815f
.ends
