* NGSPICE file created from bias_vi.ext - technology: gf180mcuD

.subckt p_w0p8_l2 w_n374_n210# a_n288_n80# a_200_n80# a_n200_n124# VSUBS
X0 a_200_n80# a_n200_n124# a_n288_n80# w_n374_n210# pfet_03v3 ad=0.352p pd=2.48u as=0.352p ps=2.48u w=0.8u l=2u
C0 a_200_n80# a_n288_n80# 0.0084f
C1 a_n288_n80# w_n374_n210# 0.02527f
C2 a_n200_n124# a_n288_n80# 0.02312f
C3 a_200_n80# w_n374_n210# 0.02527f
C4 a_200_n80# a_n200_n124# 0.02312f
C5 a_n200_n124# w_n374_n210# 0.22666f
C6 a_200_n80# VSUBS 0.09823f
C7 a_n288_n80# VSUBS 0.09823f
C8 w_n374_n210# VSUBS 0.94248f
.ends

.subckt p_w4_l2_f4 w_n1130_n530# a_n956_n444# a_556_n444# a_n52_n400# a_452_n400#
+ a_n452_n444# a_n556_n400# a_52_n444# a_956_n400# a_n1044_n400# VSUBS
X0 a_n556_n400# a_n956_n444# a_n1044_n400# w_n1130_n530# pfet_03v3 ad=1.04p pd=4.52u as=1.76p ps=8.88u w=4u l=2u
X1 a_n52_n400# a_n452_n444# a_n556_n400# w_n1130_n530# pfet_03v3 ad=1.04p pd=4.52u as=1.04p ps=4.52u w=4u l=2u
X2 a_452_n400# a_52_n444# a_n52_n400# w_n1130_n530# pfet_03v3 ad=1.04p pd=4.52u as=1.04p ps=4.52u w=4u l=2u
X3 a_956_n400# a_556_n444# a_452_n400# w_n1130_n530# pfet_03v3 ad=1.76p pd=8.88u as=1.04p ps=4.52u w=4u l=2u
C0 a_n556_n400# a_n1044_n400# 0.04287f
C1 a_52_n444# a_556_n444# 0.00519f
C2 a_52_n444# a_n52_n400# 0.11799f
C3 w_n1130_n530# a_556_n444# 0.2233f
C4 a_452_n400# a_956_n400# 0.04287f
C5 w_n1130_n530# a_n52_n400# 0.18497f
C6 a_52_n444# a_n452_n444# 0.00519f
C7 a_n452_n444# w_n1130_n530# 0.21994f
C8 w_n1130_n530# a_n556_n400# 0.18497f
C9 a_52_n444# a_452_n400# 0.11799f
C10 w_n1130_n530# a_452_n400# 0.18497f
C11 w_n1130_n530# a_956_n400# 0.12268f
C12 w_n1130_n530# a_n1044_n400# 0.12268f
C13 a_n956_n444# a_n452_n444# 0.00519f
C14 a_52_n444# w_n1130_n530# 0.21994f
C15 a_n956_n444# a_n556_n400# 0.11799f
C16 a_n452_n444# a_n52_n400# 0.11799f
C17 a_n556_n400# a_n52_n400# 0.04287f
C18 a_n452_n444# a_n556_n400# 0.11799f
C19 a_n956_n444# a_n1044_n400# 0.11799f
C20 a_556_n444# a_452_n400# 0.11799f
C21 a_452_n400# a_n52_n400# 0.04287f
C22 a_556_n444# a_956_n400# 0.11799f
C23 a_n956_n444# w_n1130_n530# 0.2233f
C24 a_956_n400# VSUBS 0.19832f
C25 a_452_n400# VSUBS 0.12191f
C26 a_n52_n400# VSUBS 0.11851f
C27 a_n556_n400# VSUBS 0.12191f
C28 a_n1044_n400# VSUBS 0.19832f
C29 w_n1130_n530# VSUBS 7.1868f
.ends

.subckt p_w0p5_l10 a_n1088_n50# a_1000_n50# w_n1174_n180# a_n1000_n94# VSUBS
X0 a_1000_n50# a_n1000_n94# a_n1088_n50# w_n1174_n180# pfet_03v3 ad=0.22p pd=1.88u as=0.22p ps=1.88u w=0.5u l=10u
C0 a_n1088_n50# a_n1000_n94# 0.01858f
C1 w_n1174_n180# a_1000_n50# 0.02013f
C2 w_n1174_n180# a_n1088_n50# 0.02013f
C3 w_n1174_n180# a_n1000_n94# 1.0092f
C4 a_n1000_n94# a_1000_n50# 0.01858f
C5 a_1000_n50# VSUBS 0.30033f
C6 a_n1088_n50# VSUBS 0.30033f
C7 w_n1174_n180# VSUBS 2.53584f
.ends

.subckt n_w2_l2_f4 a_n52_n200# a_452_n200# a_n452_n244# a_n556_n200# a_52_n244# a_956_n200#
+ a_n1044_n200# a_n956_n244# a_556_n244# VSUBS
X0 a_452_n200# a_52_n244# a_n52_n200# VSUBS nfet_03v3 ad=0.52p pd=2.52u as=0.52p ps=2.52u w=2u l=2u
X1 a_956_n200# a_556_n244# a_452_n200# VSUBS nfet_03v3 ad=0.88p pd=4.88u as=0.52p ps=2.52u w=2u l=2u
X2 a_n556_n200# a_n956_n244# a_n1044_n200# VSUBS nfet_03v3 ad=0.52p pd=2.52u as=0.88p ps=4.88u w=2u l=2u
X3 a_n52_n200# a_n452_n244# a_n556_n200# VSUBS nfet_03v3 ad=0.52p pd=2.52u as=0.52p ps=2.52u w=2u l=2u
C0 a_52_n244# a_n452_n244# 0.00519f
C1 a_n1044_n200# a_n556_n200# 0.02133f
C2 a_n52_n200# a_52_n244# 0.0587f
C3 a_n452_n244# a_n556_n200# 0.0587f
C4 a_452_n200# a_956_n200# 0.02133f
C5 a_n52_n200# a_n556_n200# 0.02133f
C6 a_452_n200# a_556_n244# 0.0587f
C7 a_n52_n200# a_n452_n244# 0.0587f
C8 a_452_n200# a_52_n244# 0.0587f
C9 a_556_n244# a_956_n200# 0.0587f
C10 a_52_n244# a_556_n244# 0.00519f
C11 a_n52_n200# a_452_n200# 0.02133f
C12 a_n956_n244# a_n1044_n200# 0.0587f
C13 a_n956_n244# a_n556_n200# 0.0587f
C14 a_n956_n244# a_n452_n244# 0.00519f
C15 a_956_n200# VSUBS 0.26162f
C16 a_452_n200# VSUBS 0.34773f
C17 a_n52_n200# VSUBS 0.34265f
C18 a_n556_n200# VSUBS 0.34773f
C19 a_n1044_n200# VSUBS 0.26162f
.ends

.subckt p_w4_l1_f4 a_252_n400# a_n556_n444# a_n644_n400# a_n252_n444# a_n356_n400#
+ a_n52_n400# a_356_n444# w_n730_n530# a_52_n444# a_556_n400# VSUBS
X0 a_n356_n400# a_n556_n444# a_n644_n400# w_n730_n530# pfet_03v3 ad=1.04p pd=4.52u as=1.76p ps=8.88u w=4u l=1u
X1 a_556_n400# a_356_n444# a_252_n400# w_n730_n530# pfet_03v3 ad=1.76p pd=8.88u as=1.04p ps=4.52u w=4u l=1u
X2 a_n52_n400# a_n252_n444# a_n356_n400# w_n730_n530# pfet_03v3 ad=1.04p pd=4.52u as=1.04p ps=4.52u w=4u l=1u
X3 a_252_n400# a_52_n444# a_n52_n400# w_n730_n530# pfet_03v3 ad=1.04p pd=4.52u as=1.04p ps=4.52u w=4u l=1u
C0 w_n730_n530# a_252_n400# 0.12997f
C1 a_52_n444# a_n52_n400# 0.08505f
C2 a_n556_n444# a_n252_n444# 0.00519f
C3 a_52_n444# w_n730_n530# 0.12212f
C4 a_n556_n444# a_n356_n400# 0.08505f
C5 a_n356_n400# a_n252_n444# 0.08505f
C6 w_n730_n530# a_556_n400# 0.09518f
C7 a_52_n444# a_n252_n444# 0.00519f
C8 a_356_n444# w_n730_n530# 0.12548f
C9 a_52_n444# a_252_n400# 0.08505f
C10 a_252_n400# a_556_n400# 0.07756f
C11 w_n730_n530# a_n644_n400# 0.09518f
C12 a_n52_n400# w_n730_n530# 0.12997f
C13 a_356_n444# a_252_n400# 0.08505f
C14 a_n556_n444# a_n644_n400# 0.08505f
C15 a_52_n444# a_356_n444# 0.00519f
C16 a_n356_n400# a_n644_n400# 0.07756f
C17 a_n556_n444# w_n730_n530# 0.12548f
C18 a_n52_n400# a_n252_n444# 0.08505f
C19 w_n730_n530# a_n252_n444# 0.12212f
C20 a_356_n444# a_556_n400# 0.08505f
C21 a_n52_n400# a_n356_n400# 0.07756f
C22 a_n356_n400# w_n730_n530# 0.12997f
C23 a_n52_n400# a_252_n400# 0.07756f
C24 a_556_n400# VSUBS 0.17216f
C25 a_252_n400# VSUBS 0.0696f
C26 a_n52_n400# VSUBS 0.06619f
C27 a_n356_n400# VSUBS 0.0696f
C28 a_n644_n400# VSUBS 0.17216f
C29 w_n730_n530# VSUBS 4.6428f
.ends

.subckt p_w2_l2 a_n288_n200# a_200_n200# a_n200_n244# w_n374_n330# VSUBS
X0 a_200_n200# a_n200_n244# a_n288_n200# w_n374_n330# pfet_03v3 ad=0.88p pd=4.88u as=0.88p ps=4.88u w=2u l=2u
C0 w_n374_n330# a_n200_n244# 0.22666f
C1 w_n374_n330# a_200_n200# 0.0618f
C2 a_200_n200# a_n200_n244# 0.0587f
C3 w_n374_n330# a_n288_n200# 0.0618f
C4 a_n288_n200# a_n200_n244# 0.0587f
C5 a_200_n200# a_n288_n200# 0.02133f
C6 a_200_n200# VSUBS 0.13704f
C7 a_n288_n200# VSUBS 0.13704f
C8 w_n374_n330# VSUBS 1.48104f
.ends

.subckt n_w4_l2_f2 a_n52_n400# a_452_n400# a_n452_n444# a_n540_n400# a_52_n444# VSUBS
X0 a_n52_n400# a_n452_n444# a_n540_n400# VSUBS nfet_03v3 ad=1.04p pd=4.52u as=1.76p ps=8.88u w=4u l=2u
X1 a_452_n400# a_52_n444# a_n52_n400# VSUBS nfet_03v3 ad=1.76p pd=8.88u as=1.04p ps=4.52u w=4u l=2u
C0 a_n452_n444# a_52_n444# 0.00519f
C1 a_n452_n444# a_n52_n400# 0.11799f
C2 a_n52_n400# a_52_n444# 0.11799f
C3 a_n452_n444# a_n540_n400# 0.11799f
C4 a_452_n400# a_52_n444# 0.11799f
C5 a_n52_n400# a_n540_n400# 0.04287f
C6 a_n52_n400# a_452_n400# 0.04287f
C7 a_452_n400# VSUBS 0.33857f
C8 a_n52_n400# VSUBS 0.35281f
C9 a_n540_n400# VSUBS 0.33857f
.ends

.subckt p_w1_l0p5 a_n138_n100# a_50_n100# a_n50_n144# w_n224_n230# VSUBS
X0 a_50_n100# a_n50_n144# a_n138_n100# w_n224_n230# pfet_03v3 ad=0.44p pd=2.88u as=0.44p ps=2.88u w=1u l=0.5u
C0 w_n224_n230# a_n50_n144# 0.07993f
C1 w_n224_n230# a_50_n100# 0.0205f
C2 a_50_n100# a_n50_n144# 0.01275f
C3 w_n224_n230# a_n138_n100# 0.0205f
C4 a_n138_n100# a_n50_n144# 0.01275f
C5 a_50_n100# a_n138_n100# 0.03085f
C6 a_50_n100# VSUBS 0.06546f
C7 a_n138_n100# VSUBS 0.06546f
C8 w_n224_n230# VSUBS 0.61824f
.ends

.subckt n_w0p5_l1 a_100_n50# a_n100_n94# a_n188_n50# VSUBS
X0 a_100_n50# a_n100_n94# a_n188_n50# VSUBS nfet_03v3 ad=0.22p pd=1.88u as=0.22p ps=1.88u w=0.5u l=1u
C0 a_n100_n94# a_n188_n50# 0.01026f
C1 a_n100_n94# a_100_n50# 0.01026f
C2 a_100_n50# a_n188_n50# 0.00935f
C3 a_100_n50# VSUBS 0.13392f
C4 a_n188_n50# VSUBS 0.13392f
.ends

.subckt n_w2_l2 a_n288_n200# a_200_n200# a_n200_n244# VSUBS
X0 a_200_n200# a_n200_n244# a_n288_n200# VSUBS nfet_03v3 ad=0.88p pd=4.88u as=0.88p ps=4.88u w=2u l=2u
C0 a_n200_n244# a_n288_n200# 0.0587f
C1 a_n200_n244# a_200_n200# 0.0587f
C2 a_200_n200# a_n288_n200# 0.02133f
C3 a_200_n200# VSUBS 0.2667f
C4 a_n288_n200# VSUBS 0.2667f
.ends

.subckt p_w4_l2 w_n374_n530# a_n288_n400# a_200_n400# a_n200_n444# VSUBS
X0 a_200_n400# a_n200_n444# a_n288_n400# w_n374_n530# pfet_03v3 ad=1.76p pd=8.88u as=1.76p ps=8.88u w=4u l=2u
C0 w_n374_n530# a_n200_n444# 0.22666f
C1 w_n374_n530# a_200_n400# 0.12268f
C2 a_200_n400# a_n200_n444# 0.11799f
C3 w_n374_n530# a_n288_n400# 0.12268f
C4 a_n288_n400# a_n200_n444# 0.11799f
C5 a_200_n400# a_n288_n400# 0.04287f
C6 a_200_n400# VSUBS 0.20173f
C7 a_n288_n400# VSUBS 0.20173f
C8 w_n374_n530# VSUBS 2.37864f
.ends

.subckt n_w4_l2 a_n288_n400# a_200_n400# a_n200_n444# VSUBS
X0 a_200_n400# a_n200_n444# a_n288_n400# VSUBS nfet_03v3 ad=1.76p pd=8.88u as=1.76p ps=8.88u w=4u l=2u
C0 a_n200_n444# a_n288_n400# 0.11799f
C1 a_n200_n444# a_200_n400# 0.11799f
C2 a_200_n400# a_n288_n400# 0.04287f
C3 a_200_n400# VSUBS 0.34365f
C4 a_n288_n400# VSUBS 0.34365f
.ends

.subckt p_w4_l1 a_n188_n400# a_100_n400# a_n100_n444# w_n274_n530# VSUBS
X0 a_100_n400# a_n100_n444# a_n188_n400# w_n274_n530# pfet_03v3 ad=1.76p pd=8.88u as=1.76p ps=8.88u w=4u l=1u
C0 w_n274_n530# a_n100_n444# 0.12884f
C1 w_n274_n530# a_100_n400# 0.09518f
C2 a_100_n400# a_n100_n444# 0.08505f
C3 w_n274_n530# a_n188_n400# 0.09518f
C4 a_n188_n400# a_n100_n444# 0.08505f
C5 a_100_n400# a_n188_n400# 0.07756f
C6 a_100_n400# VSUBS 0.17557f
C7 a_n188_n400# VSUBS 0.17557f
C8 w_n274_n530# VSUBS 1.74264f
.ends

.subckt r_w1_l14p19 a_n100_1419# a_n100_n1541# VSUBS
X0 a_n100_1419# a_n100_n1541# VSUBS ppolyf_u_1k r_width=1u r_length=14.19u
C0 a_n100_n1541# VSUBS 0.27003f
C1 a_n100_1419# VSUBS 0.27003f
.ends

.subckt p_w0p5_l4 a_n488_n50# a_400_n50# a_n400_n94# w_n574_n180# VSUBS
X0 a_400_n50# a_n400_n94# a_n488_n50# w_n574_n180# pfet_03v3 ad=0.22p pd=1.88u as=0.22p ps=1.88u w=0.5u l=4u
C0 w_n574_n180# a_n400_n94# 0.42229f
C1 w_n574_n180# a_400_n50# 0.01856f
C2 a_400_n50# a_n400_n94# 0.01702f
C3 w_n574_n180# a_n488_n50# 0.01856f
C4 a_n488_n50# a_n400_n94# 0.01702f
C5 a_400_n50# a_n488_n50# 0.0026f
C6 a_400_n50# VSUBS 0.14084f
C7 a_n488_n50# VSUBS 0.14084f
C8 w_n574_n180# VSUBS 1.23984f
.ends

.subckt n_w4_l0p5 a_n138_n400# a_50_n400# a_n50_n444# VSUBS
X0 a_50_n400# a_n50_n444# a_n138_n400# VSUBS nfet_03v3 ad=1.76p pd=8.88u as=1.76p ps=8.88u w=4u l=0.5u
C0 a_n50_n444# a_n138_n400# 0.05179f
C1 a_n50_n444# a_50_n400# 0.05179f
C2 a_50_n400# a_n138_n400# 0.12527f
C3 a_50_n400# VSUBS 0.23105f
C4 a_n138_n400# VSUBS 0.23105f
.ends

.subckt bias_vi en ib_x2 vbn_prb ib_r1 iint vglp vgln vdd el vreset_src vth_cmp vth_ref
+ vss
XPP vdd vdd vbn_prb a_864_6450# vss p_w0p8_l2
XMO vdd a_864_6450# a_864_6450# vdd m1_1276_6360# a_864_6450# m1_1276_6360# a_864_6450#
+ vdd vdd vss p_w4_l2_f4
XPS vdd m1_7102_850# vdd vgln vss p_w0p5_l10
XOR vss ib_r1 vbn_prb ib_r1 vbn_prb vss vss vbn_prb vbn_prb vss n_w2_l2_f4
XKO a_4976_1528# vglp m1_1276_6360# vglp a_4976_1528# m1_1276_6360# vglp vdd vglp
+ m1_1276_6360# vss p_w4_l1_f4
XMR vdd a_864_6450# a_864_6450# vdd m1_5388_6960# a_864_6450# m1_5388_6960# a_864_6450#
+ vdd vdd vss p_w4_l2_f4
XP1 vdd a_2102_5152# a_2102_5152# vdd vss p_w2_l2
XNS vss m1_7102_850# a_5712_1328# m1_7102_850# a_5712_1328# vss n_w4_l2_f2
XPOFF vdd a_864_6450# en vdd vss p_w1_l0p5
XP2 vdd a_864_6450# a_2102_5152# vdd vss p_w2_l2
XMS2 vss en m1_8646_1098# vss n_w0p5_l1
XMS1 m1_8646_1098# m1_7102_850# a_864_6450# vss n_w0p5_l1
XNT vss m1_4894_1238# a_5712_1328# vss n_w2_l2
XMT vdd vdd m1_8332_7080# a_864_6450# vss p_w4_l2
XKR vreset_src vglp m1_5388_6960# vglp vreset_src m1_5388_6960# vglp vdd vglp m1_5388_6960#
+ vss p_w4_l1_f4
XN1 m1_4894_1238# a_864_6450# vglp vss n_w4_l2
XN2 m1_4894_1238# a_2102_5152# a_4976_1528# vss n_w4_l2
XKT m1_8332_7080# vth_ref vglp vdd vss p_w4_l1
XOX vss m1_7440_2050# vbn_prb m1_7440_2050# vbn_prb vss vss vbn_prb vbn_prb vss n_w2_l2_f4
XXR00 a_4976_1528# m1_502_738# vss r_w1_l14p19
XXR01 m1_502_738# m1_942_738# vss r_w1_l14p19
XXR03 m1_1382_738# vss vss r_w1_l14p19
XXR02 m1_942_738# m1_1382_738# vss r_w1_l14p19
XPB vdd a_5712_1328# a_864_6450# vdd vss p_w0p5_l4
XNB vss a_5712_1328# a_5712_1328# vss n_w2_l2
XMC vdd a_864_6450# a_864_6450# vdd m1_8042_6360# a_864_6450# m1_8042_6360# a_864_6450#
+ vdd vdd vss p_w4_l2_f4
XKC vth_cmp vglp m1_8042_6360# vglp vth_cmp m1_8042_6360# vglp vdd vglp m1_8042_6360#
+ vss p_w4_l1_f4
XME vdd a_864_6450# a_864_6450# vdd m1_4546_7560# a_864_6450# m1_4546_7560# a_864_6450#
+ vdd vdd vss p_w4_l2_f4
XPI vdd vdd iint a_864_6450# vss p_w0p8_l2
XSX2 m1_7440_2050# ib_r1 ib_x2 vss n_w4_l0p5
XKE el vglp m1_4546_7560# vglp el m1_4546_7560# vglp vdd vglp m1_4546_7560# vss p_w4_l1_f4
XDB vss vbn_prb vbn_prb vss n_w2_l2
C0 m1_8332_7080# vth_cmp 0.00111f
C1 m1_7440_2050# m1_7102_850# 0.02863f
C2 a_864_6450# m1_4546_7560# 0.73f
C3 m1_8332_7080# el 0.00199f
C4 m1_7440_2050# vgln 0
C5 en a_4976_1528# 0.05046f
C6 vdd m1_4546_7560# 0.40586f
C7 iint a_2102_5152# 0
C8 m1_8042_6360# m1_5388_6960# 0.11312f
C9 vth_ref vth_cmp 0.05697f
C10 m1_8646_1098# m1_7102_850# -0.00509f
C11 vth_ref el 0.71135f
C12 m1_4894_1238# a_4976_1528# 0.17878f
C13 a_4976_1528# vglp 0.38892f
C14 m1_942_738# m1_502_738# 0.42104f
C15 m1_4546_7560# m1_1276_6360# 0.14038f
C16 m1_7102_850# iint 0.3658f
C17 vreset_src m1_8042_6360# 0.26401f
C18 iint vgln 0.12915f
C19 a_5712_1328# a_4976_1528# 0.0106f
C20 a_2102_5152# vgln 0.08399f
C21 m1_8332_7080# m1_8042_6360# 0.13476f
C22 a_864_6450# a_4976_1528# 0.73462f
C23 vbn_prb a_4976_1528# 0.11005f
C24 en m1_4894_1238# 0
C25 m1_4546_7560# el 0.12283f
C26 en vglp 0.59159f
C27 vdd a_4976_1528# 1.4633f
C28 m1_7102_850# vgln 0.08937f
C29 vth_ref m1_8042_6360# 0.00285f
C30 ib_r1 a_4976_1528# 0.24273f
C31 m1_4894_1238# vglp 0.286f
C32 a_4976_1528# m1_1382_738# 0.00776f
C33 en a_5712_1328# 0.05214f
C34 a_4976_1528# m1_1276_6360# 0.30906f
C35 vgln m1_5388_6960# 0.00536f
C36 a_5712_1328# m1_4894_1238# 0.16211f
C37 a_5712_1328# vglp 0.16841f
C38 a_864_6450# en 0.33221f
C39 vbn_prb en 0.26578f
C40 vdd en 0.32674f
C41 vreset_src vgln 0
C42 a_864_6450# m1_4894_1238# 0.3222f
C43 a_864_6450# vglp 0.83998f
C44 vbn_prb m1_4894_1238# 0.02997f
C45 vbn_prb vglp 0.48983f
C46 vreset_src m1_5388_6960# 0.26696f
C47 en ib_r1 0.13773f
C48 en m1_1382_738# 0.14813f
C49 a_4976_1528# el 0.00185f
C50 vdd vglp 5.25107f
C51 ib_r1 m1_4894_1238# 0.16682f
C52 a_864_6450# a_5712_1328# 0.04659f
C53 ib_r1 vglp 0.44719f
C54 vbn_prb a_5712_1328# 0.18056f
C55 vglp m1_1382_738# 0.00131f
C56 ib_x2 a_4976_1528# 0.04795f
C57 vglp m1_1276_6360# 0.16358f
C58 vdd a_5712_1328# 0.56694f
C59 a_5712_1328# ib_r1 0.15887f
C60 vbn_prb a_864_6450# 0.59172f
C61 vth_ref m1_5388_6960# 0
C62 vdd a_864_6450# 10.38485f
C63 vreset_src m1_8332_7080# 0.01543f
C64 vdd vbn_prb 0.24855f
C65 m1_4546_7560# a_2102_5152# 0.0186f
C66 a_864_6450# ib_r1 0.24976f
C67 a_4976_1528# m1_942_738# 0.00922f
C68 vbn_prb ib_r1 0.81062f
C69 vglp vth_cmp 0.28484f
C70 vbn_prb m1_1382_738# 0
C71 a_864_6450# m1_1276_6360# 0.39666f
C72 el vglp 0.41693f
C73 ib_x2 en 0.14421f
C74 vdd ib_r1 0
C75 vth_ref vreset_src 0.1174f
C76 vdd m1_1382_738# 0.0035f
C77 vdd m1_1276_6360# 0.61385f
C78 ib_x2 m1_4894_1238# 0.06226f
C79 ib_x2 vglp 0.10572f
C80 m1_4546_7560# m1_5388_6960# 0.09335f
C81 vth_ref m1_8332_7080# 0.06042f
C82 a_864_6450# vth_cmp 0.02777f
C83 en m1_942_738# 0.00966f
C84 iint a_4976_1528# 0
C85 ib_x2 a_5712_1328# 0.10242f
C86 a_864_6450# el 0.02982f
C87 en m1_7440_2050# 0.05869f
C88 en m1_8042_6360# 0
C89 vdd vth_cmp 0.17797f
C90 m1_4546_7560# vreset_src 0.00447f
C91 vdd el 0.94055f
C92 a_4976_1528# a_2102_5152# 0.4055f
C93 a_864_6450# ib_x2 0.02181f
C94 vbn_prb ib_x2 0.06125f
C95 m1_7440_2050# vglp 0.05819f
C96 vglp m1_8042_6360# 0.2232f
C97 m1_8646_1098# en 0.001f
C98 el m1_1276_6360# 0.00217f
C99 vdd ib_x2 0
C100 ib_x2 ib_r1 0.20298f
C101 en iint 0.17194f
C102 ib_x2 m1_1382_738# 0
C103 a_5712_1328# m1_7440_2050# 0.03242f
C104 a_4976_1528# vgln 0
C105 m1_8646_1098# vglp 0
C106 en a_2102_5152# 0.04646f
C107 m1_4894_1238# iint 0.00172f
C108 iint vglp 0.04831f
C109 a_864_6450# m1_7440_2050# 0.06786f
C110 a_864_6450# m1_8042_6360# 0.5698f
C111 el vth_cmp 0.048f
C112 vbn_prb m1_7440_2050# 0.36218f
C113 vdd m1_942_738# 0.00344f
C114 vbn_prb m1_8042_6360# 0
C115 m1_4894_1238# a_2102_5152# 0.06382f
C116 vdd m1_8042_6360# 0.53891f
C117 a_4976_1528# m1_502_738# 0.04144f
C118 a_2102_5152# vglp 0.09855f
C119 m1_942_738# m1_1382_738# 0.08765f
C120 a_5712_1328# iint 0.29607f
C121 en m1_7102_850# 0.14198f
C122 ib_r1 m1_7440_2050# 0.00546f
C123 m1_8646_1098# a_864_6450# 0.03779f
C124 m1_8646_1098# vbn_prb 0
C125 en vgln 0.06792f
C126 a_5712_1328# a_2102_5152# 0.15699f
C127 m1_4894_1238# m1_7102_850# 0
C128 m1_7102_850# vglp 0.18545f
C129 a_864_6450# iint 0.13343f
C130 vbn_prb iint 0.08998f
C131 vglp vgln 0
C132 vdd iint 0.18374f
C133 vglp m1_5388_6960# 0.15331f
C134 a_864_6450# a_2102_5152# 0.40639f
C135 vbn_prb a_2102_5152# 0.11077f
C136 a_5712_1328# m1_7102_850# 0.54324f
C137 en m1_502_738# 0.01007f
C138 ib_r1 iint 0.10242f
C139 vdd a_2102_5152# 1.73077f
C140 a_5712_1328# vgln 0.3298f
C141 m1_8042_6360# vth_cmp 0.21651f
C142 a_5712_1328# m1_5388_6960# 0.00317f
C143 ib_r1 a_2102_5152# 0.11035f
C144 a_2102_5152# m1_1382_738# 0
C145 a_864_6450# m1_7102_850# 0.14649f
C146 vbn_prb m1_7102_850# 0.11192f
C147 vreset_src vglp 0.54612f
C148 a_2102_5152# m1_1276_6360# 0.00961f
C149 a_864_6450# vgln 0.12647f
C150 vbn_prb vgln 0.23038f
C151 vdd m1_7102_850# 0.12129f
C152 ib_x2 m1_7440_2050# 0.08935f
C153 a_864_6450# m1_5388_6960# 0.32262f
C154 vdd vgln 2.2258f
C155 ib_r1 m1_7102_850# 0.03826f
C156 m1_8332_7080# vglp 0.0652f
C157 vdd m1_5388_6960# 0.62183f
C158 ib_r1 vgln 0.04275f
C159 m1_4546_7560# a_4976_1528# 0.00278f
C160 m1_8646_1098# ib_x2 0.01147f
C161 a_864_6450# vreset_src 0.08448f
C162 vth_ref vglp 0.06719f
C163 ib_x2 iint 0.04728f
C164 vdd m1_502_738# 0.00342f
C165 vdd vreset_src 0.46224f
C166 m1_1382_738# m1_502_738# 0
C167 ib_x2 a_2102_5152# 0.01217f
C168 a_864_6450# m1_8332_7080# 0.09337f
C169 vdd m1_8332_7080# 0.82484f
C170 vth_cmp m1_5388_6960# 0.00607f
C171 m1_8646_1098# m1_7440_2050# 0.00687f
C172 el m1_5388_6960# 0
C173 vth_ref a_864_6450# 0.00723f
C174 ib_x2 m1_7102_850# 0.07339f
C175 m1_7440_2050# iint 0
C176 iint m1_8042_6360# 0
C177 m1_4546_7560# vglp 0.73349f
C178 ib_x2 vgln 0.26925f
C179 vth_ref vdd 0.31053f
C180 vreset_src vth_cmp 0.14964f
C181 vreset_src el 0.03609f
C182 m1_4546_7560# a_5712_1328# 0
C183 m1_7102_850# vss 0.68137f
C184 vbn_prb vss 3.71278f
C185 el vss 0.65712f
C186 ib_x2 vss 3.37258f
C187 iint vss 1.91268f
C188 m1_4546_7560# vss -0.26802f
C189 vth_cmp vss 0.07828f
C190 m1_8042_6360# vss -0.29705f
C191 m1_1382_738# vss 1.13003f
C192 m1_942_738# vss 0.5126f
C193 m1_502_738# vss 0.71186f
C194 m1_7440_2050# vss 0.52223f
C195 vth_ref vss 0.57598f
C196 m1_8332_7080# vss -0.04322f
C197 a_2102_5152# vss 0.19991f
C198 a_4976_1528# vss 1.61618f
C199 a_864_6450# vss -0.98223f
C200 m1_4894_1238# vss 0.33472f
C201 vglp vss 1.49743f
C202 vreset_src vss 0.10863f
C203 m1_5388_6960# vss -0.271f
C204 a_5712_1328# vss 1.81802f
C205 m1_8646_1098# vss 0.01901f
C206 en vss 2.7871f
C207 vdd vss 64.84496f
C208 ib_r1 vss 1.6597f
C209 vgln vss 0.40803f
C210 m1_1276_6360# vss -0.17835f
.ends
