* NGSPICE file created from vdacr_vt.ext - technology: gf180mcuD

.subckt r_w1_l9p86 a_n100_n1108# a_n100_986# VSUBS
X0 a_n100_986# a_n100_n1108# VSUBS ppolyf_u_1k r_width=1u r_length=9.86u
C0 a_n100_n1108# VSUBS 0.27003f
C1 a_n100_986# VSUBS 0.27003f
.ends

.subckt r_w2_l2p5 a_n200_250# a_n200_n372# VSUBS
X0 a_n200_250# a_n200_n372# VSUBS ppolyf_u_1k r_width=2u r_length=2.5u
C0 a_n200_n372# a_n200_250# 0.01672f
C1 a_n200_n372# VSUBS 0.4345f
C2 a_n200_250# VSUBS 0.4345f
.ends

.subckt r_w1_l2p465 a_n100_n369# a_n100_247# VSUBS
X0 a_n100_247# a_n100_n369# VSUBS ppolyf_u_1k r_width=1u r_length=2.47u
C0 a_n100_n369# a_n100_247# 0.00837f
C1 a_n100_n369# VSUBS 0.25651f
C2 a_n100_247# VSUBS 0.25651f
.ends

.subckt r_w1_l4p93 a_n100_n615# a_n100_493# VSUBS
X0 a_n100_493# a_n100_n615# VSUBS ppolyf_u_1k r_width=1u r_length=4.93u
C0 a_n100_n615# a_n100_493# 0.0042f
C1 a_n100_n615# VSUBS 0.2623f
C2 a_n100_493# VSUBS 0.2623f
.ends

.subckt n_w0p5_l0p28 a_n28_n94# a_n116_n50# a_28_n50# VSUBS
X0 a_28_n50# a_n28_n94# a_n116_n50# VSUBS nfet_03v3 ad=0.22p pd=1.88u as=0.22p ps=1.88u w=0.5u l=0.28u
C0 a_n28_n94# a_n116_n50# 0.00377f
C1 a_28_n50# a_n116_n50# 0.02085f
C2 a_28_n50# a_n28_n94# 0.00377f
C3 a_28_n50# VSUBS 0.07987f
C4 a_n116_n50# VSUBS 0.07987f
.ends

.subckt p_w1_l0p28 w_n202_n230# a_28_n100# a_n28_n144# a_n116_n100# VSUBS
X0 a_28_n100# a_n28_n144# a_n116_n100# w_n202_n230# pfet_03v3 ad=0.44p pd=2.88u as=0.44p ps=2.88u w=1u l=0.28u
C0 a_28_n100# w_n202_n230# 0.01808f
C1 w_n202_n230# a_n28_n144# 0.05841f
C2 a_n116_n100# a_28_n100# 0.04256f
C3 a_n116_n100# a_n28_n144# 0.00769f
C4 a_28_n100# a_n28_n144# 0.00769f
C5 a_n116_n100# w_n202_n230# 0.01808f
C6 a_28_n100# VSUBS 0.0597f
C7 a_n116_n100# VSUBS 0.0597f
C8 w_n202_n230# VSUBS 0.55752f
.ends

.subckt r_w1_l13p145 a_n100_1315# a_n100_n1437# VSUBS
X0 a_n100_1315# a_n100_n1437# VSUBS ppolyf_u_1k r_width=1u r_length=13.15u
C0 a_n100_n1437# VSUBS 0.27003f
C1 a_n100_1315# VSUBS 0.27003f
.ends

.subckt r_w1_l13p39 a_n100_n1461# a_n100_1339# VSUBS
X0 a_n100_1339# a_n100_n1461# VSUBS ppolyf_u_1k r_width=1u r_length=13.39u
C0 a_n100_n1461# VSUBS 0.27003f
C1 a_n100_1339# VSUBS 0.27003f
.ends

.subckt n_w6_l0p28_f2 a_52_n644# a_108_n600# a_n108_n644# a_n196_n600# a_n52_n600#
+ VSUBS
X0 a_108_n600# a_52_n644# a_n52_n600# VSUBS nfet_03v3 ad=2.64p pd=12.88u as=1.56p ps=6.52u w=6u l=0.28u
X1 a_n52_n600# a_n108_n644# a_n196_n600# VSUBS nfet_03v3 ad=1.56p pd=6.52u as=2.64p ps=12.88u w=6u l=0.28u
C0 a_n52_n600# a_n108_n644# 0.04695f
C1 a_n108_n644# a_52_n644# 0.00519f
C2 a_108_n600# a_n52_n600# 0.2597f
C3 a_108_n600# a_52_n644# 0.04695f
C4 a_n196_n600# a_n52_n600# 0.2597f
C5 a_n52_n600# a_52_n644# 0.04695f
C6 a_n196_n600# a_n108_n644# 0.04695f
C7 a_108_n600# VSUBS 0.28641f
C8 a_n52_n600# VSUBS 0.09458f
C9 a_n196_n600# VSUBS 0.28641f
.ends

.subckt vdacr_vt b0 b1 b2 b3 b4 b5 vdd out vss
XXRS4_0 m1_4662_4448# m1_4338_2410# vss r_w1_l9p86
XXRS4_1 m1_5102_4448# m1_4662_4448# vss r_w1_l9p86
XXRS0 m1_1960_3480# m1_2552_3600# vss r_w2_l2p5
XXRS1 m1_3154_2770# m1_2552_3600# vss r_w1_l2p465
XXRS3 m1_4338_2410# m1_3782_4448# vss r_w1_l9p86
XXRS2 m1_3782_4448# m1_3154_2770# vss r_w1_l4p93
XIB5n b5 vss a_5004_3816# vss n_w0p5_l0p28
XIB4n b4 vss a_4412_3816# vss n_w0p5_l0p28
XIB5p vdd a_5004_3816# b5 vdd vss p_w1_l0p28
XIB3n b3 vss a_3820_3816# vss n_w0p5_l0p28
XIB4p vdd a_4412_3816# b4 vdd vss p_w1_l0p28
XIB2n b2 vss a_3228_3816# vss n_w0p5_l0p28
XIB3p vdd a_3820_3816# b3 vdd vss p_w1_l0p28
XIB2p vdd a_3228_3816# b2 vdd vss p_w1_l0p28
XIB1n b1 vss a_2636_3816# vss n_w0p5_l0p28
XIB0n b0 vss a_2044_3816# vss n_w0p5_l0p28
XIB1p vdd a_2636_3816# b1 vdd vss p_w1_l0p28
XIB0p vdd a_2044_3816# b0 vdd vss p_w1_l0p28
XXRS5_0 m1_5102_4448# m1_5520_4446# vss r_w1_l13p145
XXRS5_1 m1_5520_4446# m1_5982_4448# vss r_w1_l13p145
XXRB0 m1_502_4448# out vss r_w1_l13p39
XSW0 a_2044_3816# m1_1960_3480# a_2044_3816# m1_1960_3480# m1_2552_3600# vss n_w6_l0p28_f2
XXRS5_2 m1_5982_4448# vss vss r_w1_l13p145
XXRB1 m1_942_4448# m1_502_4448# vss r_w1_l13p39
XSW2 a_3228_3816# m1_3154_2770# a_3228_3816# m1_3154_2770# m1_3782_4448# vss n_w6_l0p28_f2
XSW1 a_2636_3816# m1_2552_3600# a_2636_3816# m1_2552_3600# m1_3154_2770# vss n_w6_l0p28_f2
XXRB3 m1_1800_4446# m1_1382_4448# vss r_w1_l13p39
XXRB2 m1_1382_4448# m1_942_4448# vss r_w1_l13p39
XSW3 a_3820_3816# m1_3782_4448# a_3820_3816# m1_3782_4448# m1_4338_2410# vss n_w6_l0p28_f2
XXRB4 m1_1960_3480# m1_1800_4446# vss r_w1_l13p39
XSW4 a_4412_3816# m1_4338_2410# a_4412_3816# m1_4338_2410# m1_5102_4448# vss n_w6_l0p28_f2
XSW5 a_5004_3816# m1_5102_4448# a_5004_3816# m1_5102_4448# vss vss n_w6_l0p28_f2
C0 vdd m1_3782_4448# 0
C1 vdd a_4412_3816# 0.58013f
C2 vdd m1_3154_2770# 0
C3 m1_5102_4448# b4 0.02031f
C4 b4 m1_4338_2410# 0
C5 vdd b0 0.72903f
C6 m1_1382_4448# m1_502_4448# 0.00218f
C7 m1_5102_4448# m1_4338_2410# 0.20899f
C8 m1_2552_3600# b2 0.00776f
C9 m1_5520_4446# a_5004_3816# 0
C10 a_2044_3816# a_2636_3816# 0.12355f
C11 m1_2552_3600# m1_3782_4448# 0.00817f
C12 m1_2552_3600# m1_3154_2770# 0.36701f
C13 a_2636_3816# m1_4338_2410# 0
C14 m1_4662_4448# m1_5102_4448# 0.0195f
C15 m1_1960_3480# m1_3782_4448# 0
C16 m1_4662_4448# m1_4338_2410# 0.14655f
C17 m1_1960_3480# m1_3154_2770# 0.00496f
C18 m1_1382_4448# out 0.03295f
C19 b4 b5 0.03934f
C20 m1_1800_4446# out 0.01776f
C21 m1_5982_4448# m1_5520_4446# 0.09588f
C22 m1_5102_4448# b5 0.00829f
C23 m1_2552_3600# vdd 0.00405f
C24 b1 b2 0.10373f
C25 a_3820_3816# b3 0.08757f
C26 m1_5520_4446# m1_3782_4448# 0
C27 m1_1960_3480# m1_942_4448# 0
C28 a_3820_3816# a_3228_3816# 0.11538f
C29 b3 b2 0.03065f
C30 b2 a_3228_3816# 0.05855f
C31 m1_3782_4448# b3 0.04072f
C32 b3 a_4412_3816# 0.01861f
C33 b1 b0 0.01305f
C34 b4 a_5004_3816# 0.00878f
C35 m1_3782_4448# a_3228_3816# 0.22601f
C36 a_4412_3816# a_3228_3816# 0
C37 m1_3154_2770# a_3228_3816# 0.26207f
C38 m1_1382_4448# a_2044_3816# 0.00163f
C39 m1_942_4448# m1_502_4448# 0.19644f
C40 m1_5102_4448# a_5004_3816# 0.28378f
C41 m1_2552_3600# m1_1960_3480# 0.37841f
C42 m1_1800_4446# a_2044_3816# 0.00176f
C43 m1_4338_2410# a_5004_3816# 0.02538f
C44 b1 vdd 0.53843f
C45 vdd b3 0.67459f
C46 a_3820_3816# b4 0.00664f
C47 m1_1800_4446# a_2636_3816# 0.00122f
C48 m1_4662_4448# a_5004_3816# 0.00155f
C49 vdd a_3228_3816# 0.23357f
C50 m1_942_4448# out 0.01887f
C51 b4 b2 0
C52 m1_5102_4448# a_3820_3816# 0
C53 m1_5102_4448# m1_5982_4448# 0.57405f
C54 a_3820_3816# m1_4338_2410# 0.19218f
C55 m1_2552_3600# b1 0.01147f
C56 b4 a_4412_3816# 0.35266f
C57 m1_1960_3480# m1_502_4448# 0
C58 b5 a_5004_3816# 0.15307f
C59 m1_3782_4448# a_2044_3816# 0
C60 a_2636_3816# a_3820_3816# 0
C61 a_2044_3816# m1_3154_2770# 0.00373f
C62 m1_5102_4448# m1_3782_4448# 0.00186f
C63 m1_1960_3480# b1 0.00709f
C64 m1_5102_4448# a_4412_3816# 0.1614f
C65 m1_3782_4448# m1_4338_2410# 0.61954f
C66 m1_2552_3600# a_3228_3816# 0.01374f
C67 a_4412_3816# m1_4338_2410# 0.28026f
C68 m1_3154_2770# m1_4338_2410# 0.00391f
C69 m1_4662_4448# m1_5982_4448# 0
C70 a_2636_3816# b2 0.03126f
C71 a_2044_3816# b0 0.1097f
C72 m1_3782_4448# a_2636_3816# 0.0022f
C73 m1_1960_3480# a_3228_3816# 0.0051f
C74 a_2636_3816# m1_3154_2770# 0.05698f
C75 vdd b4 0.37675f
C76 m1_4662_4448# m1_3782_4448# 0.00116f
C77 m1_4662_4448# m1_3154_2770# 0
C78 a_2636_3816# b0 0.00192f
C79 vdd a_2044_3816# 0.21932f
C80 m1_5102_4448# vdd 0.00843f
C81 vdd m1_4338_2410# 0.01247f
C82 m1_1382_4448# m1_1800_4446# 0.20167f
C83 b1 b3 0
C84 b5 a_4412_3816# 0.07213f
C85 vdd a_2636_3816# 0.48405f
C86 out m1_502_4448# 0.06313f
C87 b1 a_3228_3816# 0
C88 m1_2552_3600# a_2044_3816# 0.05424f
C89 b3 a_3228_3816# 0.07364f
C90 m1_2552_3600# m1_4338_2410# 0
C91 a_3820_3816# a_5004_3816# 0
C92 m1_1960_3480# a_2044_3816# 0.11684f
C93 vdd b5 0.82504f
C94 m1_1960_3480# m1_4338_2410# 0
C95 m1_2552_3600# a_2636_3816# 0.45123f
C96 m1_4662_4448# m1_2552_3600# 0
C97 a_4412_3816# a_5004_3816# 0.11341f
C98 m1_1960_3480# a_2636_3816# 0.33503f
C99 m1_1800_4446# m1_3154_2770# 0
C100 m1_5102_4448# m1_5520_4446# 0.51516f
C101 b1 a_2044_3816# 0.01614f
C102 b3 b4 0.01497f
C103 m1_1382_4448# m1_942_4448# 0.23293f
C104 m1_3782_4448# a_3820_3816# 0.28025f
C105 vdd a_5004_3816# 0.28994f
C106 a_3820_3816# a_4412_3816# 0.3723f
C107 a_3820_3816# m1_3154_2770# 0.01262f
C108 m1_1800_4446# m1_942_4448# 0.00177f
C109 a_2044_3816# a_3228_3816# 0.00201f
C110 b3 m1_4338_2410# 0.00198f
C111 m1_4662_4448# m1_5520_4446# 0.06288f
C112 b1 a_2636_3816# 0.31501f
C113 m1_5102_4448# a_3228_3816# 0
C114 a_4412_3816# b2 0
C115 m1_3154_2770# b2 0.0129f
C116 m1_4338_2410# a_3228_3816# 0.01198f
C117 a_2636_3816# b3 0
C118 m1_3782_4448# a_4412_3816# 0.01877f
C119 m1_3782_4448# m1_3154_2770# 0.41159f
C120 m1_3154_2770# a_4412_3816# 0
C121 a_2636_3816# a_3228_3816# 0.02455f
C122 vdd a_3820_3816# 0.22012f
C123 m1_2552_3600# m1_1800_4446# 0
C124 m1_1382_4448# m1_1960_3480# 0
C125 vdd b2 0.59159f
C126 m1_1960_3480# m1_1800_4446# 0.1115f
C127 m1_5102_4448# vss 1.5708f
C128 m1_4338_2410# vss 0.35422f
C129 m1_1382_4448# vss 0.42929f
C130 m1_1800_4446# vss 0.74335f
C131 m1_3782_4448# vss 0.6934f
C132 m1_3154_2770# vss 0.501f
C133 m1_942_4448# vss 0.46029f
C134 m1_2552_3600# vss 0.22851f
C135 m1_1960_3480# vss 0.2572f
C136 m1_502_4448# vss 0.81591f
C137 out vss 0.86822f
C138 m1_5982_4448# vss 0.64037f
C139 m1_5520_4446# vss 0.49895f
C140 a_2044_3816# vss 1.04554f
C141 b0 vss 0.67834f
C142 vdd vss 19.03292f
C143 a_2636_3816# vss 1.21061f
C144 b1 vss 0.51924f
C145 a_3228_3816# vss 0.53148f
C146 b2 vss 0.5744f
C147 a_3820_3816# vss 0.37608f
C148 b3 vss 0.49257f
C149 a_4412_3816# vss 0.56001f
C150 b4 vss 0.64441f
C151 a_5004_3816# vss 1.09951f
C152 b5 vss 0.58902f
C153 m1_4662_4448# vss 0.49234f
.ends
