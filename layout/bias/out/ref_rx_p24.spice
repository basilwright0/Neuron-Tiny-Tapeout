.subckt rx_p24 line vdd vss
XD0 line line vdd vdd pfet_03v3 W=2u L=4u
.ends rx_p24
