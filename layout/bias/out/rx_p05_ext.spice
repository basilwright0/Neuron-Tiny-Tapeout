* NGSPICE file created from rx_p05.ext - technology: gf180mcuD

.subckt p_w1_l4 a_n488_n100# a_400_n100# a_n400_n144# w_n574_n230#
X0 a_400_n100# a_n400_n144# a_n488_n100# w_n574_n230# pfet_03v3 ad=0.44p pd=2.88u as=0.44p ps=2.88u w=1u l=4u
.ends

.subckt rx_p05 line vdd vss
XD vdd line line vdd p_w1_l4
.ends
