* NGSPICE file created from bias_b1.ext - technology: gf180mcuD

.subckt n_w2_l4_f4 a_n52_n200# a_852_n200# a_n852_n244# a_n956_n200# a_52_n244# a_n1756_n244#
+ a_1756_n200# a_n1844_n200# a_956_n244# VSUBS
X0 a_852_n200# a_52_n244# a_n52_n200# VSUBS nfet_03v3 ad=0.52p pd=2.52u as=0.52p ps=2.52u w=2u l=4u
X1 a_1756_n200# a_956_n244# a_852_n200# VSUBS nfet_03v3 ad=0.88p pd=4.88u as=0.52p ps=2.52u w=2u l=4u
X2 a_n956_n200# a_n1756_n244# a_n1844_n200# VSUBS nfet_03v3 ad=0.52p pd=2.52u as=0.88p ps=4.88u w=2u l=4u
X3 a_n52_n200# a_n852_n244# a_n956_n200# VSUBS nfet_03v3 ad=0.52p pd=2.52u as=0.52p ps=2.52u w=2u l=4u
C0 a_n852_n244# a_n956_n200# 0.07019f
C1 a_52_n244# a_n52_n200# 0.07019f
C2 a_52_n244# a_852_n200# 0.07019f
C3 a_52_n244# a_956_n244# 0.00519f
C4 a_n1756_n244# a_n1844_n200# 0.07019f
C5 a_52_n244# a_n852_n244# 0.00519f
C6 a_n1756_n244# a_n956_n200# 0.07019f
C7 a_n52_n200# a_852_n200# 0.01073f
C8 a_n1756_n244# a_n852_n244# 0.00519f
C9 a_n52_n200# a_n956_n200# 0.01073f
C10 a_956_n244# a_852_n200# 0.07019f
C11 a_n1844_n200# a_n956_n200# 0.01073f
C12 a_n852_n244# a_n52_n200# 0.07019f
C13 a_852_n200# a_1756_n200# 0.01073f
C14 a_956_n244# a_1756_n200# 0.07019f
C15 a_1756_n200# VSUBS 0.41176f
C16 a_852_n200# VSUBS 0.648f
C17 a_n52_n200# VSUBS 0.64292f
C18 a_n956_n200# VSUBS 0.648f
C19 a_n1844_n200# VSUBS 0.41176f
.ends

.subckt rx_n4 line vdd vss
XD vss line line line line line vss vss line vss n_w2_l4_f4
C0 vdd vss 0.06604f
C1 line vss 2.16208f
.ends

.subckt n_w2_l4_f2 a_n52_n200# a_852_n200# a_n852_n244# a_n940_n200# a_52_n244# VSUBS
X0 a_852_n200# a_52_n244# a_n52_n200# VSUBS nfet_03v3 ad=0.88p pd=4.88u as=0.52p ps=2.52u w=2u l=4u
X1 a_n52_n200# a_n852_n244# a_n940_n200# VSUBS nfet_03v3 ad=0.52p pd=2.52u as=0.88p ps=4.88u w=2u l=4u
C0 a_n940_n200# a_n52_n200# 0.01073f
C1 a_52_n244# a_n852_n244# 0.00519f
C2 a_52_n244# a_852_n200# 0.07019f
C3 a_52_n244# a_n52_n200# 0.07019f
C4 a_n852_n244# a_n52_n200# 0.07019f
C5 a_n940_n200# a_n852_n244# 0.07019f
C6 a_852_n200# a_n52_n200# 0.01073f
C7 a_852_n200# VSUBS 0.41176f
C8 a_n52_n200# VSUBS 0.65308f
C9 a_n940_n200# VSUBS 0.41176f
.ends

.subckt rx_n2 line vdd vss
XD line vss line vss line vss n_w2_l4_f2
C0 line vdd 0.00181f
C1 vdd vss 0.06098f
C2 line vss 1.08247f
.ends

.subckt p_w2_l4 a_400_n200# a_n400_n244# w_n574_n330# a_n488_n200# VSUBS
X0 a_400_n200# a_n400_n244# a_n488_n200# w_n574_n330# pfet_03v3 ad=0.88p pd=4.88u as=0.88p ps=4.88u w=2u l=4u
C0 w_n574_n330# a_n488_n200# 0.07409f
C1 w_n574_n330# a_n400_n244# 0.42229f
C2 w_n574_n330# a_400_n200# 0.07409f
C3 a_n488_n200# a_n400_n244# 0.07019f
C4 a_n488_n200# a_400_n200# 0.01073f
C5 a_n400_n244# a_400_n200# 0.07019f
C6 a_400_n200# VSUBS 0.18936f
C7 a_n488_n200# VSUBS 0.18936f
C8 w_n574_n330# VSUBS 2.27304f
.ends

.subckt rx_p24 vss vdd line
XD line line vdd vdd vss p_w2_l4
C0 vdd line 0.78494f
C1 line vss -0.06364f
C2 vdd vss 5.17939f
.ends

.subckt n_w2_l4 a_400_n200# a_n400_n244# a_n488_n200# VSUBS
X0 a_400_n200# a_n400_n244# a_n488_n200# VSUBS nfet_03v3 ad=0.88p pd=4.88u as=0.88p ps=4.88u w=2u l=4u
C0 a_n488_n200# a_n400_n244# 0.07019f
C1 a_n400_n244# a_400_n200# 0.07019f
C2 a_n488_n200# a_400_n200# 0.01073f
C3 a_400_n200# VSUBS 0.41684f
C4 a_n488_n200# VSUBS 0.41684f
.ends

.subckt rx_n1 vdd vss line
XD line line vss vss n_w2_l4
C0 vdd line 0.00323f
C1 vdd vss 0.05846f
C2 line vss 0.60968f
.ends

.subckt p_w1_l4 a_n488_n100# a_400_n100# a_n400_n144# w_n574_n230# VSUBS
X0 a_400_n100# a_n400_n144# a_n488_n100# w_n574_n230# pfet_03v3 ad=0.44p pd=2.88u as=0.44p ps=2.88u w=1u l=4u
C0 a_400_n100# w_n574_n230# 0.03707f
C1 a_400_n100# a_n488_n100# 0.00531f
C2 w_n574_n230# a_n488_n100# 0.03707f
C3 a_400_n100# a_n400_n144# 0.03474f
C4 a_n400_n144# w_n574_n230# 0.42229f
C5 a_n400_n144# a_n488_n100# 0.03474f
C6 a_400_n100# VSUBS 0.15701f
C7 a_n488_n100# VSUBS 0.15701f
C8 w_n574_n230# VSUBS 1.58424f
.ends

.subckt rx_p05 line vdd vss
XD vdd line line vdd vss p_w1_l4
C0 line vdd 0.81576f
C1 line vss 0.00304f
C2 vdd vss 5.0752f
.ends

.subckt p_w4_l2_f5 a_n304_n400# a_704_n400# a_n704_n444# a_n808_n400# a_304_n444#
+ a_n1208_n444# a_n1296_n400# a_1208_n400# w_n1382_n530# a_200_n400# a_808_n444# a_n200_n444#
+ VSUBS
X0 a_1208_n400# a_808_n444# a_704_n400# w_n1382_n530# pfet_03v3 ad=1.76p pd=8.88u as=1.04p ps=4.52u w=4u l=2u
X1 a_704_n400# a_304_n444# a_200_n400# w_n1382_n530# pfet_03v3 ad=1.04p pd=4.52u as=1.04p ps=4.52u w=4u l=2u
X2 a_n808_n400# a_n1208_n444# a_n1296_n400# w_n1382_n530# pfet_03v3 ad=1.04p pd=4.52u as=1.76p ps=8.88u w=4u l=2u
X3 a_n304_n400# a_n704_n444# a_n808_n400# w_n1382_n530# pfet_03v3 ad=1.04p pd=4.52u as=1.04p ps=4.52u w=4u l=2u
X4 a_200_n400# a_n200_n444# a_n304_n400# w_n1382_n530# pfet_03v3 ad=1.04p pd=4.52u as=1.04p ps=4.52u w=4u l=2u
C0 a_304_n444# a_200_n400# 0.11799f
C1 a_n808_n400# w_n1382_n530# 0.18497f
C2 w_n1382_n530# a_808_n444# 0.2233f
C3 a_n200_n444# w_n1382_n530# 0.21994f
C4 w_n1382_n530# a_n1296_n400# 0.12268f
C5 w_n1382_n530# a_n1208_n444# 0.2233f
C6 a_200_n400# a_n304_n400# 0.04287f
C7 a_304_n444# a_808_n444# 0.00519f
C8 a_304_n444# a_n200_n444# 0.00519f
C9 w_n1382_n530# a_n704_n444# 0.21994f
C10 w_n1382_n530# a_704_n400# 0.18497f
C11 a_n808_n400# a_n304_n400# 0.04287f
C12 a_n200_n444# a_200_n400# 0.11799f
C13 a_n200_n444# a_n304_n400# 0.11799f
C14 a_1208_n400# a_808_n444# 0.11799f
C15 a_304_n444# a_704_n400# 0.11799f
C16 a_n304_n400# a_n704_n444# 0.11799f
C17 a_n808_n400# a_n1296_n400# 0.04287f
C18 a_200_n400# a_704_n400# 0.04287f
C19 a_n808_n400# a_n1208_n444# 0.11799f
C20 a_1208_n400# a_704_n400# 0.04287f
C21 a_n1296_n400# a_n1208_n444# 0.11799f
C22 a_n808_n400# a_n704_n444# 0.11799f
C23 a_304_n444# w_n1382_n530# 0.21994f
C24 a_n200_n444# a_n704_n444# 0.00519f
C25 a_n1208_n444# a_n704_n444# 0.00519f
C26 a_808_n444# a_704_n400# 0.11799f
C27 a_200_n400# w_n1382_n530# 0.18497f
C28 w_n1382_n530# a_n304_n400# 0.18497f
C29 a_1208_n400# w_n1382_n530# 0.12268f
C30 a_1208_n400# VSUBS 0.19832f
C31 a_704_n400# VSUBS 0.12191f
C32 a_200_n400# VSUBS 0.11851f
C33 a_n304_n400# VSUBS 0.11851f
C34 a_n808_n400# VSUBS 0.12191f
C35 a_n1296_n400# VSUBS 0.19832f
C36 w_n1382_n530# VSUBS 8.78952f
.ends

.subckt p_w2_l1 a_100_n200# a_n100_n244# w_n274_n330# a_n188_n200# VSUBS
X0 a_100_n200# a_n100_n244# a_n188_n200# w_n274_n330# pfet_03v3 ad=0.88p pd=4.88u as=0.88p ps=4.88u w=2u l=1u
C0 a_100_n200# a_n188_n200# 0.03858f
C1 a_100_n200# a_n100_n244# 0.04231f
C2 a_n100_n244# a_n188_n200# 0.04231f
C3 a_100_n200# w_n274_n330# 0.04851f
C4 a_n188_n200# w_n274_n330# 0.04851f
C5 a_n100_n244# w_n274_n330# 0.12884f
C6 a_100_n200# VSUBS 0.11088f
C7 a_n188_n200# VSUBS 0.11088f
C8 w_n274_n330# VSUBS 1.08504f
.ends

.subckt n_w4_l2_f6 a_n956_n444# a_1060_n444# a_556_n444# a_n52_n400# a_n1548_n400#
+ a_n1060_n400# a_452_n400# a_n452_n444# a_n556_n400# a_n1460_n444# a_1460_n400# a_52_n444#
+ a_956_n400# VSUBS
X0 a_n556_n400# a_n956_n444# a_n1060_n400# VSUBS nfet_03v3 ad=1.04p pd=4.52u as=1.04p ps=4.52u w=4u l=2u
X1 a_n52_n400# a_n452_n444# a_n556_n400# VSUBS nfet_03v3 ad=1.04p pd=4.52u as=1.04p ps=4.52u w=4u l=2u
X2 a_452_n400# a_52_n444# a_n52_n400# VSUBS nfet_03v3 ad=1.04p pd=4.52u as=1.04p ps=4.52u w=4u l=2u
X3 a_n1060_n400# a_n1460_n444# a_n1548_n400# VSUBS nfet_03v3 ad=1.04p pd=4.52u as=1.76p ps=8.88u w=4u l=2u
X4 a_956_n400# a_556_n444# a_452_n400# VSUBS nfet_03v3 ad=1.04p pd=4.52u as=1.04p ps=4.52u w=4u l=2u
X5 a_1460_n400# a_1060_n444# a_956_n400# VSUBS nfet_03v3 ad=1.76p pd=8.88u as=1.04p ps=4.52u w=4u l=2u
C0 a_956_n400# a_556_n444# 0.11799f
C1 a_1060_n444# a_1460_n400# 0.11799f
C2 a_n52_n400# a_452_n400# 0.04287f
C3 a_52_n444# a_n452_n444# 0.00519f
C4 a_n1060_n400# a_n956_n444# 0.11799f
C5 a_n1060_n400# a_n1548_n400# 0.04287f
C6 a_n556_n400# a_n52_n400# 0.04287f
C7 a_n1060_n400# a_n1460_n444# 0.11799f
C8 a_n956_n444# a_n452_n444# 0.00519f
C9 a_n1060_n400# a_n556_n400# 0.04287f
C10 a_52_n444# a_452_n400# 0.11799f
C11 a_1460_n400# a_956_n400# 0.04287f
C12 a_n956_n444# a_n1460_n444# 0.00519f
C13 a_n556_n400# a_n452_n444# 0.11799f
C14 a_1060_n444# a_956_n400# 0.11799f
C15 a_52_n444# a_556_n444# 0.00519f
C16 a_n1548_n400# a_n1460_n444# 0.11799f
C17 a_1060_n444# a_556_n444# 0.00519f
C18 a_n556_n400# a_n956_n444# 0.11799f
C19 a_452_n400# a_956_n400# 0.04287f
C20 a_52_n444# a_n52_n400# 0.11799f
C21 a_n52_n400# a_n452_n444# 0.11799f
C22 a_452_n400# a_556_n444# 0.11799f
C23 a_1460_n400# VSUBS 0.33857f
C24 a_956_n400# VSUBS 0.34773f
C25 a_452_n400# VSUBS 0.34265f
C26 a_n52_n400# VSUBS 0.34265f
C27 a_n556_n400# VSUBS 0.34265f
C28 a_n1060_n400# VSUBS 0.34773f
C29 a_n1548_n400# VSUBS 0.33857f
.ends

.subckt n_w2_l2_f2 a_n52_n200# a_452_n200# a_n452_n244# a_n540_n200# a_52_n244# VSUBS
X0 a_452_n200# a_52_n244# a_n52_n200# VSUBS nfet_03v3 ad=0.88p pd=4.88u as=0.52p ps=2.52u w=2u l=2u
X1 a_n52_n200# a_n452_n244# a_n540_n200# VSUBS nfet_03v3 ad=0.52p pd=2.52u as=0.88p ps=4.88u w=2u l=2u
C0 a_52_n244# a_452_n200# 0.0587f
C1 a_n540_n200# a_n52_n200# 0.02133f
C2 a_n452_n244# a_n52_n200# 0.0587f
C3 a_n452_n244# a_52_n244# 0.00519f
C4 a_n452_n244# a_n540_n200# 0.0587f
C5 a_n52_n200# a_452_n200# 0.02133f
C6 a_52_n244# a_n52_n200# 0.0587f
C7 a_452_n200# VSUBS 0.26162f
C8 a_n52_n200# VSUBS 0.35281f
C9 a_n540_n200# VSUBS 0.26162f
.ends

.subckt n_w2_l1 a_100_n200# a_n100_n244# a_n188_n200# VSUBS
X0 a_100_n200# a_n100_n244# a_n188_n200# VSUBS nfet_03v3 ad=0.88p pd=4.88u as=0.88p ps=4.88u w=2u l=1u
C0 a_n188_n200# a_100_n200# 0.03858f
C1 a_n100_n244# a_n188_n200# 0.04231f
C2 a_n100_n244# a_100_n200# 0.04231f
C3 a_100_n200# VSUBS 0.19164f
C4 a_n188_n200# VSUBS 0.19164f
.ends

.subckt p_w2_l2_f8 a_n52_n200# a_n1060_n200# a_452_n200# a_1564_n244# a_n452_n244#
+ w_n2138_n330# a_n556_n200# a_n1460_n244# a_1460_n200# a_52_n244# a_n1564_n200# a_956_n200#
+ a_n2052_n200# a_n956_n244# a_1060_n244# a_n1964_n244# a_556_n244# a_1964_n200# VSUBS
X0 a_1964_n200# a_1564_n244# a_1460_n200# w_n2138_n330# pfet_03v3 ad=0.88p pd=4.88u as=0.52p ps=2.52u w=2u l=2u
X1 a_452_n200# a_52_n244# a_n52_n200# w_n2138_n330# pfet_03v3 ad=0.52p pd=2.52u as=0.52p ps=2.52u w=2u l=2u
X2 a_956_n200# a_556_n244# a_452_n200# w_n2138_n330# pfet_03v3 ad=0.52p pd=2.52u as=0.52p ps=2.52u w=2u l=2u
X3 a_1460_n200# a_1060_n244# a_956_n200# w_n2138_n330# pfet_03v3 ad=0.52p pd=2.52u as=0.52p ps=2.52u w=2u l=2u
X4 a_n1564_n200# a_n1964_n244# a_n2052_n200# w_n2138_n330# pfet_03v3 ad=0.52p pd=2.52u as=0.88p ps=4.88u w=2u l=2u
X5 a_n1060_n200# a_n1460_n244# a_n1564_n200# w_n2138_n330# pfet_03v3 ad=0.52p pd=2.52u as=0.52p ps=2.52u w=2u l=2u
X6 a_n556_n200# a_n956_n244# a_n1060_n200# w_n2138_n330# pfet_03v3 ad=0.52p pd=2.52u as=0.52p ps=2.52u w=2u l=2u
X7 a_n52_n200# a_n452_n244# a_n556_n200# w_n2138_n330# pfet_03v3 ad=0.52p pd=2.52u as=0.52p ps=2.52u w=2u l=2u
C0 w_n2138_n330# a_n556_n200# 0.09155f
C1 a_n1564_n200# a_n1460_n244# 0.0587f
C2 w_n2138_n330# a_n1060_n200# 0.09155f
C3 a_1564_n244# w_n2138_n330# 0.2233f
C4 a_1460_n200# a_1060_n244# 0.0587f
C5 a_956_n200# a_1060_n244# 0.0587f
C6 a_1460_n200# a_1964_n200# 0.02133f
C7 a_n1460_n244# a_n956_n244# 0.00519f
C8 a_n556_n200# a_n1060_n200# 0.02133f
C9 w_n2138_n330# a_n1564_n200# 0.09155f
C10 a_n52_n200# a_n452_n244# 0.0587f
C11 w_n2138_n330# a_1060_n244# 0.21994f
C12 w_n2138_n330# a_1964_n200# 0.0618f
C13 a_n1964_n244# a_n1460_n244# 0.00519f
C14 w_n2138_n330# a_n2052_n200# 0.0618f
C15 w_n2138_n330# a_n956_n244# 0.21994f
C16 a_n1564_n200# a_n1060_n200# 0.02133f
C17 a_956_n200# a_556_n244# 0.0587f
C18 a_452_n200# a_556_n244# 0.0587f
C19 w_n2138_n330# a_n452_n244# 0.21994f
C20 w_n2138_n330# a_n1964_n244# 0.2233f
C21 a_1564_n244# a_1060_n244# 0.00519f
C22 a_n556_n200# a_n956_n244# 0.0587f
C23 a_52_n244# a_n452_n244# 0.00519f
C24 a_1564_n244# a_1964_n200# 0.0587f
C25 a_n1060_n200# a_n956_n244# 0.0587f
C26 w_n2138_n330# a_556_n244# 0.21994f
C27 a_n556_n200# a_n452_n244# 0.0587f
C28 a_52_n244# a_556_n244# 0.00519f
C29 a_n52_n200# a_452_n200# 0.02133f
C30 a_n1564_n200# a_n2052_n200# 0.02133f
C31 a_956_n200# a_1460_n200# 0.02133f
C32 a_452_n200# a_956_n200# 0.02133f
C33 w_n2138_n330# a_n52_n200# 0.09155f
C34 w_n2138_n330# a_n1460_n244# 0.21994f
C35 w_n2138_n330# a_1460_n200# 0.09155f
C36 a_52_n244# a_n52_n200# 0.0587f
C37 a_n1964_n244# a_n1564_n200# 0.0587f
C38 w_n2138_n330# a_956_n200# 0.09155f
C39 w_n2138_n330# a_452_n200# 0.09155f
C40 a_n52_n200# a_n556_n200# 0.02133f
C41 a_52_n244# a_452_n200# 0.0587f
C42 a_n1964_n244# a_n2052_n200# 0.0587f
C43 a_n956_n244# a_n452_n244# 0.00519f
C44 a_1060_n244# a_556_n244# 0.00519f
C45 a_n1460_n244# a_n1060_n200# 0.0587f
C46 w_n2138_n330# a_52_n244# 0.21994f
C47 a_1564_n244# a_1460_n200# 0.0587f
C48 a_1964_n200# VSUBS 0.13364f
C49 a_1460_n200# VSUBS 0.12191f
C50 a_956_n200# VSUBS 0.11851f
C51 a_452_n200# VSUBS 0.11851f
C52 a_n52_n200# VSUBS 0.11851f
C53 a_n556_n200# VSUBS 0.11851f
C54 a_n1060_n200# VSUBS 0.11851f
C55 a_n1564_n200# VSUBS 0.12191f
C56 a_n2052_n200# VSUBS 0.13364f
C57 w_n2138_n330# VSUBS 8.46648f
.ends

.subckt n_w2_l2_f8 a_n52_n200# a_n1060_n200# a_452_n200# a_1564_n244# a_n452_n244#
+ a_n556_n200# a_n1460_n244# a_1460_n200# a_52_n244# a_n1564_n200# a_956_n200# a_n2052_n200#
+ a_n956_n244# a_1060_n244# a_n1964_n244# a_556_n244# a_1964_n200# VSUBS
X0 a_1964_n200# a_1564_n244# a_1460_n200# VSUBS nfet_03v3 ad=0.88p pd=4.88u as=0.52p ps=2.52u w=2u l=2u
X1 a_452_n200# a_52_n244# a_n52_n200# VSUBS nfet_03v3 ad=0.52p pd=2.52u as=0.52p ps=2.52u w=2u l=2u
X2 a_956_n200# a_556_n244# a_452_n200# VSUBS nfet_03v3 ad=0.52p pd=2.52u as=0.52p ps=2.52u w=2u l=2u
X3 a_1460_n200# a_1060_n244# a_956_n200# VSUBS nfet_03v3 ad=0.52p pd=2.52u as=0.52p ps=2.52u w=2u l=2u
X4 a_n1564_n200# a_n1964_n244# a_n2052_n200# VSUBS nfet_03v3 ad=0.52p pd=2.52u as=0.88p ps=4.88u w=2u l=2u
X5 a_n1060_n200# a_n1460_n244# a_n1564_n200# VSUBS nfet_03v3 ad=0.52p pd=2.52u as=0.52p ps=2.52u w=2u l=2u
X6 a_n556_n200# a_n956_n244# a_n1060_n200# VSUBS nfet_03v3 ad=0.52p pd=2.52u as=0.52p ps=2.52u w=2u l=2u
X7 a_n52_n200# a_n452_n244# a_n556_n200# VSUBS nfet_03v3 ad=0.52p pd=2.52u as=0.52p ps=2.52u w=2u l=2u
C0 a_1460_n200# a_1964_n200# 0.02133f
C1 a_n1460_n244# a_n1564_n200# 0.0587f
C2 a_52_n244# a_556_n244# 0.00519f
C3 a_52_n244# a_452_n200# 0.0587f
C4 a_n2052_n200# a_n1564_n200# 0.02133f
C5 a_n1460_n244# a_n1060_n200# 0.0587f
C6 a_n956_n244# a_n1060_n200# 0.0587f
C7 a_52_n244# a_n52_n200# 0.0587f
C8 a_n452_n244# a_n52_n200# 0.0587f
C9 a_1460_n200# a_1060_n244# 0.0587f
C10 a_1964_n200# a_1564_n244# 0.0587f
C11 a_1460_n200# a_956_n200# 0.02133f
C12 a_n1964_n244# a_n1564_n200# 0.0587f
C13 a_n556_n200# a_n1060_n200# 0.02133f
C14 a_n556_n200# a_n52_n200# 0.02133f
C15 a_956_n200# a_1060_n244# 0.0587f
C16 a_556_n244# a_1060_n244# 0.00519f
C17 a_n1460_n244# a_n956_n244# 0.00519f
C18 a_n452_n244# a_52_n244# 0.00519f
C19 a_1460_n200# a_1564_n244# 0.0587f
C20 a_556_n244# a_956_n200# 0.0587f
C21 a_956_n200# a_452_n200# 0.02133f
C22 a_n956_n244# a_n452_n244# 0.00519f
C23 a_556_n244# a_452_n200# 0.0587f
C24 a_1564_n244# a_1060_n244# 0.00519f
C25 a_n556_n200# a_n452_n244# 0.0587f
C26 a_n1460_n244# a_n1964_n244# 0.00519f
C27 a_n556_n200# a_n956_n244# 0.0587f
C28 a_n1564_n200# a_n1060_n200# 0.02133f
C29 a_n1964_n244# a_n2052_n200# 0.0587f
C30 a_452_n200# a_n52_n200# 0.02133f
C31 a_1964_n200# VSUBS 0.26162f
C32 a_1460_n200# VSUBS 0.34773f
C33 a_956_n200# VSUBS 0.34265f
C34 a_452_n200# VSUBS 0.34265f
C35 a_n52_n200# VSUBS 0.34265f
C36 a_n556_n200# VSUBS 0.34265f
C37 a_n1060_n200# VSUBS 0.34265f
C38 a_n1564_n200# VSUBS 0.34773f
C39 a_n2052_n200# VSUBS 0.26162f
.ends

.subckt p_w2_l2 a_n288_n200# a_200_n200# a_n200_n244# w_n374_n330# VSUBS
X0 a_200_n200# a_n200_n244# a_n288_n200# w_n374_n330# pfet_03v3 ad=0.88p pd=4.88u as=0.88p ps=4.88u w=2u l=2u
C0 a_200_n200# a_n288_n200# 0.02133f
C1 a_200_n200# a_n200_n244# 0.0587f
C2 a_n288_n200# a_n200_n244# 0.0587f
C3 a_200_n200# w_n374_n330# 0.0618f
C4 a_n288_n200# w_n374_n330# 0.0618f
C5 a_n200_n244# w_n374_n330# 0.22666f
C6 a_200_n200# VSUBS 0.13704f
C7 a_n288_n200# VSUBS 0.13704f
C8 w_n374_n330# VSUBS 1.48104f
.ends

.subckt n_w2_l2 a_n288_n200# a_200_n200# a_n200_n244# VSUBS
X0 a_200_n200# a_n200_n244# a_n288_n200# VSUBS nfet_03v3 ad=0.88p pd=4.88u as=0.88p ps=4.88u w=2u l=2u
C0 a_200_n200# a_n288_n200# 0.02133f
C1 a_200_n200# a_n200_n244# 0.0587f
C2 a_n288_n200# a_n200_n244# 0.0587f
C3 a_200_n200# VSUBS 0.2667f
C4 a_n288_n200# VSUBS 0.2667f
.ends

.subckt p_w2_l2_f2 a_n52_n200# a_452_n200# a_n452_n244# a_n540_n200# w_n626_n330#
+ a_52_n244# VSUBS
X0 a_452_n200# a_52_n244# a_n52_n200# w_n626_n330# pfet_03v3 ad=0.88p pd=4.88u as=0.52p ps=2.52u w=2u l=2u
X1 a_n52_n200# a_n452_n244# a_n540_n200# w_n626_n330# pfet_03v3 ad=0.52p pd=2.52u as=0.88p ps=4.88u w=2u l=2u
C0 a_n540_n200# a_n52_n200# 0.02133f
C1 a_n52_n200# a_452_n200# 0.02133f
C2 a_n52_n200# a_52_n244# 0.0587f
C3 a_n52_n200# a_n452_n244# 0.0587f
C4 a_n540_n200# a_n452_n244# 0.0587f
C5 a_n52_n200# w_n626_n330# 0.09155f
C6 a_52_n244# a_452_n200# 0.0587f
C7 a_52_n244# a_n452_n244# 0.00519f
C8 a_n540_n200# w_n626_n330# 0.0618f
C9 a_452_n200# w_n626_n330# 0.0618f
C10 a_52_n244# w_n626_n330# 0.2233f
C11 a_n452_n244# w_n626_n330# 0.2233f
C12 a_452_n200# VSUBS 0.13364f
C13 a_n52_n200# VSUBS 0.12532f
C14 a_n540_n200# VSUBS 0.13364f
C15 w_n626_n330# VSUBS 2.47896f
.ends

.subckt bias_ladder in_n vgp3 m1_4760_1320# m1_6020_10200# m1_3298_2050# m1_5022_10210#
+ m1_3530_1930# m1_3898_9610# a_7580_5314# vss vgp5 m1_4906_9490# vdd m1_6282_1450#
+ a_1580_5314# m1_3666_9610# m1_5516_1920# a_4580_5314# m1_4538_1930# vgn3 a_5188_4156#
+ vgn5 vsp vsn vglp vgp6 a_3036_4156# vgln in_p
XnpSE m1_3898_9610# m1_4906_9490# vglp m1_3666_9610# vglp vglp in_p m1_6020_10200#
+ vdd m1_5022_10210# vglp vglp vss p_w4_l2_f5
XFP3 vgp3 a_1580_5314# vgp3 vss vss p_w2_l1
XnnSE vgln vgln vgln m1_4760_1320# in_n m1_3298_2050# m1_4538_1930# vgln m1_3530_1930#
+ vgln m1_6282_1450# vgln m1_5516_1920# vss n_w4_l2_f6
XnnSH6T m1_6282_1450# vdd vgln a_7580_5314# vgln vss n_w2_l2_f2
XFP5 vgp5 a_4580_5314# vgp5 vss vss p_w2_l1
XFN3 vgn3 a_3036_4156# vdd vss n_w2_l1
XDP3 vsp vsp a_1580_5314# vgp3 vgp3 vdd a_1580_5314# vgp3 a_1580_5314# vgp3 a_1580_5314#
+ vsp vsp vgp3 vgp3 vgp3 vgp3 vsp vss p_w2_l2_f8
XFP6 vgp6 a_7580_5314# vgp6 vss vss p_w2_l1
XFN5 vgn5 a_5188_4156# vdd vss n_w2_l1
XDP5 vsp vsp a_4580_5314# vgp5 vgp5 vdd a_4580_5314# vgp5 a_4580_5314# vgp5 a_4580_5314#
+ vsp vsp vgp5 vgp5 vgp5 vgp5 vsp vss p_w2_l2_f8
XDN3 vsn vsn a_3036_4156# vgn3 vgn3 a_3036_4156# vgn3 a_3036_4156# vgn3 a_3036_4156#
+ vsn vsn vgn3 vgn3 vgn3 vgn3 vsn vss n_w2_l2_f8
XDP6 vsp vsp a_7580_5314# vgp6 vgp6 vdd a_7580_5314# vgp6 a_7580_5314# vgp6 a_7580_5314#
+ vsp vsp vgp6 vgp6 vgp6 vgp6 vsp vss p_w2_l2_f8
XBP3 vsp vgp3 vgp6 vdd vss p_w2_l2
XDN5 vsn vsn a_5188_4156# vgn5 vgn5 a_5188_4156# vgn5 a_5188_4156# vgn5 a_5188_4156#
+ vsn vsn vgn5 vgn5 vgn5 vgn5 vsn vss n_w2_l2_f8
XBP5 vsp vgp5 vgp6 vdd vss p_w2_l2
XBN3 vgn3 vsn vgn5 vss n_w2_l2
XnnSH01 vdd m1_3298_2050# vgln in_n vgln vss n_w2_l2_f2
XBP6 vsp vgp6 vgp6 vdd vss p_w2_l2
XnnSH24 vdd m1_4538_1930# vgln m1_3530_1930# vgln vss n_w2_l2_f2
XBN5 vgn5 vsn vgn5 vss n_w2_l2
XnpSH3 m1_5022_10210# a_3036_4156# vglp vdd vss p_w2_l2
XnpSH5T m1_6020_10200# vss vglp a_5188_4156# vdd vglp vss p_w2_l2_f2
XnpSH01 vss m1_3666_9610# vglp in_p vdd vglp vss p_w2_l2_f2
XnpSH24 vss m1_4906_9490# vglp m1_3898_9610# vdd vglp vss p_w2_l2_f2
XnnSH3 m1_4760_1320# a_1580_5314# vgln vss n_w2_l2
XnnSH5 m1_5516_1920# a_4580_5314# vgln vss n_w2_l2
C0 a_1580_5314# m1_5516_1920# 0.05179f
C1 vsn m1_3298_2050# 0.01482f
C2 in_n m1_3298_2050# 0.02053f
C3 a_4580_5314# a_3036_4156# 0.1705f
C4 vdd a_5188_4156# 0.39619f
C5 vgn3 vgp3 0.00714f
C6 m1_4760_1320# m1_6282_1450# 0
C7 vgln m1_3298_2050# 0.28259f
C8 a_1580_5314# m1_4760_1320# -0.02087f
C9 a_7580_5314# a_5188_4156# 0.41188f
C10 vsn a_5188_4156# 0.39706f
C11 vgp5 a_3036_4156# 0.72992f
C12 vglp a_3036_4156# 0.03135f
C13 vgln a_5188_4156# 0.06289f
C14 m1_3898_9610# m1_3666_9610# 0.08953f
C15 m1_3666_9610# vgp6 0.00881f
C16 m1_3666_9610# vgp3 0
C17 vdd vsp 3.61245f
C18 a_1580_5314# vgn3 0.04478f
C19 m1_4906_9490# vglp 0.38823f
C20 vglp m1_5022_10210# 0.22247f
C21 a_7580_5314# vsp 0.4942f
C22 in_p vgp3 0.0017f
C23 in_p vgp6 0
C24 m1_5516_1920# vgn3 0.00897f
C25 a_4580_5314# vgp6 0.58598f
C26 a_3036_4156# a_5188_4156# 0.27107f
C27 vgp5 vgp3 0.00867f
C28 vgp5 vgp6 0.35193f
C29 m1_3898_9610# vglp 0.4412f
C30 vglp vgp3 0.48996f
C31 vglp vgp6 0.49335f
C32 m1_4760_1320# vgn3 0.12142f
C33 m1_6282_1450# m1_4538_1930# 0
C34 a_1580_5314# m1_4538_1930# 0.00316f
C35 m1_5516_1920# m1_4538_1930# 0.04505f
C36 m1_4906_9490# a_5188_4156# 0
C37 m1_5022_10210# a_5188_4156# 0
C38 m1_6282_1450# a_4580_5314# 0.21332f
C39 a_1580_5314# a_4580_5314# 0.06015f
C40 a_3036_4156# vsp 0.0883f
C41 m1_5516_1920# a_4580_5314# -0.00812f
C42 a_1580_5314# vgp5 0.16694f
C43 m1_4760_1320# m1_4538_1930# 0.16397f
C44 a_1580_5314# vglp 0
C45 a_5188_4156# vgp3 0.00485f
C46 vgp6 a_5188_4156# 0.14378f
C47 m1_6020_10200# vgp5 0.01029f
C48 vgn5 vdd 0.10294f
C49 vglp m1_6020_10200# 0.27284f
C50 m1_4760_1320# a_4580_5314# 0
C51 m1_4760_1320# m1_3530_1930# 0
C52 vgn5 a_7580_5314# 0.26387f
C53 vgn5 vsn 1.27598f
C54 m1_4906_9490# vsp 0.00394f
C55 m1_5022_10210# vsp 0.00393f
C56 vgn5 vgln 0.02641f
C57 vgn3 m1_4538_1930# 0.08119f
C58 m1_3898_9610# vsp 0.00217f
C59 vsp vgp3 1.5721f
C60 vgp6 vsp 1.5758f
C61 m1_6282_1450# a_5188_4156# 0.00163f
C62 a_1580_5314# a_5188_4156# 0.12061f
C63 vdd a_7580_5314# 0.83515f
C64 a_4580_5314# vgn3 0
C65 vdd vsn 0.58029f
C66 m1_5516_1920# a_5188_4156# 0
C67 in_n vdd 0.07179f
C68 vgn3 m1_3530_1930# 0.04819f
C69 m1_4760_1320# m1_3298_2050# -0
C70 a_7580_5314# vsn 0.31213f
C71 m1_6020_10200# a_5188_4156# 0.00728f
C72 vgp5 vgn3 0
C73 in_n vsn 0.17665f
C74 vgln vdd 2.28298f
C75 in_p m1_3666_9610# 0.0161f
C76 vgn5 a_3036_4156# 0.11976f
C77 vgln a_7580_5314# 0.10386f
C78 vgln vsn 0.48987f
C79 vgln in_n 0.47579f
C80 a_4580_5314# m1_4538_1930# 0.00211f
C81 a_1580_5314# vsp 0.66577f
C82 vglp m1_3666_9610# 0.38355f
C83 vgn3 m1_3298_2050# 0.00878f
C84 m1_6020_10200# vsp 0.02019f
C85 vdd a_3036_4156# 1.03471f
C86 a_7580_5314# a_3036_4156# 0.0745f
C87 vglp in_p 0.7203f
C88 a_3036_4156# vsn 0.14439f
C89 vgp5 a_4580_5314# 1.87678f
C90 vglp a_4580_5314# 0
C91 vgn5 vgp6 0.00421f
C92 vgln a_3036_4156# 0.00497f
C93 vglp vgp5 0.1447f
C94 m1_4906_9490# vdd 0.08697f
C95 vdd m1_5022_10210# 0.0596f
C96 m1_3298_2050# m1_3530_1930# 0.33404f
C97 m1_3898_9610# vdd 0.15129f
C98 vdd vgp3 3.78758f
C99 vdd vgp6 5.47456f
C100 vgn5 m1_6282_1450# 0
C101 a_4580_5314# a_5188_4156# 0.4945f
C102 a_7580_5314# vgp3 0.20875f
C103 vgp6 a_7580_5314# 1.8657f
C104 a_1580_5314# vgn5 0.21481f
C105 vgp6 vsn 0.03394f
C106 vgn5 m1_5516_1920# 0.00187f
C107 vgp5 a_5188_4156# 0.18257f
C108 m1_3666_9610# vsp 0.00336f
C109 vglp a_5188_4156# 0.03121f
C110 m1_4906_9490# a_3036_4156# 0.00404f
C111 m1_5022_10210# a_3036_4156# 0
C112 in_p vsp 0.13384f
C113 vdd m1_6282_1450# 0.04143f
C114 a_1580_5314# vdd 1.62506f
C115 a_4580_5314# vsp 0.80414f
C116 m1_6282_1450# a_7580_5314# 0.00102f
C117 a_1580_5314# a_7580_5314# 0.02594f
C118 vdd m1_5516_1920# 0.03975f
C119 a_1580_5314# vsn 0.16559f
C120 vgp5 vsp 0.78845f
C121 vdd m1_6020_10200# 0.18314f
C122 m1_5516_1920# a_7580_5314# 0
C123 m1_3898_9610# a_3036_4156# 0
C124 vglp vsp 0.34417f
C125 a_3036_4156# vgp3 0.03477f
C126 vgp6 a_3036_4156# 0.42099f
C127 vgln m1_6282_1450# 0.19109f
C128 a_1580_5314# vgln 0.07765f
C129 m1_4906_9490# m1_5022_10210# 0.22756f
C130 vdd m1_4760_1320# 0.02112f
C131 vgln m1_5516_1920# 0.29348f
C132 vgn5 vgn3 0.06099f
C133 m1_4760_1320# vsn 0
C134 m1_3898_9610# m1_4906_9490# 0.00256f
C135 m1_3898_9610# m1_5022_10210# 0
C136 m1_4906_9490# vgp3 0.0279f
C137 m1_4906_9490# vgp6 0.01016f
C138 vgln m1_4760_1320# 0.22369f
C139 m1_5022_10210# vgp6 0.00778f
C140 m1_5022_10210# vgp3 0.00919f
C141 a_1580_5314# a_3036_4156# 0.14234f
C142 vsp a_5188_4156# 0.36532f
C143 vgn5 m1_4538_1930# 0.00106f
C144 vdd vgn3 0.17852f
C145 m1_3898_9610# vgp3 0.04635f
C146 m1_3898_9610# vgp6 0.01466f
C147 vgp6 vgp3 0.38706f
C148 m1_6020_10200# a_3036_4156# 0.00106f
C149 vsn vgn3 1.08253f
C150 in_n vgn3 0.00344f
C151 vgn5 a_4580_5314# 0.10109f
C152 vgln vgn3 0.47992f
C153 m1_3666_9610# vdd 0.05802f
C154 vgn5 vgp5 0.0996f
C155 vdd m1_4538_1930# 0.27134f
C156 m1_4906_9490# m1_6020_10200# 0.00282f
C157 m1_5022_10210# m1_6020_10200# 0.0182f
C158 in_p vdd 1.4091f
C159 a_1580_5314# vgp3 1.41665f
C160 a_1580_5314# vgp6 0.24833f
C161 vdd a_4580_5314# 1.73154f
C162 vdd m1_3530_1930# 0.05235f
C163 vgln m1_4538_1930# 0.37308f
C164 a_4580_5314# a_7580_5314# 0.29998f
C165 a_4580_5314# vsn 0.36645f
C166 a_3036_4156# vgn3 0.80773f
C167 m1_6020_10200# vgp6 0.04538f
C168 vdd vgp5 3.48321f
C169 vsn m1_3530_1930# 0.01898f
C170 in_n m1_3530_1930# 0.00742f
C171 vglp vdd 5.16392f
C172 vgp5 a_7580_5314# 0.32553f
C173 vgp5 vsn 0.17915f
C174 vglp a_7580_5314# 0
C175 vgln a_4580_5314# 0.49007f
C176 vgln m1_3530_1930# 0.4385f
C177 vgn5 a_5188_4156# 1.16612f
C178 m1_5516_1920# m1_6282_1450# 0.00546f
C179 vdd m1_3298_2050# 0.05664f
C180 a_1580_5314# vss 1.70876f
C181 m1_4906_9490# vss -0.04028f
C182 m1_3898_9610# vss 0.09303f
C183 m1_3666_9610# vss -0.03204f
C184 in_p vss -0
C185 vglp vss -0.37909f
C186 m1_4538_1930# vss 0.07674f
C187 m1_3530_1930# vss 0.05197f
C188 m1_3298_2050# vss 0.04402f
C189 vdd vss 86.64923f
C190 in_n vss 1.35999f
C191 vgln vss 3.3753f
C192 vgn5 vss 4.03953f
C193 a_5188_4156# vss 1.44532f
C194 vsp vss -0.14973f
C195 a_7580_5314# vss 1.40837f
C196 vsn vss 4.2523f
C197 a_3036_4156# vss 1.80989f
C198 vgn3 vss 3.02208f
C199 vgp6 vss 2.43502f
C200 a_4580_5314# vss 3.24613f
C201 vgp5 vss 1.91603f
C202 m1_6282_1450# vss 0.17092f
C203 m1_5516_1920# vss -0.01345f
C204 m1_4760_1320# vss -0.06206f
C205 vgp3 vss 2.7134f
C206 m1_6020_10200# vss -0.16436f
C207 m1_5022_10210# vss -0.09509f
.ends

.subckt p_w1_l0p28_f2 a_n196_n100# a_n52_n100# w_n282_n230# a_108_n100# a_52_n144#
+ a_n108_n144# VSUBS
X0 a_n52_n100# a_n108_n144# a_n196_n100# w_n282_n230# pfet_03v3 ad=0.26p pd=1.52u as=0.44p ps=2.88u w=1u l=0.28u
X1 a_108_n100# a_52_n144# a_n52_n100# w_n282_n230# pfet_03v3 ad=0.44p pd=2.88u as=0.26p ps=1.52u w=1u l=0.28u
C0 a_n52_n100# a_52_n144# 0.00769f
C1 a_n52_n100# w_n282_n230# 0.01828f
C2 w_n282_n230# a_52_n144# 0.05505f
C3 a_n108_n144# a_n196_n100# 0.00769f
C4 a_n52_n100# a_108_n100# 0.04256f
C5 a_108_n100# a_52_n144# 0.00769f
C6 a_n52_n100# a_n196_n100# 0.04256f
C7 w_n282_n230# a_108_n100# 0.01808f
C8 w_n282_n230# a_n196_n100# 0.01808f
C9 a_n52_n100# a_n108_n144# 0.00769f
C10 a_n108_n144# a_52_n144# 0.00519f
C11 w_n282_n230# a_n108_n144# 0.05505f
C12 a_108_n100# VSUBS 0.0563f
C13 a_n52_n100# VSUBS 0.03533f
C14 a_n196_n100# VSUBS 0.0563f
C15 w_n282_n230# VSUBS 0.77832f
.ends

.subckt n_w0p5_l0p28_f2 a_n52_n50# a_n196_n50# a_52_n94# a_108_n50# a_n108_n94# VSUBS
X0 a_108_n50# a_52_n94# a_n52_n50# VSUBS nfet_03v3 ad=0.22p pd=1.88u as=0.13p ps=1.02u w=0.5u l=0.28u
X1 a_n52_n50# a_n108_n94# a_n196_n50# VSUBS nfet_03v3 ad=0.13p pd=1.02u as=0.22p ps=1.88u w=0.5u l=0.28u
C0 a_n108_n94# a_n196_n50# 0.00377f
C1 a_52_n94# a_n52_n50# 0.00377f
C2 a_108_n50# a_n52_n50# 0.02085f
C3 a_n52_n50# a_n196_n50# 0.02085f
C4 a_n108_n94# a_n52_n50# 0.00377f
C5 a_108_n50# a_52_n94# 0.00377f
C6 a_n108_n94# a_52_n94# 0.00519f
C7 a_108_n50# VSUBS 0.07479f
C8 a_n52_n50# VSUBS 0.09458f
C9 a_n196_n50# VSUBS 0.07479f
.ends

.subckt p_w2_l2_f7 a_n704_n244# a_n808_n200# a_304_n244# a_n1712_n244# a_1712_n200#
+ a_n1800_n200# a_n1208_n244# a_1208_n200# a_200_n200# a_1312_n244# a_808_n244# a_n200_n244#
+ a_n304_n200# w_n1886_n330# a_n1312_n200# a_704_n200# VSUBS
X0 a_n1312_n200# a_n1712_n244# a_n1800_n200# w_n1886_n330# pfet_03v3 ad=0.52p pd=2.52u as=0.88p ps=4.88u w=2u l=2u
X1 a_n304_n200# a_n704_n244# a_n808_n200# w_n1886_n330# pfet_03v3 ad=0.52p pd=2.52u as=0.52p ps=2.52u w=2u l=2u
X2 a_200_n200# a_n200_n244# a_n304_n200# w_n1886_n330# pfet_03v3 ad=0.52p pd=2.52u as=0.52p ps=2.52u w=2u l=2u
X3 a_1712_n200# a_1312_n244# a_1208_n200# w_n1886_n330# pfet_03v3 ad=0.88p pd=4.88u as=0.52p ps=2.52u w=2u l=2u
X4 a_1208_n200# a_808_n244# a_704_n200# w_n1886_n330# pfet_03v3 ad=0.52p pd=2.52u as=0.52p ps=2.52u w=2u l=2u
X5 a_n808_n200# a_n1208_n244# a_n1312_n200# w_n1886_n330# pfet_03v3 ad=0.52p pd=2.52u as=0.52p ps=2.52u w=2u l=2u
X6 a_704_n200# a_304_n244# a_200_n200# w_n1886_n330# pfet_03v3 ad=0.52p pd=2.52u as=0.52p ps=2.52u w=2u l=2u
C0 a_1312_n244# a_1208_n200# 0.0587f
C1 a_1312_n244# w_n1886_n330# 0.2233f
C2 a_n1712_n244# a_n1312_n200# 0.0587f
C3 a_n1712_n244# a_n1800_n200# 0.0587f
C4 a_808_n244# a_304_n244# 0.00519f
C5 a_n200_n244# w_n1886_n330# 0.21994f
C6 a_n304_n200# a_n704_n244# 0.0587f
C7 a_1208_n200# w_n1886_n330# 0.09155f
C8 a_704_n200# a_200_n200# 0.02133f
C9 w_n1886_n330# a_n1208_n244# 0.21994f
C10 a_304_n244# a_200_n200# 0.0587f
C11 a_n1208_n244# a_n1312_n200# 0.0587f
C12 w_n1886_n330# a_n1312_n200# 0.09155f
C13 w_n1886_n330# a_n1800_n200# 0.0618f
C14 a_n304_n200# a_200_n200# 0.02133f
C15 a_1208_n200# a_704_n200# 0.02133f
C16 a_n808_n200# a_n1208_n244# 0.0587f
C17 w_n1886_n330# a_704_n200# 0.09155f
C18 a_n200_n244# a_304_n244# 0.00519f
C19 w_n1886_n330# a_n808_n200# 0.09155f
C20 a_1312_n244# a_1712_n200# 0.0587f
C21 a_1312_n244# a_808_n244# 0.00519f
C22 a_n1800_n200# a_n1312_n200# 0.02133f
C23 a_n200_n244# a_n704_n244# 0.00519f
C24 a_n200_n244# a_n304_n200# 0.0587f
C25 w_n1886_n330# a_304_n244# 0.21994f
C26 a_n808_n200# a_n1312_n200# 0.02133f
C27 a_n704_n244# a_n1208_n244# 0.00519f
C28 a_1208_n200# a_1712_n200# 0.02133f
C29 a_1208_n200# a_808_n244# 0.0587f
C30 w_n1886_n330# a_n704_n244# 0.21994f
C31 w_n1886_n330# a_1712_n200# 0.0618f
C32 w_n1886_n330# a_n304_n200# 0.09155f
C33 w_n1886_n330# a_808_n244# 0.21994f
C34 a_704_n200# a_304_n244# 0.0587f
C35 a_n200_n244# a_200_n200# 0.0587f
C36 a_n1712_n244# a_n1208_n244# 0.00519f
C37 w_n1886_n330# a_n1712_n244# 0.2233f
C38 a_n808_n200# a_n704_n244# 0.0587f
C39 a_704_n200# a_808_n244# 0.0587f
C40 a_n808_n200# a_n304_n200# 0.02133f
C41 w_n1886_n330# a_200_n200# 0.09155f
C42 a_1712_n200# VSUBS 0.13364f
C43 a_1208_n200# VSUBS 0.12191f
C44 a_704_n200# VSUBS 0.11851f
C45 a_200_n200# VSUBS 0.11851f
C46 a_n304_n200# VSUBS 0.11851f
C47 a_n808_n200# VSUBS 0.11851f
C48 a_n1312_n200# VSUBS 0.12191f
C49 a_n1800_n200# VSUBS 0.13364f
C50 w_n1886_n330# VSUBS 7.46856f
.ends

.subckt p_w0p5_l0p5_f2 a_n52_n50# w_n326_n180# a_52_n94# a_152_n50# a_n240_n50# a_n152_n94#
+ VSUBS
X0 a_152_n50# a_52_n94# a_n52_n50# w_n326_n180# pfet_03v3 ad=0.22p pd=1.88u as=0.13p ps=1.02u w=0.5u l=0.5u
X1 a_n52_n50# a_n152_n94# a_n240_n50# w_n326_n180# pfet_03v3 ad=0.13p pd=1.02u as=0.22p ps=1.88u w=0.5u l=0.5u
C0 a_n52_n50# a_n240_n50# 0.01511f
C1 a_n152_n94# a_n240_n50# 0.00625f
C2 w_n326_n180# a_n52_n50# 0.01225f
C3 w_n326_n180# a_152_n50# 0.01152f
C4 w_n326_n180# a_n152_n94# 0.07657f
C5 w_n326_n180# a_52_n94# 0.07657f
C6 a_n52_n50# a_152_n50# 0.01511f
C7 a_n52_n50# a_n152_n94# 0.00625f
C8 a_n52_n50# a_52_n94# 0.00625f
C9 a_152_n50# a_52_n94# 0.00625f
C10 a_n152_n94# a_52_n94# 0.00519f
C11 w_n326_n180# a_n240_n50# 0.01152f
C12 a_152_n50# VSUBS 0.04588f
C13 a_n52_n50# VSUBS 0.04684f
C14 a_n240_n50# VSUBS 0.04588f
C15 w_n326_n180# VSUBS 0.70416f
.ends

.subckt idac_p b0 b1 b2 b3 b4 out vdd vss a_1582_4572# m1_988_3644# m1_988_2984# a_528_4572#
+ a_1378_4572# a_3078_4572# m1_988_1168# a_2228_4572# dump m1_650_4492# g vsp a_3928_4572#
+ a_4132_4572# a_2432_4572# m1_1460_4102# a_732_4572# vcas a_3282_4572#
XU4b vsp vsp m1_988_1168# g g vdd m1_988_1168# g m1_988_1168# g m1_988_1168# vsp vsp
+ g g g g vsp vss p_w2_l2_f8
XU3 vsp vsp m1_988_2984# g g vdd m1_988_2984# g m1_988_2984# g m1_988_2984# vsp vsp
+ g g g g vsp vss p_w2_l2_f8
XIP0 a_528_4572# vdd vdd a_732_4572# a_528_4572# b0 vss p_w1_l0p28_f2
XIP1 a_1378_4572# vdd vdd a_1582_4572# a_1378_4572# b1 vss p_w1_l0p28_f2
XIN0 vcas a_528_4572# a_528_4572# a_732_4572# b0 vss n_w0p5_l0p28_f2
XIP2 a_2228_4572# vdd vdd a_2432_4572# a_2228_4572# b2 vss p_w1_l0p28_f2
XIN1 vcas a_1378_4572# a_1378_4572# a_1582_4572# b1 vss n_w0p5_l0p28_f2
XIP3 a_3078_4572# vdd vdd a_3282_4572# a_3078_4572# b3 vss p_w1_l0p28_f2
XIN3 vcas a_3078_4572# a_3078_4572# a_3282_4572# b3 vss n_w0p5_l0p28_f2
XIN2 vcas a_2228_4572# a_2228_4572# a_2432_4572# b2 vss n_w0p5_l0p28_f2
XIP4 a_3928_4572# vdd vdd a_4132_4572# a_3928_4572# b4 vss p_w1_l0p28_f2
XIN4 vcas a_3928_4572# a_3928_4572# a_4132_4572# b4 vss n_w0p5_l0p28_f2
XU210 g vsp g g m1_650_4492# vsp g vsp vsp g g g m1_988_3644# vdd m1_988_3644# m1_1460_4102#
+ vss p_w2_l2_f7
XSW0 m1_650_4492# vdd a_732_4572# dump out a_528_4572# vss p_w0p5_l0p5_f2
XSW2 m1_988_3644# vdd a_2432_4572# dump out a_2228_4572# vss p_w0p5_l0p5_f2
XSW1 m1_1460_4102# vdd a_1582_4572# dump out a_1378_4572# vss p_w0p5_l0p5_f2
XSW3 m1_988_2984# vdd a_3282_4572# dump out a_3078_4572# vss p_w0p5_l0p5_f2
XSW4 m1_988_1168# vdd a_4132_4572# dump out a_3928_4572# vss p_w0p5_l0p5_f2
XU4a vsp vsp m1_988_1168# g g vdd m1_988_1168# g m1_988_1168# g m1_988_1168# vsp vsp
+ g g g g vsp vss p_w2_l2_f8
C0 b2 m1_988_3644# 0.00149f
C1 vdd m1_988_3644# 0.15596f
C2 a_732_4572# out 0.18479f
C3 a_528_4572# g 0.00514f
C4 b0 vsp 0
C5 a_2228_4572# b1 0
C6 vdd a_732_4572# 0.36344f
C7 g a_1378_4572# 0.00659f
C8 a_2228_4572# a_1582_4572# 0.0132f
C9 a_528_4572# dump 0
C10 a_2228_4572# b3 0.00203f
C11 g m1_988_1168# 2.25905f
C12 dump a_1378_4572# 0.06699f
C13 a_2432_4572# m1_1460_4102# 0.00133f
C14 m1_988_1168# a_4132_4572# 0.0253f
C15 out b2 0.01202f
C16 vdd out 1.37197f
C17 b0 vcas 0.04594f
C18 g m1_650_4492# 1.86486f
C19 a_2228_4572# a_3282_4572# 0
C20 dump m1_988_1168# 0.14336f
C21 m1_650_4492# a_4132_4572# 0
C22 vdd b2 0.40027f
C23 m1_988_1168# a_3078_4572# 0.04118f
C24 a_2432_4572# b4 0
C25 dump m1_650_4492# 0.05484f
C26 m1_988_1168# m1_988_2984# 0.4309f
C27 a_3928_4572# m1_988_1168# 0.02302f
C28 m1_1460_4102# b1 0
C29 a_3078_4572# m1_650_4492# 0.01008f
C30 a_2432_4572# vcas 0.11606f
C31 m1_988_2984# m1_650_4492# 0.40258f
C32 a_3928_4572# m1_650_4492# 0.001f
C33 m1_1460_4102# a_1582_4572# 0.01157f
C34 a_2228_4572# g 0.00234f
C35 a_732_4572# b0 0.00646f
C36 a_2432_4572# m1_988_3644# 0.00185f
C37 a_2228_4572# dump 0.14613f
C38 b1 vcas 0.26352f
C39 a_2228_4572# a_3078_4572# 0.01385f
C40 b4 b3 0.00638f
C41 out b0 0.01451f
C42 a_1582_4572# vcas 0.05158f
C43 b3 vcas 0.14476f
C44 b1 m1_988_3644# 0
C45 a_528_4572# a_1378_4572# 0.00565f
C46 vdd b0 0.33876f
C47 b4 a_3282_4572# 0.00266f
C48 a_1582_4572# m1_988_3644# 0.00521f
C49 a_2432_4572# out 0.07529f
C50 m1_1460_4102# g 0.50847f
C51 g vsp 4.06891f
C52 a_3282_4572# vcas 0.03139f
C53 vsp a_4132_4572# 0
C54 a_732_4572# b1 0
C55 a_528_4572# m1_650_4492# 0.02127f
C56 a_2432_4572# b2 0.16627f
C57 a_1582_4572# a_732_4572# 0.002f
C58 a_2432_4572# vdd 0.37857f
C59 dump vsp 0
C60 m1_1460_4102# dump 0.14116f
C61 a_3282_4572# m1_988_3644# 0
C62 m1_650_4492# a_1378_4572# 0
C63 m1_1460_4102# a_3078_4572# 0
C64 a_3078_4572# vsp 0.00385f
C65 b4 a_4132_4572# 0.15044f
C66 m1_1460_4102# m1_988_2984# 0.05766f
C67 m1_988_2984# vsp 0.2942f
C68 out b1 0.27469f
C69 a_3928_4572# vsp 0
C70 m1_988_1168# m1_650_4492# 0.39889f
C71 a_1582_4572# out 0.09368f
C72 vcas a_4132_4572# 0.08601f
C73 b4 dump 0
C74 b2 b1 0.00252f
C75 vdd b1 0.23981f
C76 out b3 0.00306f
C77 b4 a_3078_4572# 0.13901f
C78 dump vcas 0.17396f
C79 a_1582_4572# b2 0
C80 g m1_988_3644# 0.39331f
C81 a_3928_4572# b4 0.15141f
C82 vdd a_1582_4572# 0.37736f
C83 a_2228_4572# a_1378_4572# 0.0022f
C84 a_3078_4572# vcas 0.58185f
C85 b3 b2 0.15952f
C86 vdd b3 0.30654f
C87 a_3282_4572# out 0.05302f
C88 a_3928_4572# vcas 0.16267f
C89 dump m1_988_3644# 0.16715f
C90 a_732_4572# g 0.00218f
C91 m1_988_3644# a_3078_4572# 0
C92 a_3282_4572# b2 0
C93 vdd a_3282_4572# 0.58819f
C94 m1_988_2984# m1_988_3644# 0.03286f
C95 a_2228_4572# m1_650_4492# 0
C96 dump a_732_4572# 0.06755f
C97 g out 0.09093f
C98 out a_4132_4572# 0
C99 a_528_4572# vsp 0
C100 g b2 0
C101 m1_1460_4102# a_1378_4572# 0.03861f
C102 b1 b0 0.00881f
C103 dump out 0.48021f
C104 vdd g 9.02222f
C105 vdd a_4132_4572# 0.34563f
C106 a_1582_4572# b0 0
C107 out a_3078_4572# 0.14081f
C108 out m1_988_2984# 0.09522f
C109 m1_988_1168# vsp 0.61316f
C110 dump b2 0.02903f
C111 a_3928_4572# out 0.00526f
C112 vdd dump 0.99313f
C113 b2 a_3078_4572# 0.00501f
C114 a_528_4572# vcas 0.06041f
C115 vdd a_3078_4572# 0.94665f
C116 m1_1460_4102# m1_650_4492# 0.00149f
C117 vsp m1_650_4492# 0.25939f
C118 vdd m1_988_2984# 0.25832f
C119 a_3928_4572# vdd 0.55267f
C120 vcas a_1378_4572# 0.1047f
C121 b4 m1_988_1168# 0
C122 a_2432_4572# b3 0.00219f
C123 b4 m1_650_4492# 0
C124 m1_988_3644# a_1378_4572# 0.00163f
C125 a_2432_4572# a_3282_4572# 0
C126 m1_1460_4102# a_2228_4572# 0
C127 a_528_4572# a_732_4572# 0.17763f
C128 a_1582_4572# b1 0.32231f
C129 g b0 0
C130 a_732_4572# a_1378_4572# 0.0125f
C131 m1_988_3644# m1_650_4492# 0.06805f
C132 a_528_4572# out 0.05579f
C133 a_2432_4572# g 0.00216f
C134 a_2228_4572# vcas 0.3011f
C135 out a_1378_4572# 0.31303f
C136 a_732_4572# m1_650_4492# 0.01944f
C137 a_528_4572# vdd 0.60074f
C138 a_3282_4572# b3 0.00365f
C139 a_2432_4572# dump 0.0666f
C140 b2 a_1378_4572# 0.00157f
C141 out m1_988_1168# 0.03455f
C142 vdd a_1378_4572# 0.52764f
C143 a_2228_4572# m1_988_3644# 0.03738f
C144 m1_1460_4102# vsp 0.04575f
C145 a_2432_4572# a_3078_4572# 0.03391f
C146 a_2432_4572# m1_988_2984# 0
C147 out m1_650_4492# 0.09864f
C148 a_2432_4572# a_3928_4572# 0
C149 g b1 0
C150 vdd m1_988_1168# 0.86013f
C151 a_1582_4572# g 0.0023f
C152 vdd m1_650_4492# 1.01833f
C153 b4 vsp 0
C154 dump b1 0.24305f
C155 g b3 0
C156 b3 a_4132_4572# 0
C157 a_1582_4572# dump 0.18244f
C158 dump b3 0
C159 a_2228_4572# out 0.1275f
C160 g a_3282_4572# 0.00246f
C161 a_3282_4572# a_4132_4572# 0.0018f
C162 b3 a_3078_4572# 0.13359f
C163 m1_1460_4102# m1_988_3644# 0.14466f
C164 m1_988_3644# vsp 0.07096f
C165 b3 m1_988_2984# 0.00137f
C166 a_528_4572# b0 0.25598f
C167 a_3928_4572# b3 0
C168 a_2228_4572# b2 0.06497f
C169 b4 vcas 0.03901f
C170 dump a_3282_4572# 0.0467f
C171 vdd a_2228_4572# 0.55826f
C172 b0 a_1378_4572# 0
C173 a_3282_4572# a_3078_4572# 0.33407f
C174 a_3282_4572# m1_988_2984# 0.02053f
C175 a_3928_4572# a_3282_4572# 0.14401f
C176 g a_4132_4572# 0
C177 b0 m1_650_4492# 0.00204f
C178 dump g 0.2083f
C179 dump a_4132_4572# 0.05544f
C180 m1_1460_4102# out 0.05383f
C181 out vsp 0.00962f
C182 g a_3078_4572# 0.00748f
C183 a_3078_4572# a_4132_4572# 0.25655f
C184 g m1_988_2984# 1.08988f
C185 a_732_4572# vcas 0.04204f
C186 a_3928_4572# g 0
C187 a_528_4572# b1 0.00166f
C188 a_3928_4572# a_4132_4572# 0.13001f
C189 m1_1460_4102# b2 0
C190 vdd vsp 2.37304f
C191 vdd m1_1460_4102# 0.31124f
C192 dump a_3078_4572# 0.09418f
C193 a_528_4572# a_1582_4572# 0.00112f
C194 dump m1_988_2984# 0.09035f
C195 b1 a_1378_4572# 0.10949f
C196 a_3928_4572# dump 0.01456f
C197 a_732_4572# m1_988_3644# 0
C198 m1_988_2984# a_3078_4572# 0.01439f
C199 a_1582_4572# a_1378_4572# 0.14513f
C200 out vcas 0.09048f
C201 a_3928_4572# a_3078_4572# 0.20614f
C202 b4 b2 0
C203 a_3928_4572# m1_988_2984# 0
C204 vdd b4 0.58144f
C205 b2 vcas 0.24768f
C206 vdd vcas 0.54087f
C207 out m1_988_3644# 0.09583f
C208 a_2432_4572# a_2228_4572# 0.11855f
C209 a_1582_4572# m1_650_4492# 0
C210 m1_988_1168# vss 0.1501f
C211 vsp vss 0.05972f
C212 g vss -2.69355f
C213 vdd vss 31.94884f
C214 a_4132_4572# vss 0.0154f
C215 a_3928_4572# vss 0.05244f
C216 a_3282_4572# vss 0.04518f
C217 a_3078_4572# vss 0.45712f
C218 a_1582_4572# vss -0.05476f
C219 a_1378_4572# vss 0.05508f
C220 a_2432_4572# vss -0.05086f
C221 a_2228_4572# vss 0.02015f
C222 dump vss 0.03637f
C223 out vss 0.27373f
C224 a_732_4572# vss -0.03275f
C225 a_528_4572# vss 0.12165f
C226 m1_650_4492# vss 0.07291f
C227 m1_1460_4102# vss -0.02161f
C228 m1_988_3644# vss -0.03566f
C229 b4 vss 0.76939f
C230 b3 vss 0.2234f
C231 b2 vss 0.46373f
C232 vcas vss 1.24466f
C233 b1 vss 0.25118f
C234 b0 vss 0.51454f
C235 m1_988_2984# vss -0.00584f
.ends

.subckt r_w4_l3p97 a_n400_n519# a_n400_397# VSUBS
X0 a_n400_397# a_n400_n519# VSUBS ppolyf_u_1k r_width=4u r_length=3.97u
C0 a_n400_n519# a_n400_397# 0.02123f
C1 a_n400_n519# VSUBS 0.80683f
C2 a_n400_397# VSUBS 0.80683f
.ends

.subckt n_w8_l0p5 a_50_n800# a_n50_n844# a_n138_n800# VSUBS
X0 a_50_n800# a_n50_n844# a_n138_n800# VSUBS nfet_03v3 ad=3.52p pd=16.88u as=3.52p ps=16.88u w=8u l=0.5u
C0 a_n50_n844# a_n138_n800# 0.10385f
C1 a_50_n800# a_n138_n800# 0.25117f
C2 a_50_n800# a_n50_n844# 0.10385f
C3 a_50_n800# VSUBS 0.38495f
C4 a_n138_n800# VSUBS 0.38495f
.ends

.subckt n_w4_l0p5 a_n138_n400# a_50_n400# a_n50_n444# VSUBS
X0 a_50_n400# a_n50_n444# a_n138_n400# VSUBS nfet_03v3 ad=1.76p pd=8.88u as=1.76p ps=8.88u w=4u l=0.5u
C0 a_n50_n444# a_n138_n400# 0.05179f
C1 a_50_n400# a_n138_n400# 0.12527f
C2 a_50_n400# a_n50_n444# 0.05179f
C3 a_50_n400# VSUBS 0.23105f
C4 a_n138_n400# VSUBS 0.23105f
.ends

.subckt n_w0p5_l0p28 a_n28_n94# a_n116_n50# a_28_n50# VSUBS
X0 a_28_n50# a_n28_n94# a_n116_n50# VSUBS nfet_03v3 ad=0.22p pd=1.88u as=0.22p ps=1.88u w=0.5u l=0.28u
C0 a_n28_n94# a_n116_n50# 0.00377f
C1 a_28_n50# a_n116_n50# 0.02085f
C2 a_28_n50# a_n28_n94# 0.00377f
C3 a_28_n50# VSUBS 0.07987f
C4 a_n116_n50# VSUBS 0.07987f
.ends

.subckt p_w1_l0p28 w_n202_n230# a_28_n100# a_n28_n144# a_n116_n100# VSUBS
X0 a_28_n100# a_n28_n144# a_n116_n100# w_n202_n230# pfet_03v3 ad=0.44p pd=2.88u as=0.44p ps=2.88u w=1u l=0.28u
C0 w_n202_n230# a_28_n100# 0.01808f
C1 w_n202_n230# a_n28_n144# 0.05841f
C2 a_n116_n100# a_28_n100# 0.04256f
C3 a_n116_n100# a_n28_n144# 0.00769f
C4 a_n28_n144# a_28_n100# 0.00769f
C5 a_n116_n100# w_n202_n230# 0.01808f
C6 a_28_n100# VSUBS 0.0597f
C7 a_n116_n100# VSUBS 0.0597f
C8 w_n202_n230# VSUBS 0.55752f
.ends

.subckt p_w2_l2_f4 a_n52_n200# a_452_n200# a_n452_n244# a_n556_n200# a_52_n244# a_956_n200#
+ a_n1044_n200# w_n1130_n330# a_n956_n244# a_556_n244# VSUBS
X0 a_452_n200# a_52_n244# a_n52_n200# w_n1130_n330# pfet_03v3 ad=0.52p pd=2.52u as=0.52p ps=2.52u w=2u l=2u
X1 a_956_n200# a_556_n244# a_452_n200# w_n1130_n330# pfet_03v3 ad=0.88p pd=4.88u as=0.52p ps=2.52u w=2u l=2u
X2 a_n556_n200# a_n956_n244# a_n1044_n200# w_n1130_n330# pfet_03v3 ad=0.52p pd=2.52u as=0.88p ps=4.88u w=2u l=2u
X3 a_n52_n200# a_n452_n244# a_n556_n200# w_n1130_n330# pfet_03v3 ad=0.52p pd=2.52u as=0.52p ps=2.52u w=2u l=2u
C0 a_n452_n244# a_n556_n200# 0.0587f
C1 a_n52_n200# a_n556_n200# 0.02133f
C2 w_n1130_n330# a_52_n244# 0.21994f
C3 w_n1130_n330# a_n956_n244# 0.2233f
C4 a_556_n244# a_956_n200# 0.0587f
C5 a_n1044_n200# w_n1130_n330# 0.0618f
C6 a_452_n200# a_52_n244# 0.0587f
C7 a_556_n244# w_n1130_n330# 0.2233f
C8 a_n452_n244# a_52_n244# 0.00519f
C9 a_n452_n244# a_n956_n244# 0.00519f
C10 a_n52_n200# a_52_n244# 0.0587f
C11 a_452_n200# a_556_n244# 0.0587f
C12 a_n956_n244# a_n556_n200# 0.0587f
C13 a_n1044_n200# a_n556_n200# 0.02133f
C14 w_n1130_n330# a_956_n200# 0.0618f
C15 a_452_n200# a_956_n200# 0.02133f
C16 a_n1044_n200# a_n956_n244# 0.0587f
C17 a_556_n244# a_52_n244# 0.00519f
C18 a_452_n200# w_n1130_n330# 0.09155f
C19 a_n452_n244# w_n1130_n330# 0.21994f
C20 w_n1130_n330# a_n52_n200# 0.09155f
C21 a_452_n200# a_n52_n200# 0.02133f
C22 a_n452_n244# a_n52_n200# 0.0587f
C23 w_n1130_n330# a_n556_n200# 0.09155f
C24 a_956_n200# VSUBS 0.13364f
C25 a_452_n200# VSUBS 0.12191f
C26 a_n52_n200# VSUBS 0.11851f
C27 a_n556_n200# VSUBS 0.12191f
C28 a_n1044_n200# VSUBS 0.13364f
C29 w_n1130_n330# VSUBS 4.4748f
.ends

.subckt p_w2_l0p5 a_50_n200# a_n50_n244# w_n224_n330# a_n138_n200# VSUBS
X0 a_50_n200# a_n50_n244# a_n138_n200# w_n224_n330# pfet_03v3 ad=0.88p pd=4.88u as=0.88p ps=4.88u w=2u l=0.5u
C0 a_50_n200# a_n50_n244# 0.02577f
C1 a_n50_n244# a_n138_n200# 0.02577f
C2 a_50_n200# w_n224_n330# 0.03848f
C3 w_n224_n330# a_n138_n200# 0.03848f
C4 w_n224_n330# a_n50_n244# 0.07993f
C5 a_50_n200# a_n138_n200# 0.06232f
C6 a_50_n200# VSUBS 0.0978f
C7 a_n138_n200# VSUBS 0.0978f
C8 w_n224_n330# VSUBS 0.88704f
.ends

.subckt n_w2_l0p5 a_50_n200# a_n50_n244# a_n138_n200# VSUBS
X0 a_50_n200# a_n50_n244# a_n138_n200# VSUBS nfet_03v3 ad=0.88p pd=4.88u as=0.88p ps=4.88u w=2u l=0.5u
C0 a_n138_n200# a_50_n200# 0.06232f
C1 a_n50_n244# a_50_n200# 0.02577f
C2 a_n50_n244# a_n138_n200# 0.02577f
C3 a_50_n200# VSUBS 0.1541f
C4 a_n138_n200# VSUBS 0.1541f
.ends

.subckt p_w4_l0p5 a_n138_n400# a_50_n400# a_n50_n444# w_n224_n530# VSUBS
X0 a_50_n400# a_n50_n444# a_n138_n400# w_n224_n530# pfet_03v3 ad=1.76p pd=8.88u as=1.76p ps=8.88u w=4u l=0.5u
C0 a_50_n400# a_n50_n444# 0.05179f
C1 a_n50_n444# a_n138_n400# 0.05179f
C2 a_50_n400# w_n224_n530# 0.07442f
C3 w_n224_n530# a_n138_n400# 0.07442f
C4 w_n224_n530# a_n50_n444# 0.07993f
C5 a_50_n400# a_n138_n400# 0.12527f
C6 a_50_n400# VSUBS 0.16249f
C7 a_n138_n400# VSUBS 0.16249f
C8 w_n224_n530# VSUBS 1.42464f
.ends

.subckt bias_master pad s0 s1 stim intref en in_n in_p iint en_b vbp_st ua0_stim a_1744_9182#
+ vss vdd a_1764_11418# a_1744_10100# a_2240_11218# a_736_5516# a_420_700# a_736_7228#
XOP vss a_1744_10100# a_736_7228# vss n_w2_l2
XRS pad a_420_700# vss r_w4_l3p97
XS1 a_736_5516# s1 a_420_700# vss n_w8_l0p5
XS0 a_420_700# a_736_7228# s0 vss n_w4_l0p5
XOS vss vbp_st a_736_7228# vss n_w2_l2
XIENn en vss en_b vss n_w0p5_l0p28
XIENp vdd en_b en vdd vss p_w1_l0p28
XQX a_1744_9182# vdd a_1744_9182# vdd a_1744_9182# a_736_7228# a_736_7228# vdd a_1744_9182#
+ a_1744_9182# vss p_w2_l2_f4
XDXa vss vss a_736_5516# a_736_5516# a_736_5516# a_736_5516# a_736_5516# a_736_5516#
+ a_736_5516# a_736_5516# vss vss a_736_5516# a_736_5516# a_736_5516# a_736_5516#
+ vss vss n_w2_l2_f8
XOX vss a_1744_9182# a_736_5516# vss n_w2_l2
XDXb vss vss a_736_5516# a_736_5516# a_736_5516# a_736_5516# a_736_5516# a_736_5516#
+ a_736_5516# a_736_5516# vss vss a_736_5516# a_736_5516# a_736_5516# a_736_5516#
+ vss vss n_w2_l2_f8
XISTn stim vss a_1764_11418# vss n_w0p5_l0p28
XISTp vdd a_1764_11418# stim vdd vss p_w1_l0p28
XSWI a_736_7228# a_2240_11218# vdd iint vss p_w2_l0p5
XPD vdd a_1744_10100# a_1744_10100# in_p a_1744_10100# vdd vdd vdd a_1744_10100# a_1744_10100#
+ vss p_w2_l2_f4
XSTN ua0_stim stim a_420_700# vss n_w2_l0p5
XSTP a_420_700# ua0_stim a_1764_11418# vdd vss p_w4_l0p5
XPDN a_736_7228# vss en_b vss n_w4_l0p5
XDa vss vss a_736_7228# a_736_7228# a_736_7228# a_736_7228# a_736_7228# a_736_7228#
+ a_736_7228# a_736_7228# vss vss a_736_7228# a_736_7228# a_736_7228# a_736_7228#
+ vss vss n_w2_l2_f8
XDb vss vss a_736_7228# a_736_7228# a_736_7228# a_736_7228# a_736_7228# a_736_7228#
+ a_736_7228# a_736_7228# vss vss a_736_7228# a_736_7228# a_736_7228# a_736_7228#
+ vss vss n_w2_l2_f8
XIIRn intref vss a_2240_11218# vss n_w0p5_l0p28
XIIRp vdd a_2240_11218# intref vdd vss p_w1_l0p28
XON vss in_n a_736_7228# vss n_w2_l2
D0 vss a_420_700# diode_nd2ps_03v3 pj=22u area=10p
D1 a_420_700# vdd diode_pd2nw_03v3 pj=22u area=10p
C0 s0 en 0.08622f
C1 a_1744_9182# in_n 0.05554f
C2 a_1744_9182# a_420_700# 0
C3 a_736_5516# a_420_700# 0.22588f
C4 in_n in_p 0.00893f
C5 en_b a_420_700# 0.00238f
C6 vbp_st a_1764_11418# 0.24107f
C7 pad en_b 0.00118f
C8 s0 ua0_stim 0
C9 intref s1 0.00169f
C10 a_420_700# in_p 0.14384f
C11 vbp_st en 0.4389f
C12 vbp_st vdd 1.24211f
C13 vbp_st ua0_stim 0.28759f
C14 s1 s0 0.37932f
C15 a_1764_11418# stim 0.89967f
C16 vbp_st a_1744_10100# 0.06941f
C17 a_1744_9182# a_736_7228# 0.40049f
C18 a_736_5516# a_736_7228# 0.94834f
C19 intref s0 0
C20 a_2240_11218# a_1764_11418# 0.0155f
C21 en_b a_736_7228# 0.01852f
C22 en stim 0.16867f
C23 a_736_7228# in_p 0.13123f
C24 stim vdd 0.43645f
C25 a_2240_11218# en 0.0689f
C26 a_2240_11218# vdd 1.56335f
C27 a_1764_11418# in_n 0
C28 vbp_st iint 0.03426f
C29 a_1764_11418# a_420_700# 0.01871f
C30 ua0_stim stim 0.17275f
C31 a_736_5516# a_1744_9182# 0.06682f
C32 stim a_1744_10100# 0.5686f
C33 en in_n 0.22085f
C34 vbp_st intref 0.10375f
C35 vdd in_n 0.93129f
C36 en_b a_736_5516# 0.10641f
C37 a_2240_11218# ua0_stim 0.01891f
C38 a_1744_9182# in_p 0.0074f
C39 a_2240_11218# a_1744_10100# 0.00646f
C40 en a_420_700# 1.35379f
C41 a_420_700# vdd 1.39245f
C42 pad en 0.07917f
C43 pad vdd 0.30131f
C44 ua0_stim in_n 0.13986f
C45 a_1744_10100# in_n 0
C46 iint stim 0
C47 s1 stim 0.05023f
C48 ua0_stim a_420_700# 0.27553f
C49 a_420_700# a_1744_10100# 0
C50 a_2240_11218# iint 0.04705f
C51 intref stim 0.10135f
C52 a_1764_11418# a_736_7228# 0.58069f
C53 a_2240_11218# intref 0.51277f
C54 en a_736_7228# 0.06595f
C55 a_736_7228# vdd 1.34623f
C56 s1 a_420_700# 0.34537f
C57 pad s1 0.04303f
C58 s0 stim 0
C59 a_1764_11418# a_1744_9182# 0.08433f
C60 intref a_420_700# 0.08048f
C61 a_1764_11418# a_736_5516# 0.29581f
C62 pad intref 0.04537f
C63 en_b a_1764_11418# 0.04298f
C64 a_736_7228# ua0_stim 0.65944f
C65 a_736_7228# a_1744_10100# 0.21495f
C66 a_1764_11418# in_p 0.10845f
C67 a_1744_9182# en 0
C68 a_1744_9182# vdd 1.89441f
C69 a_736_5516# en 0.1206f
C70 a_736_5516# vdd 0.03946f
C71 en_b en 0.16284f
C72 en_b vdd 1.53555f
C73 en in_p 0.1023f
C74 vdd in_p 0.3992f
C75 vbp_st stim 0.03538f
C76 s0 a_420_700# 0.23128f
C77 a_1744_9182# ua0_stim 0
C78 pad s0 0.04859f
C79 a_736_7228# iint 0.07137f
C80 s1 a_736_7228# 0.26174f
C81 a_2240_11218# vbp_st 0.09119f
C82 a_736_5516# ua0_stim 0.76166f
C83 a_1744_9182# a_1744_10100# 0.21634f
C84 en_b ua0_stim 0.11556f
C85 en_b a_1744_10100# 0
C86 intref a_736_7228# 1.05564f
C87 ua0_stim in_p 0.13299f
C88 a_1744_10100# in_p 0.1228f
C89 vbp_st in_n 0
C90 vbp_st a_420_700# 0.00221f
C91 s1 a_736_5516# 0.04485f
C92 en_b iint 0.00566f
C93 en_b s1 0.04984f
C94 a_2240_11218# stim 0.02672f
C95 intref a_1744_9182# 0.06003f
C96 s0 a_736_7228# 0.08339f
C97 iint in_p 0
C98 intref a_736_5516# 0.42454f
C99 en_b intref 0.13348f
C100 a_1764_11418# en 0.00964f
C101 a_1764_11418# vdd 0.9203f
C102 stim in_n 0
C103 stim a_420_700# 0.39449f
C104 pad stim 0.03728f
C105 en vdd 1.40435f
C106 a_2240_11218# a_420_700# 0
C107 vbp_st a_736_7228# 0.19283f
C108 a_736_5516# s0 0.00164f
C109 a_1764_11418# ua0_stim 0.39761f
C110 en_b s0 0
C111 a_1764_11418# a_1744_10100# 0.20361f
C112 a_420_700# in_n 0.06513f
C113 en ua0_stim 0.04932f
C114 ua0_stim vdd 0.7438f
C115 en a_1744_10100# 0
C116 a_1744_10100# vdd 2.14231f
C117 pad a_420_700# 0.54069f
C118 vbp_st a_1744_9182# 0.27778f
C119 vbp_st a_736_5516# 0.01681f
C120 a_1764_11418# iint 0.04831f
C121 en_b vbp_st 0.22396f
C122 a_736_7228# stim 0.67831f
C123 ua0_stim a_1744_10100# 0.0495f
C124 vbp_st in_p 0.01109f
C125 intref a_1764_11418# 0.13911f
C126 a_2240_11218# a_736_7228# 0.1092f
C127 en iint 0.04364f
C128 s1 en 0.05296f
C129 iint vdd 0.20167f
C130 s1 vdd 0
C131 intref en 0.18747f
C132 intref vdd 1.1637f
C133 a_736_7228# in_n 0.22106f
C134 a_1744_9182# stim 0.09507f
C135 iint ua0_stim 0.22215f
C136 s1 ua0_stim 0
C137 a_736_5516# stim 0.46322f
C138 a_736_7228# a_420_700# 0.60616f
C139 iint a_1744_10100# 0.0038f
C140 en_b stim 0.09516f
C141 pad a_736_7228# 0.00246f
C142 a_2240_11218# a_1744_9182# 0.04423f
C143 a_2240_11218# a_736_5516# 0.20875f
C144 intref ua0_stim 0.38842f
C145 stim in_p 0
C146 a_2240_11218# en_b 0.55285f
C147 intref a_1744_10100# 0.00123f
C148 a_2240_11218# in_p 0
C149 in_n vss 0.4171f
C150 a_2240_11218# vss 1.12079f
C151 intref vss 1.56078f
C152 a_736_7228# vss 7.21627f
C153 en_b vss 2.84339f
C154 ua0_stim vss 1.3904f
C155 stim vss 1.68124f
C156 in_p vss 0.10852f
C157 iint vss -0.02046f
C158 a_1764_11418# vss 0.23987f
C159 a_736_5516# vss 5.14983f
C160 a_1744_9182# vss -0.31499f
C161 vdd vss 48.57603f
C162 en vss 2.99933f
C163 vbp_st vss 0.13312f
C164 a_420_700# vss 2.09001f
C165 s0 vss 0.69974f
C166 s1 vss 0.67954f
C167 pad vss 1.41208f
C168 a_1744_10100# vss -0.2385f
.ends

.subckt n_w2_l2_f7 a_n704_n244# a_n808_n200# a_304_n244# a_n1712_n244# a_1712_n200#
+ a_n1800_n200# a_n1208_n244# a_1208_n200# a_200_n200# a_1312_n244# a_808_n244# a_n200_n244#
+ a_n304_n200# a_n1312_n200# a_704_n200# VSUBS
X0 a_n304_n200# a_n704_n244# a_n808_n200# VSUBS nfet_03v3 ad=0.52p pd=2.52u as=0.52p ps=2.52u w=2u l=2u
X1 a_200_n200# a_n200_n244# a_n304_n200# VSUBS nfet_03v3 ad=0.52p pd=2.52u as=0.52p ps=2.52u w=2u l=2u
X2 a_1712_n200# a_1312_n244# a_1208_n200# VSUBS nfet_03v3 ad=0.88p pd=4.88u as=0.52p ps=2.52u w=2u l=2u
X3 a_1208_n200# a_808_n244# a_704_n200# VSUBS nfet_03v3 ad=0.52p pd=2.52u as=0.52p ps=2.52u w=2u l=2u
X4 a_704_n200# a_304_n244# a_200_n200# VSUBS nfet_03v3 ad=0.52p pd=2.52u as=0.52p ps=2.52u w=2u l=2u
X5 a_n1312_n200# a_n1712_n244# a_n1800_n200# VSUBS nfet_03v3 ad=0.52p pd=2.52u as=0.88p ps=4.88u w=2u l=2u
X6 a_n808_n200# a_n1208_n244# a_n1312_n200# VSUBS nfet_03v3 ad=0.52p pd=2.52u as=0.52p ps=2.52u w=2u l=2u
C0 a_n1208_n244# a_n1312_n200# 0.0587f
C1 a_704_n200# a_200_n200# 0.02133f
C2 a_704_n200# a_808_n244# 0.0587f
C3 a_304_n244# a_200_n200# 0.0587f
C4 a_n304_n200# a_200_n200# 0.02133f
C5 a_304_n244# a_808_n244# 0.00519f
C6 a_704_n200# a_1208_n200# 0.02133f
C7 a_n808_n200# a_n304_n200# 0.02133f
C8 a_n200_n244# a_n704_n244# 0.00519f
C9 a_n1208_n244# a_n1712_n244# 0.00519f
C10 a_1208_n200# a_808_n244# 0.0587f
C11 a_n1800_n200# a_n1312_n200# 0.02133f
C12 a_n1208_n244# a_n808_n200# 0.0587f
C13 a_n704_n244# a_n304_n200# 0.0587f
C14 a_1208_n200# a_1712_n200# 0.02133f
C15 a_n200_n244# a_304_n244# 0.00519f
C16 a_n200_n244# a_n304_n200# 0.0587f
C17 a_1312_n244# a_808_n244# 0.00519f
C18 a_n704_n244# a_n808_n200# 0.0587f
C19 a_n1712_n244# a_n1312_n200# 0.0587f
C20 a_1312_n244# a_1208_n200# 0.0587f
C21 a_704_n200# a_304_n244# 0.0587f
C22 a_n200_n244# a_200_n200# 0.0587f
C23 a_n1208_n244# a_n704_n244# 0.00519f
C24 a_n808_n200# a_n1312_n200# 0.02133f
C25 a_n1712_n244# a_n1800_n200# 0.0587f
C26 a_1312_n244# a_1712_n200# 0.0587f
C27 a_1712_n200# VSUBS 0.26162f
C28 a_1208_n200# VSUBS 0.34773f
C29 a_704_n200# VSUBS 0.34265f
C30 a_200_n200# VSUBS 0.34265f
C31 a_n304_n200# VSUBS 0.34265f
C32 a_n808_n200# VSUBS 0.34265f
C33 a_n1312_n200# VSUBS 0.34773f
C34 a_n1800_n200# VSUBS 0.26162f
.ends

.subckt n_w0p5_l0p5_f2 a_n52_n50# a_52_n94# a_152_n50# a_n240_n50# a_n152_n94# VSUBS
X0 a_152_n50# a_52_n94# a_n52_n50# VSUBS nfet_03v3 ad=0.22p pd=1.88u as=0.13p ps=1.02u w=0.5u l=0.5u
X1 a_n52_n50# a_n152_n94# a_n240_n50# VSUBS nfet_03v3 ad=0.13p pd=1.02u as=0.22p ps=1.88u w=0.5u l=0.5u
C0 a_n52_n50# a_n152_n94# 0.00625f
C1 a_n240_n50# a_n152_n94# 0.00625f
C2 a_n240_n50# a_n52_n50# 0.01511f
C3 a_n52_n50# a_152_n50# 0.01511f
C4 a_52_n94# a_n152_n94# 0.00519f
C5 a_52_n94# a_n52_n50# 0.00625f
C6 a_52_n94# a_152_n50# 0.00625f
C7 a_152_n50# VSUBS 0.09131f
C8 a_n52_n50# VSUBS 0.12761f
C9 a_n240_n50# VSUBS 0.09131f
.ends

.subckt idac_n b0 b1 b2 b3 b4 out vcas vdd vss m1_988_3644# a_3928_4510# m1_988_2984#
+ a_732_4510# a_1582_4510# a_4132_4510# a_3282_4510# m1_988_1168# g a_2432_4510# m1_640_4420#
+ a_1378_4510# a_528_4510# dump m1_1500_4102# a_2228_4510# vsn a_3078_4510#
XU4b vsn vsn m1_988_1168# g g m1_988_1168# g m1_988_1168# g m1_988_1168# vsn vsn g
+ g g g vsn vss n_w2_l2_f8
XU3 vsn vsn m1_988_2984# g g m1_988_2984# g m1_988_2984# g m1_988_2984# vsn vsn g
+ g g g vsn vss n_w2_l2_f8
XIP0 a_732_4510# vcas vcas a_528_4510# a_732_4510# b0 vss p_w1_l0p28_f2
XIP1 a_1582_4510# vcas vcas a_1378_4510# a_1582_4510# b1 vss p_w1_l0p28_f2
XIP2 a_2432_4510# vcas vcas a_2228_4510# a_2432_4510# b2 vss p_w1_l0p28_f2
XIN0 vss a_732_4510# a_732_4510# a_528_4510# b0 vss n_w0p5_l0p28_f2
XIP3 a_3282_4510# vcas vcas a_3078_4510# a_3282_4510# b3 vss p_w1_l0p28_f2
XIN1 vss a_1582_4510# a_1582_4510# a_1378_4510# b1 vss n_w0p5_l0p28_f2
XIP4 a_4132_4510# vcas vcas a_3928_4510# a_4132_4510# b4 vss p_w1_l0p28_f2
XIN3 vss a_3282_4510# a_3282_4510# a_3078_4510# b3 vss n_w0p5_l0p28_f2
XIN2 vss a_2432_4510# a_2432_4510# a_2228_4510# b2 vss n_w0p5_l0p28_f2
XIN4 vss a_4132_4510# a_4132_4510# a_3928_4510# b4 vss n_w0p5_l0p28_f2
XU210 g vsn g g m1_640_4420# vsn g vsn vsn g g g m1_988_3644# m1_988_3644# m1_1500_4102#
+ vss n_w2_l2_f7
XSW0 m1_640_4420# a_732_4510# dump out a_528_4510# vss n_w0p5_l0p5_f2
XSW2 m1_988_3644# a_2432_4510# dump out a_2228_4510# vss n_w0p5_l0p5_f2
XSW1 m1_1500_4102# a_1582_4510# dump out a_1378_4510# vss n_w0p5_l0p5_f2
XSW3 m1_988_2984# a_3282_4510# dump out a_3078_4510# vss n_w0p5_l0p5_f2
XSW4 m1_988_1168# a_4132_4510# dump out a_3928_4510# vss n_w0p5_l0p5_f2
XU4a vsn vsn m1_988_1168# g g m1_988_1168# g m1_988_1168# g m1_988_1168# vsn vsn g
+ g g g vsn vss n_w2_l2_f8
C0 a_528_4510# b0 0.07632f
C1 m1_988_3644# a_2432_4510# 0.00358f
C2 m1_988_3644# m1_988_2984# 0.02717f
C3 a_1378_4510# a_2432_4510# 0.0516f
C4 a_1378_4510# a_1582_4510# 0.16506f
C5 a_3078_4510# g 0.00277f
C6 a_3078_4510# a_4132_4510# 0.02801f
C7 b2 m1_988_3644# 0.00245f
C8 b2 a_1378_4510# 0.00372f
C9 a_528_4510# vsn 0.00272f
C10 out m1_988_1168# 0.03637f
C11 dump m1_1500_4102# 0.19754f
C12 m1_988_2984# m1_640_4420# 0.42567f
C13 b0 a_1378_4510# 0
C14 vcas a_3928_4510# 0.14312f
C15 dump b3 0.1188f
C16 out dump 0.63429f
C17 g a_4132_4510# 0.00179f
C18 a_3282_4510# b3 0.16136f
C19 out a_3282_4510# 0.01963f
C20 a_732_4510# g 0.00302f
C21 m1_988_3644# vsn 0.10763f
C22 dump a_2228_4510# 0.20003f
C23 dump b1 0.20373f
C24 b0 m1_640_4420# 0
C25 m1_988_2984# a_3928_4510# 0
C26 a_3282_4510# a_2228_4510# 0.05966f
C27 a_3282_4510# b1 0
C28 b4 b3 0.02332f
C29 vdd dump 0.02751f
C30 a_528_4510# m1_640_4420# -0
C31 m1_988_3644# a_1378_4510# 0
C32 m1_640_4420# vsn 0.21018f
C33 dump vcas 0.48072f
C34 a_3078_4510# m1_1500_4102# 0.00565f
C35 b4 a_2228_4510# 0
C36 a_3282_4510# vcas 0.25118f
C37 a_3078_4510# b3 0.21645f
C38 out a_3078_4510# 0.05011f
C39 m1_988_1168# m1_988_2984# 0.36873f
C40 m1_988_3644# m1_640_4420# 0.06234f
C41 vdd b4 0.0055f
C42 a_3928_4510# vsn 0
C43 dump a_2432_4510# 0.05327f
C44 dump a_1582_4510# 0.15501f
C45 dump m1_988_2984# 0.008f
C46 a_3078_4510# a_2228_4510# 0.08352f
C47 a_3282_4510# a_2432_4510# 0.0139f
C48 a_3282_4510# a_1582_4510# 0
C49 b2 dump 0.03736f
C50 a_3282_4510# m1_988_2984# 0.00685f
C51 m1_1500_4102# g 0.48065f
C52 vcas b4 0.57541f
C53 b2 a_3282_4510# 0.00507f
C54 g b3 0
C55 a_4132_4510# b3 0.07656f
C56 out g 0.47621f
C57 out a_4132_4510# 0
C58 vdd a_3078_4510# 0
C59 out a_732_4510# 0.22696f
C60 dump b0 0.02448f
C61 a_3078_4510# vcas 0.19953f
C62 g a_2228_4510# 0.00298f
C63 a_4132_4510# a_2228_4510# 0
C64 m1_988_1168# vsn 0.64878f
C65 dump a_528_4510# 0.05747f
C66 b1 g 0
C67 dump vsn 0.00243f
C68 a_732_4510# b1 0.00175f
C69 a_3928_4510# m1_640_4420# 0.00207f
C70 a_3078_4510# a_2432_4510# 0.08149f
C71 a_3078_4510# a_1582_4510# 0
C72 a_3078_4510# m1_988_2984# 0.01645f
C73 vcas g 0.00165f
C74 vcas a_4132_4510# 0.30332f
C75 b2 a_3078_4510# 0
C76 dump m1_988_3644# 0.18463f
C77 vcas a_732_4510# 0.26628f
C78 dump a_1378_4510# 0.09756f
C79 a_3282_4510# a_1378_4510# 0
C80 m1_988_1168# m1_640_4420# 0.40443f
C81 g a_2432_4510# 0.00282f
C82 g a_1582_4510# 0.00302f
C83 g m1_988_2984# 1.04697f
C84 out m1_1500_4102# 0.23687f
C85 a_732_4510# a_1582_4510# 0.01858f
C86 dump m1_640_4420# 0.0671f
C87 b2 g 0
C88 out b3 0.00579f
C89 m1_1500_4102# a_2228_4510# 0
C90 m1_988_1168# a_3928_4510# 0.05714f
C91 b0 g 0
C92 m1_1500_4102# b1 0
C93 a_2228_4510# b3 0.0693f
C94 out a_2228_4510# 0.05944f
C95 a_732_4510# b0 0.2633f
C96 dump a_3928_4510# 0.24085f
C97 out b1 0
C98 a_528_4510# g 0.00314f
C99 a_3282_4510# a_3928_4510# 0.01295f
C100 b4 m1_640_4420# 0
C101 a_732_4510# a_528_4510# 0.20157f
C102 vdd b3 0.00856f
C103 g vsn 4.13912f
C104 a_4132_4510# vsn 0.00246f
C105 b1 a_2228_4510# 0.03121f
C106 vcas m1_1500_4102# 0
C107 vcas b3 0.62689f
C108 out vcas 0.32837f
C109 m1_988_3644# g 0.65607f
C110 b4 a_3928_4510# 0.19804f
C111 g a_1378_4510# 0.00386f
C112 dump m1_988_1168# 0.09736f
C113 m1_1500_4102# a_2432_4510# 0.00549f
C114 vcas a_2228_4510# 0.88181f
C115 m1_1500_4102# a_1582_4510# 0.01438f
C116 m1_1500_4102# m1_988_2984# 0.12093f
C117 a_732_4510# a_1378_4510# 0.00704f
C118 vcas b1 0.36568f
C119 a_2432_4510# b3 0.00174f
C120 out a_2432_4510# 0.01737f
C121 out a_1582_4510# 0.03274f
C122 m1_988_2984# b3 0
C123 b2 m1_1500_4102# 0
C124 out m1_988_2984# 0.11859f
C125 dump a_3282_4510# 0.0375f
C126 a_3078_4510# a_3928_4510# 0
C127 b2 b3 0.00131f
C128 b2 out 0
C129 vdd vcas 0.00553f
C130 g m1_640_4420# 1.80971f
C131 a_4132_4510# m1_640_4420# 0.00424f
C132 a_2432_4510# a_2228_4510# 0.21918f
C133 a_2228_4510# a_1582_4510# 0.04378f
C134 a_732_4510# m1_640_4420# 0.00799f
C135 b1 a_2432_4510# 0
C136 b1 a_1582_4510# 0.20863f
C137 m1_988_1168# b4 0
C138 b2 a_2228_4510# 0.1862f
C139 out b0 0.18193f
C140 b2 b1 0.00754f
C141 dump b4 0.19408f
C142 g a_3928_4510# 0.00134f
C143 out a_528_4510# 0.1447f
C144 a_4132_4510# a_3928_4510# 0.22322f
C145 m1_1500_4102# vsn 0.02779f
C146 a_3282_4510# b4 0.00157f
C147 vcas a_2432_4510# 0.28651f
C148 vcas a_1582_4510# 0.32387f
C149 out vsn 0.08074f
C150 vcas m1_988_2984# 0
C151 b1 b0 0.00416f
C152 b2 vcas 0.43587f
C153 dump a_3078_4510# 0.00123f
C154 m1_1500_4102# m1_988_3644# 0.1f
C155 b1 a_528_4510# 0.00107f
C156 a_3078_4510# a_3282_4510# 0.23138f
C157 m1_1500_4102# a_1378_4510# 0
C158 out m1_988_3644# 0.36927f
C159 a_2432_4510# a_1582_4510# 0.00399f
C160 out a_1378_4510# 0.07248f
C161 vcas b0 0.35488f
C162 m1_988_1168# g 2.38663f
C163 m1_988_1168# a_4132_4510# 0.00827f
C164 b2 a_2432_4510# 0.26648f
C165 b2 a_1582_4510# 0.00194f
C166 m1_988_3644# a_2228_4510# 0.01831f
C167 vcas a_528_4510# 0.12659f
C168 dump g 0.06247f
C169 dump a_4132_4510# 0.16313f
C170 a_1378_4510# a_2228_4510# 0.08075f
C171 m1_1500_4102# m1_640_4420# 0
C172 a_3078_4510# b4 0.00502f
C173 b1 a_1378_4510# 0.09632f
C174 a_3282_4510# g 0.00457f
C175 dump a_732_4510# 0.09978f
C176 a_3282_4510# a_4132_4510# 0.00734f
C177 out m1_640_4420# 0.11936f
C178 b0 a_1582_4510# 0
C179 a_528_4510# a_1582_4510# 0.15414f
C180 a_2432_4510# vsn 0
C181 vcas a_1378_4510# 0.14056f
C182 m1_988_2984# vsn 0.2568f
C183 b4 a_4132_4510# 0.14f
C184 out a_3928_4510# 0.00333f
C185 vdd vss 0.0208f
C186 m1_988_1168# vss 1.13391f
C187 vsn vss 2.23819f
C188 g vss 6.33801f
C189 a_3928_4510# vss 0.32602f
C190 a_3078_4510# vss 0.46553f
C191 a_1378_4510# vss 0.31495f
C192 a_2432_4510# vss 0.49752f
C193 a_2228_4510# vss 0.53126f
C194 dump vss 2.48651f
C195 out vss 1.55846f
C196 a_528_4510# vss 0.42948f
C197 m1_640_4420# vss 1.05766f
C198 m1_1500_4102# vss 0.27508f
C199 m1_988_3644# vss 0.10411f
C200 a_4132_4510# vss 0.73601f
C201 b4 vss 0.34915f
C202 b2 vss 0.16641f
C203 a_3282_4510# vss 0.50614f
C204 b3 vss 0.39209f
C205 a_1582_4510# vss 0.63021f
C206 b1 vss 0.16751f
C207 a_732_4510# vss 0.61485f
C208 b0 vss 0.21914f
C209 vcas vss 10.53474f
C210 m1_988_2984# vss 0.29737f
.ends

.subckt r_w1_l7p765 a_n100_n899# a_n100_777# VSUBS
X0 a_n100_777# a_n100_n899# VSUBS ppolyf_u_1k r_width=1u r_length=7.77u
C0 a_n100_n899# VSUBS 0.27003f
C1 a_n100_777# VSUBS 0.27003f
.ends

.subckt r_w2_l1p97 a_n200_n319# a_n200_197# VSUBS
X0 a_n200_197# a_n200_n319# VSUBS ppolyf_u_1k r_width=2u r_length=1.97u
C0 a_n200_n319# a_n200_197# 0.02096f
C1 a_n200_n319# VSUBS 0.42971f
C2 a_n200_197# VSUBS 0.42971f
.ends

.subckt r_w1_l1p94 a_n100_n316# a_n100_194# VSUBS
X0 a_n100_194# a_n100_n316# VSUBS ppolyf_u_1k r_width=1u r_length=1.94u
C0 a_n100_n316# a_n100_194# 0.01052f
C1 a_n100_n316# VSUBS 0.2541f
C2 a_n100_194# VSUBS 0.2541f
.ends

.subckt r_w1_l3p88 a_n100_n510# a_n100_388# VSUBS
X0 a_n100_388# a_n100_n510# VSUBS ppolyf_u_1k r_width=1u r_length=3.88u
C0 a_n100_n510# a_n100_388# 0.00535f
C1 a_n100_n510# VSUBS 0.26053f
C2 a_n100_388# VSUBS 0.26053f
.ends

.subckt n_w0p5_l1 a_100_n50# a_n100_n94# a_n188_n50# VSUBS
X0 a_100_n50# a_n100_n94# a_n188_n50# VSUBS nfet_03v3 ad=0.22p pd=1.88u as=0.22p ps=1.88u w=0.5u l=1u
C0 a_n188_n50# a_100_n50# 0.00935f
C1 a_100_n50# a_n100_n94# 0.01026f
C2 a_n188_n50# a_n100_n94# 0.01026f
C3 a_100_n50# VSUBS 0.13392f
C4 a_n188_n50# VSUBS 0.13392f
.ends

.subckt p_w1_l1 a_n188_n100# a_100_n100# a_n100_n144# w_n274_n230# VSUBS
X0 a_100_n100# a_n100_n144# a_n188_n100# w_n274_n230# pfet_03v3 ad=0.44p pd=2.88u as=0.44p ps=2.88u w=1u l=1u
C0 a_n100_n144# a_n188_n100# 0.02094f
C1 a_100_n100# w_n274_n230# 0.02517f
C2 a_n188_n100# w_n274_n230# 0.02517f
C3 a_n100_n144# w_n274_n230# 0.12884f
C4 a_100_n100# a_n188_n100# 0.0191f
C5 a_n100_n144# a_100_n100# 0.02094f
C6 a_100_n100# VSUBS 0.07854f
C7 a_n188_n100# VSUBS 0.07854f
C8 w_n274_n230# VSUBS 0.75624f
.ends

.subckt r_w1_l11p645 a_n100_1165# a_n100_n1287# VSUBS
X0 a_n100_1165# a_n100_n1287# VSUBS ppolyf_u_1k r_width=1u r_length=11.65u
C0 a_n100_n1287# VSUBS 0.27003f
C1 a_n100_1165# VSUBS 0.27003f
.ends

.subckt n_w4_l0p28_f2 a_n52_n400# a_52_n444# a_108_n400# a_n108_n444# a_n196_n400#
+ VSUBS
X0 a_108_n400# a_52_n444# a_n52_n400# VSUBS nfet_03v3 ad=1.76p pd=8.88u as=1.04p ps=4.52u w=4u l=0.28u
X1 a_n52_n400# a_n108_n444# a_n196_n400# VSUBS nfet_03v3 ad=1.04p pd=4.52u as=1.76p ps=8.88u w=4u l=0.28u
C0 a_108_n400# a_n52_n400# 0.17284f
C1 a_n52_n400# a_n108_n444# 0.03125f
C2 a_52_n444# a_108_n400# 0.03125f
C3 a_n196_n400# a_n108_n444# 0.03125f
C4 a_52_n444# a_n108_n444# 0.00519f
C5 a_n52_n400# a_n196_n400# 0.17284f
C6 a_52_n444# a_n52_n400# 0.03125f
C7 a_108_n400# VSUBS 0.20946f
C8 a_n52_n400# VSUBS 0.09458f
C9 a_n196_n400# VSUBS 0.20946f
.ends

.subckt vdacr_el b0 b1 b2 b3 b4 vdd a_2392_3416# a_3576_3416# m1_942_4048# a_1800_3416#
+ m1_2262_4048# m1_3342_4048# m1_4094_3010# m1_1382_4048# a_2984_3416# out a_4168_3416#
+ m1_2760_3412# m1_4222_4048# m1_1822_4048# vss m1_502_4048#
XXRS4_0 m1_4222_4048# m1_4094_3010# vss r_w1_l7p765
XXRS4_1 vss m1_4222_4048# vss r_w1_l7p765
XXRS0 m1_2262_4048# m1_1822_4048# vss r_w2_l1p97
XXRS1 m1_2760_3412# m1_2262_4048# vss r_w1_l1p94
XXRS3 m1_4094_3010# m1_3342_4048# vss r_w1_l7p765
XXRS2 m1_3342_4048# m1_2760_3412# vss r_w1_l3p88
XIB4n a_4168_3416# b4 vss vss n_w0p5_l1
XIB3n a_3576_3416# b3 vss vss n_w0p5_l1
XIB4p vdd a_4168_3416# b4 vdd vss p_w1_l1
XIB2n a_2984_3416# b2 vss vss n_w0p5_l1
XIB3p vdd a_3576_3416# b3 vdd vss p_w1_l1
XIB2p vdd a_2984_3416# b2 vdd vss p_w1_l1
XIB1n a_2392_3416# b1 vss vss n_w0p5_l1
XIB0n a_1800_3416# b0 vss vss n_w0p5_l1
XIB1p vdd a_2392_3416# b1 vdd vss p_w1_l1
XIB0p vdd a_1800_3416# b0 vdd vss p_w1_l1
XXRB0 out m1_502_4048# vss r_w1_l11p645
XSW0 m1_2262_4048# a_1800_3416# m1_1822_4048# a_1800_3416# m1_1822_4048# vss n_w4_l0p28_f2
XXRB1 m1_502_4048# m1_942_4048# vss r_w1_l11p645
XSW2 m1_3342_4048# a_2984_3416# m1_2760_3412# a_2984_3416# m1_2760_3412# vss n_w4_l0p28_f2
XSW1 m1_2760_3412# a_2392_3416# m1_2262_4048# a_2392_3416# m1_2262_4048# vss n_w4_l0p28_f2
XXRB3 m1_1382_4048# m1_1822_4048# vss r_w1_l11p645
XXRB2 m1_942_4048# m1_1382_4048# vss r_w1_l11p645
XSW3 m1_4094_3010# a_3576_3416# m1_3342_4048# a_3576_3416# m1_3342_4048# vss n_w4_l0p28_f2
XSW4 vss a_4168_3416# m1_4094_3010# a_4168_3416# m1_4094_3010# vss n_w4_l0p28_f2
C0 vdd a_2984_3416# 0.11011f
C1 b3 a_2984_3416# 0.11129f
C2 b0 a_2392_3416# 0
C3 m1_2760_3412# m1_2262_4048# 0.4402f
C4 b0 b1 0.02048f
C5 vdd m1_2760_3412# 0.00478f
C6 a_2392_3416# b2 0.01373f
C7 b2 b1 0.03015f
C8 b0 a_1800_3416# 0.2037f
C9 m1_3342_4048# b2 0.0068f
C10 a_3576_3416# a_4168_3416# 0.05563f
C11 vdd m1_2262_4048# 0.01298f
C12 out m1_502_4048# 0.06293f
C13 a_2392_3416# b1 0.26752f
C14 m1_1382_4048# a_1800_3416# 0.01706f
C15 a_2392_3416# m1_3342_4048# -0
C16 m1_942_4048# m1_502_4048# 0.29397f
C17 b4 a_4168_3416# 0.08723f
C18 vdd b3 0.75321f
C19 a_2984_3416# a_4168_3416# 0
C20 a_2392_3416# a_1800_3416# 0.01991f
C21 b1 a_1800_3416# 0.02378f
C22 m1_2760_3412# a_4168_3416# 0
C23 m1_4222_4048# m1_3342_4048# 0.06437f
C24 m1_2262_4048# a_4168_3416# 0
C25 m1_3342_4048# m1_4094_3010# 0.26112f
C26 vdd a_4168_3416# 0.27917f
C27 b3 a_4168_3416# 0.00279f
C28 m1_2760_3412# m1_1822_4048# 0
C29 m1_942_4048# m1_1822_4048# 0
C30 m1_4222_4048# m1_4094_3010# 0.32763f
C31 m1_2262_4048# m1_1822_4048# 0.2724f
C32 vdd m1_1822_4048# 0.00239f
C33 a_3576_3416# b2 0
C34 b4 b2 0
C35 m1_1822_4048# m1_502_4048# 0
C36 b2 a_2984_3416# 0.25515f
C37 m1_1382_4048# out 0.02493f
C38 a_3576_3416# m1_3342_4048# 0.19263f
C39 m1_2760_3412# m1_1382_4048# 0.00312f
C40 a_2392_3416# a_2984_3416# 0.04802f
C41 m1_1382_4048# m1_942_4048# 0.11001f
C42 m1_3342_4048# a_2984_3416# 0.13071f
C43 a_3576_3416# m1_4222_4048# 0
C44 m1_1382_4048# m1_2262_4048# 0
C45 m1_2760_3412# a_2392_3416# 0.1015f
C46 b0 vdd 0.49782f
C47 m1_2760_3412# m1_3342_4048# 0.31317f
C48 a_3576_3416# m1_4094_3010# 0.20164f
C49 a_2392_3416# m1_2262_4048# 0.32464f
C50 vdd b2 0.54911f
C51 b3 b2 0.0858f
C52 b1 m1_2262_4048# 0.01445f
C53 m1_2760_3412# a_1800_3416# 0
C54 b4 m1_4094_3010# 0
C55 vdd a_2392_3416# 0.19015f
C56 m1_3342_4048# m1_2262_4048# 0
C57 m1_2760_3412# m1_4222_4048# 0
C58 b3 a_2392_3416# 0
C59 a_2984_3416# m1_4094_3010# 0.00843f
C60 vdd b1 0.60011f
C61 b3 b1 0
C62 vdd m1_3342_4048# 0.00477f
C63 b3 m1_3342_4048# 0.0067f
C64 a_1800_3416# m1_2262_4048# 0.04031f
C65 m1_4222_4048# m1_2262_4048# 0
C66 m1_2760_3412# m1_4094_3010# 0.00462f
C67 vdd a_1800_3416# 0.17226f
C68 m1_4094_3010# m1_2262_4048# 0.00343f
C69 vdd m1_4094_3010# 0.00117f
C70 b3 m1_4094_3010# 0.06497f
C71 m1_3342_4048# a_4168_3416# 0
C72 m1_1382_4048# m1_1822_4048# 0.11431f
C73 b4 a_3576_3416# 0.06652f
C74 a_3576_3416# a_2984_3416# 0.03485f
C75 m1_4222_4048# a_4168_3416# 0.00345f
C76 a_2392_3416# m1_1822_4048# 0.06921f
C77 b4 a_2984_3416# 0
C78 b1 m1_1822_4048# 0.00833f
C79 a_3576_3416# m1_2760_3412# 0.00689f
C80 m1_3342_4048# m1_1822_4048# 0
C81 m1_4094_3010# a_4168_3416# 0.11823f
C82 m1_2760_3412# a_2984_3416# 0.28127f
C83 a_3576_3416# m1_2262_4048# 0
C84 a_1800_3416# m1_1822_4048# 0.09997f
C85 a_3576_3416# vdd 0.16485f
C86 a_3576_3416# b3 0.12657f
C87 m1_942_4048# out 0.06958f
C88 a_2984_3416# m1_2262_4048# 0.03635f
C89 b4 vdd 0.72875f
C90 b4 b3 0.03476f
C91 m1_4094_3010# vss 1.24421f
C92 m1_1382_4048# vss 0.63563f
C93 m1_2760_3412# vss 0.51839f
C94 m1_3342_4048# vss 0.51288f
C95 m1_942_4048# vss 0.35136f
C96 m1_2262_4048# vss 0.29456f
C97 m1_1822_4048# vss 0.33864f
C98 m1_502_4048# vss 0.6194f
C99 out vss 0.79041f
C100 vdd vss 15.08764f
C101 a_1800_3416# vss 0.84103f
C102 b0 vss 0.53222f
C103 a_2392_3416# vss 0.56569f
C104 b1 vss 0.44836f
C105 a_2984_3416# vss 0.44317f
C106 b2 vss 0.55514f
C107 b4 vss 0.62555f
C108 a_3576_3416# vss 0.65055f
C109 b3 vss 0.54803f
C110 a_4168_3416# vss 1.35234f
C111 m1_4222_4048# vss 0.2956f
.ends

.subckt r_w1_l13p91 a_n100_n1513# a_n100_1391# VSUBS
X0 a_n100_1391# a_n100_n1513# VSUBS ppolyf_u_1k r_width=1u r_length=13.91u
C0 a_n100_n1513# VSUBS 0.27003f
C1 a_n100_1391# VSUBS 0.27003f
.ends

.subckt vdacr_vr b0 b1 b2 b3 b4 vdd out m1_3782_4048# a_2392_3416# a_3576_3416# m1_942_4048#
+ m1_502_4048# a_1800_3416# m1_2318_2410# m1_3492_2640# m1_3662_2290# vss a_2984_3416#
+ a_4168_3416# m1_2910_2650# m1_1716_2640#
XXRS4_0 m1_3782_4048# m1_3662_2290# vss r_w1_l7p765
XXRS4_1 vss m1_3782_4048# vss r_w1_l7p765
XXRS0 m1_2318_2410# m1_1716_2640# vss r_w2_l1p97
XXRS1 m1_2910_2650# m1_2318_2410# vss r_w1_l1p94
XXRS3 m1_3662_2290# m1_3492_2640# vss r_w1_l7p765
XXRS2 m1_3492_2640# m1_2910_2650# vss r_w1_l3p88
XIB4n a_4168_3416# b4 vss vss n_w0p5_l1
XIB3n a_3576_3416# b3 vss vss n_w0p5_l1
XIB4p vdd a_4168_3416# b4 vdd vss p_w1_l1
XIB2n a_2984_3416# b2 vss vss n_w0p5_l1
XIB3p vdd a_3576_3416# b3 vdd vss p_w1_l1
XIB2p vdd a_2984_3416# b2 vdd vss p_w1_l1
XIB1n a_2392_3416# b1 vss vss n_w0p5_l1
XIB0n a_1800_3416# b0 vss vss n_w0p5_l1
XIB1p vdd a_2392_3416# b1 vdd vss p_w1_l1
XIB0p vdd a_1800_3416# b0 vdd vss p_w1_l1
XXRB0 m1_502_4048# out vss r_w1_l13p91
XSW0 m1_2318_2410# a_1800_3416# m1_1716_2640# a_1800_3416# m1_1716_2640# vss n_w4_l0p28_f2
XXRB1 m1_942_4048# m1_502_4048# vss r_w1_l13p91
XSW2 m1_3492_2640# a_2984_3416# m1_2910_2650# a_2984_3416# m1_2910_2650# vss n_w4_l0p28_f2
XSW1 m1_2910_2650# a_2392_3416# m1_2318_2410# a_2392_3416# m1_2318_2410# vss n_w4_l0p28_f2
XXRB2 m1_1716_2640# m1_942_4048# vss r_w1_l13p91
XSW3 m1_3662_2290# a_3576_3416# m1_3492_2640# a_3576_3416# m1_3492_2640# vss n_w4_l0p28_f2
XSW4 vss a_4168_3416# m1_3662_2290# a_4168_3416# m1_3662_2290# vss n_w4_l0p28_f2
C0 b3 vdd 0.49099f
C1 b2 vdd 0.70269f
C2 m1_3492_2640# m1_1716_2640# 0
C3 a_1800_3416# m1_942_4048# 0
C4 m1_502_4048# m1_1716_2640# 0
C5 m1_2318_2410# a_2984_3416# 0.02082f
C6 a_2984_3416# m1_3492_2640# 0.19145f
C7 a_2392_3416# b1 0.06781f
C8 a_3576_3416# vdd 0.23034f
C9 m1_3782_4048# a_3576_3416# 0.0078f
C10 b2 m1_3492_2640# 0.00107f
C11 b1 vdd 0.64727f
C12 out m1_942_4048# 0.03171f
C13 vdd a_4168_3416# 0.2173f
C14 m1_3782_4048# a_4168_3416# 0.00195f
C15 a_2392_3416# a_1800_3416# 0.03101f
C16 m1_2910_2650# a_2392_3416# 0.10575f
C17 b0 vdd 0.56802f
C18 m1_3662_2290# a_2984_3416# 0.02389f
C19 a_1800_3416# vdd 0.17745f
C20 m1_2910_2650# vdd 0.0023f
C21 m1_2910_2650# m1_3782_4048# 0
C22 b4 vdd 0.7855f
C23 b3 m1_3662_2290# 0.03077f
C24 m1_2318_2410# b1 0.01095f
C25 a_3576_3416# m1_3492_2640# 0.14935f
C26 m1_3492_2640# a_4168_3416# 0.00141f
C27 m1_2318_2410# a_1800_3416# 0.10972f
C28 m1_2910_2650# m1_2318_2410# 0.21981f
C29 m1_2910_2650# m1_3492_2640# 0.4255f
C30 a_3576_3416# m1_3662_2290# 0.30182f
C31 b3 a_2984_3416# 0.04137f
C32 m1_3662_2290# a_4168_3416# 0.09446f
C33 b2 a_2984_3416# 0.1241f
C34 b2 b3 0.03632f
C35 b1 m1_1716_2640# 0.02654f
C36 m1_2910_2650# m1_3662_2290# 0.01509f
C37 m1_2318_2410# m1_942_4048# 0
C38 a_1800_3416# m1_1716_2640# 0.06997f
C39 m1_502_4048# out 0.0905f
C40 a_2392_3416# vdd 0.27248f
C41 m1_2910_2650# m1_1716_2640# 0.04159f
C42 a_3576_3416# a_2984_3416# 0.01854f
C43 b1 a_2984_3416# 0
C44 m1_502_4048# m1_942_4048# 0.22901f
C45 a_2984_3416# a_4168_3416# 0.00142f
C46 b3 a_3576_3416# 0.23396f
C47 b2 a_3576_3416# 0
C48 b3 a_4168_3416# 0.00455f
C49 b2 b1 0.02658f
C50 m1_2910_2650# a_2984_3416# 0.33905f
C51 b4 a_2984_3416# 0
C52 m1_2318_2410# a_2392_3416# 0.24082f
C53 b4 b3 0.03565f
C54 b2 a_1800_3416# 0
C55 m1_2318_2410# vdd 0.0012f
C56 m1_2318_2410# m1_3782_4048# 0
C57 m1_2910_2650# b2 0.04099f
C58 m1_942_4048# m1_1716_2640# 0.0409f
C59 m1_3492_2640# vdd 0.00698f
C60 m1_3782_4048# m1_3492_2640# 0.01069f
C61 a_3576_3416# a_4168_3416# 0.09216f
C62 a_2392_3416# m1_3662_2290# 0
C63 b0 b1 0.03005f
C64 a_1800_3416# b1 0.06437f
C65 m1_2910_2650# a_3576_3416# 0.00192f
C66 b4 a_3576_3416# 0.03753f
C67 m1_2318_2410# m1_3492_2640# 0
C68 m1_3662_2290# vdd 0
C69 m1_3782_4048# m1_3662_2290# 0.3267f
C70 m1_2910_2650# a_4168_3416# 0
C71 b4 a_4168_3416# 0.14638f
C72 a_2392_3416# m1_1716_2640# 0.04631f
C73 b0 a_1800_3416# 0.19236f
C74 m1_502_4048# m1_2318_2410# 0
C75 m1_2910_2650# a_1800_3416# 0.00203f
C76 m1_1716_2640# vdd 0.00575f
C77 m1_2318_2410# m1_3662_2290# 0
C78 a_2392_3416# a_2984_3416# 0.06043f
C79 m1_3662_2290# m1_3492_2640# 0.29405f
C80 a_2984_3416# vdd 0.30382f
C81 b2 a_2392_3416# 0.09705f
C82 m1_2318_2410# m1_1716_2640# 0.65049f
C83 m1_3662_2290# vss 1.32246f
C84 m1_2910_2650# vss 0.57102f
C85 m1_3492_2640# vss 0.58918f
C86 m1_942_4048# vss 0.68475f
C87 m1_2318_2410# vss 0.33445f
C88 m1_1716_2640# vss 0.27476f
C89 m1_502_4048# vss 0.74307f
C90 out vss 0.95167f
C91 vdd vss 15.01984f
C92 a_1800_3416# vss 0.95743f
C93 b0 vss 0.57434f
C94 a_2392_3416# vss 0.55472f
C95 b1 vss 0.60104f
C96 a_2984_3416# vss 0.73623f
C97 b2 vss 0.77591f
C98 b4 vss 0.4195f
C99 a_3576_3416# vss 0.68085f
C100 b3 vss 0.47349f
C101 a_4168_3416# vss 1.18373f
C102 m1_3782_4048# vss 0.43439f
.ends

.subckt r_w1_l14p555 a_n100_1456# a_n100_n1578# VSUBS
X0 a_n100_1456# a_n100_n1578# VSUBS ppolyf_u_1k r_width=1u r_length=14.56u
C0 a_n100_n1578# VSUBS 0.27003f
C1 a_n100_1456# VSUBS 0.27003f
.ends

.subckt p_w10_l10 w_n1174_n1130# a_n1000_n1044# a_1000_n1000# a_n1088_n1000# VSUBS
X0 a_1000_n1000# a_n1000_n1044# a_n1088_n1000# w_n1174_n1130# pfet_03v3 ad=4.4p pd=20.88u as=4.4p ps=20.88u w=10u l=10u
C0 a_n1000_n1044# a_n1088_n1000# 0.38624f
C1 a_n1000_n1044# a_1000_n1000# 0.38624f
C2 a_n1000_n1044# w_n1174_n1130# 1.0092f
C3 a_n1088_n1000# w_n1174_n1130# 0.41194f
C4 a_1000_n1000# w_n1174_n1130# 0.41194f
C5 a_1000_n1000# VSUBS 0.65771f
C6 a_n1088_n1000# VSUBS 0.65771f
C7 w_n1174_n1130# VSUBS 15.9194f
.ends

.subckt bias_rails vsp vgln en_b vdd m1_782_438# m1_3422_438# m1_3862_3522# vss m1_1222_3522#
+ m1_342_438# vsn m1_1662_438# vglp m1_2542_438#
XR0 vsp m1_342_438# vss r_w1_l14p555
XR1 vsp m1_782_438# vss r_w1_l14p555
XR2 m1_1222_3522# m1_782_438# vss r_w1_l14p555
XR3 m1_1222_3522# m1_1662_438# vss r_w1_l14p555
XR4 vgln m1_1662_438# vss r_w1_l14p555
XHDR vdd m1_342_438# en_b vdd vss p_w4_l0p5
XR5 vgln m1_2542_438# vss r_w1_l14p555
XR6 vglp m1_2542_438# vss r_w1_l14p555
XR7 vglp m1_3422_438# vss r_w1_l14p555
XR9 m1_3862_3522# vsn vss r_w1_l14p555
XR8 m1_3862_3522# m1_3422_438# vss r_w1_l14p555
XR10 vss vsn vss r_w1_l14p555
XC2 vsp vdd vsp vsp vss p_w10_l10
XC1 vss vsn vss vss vss p_w10_l10
C0 vsp vsn 0.89734f
C1 vgln m1_1222_3522# 0.01249f
C2 vglp m1_3862_3522# 0.01077f
C3 vdd m1_3862_3522# 0.01537f
C4 m1_1222_3522# vsn 0.01495f
C5 m1_1222_3522# vsp 0.10193f
C6 vsn m1_3862_3522# 0.0092f
C7 m1_342_438# en_b 0.02924f
C8 vsp m1_3862_3522# 0.02981f
C9 vglp en_b 0.09243f
C10 vdd en_b 0.30814f
C11 m1_2542_438# m1_3422_438# 0.00961f
C12 vglp m1_342_438# 0.04118f
C13 m1_2542_438# m1_1662_438# 0.00961f
C14 vdd m1_342_438# 0.13967f
C15 vgln en_b 0.03583f
C16 m1_1662_438# m1_342_438# 0
C17 vsn en_b 0
C18 vdd vglp 0.20542f
C19 vsp en_b 0
C20 m1_782_438# m1_342_438# 0.01545f
C21 vgln m1_342_438# 0.12699f
C22 m1_2542_438# vsn 0.00151f
C23 m1_342_438# vsn 0.21777f
C24 vgln vglp 0.04051f
C25 m1_342_438# vsp 0.1737f
C26 vgln vdd 0.21356f
C27 m1_782_438# m1_1662_438# 0.00961f
C28 vglp vsn 0.55135f
C29 m1_3422_438# vsn 0.03048f
C30 m1_1222_3522# m1_342_438# 0
C31 vdd vsn 0.01756f
C32 vglp vsp 0.20078f
C33 vdd vsp 1.4201f
C34 vgln vsn 0.71755f
C35 vgln vsp 0.29255f
C36 vdd vss 3.00055f
C37 m1_3862_3522# vss 0.02069f
C38 vsn vss 2.68393f
C39 m1_3422_438# vss 0.04057f
C40 vglp vss 0.48885f
C41 m1_2542_438# vss 0.04057f
C42 en_b vss 0.58213f
C43 vgln vss 0.30142f
C44 m1_1662_438# vss 0.04061f
C45 m1_1222_3522# vss 0.03045f
C46 m1_782_438# vss 0.04119f
C47 m1_342_438# vss 2.30643f
C48 vsp vss 7.60678f
.ends

.subckt r_w2_l1p315 a_n200_n254# a_n200_132# VSUBS
X0 a_n200_132# a_n200_n254# VSUBS ppolyf_u_1k r_width=2u r_length=1.32u
C0 a_n200_132# a_n200_n254# 0.02982f
C1 a_n200_n254# VSUBS 0.42149f
C2 a_n200_132# VSUBS 0.42149f
.ends

.subckt r_w2_l2p625 a_n200_n385# a_n200_263# VSUBS
X0 a_n200_263# a_n200_n385# VSUBS ppolyf_u_1k r_width=2u r_length=2.63u
C0 a_n200_263# a_n200_n385# 0.01591f
C1 a_n200_n385# VSUBS 0.43549f
C2 a_n200_263# VSUBS 0.43549f
.ends

.subckt r_w1_l5p175 a_n100_518# a_n100_n640# VSUBS
X0 a_n100_518# a_n100_n640# VSUBS ppolyf_u_1k r_width=1u r_length=5.18u
C0 a_n100_518# a_n100_n640# 0.00399f
C1 a_n100_n640# VSUBS 0.26263f
C2 a_n100_518# VSUBS 0.26263f
.ends

.subckt r_w1_l2p59 a_n100_n381# a_n100_259# VSUBS
X0 a_n100_259# a_n100_n381# VSUBS ppolyf_u_1k r_width=1u r_length=2.59u
C0 a_n100_259# a_n100_n381# 0.00799f
C1 a_n100_n381# VSUBS 0.25697f
C2 a_n100_259# VSUBS 0.25697f
.ends

.subckt r_w1_l10p35 a_n100_n1157# a_n100_1035# VSUBS
X0 a_n100_1035# a_n100_n1157# VSUBS ppolyf_u_1k r_width=1u r_length=10.35u
C0 a_n100_n1157# VSUBS 0.27003f
C1 a_n100_1035# VSUBS 0.27003f
.ends

.subckt r_w1_l12p86 a_n100_n1408# a_n100_1286# VSUBS
X0 a_n100_1286# a_n100_n1408# VSUBS ppolyf_u_1k r_width=1u r_length=12.86u
C0 a_n100_n1408# VSUBS 0.27003f
C1 a_n100_1286# VSUBS 0.27003f
.ends

.subckt vdacr_vc b0 b1 b2 b3 b4 vdd out a_2392_3416# a_3576_3416# m1_942_4048# a_1800_3416#
+ m1_1822_4048# m1_3542_4048# m1_2900_3120# a_2984_3416# a_4168_3416# m1_2156_3240#
+ m1_3982_4048# m1_1382_4048# vss m1_502_4048#
XXRS0 m1_2156_3240# m1_1822_4048# vss r_w2_l1p315
XXRS1 m1_2900_3120# m1_2156_3240# vss r_w2_l2p625
XXRS3 m1_3542_4048# m1_3982_4048# vss r_w1_l5p175
XXRS2 m1_3542_4048# m1_2900_3120# vss r_w1_l2p59
XXRS4 vss m1_3982_4048# vss r_w1_l10p35
XIB4n a_4168_3416# b4 vss vss n_w0p5_l1
XIB3n a_3576_3416# b3 vss vss n_w0p5_l1
XIB4p vdd a_4168_3416# b4 vdd vss p_w1_l1
XIB2n a_2984_3416# b2 vss vss n_w0p5_l1
XIB3p vdd a_3576_3416# b3 vdd vss p_w1_l1
XIB2p vdd a_2984_3416# b2 vdd vss p_w1_l1
XIB1n a_2392_3416# b1 vss vss n_w0p5_l1
XIB0n a_1800_3416# b0 vss vss n_w0p5_l1
XIB1p vdd a_2392_3416# b1 vdd vss p_w1_l1
XIB0p vdd a_1800_3416# b0 vdd vss p_w1_l1
XXRB0 m1_502_4048# out vss r_w1_l12p86
XSW0 m1_2156_3240# a_1800_3416# m1_1822_4048# a_1800_3416# m1_1822_4048# vss n_w4_l0p28_f2
XXRB1 m1_942_4048# m1_502_4048# vss r_w1_l12p86
XSW2 m1_3542_4048# a_2984_3416# m1_2900_3120# a_2984_3416# m1_2900_3120# vss n_w4_l0p28_f2
XSW1 m1_2900_3120# a_2392_3416# m1_2156_3240# a_2392_3416# m1_2156_3240# vss n_w4_l0p28_f2
XXRB3 m1_1822_4048# m1_1382_4048# vss r_w1_l12p86
XXRB2 m1_1382_4048# m1_942_4048# vss r_w1_l12p86
XSW3 m1_3982_4048# a_3576_3416# m1_3542_4048# a_3576_3416# m1_3542_4048# vss n_w4_l0p28_f2
XSW4 vss a_4168_3416# m1_3982_4048# a_4168_3416# m1_3982_4048# vss n_w4_l0p28_f2
C0 vdd b0 0.48837f
C1 b4 b3 0.13917f
C2 b4 vdd 0.96713f
C3 a_2392_3416# m1_3542_4048# 0
C4 a_1800_3416# b0 0.19361f
C5 b1 b0 0.02243f
C6 a_2984_3416# b3 0.00998f
C7 a_2984_3416# vdd 0.22246f
C8 a_3576_3416# m1_3542_4048# 0.21685f
C9 a_1800_3416# a_2984_3416# 0
C10 b1 a_2984_3416# 0
C11 vdd m1_2900_3120# 0.00446f
C12 a_1800_3416# m1_2900_3120# 0
C13 b2 b3 0.02623f
C14 vdd b2 0.51583f
C15 out m1_502_4048# 0.06298f
C16 b1 b2 0.02443f
C17 b3 m1_3982_4048# 0.05346f
C18 vdd m1_3982_4048# 0.00734f
C19 vdd m1_2156_3240# 0
C20 m1_3542_4048# a_4168_3416# 0.00878f
C21 b1 m1_2156_3240# 0.03127f
C22 a_1800_3416# m1_2156_3240# 0.05712f
C23 a_3576_3416# a_4168_3416# 0.04025f
C24 a_2984_3416# m1_3542_4048# 0.13514f
C25 m1_942_4048# m1_1382_4048# 0.11722f
C26 m1_942_4048# out 0.07036f
C27 a_2984_3416# a_2392_3416# 0.06364f
C28 m1_1822_4048# vdd 0.00249f
C29 b4 a_3576_3416# 0.03989f
C30 m1_2900_3120# m1_3542_4048# 0.23213f
C31 m1_1822_4048# b1 0.0085f
C32 m1_1822_4048# a_1800_3416# 0.11392f
C33 m1_2900_3120# a_2392_3416# 0.12579f
C34 b2 m1_3542_4048# 0.00783f
C35 m1_1382_4048# m1_2156_3240# 0.00556f
C36 b2 a_2392_3416# 0.02304f
C37 m1_3982_4048# m1_3542_4048# 0.57866f
C38 a_2984_3416# a_3576_3416# 0.04562f
C39 a_2392_3416# m1_3982_4048# 0
C40 m1_2156_3240# m1_3542_4048# 0.00287f
C41 m1_2900_3120# a_3576_3416# 0.02458f
C42 a_2392_3416# m1_2156_3240# 0.25323f
C43 b4 a_4168_3416# 0.27982f
C44 a_3576_3416# b2 0.00239f
C45 a_3576_3416# m1_3982_4048# 0.26669f
C46 a_3576_3416# m1_2156_3240# 0
C47 m1_942_4048# m1_502_4048# 0.31498f
C48 m1_1822_4048# m1_1382_4048# 0.09954f
C49 m1_3982_4048# a_4168_3416# 0.09009f
C50 m1_1822_4048# m1_3542_4048# 0
C51 m1_1822_4048# a_2392_3416# 0.02442f
C52 b4 b2 0
C53 a_2984_3416# m1_2900_3120# 0.33054f
C54 a_2984_3416# b2 0.19562f
C55 m1_2900_3120# b2 0.00112f
C56 a_2984_3416# m1_3982_4048# 0.00685f
C57 a_2984_3416# m1_2156_3240# 0.08949f
C58 m1_2900_3120# m1_3982_4048# 0.0302f
C59 m1_1822_4048# m1_502_4048# 0
C60 m1_2900_3120# m1_2156_3240# 0.35505f
C61 vdd b3 0.69411f
C62 b1 vdd 0.60145f
C63 a_1800_3416# vdd 0.16313f
C64 b1 a_1800_3416# 0.02676f
C65 m1_3982_4048# m1_2156_3240# 0.00173f
C66 m1_1822_4048# a_2984_3416# 0
C67 m1_1822_4048# m1_2900_3120# 0
C68 m1_1822_4048# m1_942_4048# 0
C69 m1_1822_4048# m1_3982_4048# 0
C70 a_1800_3416# m1_1382_4048# 0.01707f
C71 m1_1822_4048# m1_2156_3240# 0.46064f
C72 b3 m1_3542_4048# 0
C73 vdd m1_3542_4048# 0
C74 a_2392_3416# b3 0
C75 vdd a_2392_3416# 0.23488f
C76 b1 a_2392_3416# 0.1487f
C77 a_1800_3416# a_2392_3416# 0.03539f
C78 a_3576_3416# b3 0.31847f
C79 vdd a_3576_3416# 0.17218f
C80 b3 a_4168_3416# 0.02366f
C81 vdd a_4168_3416# 0.22626f
C82 out m1_1382_4048# 0.02522f
C83 m1_3982_4048# vss 1.03972f
C84 m1_1382_4048# vss 0.71003f
C85 m1_2900_3120# vss 0.25398f
C86 m1_3542_4048# vss 0.91811f
C87 m1_942_4048# vss 0.38112f
C88 m1_2156_3240# vss 0.45166f
C89 m1_1822_4048# vss 0.22977f
C90 m1_502_4048# vss 0.67554f
C91 out vss 0.78918f
C92 vdd vss 14.93496f
C93 a_1800_3416# vss 0.80682f
C94 b0 vss 0.64361f
C95 a_2392_3416# vss 0.54774f
C96 b1 vss 0.49635f
C97 a_2984_3416# vss 0.60284f
C98 b2 vss 0.58464f
C99 b4 vss 0.57954f
C100 a_3576_3416# vss 0.53451f
C101 b3 vss 0.61339f
C102 a_4168_3416# vss 1.17112f
.ends

.subckt r_w1_l9p86 a_n100_n1108# a_n100_986# VSUBS
X0 a_n100_986# a_n100_n1108# VSUBS ppolyf_u_1k r_width=1u r_length=9.86u
C0 a_n100_n1108# VSUBS 0.27003f
C1 a_n100_986# VSUBS 0.27003f
.ends

.subckt r_w2_l2p5 a_n200_250# a_n200_n372# VSUBS
X0 a_n200_250# a_n200_n372# VSUBS ppolyf_u_1k r_width=2u r_length=2.5u
C0 a_n200_250# a_n200_n372# 0.01672f
C1 a_n200_n372# VSUBS 0.4345f
C2 a_n200_250# VSUBS 0.4345f
.ends

.subckt r_w1_l2p465 a_n100_n369# a_n100_247# VSUBS
X0 a_n100_247# a_n100_n369# VSUBS ppolyf_u_1k r_width=1u r_length=2.47u
C0 a_n100_247# a_n100_n369# 0.00837f
C1 a_n100_n369# VSUBS 0.25651f
C2 a_n100_247# VSUBS 0.25651f
.ends

.subckt r_w1_l4p93 a_n100_n615# a_n100_493# VSUBS
X0 a_n100_493# a_n100_n615# VSUBS ppolyf_u_1k r_width=1u r_length=4.93u
C0 a_n100_493# a_n100_n615# 0.0042f
C1 a_n100_n615# VSUBS 0.2623f
C2 a_n100_493# VSUBS 0.2623f
.ends

.subckt r_w1_l13p145 a_n100_1315# a_n100_n1437# VSUBS
X0 a_n100_1315# a_n100_n1437# VSUBS ppolyf_u_1k r_width=1u r_length=13.15u
C0 a_n100_n1437# VSUBS 0.27003f
C1 a_n100_1315# VSUBS 0.27003f
.ends

.subckt r_w1_l13p39 a_n100_n1461# a_n100_1339# VSUBS
X0 a_n100_1339# a_n100_n1461# VSUBS ppolyf_u_1k r_width=1u r_length=13.39u
C0 a_n100_n1461# VSUBS 0.27003f
C1 a_n100_1339# VSUBS 0.27003f
.ends

.subckt n_w6_l0p28_f2 a_52_n644# a_108_n600# a_n108_n644# a_n196_n600# a_n52_n600#
+ VSUBS
X0 a_108_n600# a_52_n644# a_n52_n600# VSUBS nfet_03v3 ad=2.64p pd=12.88u as=1.56p ps=6.52u w=6u l=0.28u
X1 a_n52_n600# a_n108_n644# a_n196_n600# VSUBS nfet_03v3 ad=1.56p pd=6.52u as=2.64p ps=12.88u w=6u l=0.28u
C0 a_n52_n600# a_52_n644# 0.04695f
C1 a_n108_n644# a_n196_n600# 0.04695f
C2 a_n52_n600# a_n196_n600# 0.2597f
C3 a_n52_n600# a_108_n600# 0.2597f
C4 a_n52_n600# a_n108_n644# 0.04695f
C5 a_52_n644# a_108_n600# 0.04695f
C6 a_n108_n644# a_52_n644# 0.00519f
C7 a_108_n600# VSUBS 0.28641f
C8 a_n52_n600# VSUBS 0.09458f
C9 a_n196_n600# VSUBS 0.28641f
.ends

.subckt vdacr_vt b0 b1 b2 b3 b4 b5 vdd m1_3342_4448# a_3228_3816# m1_5982_4448# m1_502_4448#
+ a_3820_3816# m1_942_4448# m1_1970_3610# out a_2636_3816# a_5004_3816# m1_1822_4448#
+ vss m1_4328_3000# a_4412_3816# m1_4488_3600# m1_4648_4446# m1_3600_4920# m1_5542_4448#
+ a_2044_3816# m1_2702_4448# m1_1382_4448#
XXRS4_0 m1_4648_4446# m1_4328_3000# vss r_w1_l9p86
XXRS4_1 m1_4488_3600# m1_4648_4446# vss r_w1_l9p86
XXRS0 m1_1970_3610# m1_2702_4448# vss r_w2_l2p5
XXRS1 m1_3342_4448# m1_2702_4448# vss r_w1_l2p465
XXRS3 m1_4328_3000# m1_3600_4920# vss r_w1_l9p86
XXRS2 m1_3600_4920# m1_3342_4448# vss r_w1_l4p93
XIB5n a_5004_3816# b5 vss vss n_w0p5_l1
XIB4n a_4412_3816# b4 vss vss n_w0p5_l1
XIB5p vdd a_5004_3816# b5 vdd vss p_w1_l1
XIB3n a_3820_3816# b3 vss vss n_w0p5_l1
XIB4p vdd a_4412_3816# b4 vdd vss p_w1_l1
XIB2n a_3228_3816# b2 vss vss n_w0p5_l1
XIB3p vdd a_3820_3816# b3 vdd vss p_w1_l1
XIB2p vdd a_3228_3816# b2 vdd vss p_w1_l1
XIB1n a_2636_3816# b1 vss vss n_w0p5_l1
XIB0n a_2044_3816# b0 vss vss n_w0p5_l1
XIB1p vdd a_2636_3816# b1 vdd vss p_w1_l1
XIB0p vdd a_2044_3816# b0 vdd vss p_w1_l1
XXRS5_0 m1_4488_3600# m1_5542_4448# vss r_w1_l13p145
XXRS5_1 m1_5542_4448# m1_5982_4448# vss r_w1_l13p145
XXRB0 m1_502_4448# out vss r_w1_l13p39
XSW0 a_2044_3816# m1_1970_3610# a_2044_3816# m1_1970_3610# m1_2702_4448# vss n_w6_l0p28_f2
XXRS5_2 m1_5982_4448# vss vss r_w1_l13p145
XXRB1 m1_942_4448# m1_502_4448# vss r_w1_l13p39
XSW2 a_3228_3816# m1_3342_4448# a_3228_3816# m1_3342_4448# m1_3600_4920# vss n_w6_l0p28_f2
XSW1 a_2636_3816# m1_2702_4448# a_2636_3816# m1_2702_4448# m1_3342_4448# vss n_w6_l0p28_f2
XXRB3 m1_1822_4448# m1_1382_4448# vss r_w1_l13p39
XXRB2 m1_1382_4448# m1_942_4448# vss r_w1_l13p39
XSW3 a_3820_3816# m1_3600_4920# a_3820_3816# m1_3600_4920# m1_4328_3000# vss n_w6_l0p28_f2
XXRB4 m1_1970_3610# m1_1822_4448# vss r_w1_l13p39
XSW4 a_4412_3816# m1_4328_3000# a_4412_3816# m1_4328_3000# m1_4488_3600# vss n_w6_l0p28_f2
XSW5 a_5004_3816# m1_4488_3600# a_5004_3816# m1_4488_3600# vss vss n_w6_l0p28_f2
C0 a_4412_3816# m1_4648_4446# 0
C1 m1_1822_4448# m1_502_4448# 0
C2 b2 vdd 0.49822f
C3 a_3228_3816# b3 0.04175f
C4 m1_4488_3600# m1_3342_4448# 0
C5 a_4412_3816# vdd 0.37257f
C6 m1_2702_4448# a_4412_3816# -0
C7 m1_3600_4920# b3 0.0043f
C8 a_3820_3816# a_3228_3816# 0.095f
C9 b5 vdd 0.77239f
C10 a_3228_3816# b1 0.02319f
C11 a_3228_3816# a_2044_3816# 0.01538f
C12 m1_2702_4448# m1_1822_4448# 0.01365f
C13 m1_4328_3000# b3 0.04902f
C14 a_3820_3816# m1_3600_4920# 0.31917f
C15 m1_2702_4448# m1_4648_4446# 0
C16 a_3228_3816# a_2636_3816# 0.11112f
C17 m1_1970_3610# m1_1822_4448# 0.05422f
C18 out m1_502_4448# 0.05317f
C19 m1_2702_4448# vdd 0
C20 a_3820_3816# m1_4328_3000# 0.13623f
C21 m1_3600_4920# a_2636_3816# 0
C22 m1_4488_3600# a_5004_3816# 0.08054f
C23 out m1_1822_4448# 0.01716f
C24 m1_2702_4448# m1_1970_3610# 0.34169f
C25 b2 a_3228_3816# 0.28704f
C26 m1_3600_4920# m1_5542_4448# 0
C27 m1_4328_3000# m1_5542_4448# 0.00102f
C28 m1_3600_4920# a_4412_3816# 0.06544f
C29 b4 a_5004_3816# 0.00821f
C30 m1_4328_3000# a_4412_3816# 0.33612f
C31 m1_4488_3600# b4 0.01234f
C32 m1_3600_4920# m1_1822_4448# 0.02531f
C33 a_3228_3816# vdd 0.27287f
C34 m1_2702_4448# a_3228_3816# 0.24753f
C35 m1_5982_4448# m1_5542_4448# 0.20108f
C36 m1_3600_4920# m1_4648_4446# 0.00845f
C37 a_3820_3816# m1_3342_4448# 0.13866f
C38 a_2044_3816# m1_3342_4448# 0
C39 m1_3600_4920# vdd 0.01058f
C40 a_3228_3816# m1_1970_3610# 0.05212f
C41 m1_2702_4448# m1_3600_4920# 0.03473f
C42 m1_4328_3000# m1_4648_4446# 0.34307f
C43 a_2636_3816# m1_3342_4448# 0.03732f
C44 m1_1970_3610# m1_3600_4920# 0.01105f
C45 m1_2702_4448# m1_4328_3000# 0
C46 b1 b0 0.01967f
C47 a_2044_3816# b0 0.1542f
C48 m1_1382_4448# m1_942_4448# 0.22008f
C49 out m1_3600_4920# 0.00168f
C50 a_2636_3816# b0 0.00455f
C51 m1_5982_4448# m1_4648_4446# 0
C52 a_2044_3816# m1_1382_4448# 0.00399f
C53 b2 m1_3342_4448# 0.02073f
C54 a_3820_3816# m1_4488_3600# 0
C55 a_3228_3816# m1_3600_4920# 0.08395f
C56 m1_1822_4448# m1_3342_4448# 0
C57 a_5004_3816# m1_5542_4448# 0.00614f
C58 b3 b4 0.03428f
C59 m1_4648_4446# m1_3342_4448# 0.00357f
C60 m1_4488_3600# m1_5542_4448# 0.43146f
C61 m1_3342_4448# vdd 0.00387f
C62 m1_2702_4448# m1_3342_4448# 0.32043f
C63 m1_1382_4448# m1_502_4448# 0
C64 a_3820_3816# b4 0.02144f
C65 a_4412_3816# a_5004_3816# 0.02705f
C66 m1_3600_4920# m1_4328_3000# 0.29676f
C67 m1_1970_3610# m1_3342_4448# 0.00116f
C68 m1_4488_3600# a_4412_3816# 0.24379f
C69 m1_1822_4448# m1_1382_4448# 0.13617f
C70 a_5004_3816# b5 0.15238f
C71 b0 vdd 0.59561f
C72 m1_4648_4446# a_5004_3816# 0
C73 a_5004_3816# vdd 0.24276f
C74 m1_4488_3600# m1_4648_4446# 0.19057f
C75 m1_1970_3610# m1_1382_4448# 0
C76 a_3820_3816# b3 0.24966f
C77 m1_4488_3600# vdd 0.00711f
C78 m1_5982_4448# m1_4328_3000# 0
C79 a_4412_3816# b4 0.35348f
C80 a_3228_3816# m1_3342_4448# 0.2721f
C81 out m1_1382_4448# 0.04481f
C82 a_2636_3816# b3 0
C83 b4 b5 0.06082f
C84 m1_3600_4920# m1_3342_4448# 0.50642f
C85 b1 a_2044_3816# 0.01431f
C86 a_3820_3816# a_2636_3816# 0.00239f
C87 m1_4328_3000# m1_3342_4448# 0.04776f
C88 b1 a_2636_3816# 0.52429f
C89 b4 vdd 0.68174f
C90 a_2044_3816# a_2636_3816# 0.24666f
C91 b2 b3 0.04726f
C92 a_4412_3816# b3 0.02259f
C93 a_3820_3816# b2 0.01081f
C94 b2 b1 0.04123f
C95 a_3820_3816# a_4412_3816# 0.13807f
C96 m1_502_4448# m1_942_4448# 0.32053f
C97 m1_3600_4920# m1_4488_3600# 0.00423f
C98 b2 a_2636_3816# 0.00158f
C99 m1_4328_3000# a_5004_3816# 0.00328f
C100 a_3820_3816# b5 0
C101 b3 vdd 0.68874f
C102 m1_1822_4448# m1_942_4448# 0
C103 m1_4488_3600# m1_4328_3000# 0.37579f
C104 m1_1822_4448# a_2044_3816# 0.00152f
C105 a_3820_3816# vdd 0.29721f
C106 a_3820_3816# m1_2702_4448# 0.00476f
C107 m1_1822_4448# a_2636_3816# 0.0315f
C108 m1_5982_4448# a_5004_3816# 0.00304f
C109 b1 vdd 0.42773f
C110 m1_2702_4448# b1 0.01432f
C111 a_2044_3816# vdd 0.21896f
C112 m1_2702_4448# a_2044_3816# 0.0396f
C113 m1_1970_3610# m1_942_4448# 0
C114 m1_4488_3600# m1_5982_4448# 0
C115 a_2636_3816# vdd 0.3449f
C116 m1_2702_4448# a_2636_3816# 0.1678f
C117 m1_1970_3610# b1 0.00571f
C118 m1_1970_3610# a_2044_3816# 0.10153f
C119 m1_4648_4446# m1_5542_4448# 0.00178f
C120 out m1_942_4448# 0.04568f
C121 m1_4328_3000# b4 0
C122 m1_1970_3610# a_2636_3816# 0.26038f
C123 a_4412_3816# b5 0.02149f
C124 m1_4488_3600# vss 0.8538f
C125 m1_4328_3000# vss 0.53806f
C126 m1_1382_4448# vss 0.44029f
C127 m1_1822_4448# vss 0.69694f
C128 m1_3342_4448# vss 0.37026f
C129 m1_2702_4448# vss 0.1525f
C130 m1_3600_4920# vss 0.84217f
C131 m1_942_4448# vss 0.30669f
C132 m1_1970_3610# vss 0.29471f
C133 m1_502_4448# vss 0.71325f
C134 out vss 0.81653f
C135 m1_5982_4448# vss 0.81009f
C136 m1_5542_4448# vss 0.39604f
C137 vdd vss 17.44801f
C138 a_2044_3816# vss 1.10805f
C139 b0 vss 0.62622f
C140 a_2636_3816# vss 1.19693f
C141 b1 vss 0.43137f
C142 a_3228_3816# vss 1.02137f
C143 b2 vss 0.41637f
C144 a_3820_3816# vss 0.80739f
C145 b3 vss 0.46252f
C146 b5 vss 0.5235f
C147 a_4412_3816# vss 0.93204f
C148 b4 vss 0.43507f
C149 a_5004_3816# vss 1.4333f
C150 m1_4648_4446# vss 0.32911f
.ends

.subckt p_w0p8_l2 w_n374_n210# a_n288_n80# a_200_n80# a_n200_n124# VSUBS
X0 a_200_n80# a_n200_n124# a_n288_n80# w_n374_n210# pfet_03v3 ad=0.352p pd=2.48u as=0.352p ps=2.48u w=0.8u l=2u
C0 a_200_n80# a_n288_n80# 0.0084f
C1 a_n200_n124# w_n374_n210# 0.22666f
C2 a_200_n80# a_n200_n124# 0.02312f
C3 a_n200_n124# a_n288_n80# 0.02312f
C4 a_200_n80# w_n374_n210# 0.02527f
C5 w_n374_n210# a_n288_n80# 0.02527f
C6 a_200_n80# VSUBS 0.09823f
C7 a_n288_n80# VSUBS 0.09823f
C8 w_n374_n210# VSUBS 0.94248f
.ends

.subckt p_w4_l2_f4 w_n1130_n530# a_n956_n444# a_556_n444# a_n52_n400# a_452_n400#
+ a_n452_n444# a_n556_n400# a_52_n444# a_956_n400# a_n1044_n400# VSUBS
X0 a_n556_n400# a_n956_n444# a_n1044_n400# w_n1130_n530# pfet_03v3 ad=1.04p pd=4.52u as=1.76p ps=8.88u w=4u l=2u
X1 a_n52_n400# a_n452_n444# a_n556_n400# w_n1130_n530# pfet_03v3 ad=1.04p pd=4.52u as=1.04p ps=4.52u w=4u l=2u
X2 a_452_n400# a_52_n444# a_n52_n400# w_n1130_n530# pfet_03v3 ad=1.04p pd=4.52u as=1.04p ps=4.52u w=4u l=2u
X3 a_956_n400# a_556_n444# a_452_n400# w_n1130_n530# pfet_03v3 ad=1.76p pd=8.88u as=1.04p ps=4.52u w=4u l=2u
C0 a_556_n444# a_452_n400# 0.11799f
C1 a_n556_n400# a_n52_n400# 0.04287f
C2 a_n556_n400# a_n452_n444# 0.11799f
C3 a_n956_n444# a_n1044_n400# 0.11799f
C4 w_n1130_n530# a_n1044_n400# 0.12268f
C5 a_n556_n400# a_n1044_n400# 0.04287f
C6 a_52_n444# a_n52_n400# 0.11799f
C7 a_52_n444# a_n452_n444# 0.00519f
C8 a_n452_n444# a_n52_n400# 0.11799f
C9 w_n1130_n530# a_452_n400# 0.18497f
C10 w_n1130_n530# a_556_n444# 0.2233f
C11 a_52_n444# a_452_n400# 0.11799f
C12 a_n52_n400# a_452_n400# 0.04287f
C13 a_n956_n444# w_n1130_n530# 0.2233f
C14 a_956_n400# a_452_n400# 0.04287f
C15 a_52_n444# a_556_n444# 0.00519f
C16 a_956_n400# a_556_n444# 0.11799f
C17 a_n956_n444# a_n556_n400# 0.11799f
C18 w_n1130_n530# a_n556_n400# 0.18497f
C19 a_n956_n444# a_n452_n444# 0.00519f
C20 a_52_n444# w_n1130_n530# 0.21994f
C21 w_n1130_n530# a_n52_n400# 0.18497f
C22 w_n1130_n530# a_n452_n444# 0.21994f
C23 a_956_n400# w_n1130_n530# 0.12268f
C24 a_956_n400# VSUBS 0.19832f
C25 a_452_n400# VSUBS 0.12191f
C26 a_n52_n400# VSUBS 0.11851f
C27 a_n556_n400# VSUBS 0.12191f
C28 a_n1044_n400# VSUBS 0.19832f
C29 w_n1130_n530# VSUBS 7.1868f
.ends

.subckt p_w0p5_l10 a_n1088_n50# a_1000_n50# w_n1174_n180# a_n1000_n94# VSUBS
X0 a_1000_n50# a_n1000_n94# a_n1088_n50# w_n1174_n180# pfet_03v3 ad=0.22p pd=1.88u as=0.22p ps=1.88u w=0.5u l=10u
C0 a_n1000_n94# a_1000_n50# 0.01858f
C1 a_1000_n50# w_n1174_n180# 0.02013f
C2 a_n1000_n94# a_n1088_n50# 0.01858f
C3 a_n1000_n94# w_n1174_n180# 1.0092f
C4 a_n1088_n50# w_n1174_n180# 0.02013f
C5 a_1000_n50# VSUBS 0.30033f
C6 a_n1088_n50# VSUBS 0.30033f
C7 w_n1174_n180# VSUBS 2.53584f
.ends

.subckt n_w2_l2_f4 a_n52_n200# a_452_n200# a_n452_n244# a_n556_n200# a_52_n244# a_956_n200#
+ a_n1044_n200# a_n956_n244# a_556_n244# VSUBS
X0 a_452_n200# a_52_n244# a_n52_n200# VSUBS nfet_03v3 ad=0.52p pd=2.52u as=0.52p ps=2.52u w=2u l=2u
X1 a_956_n200# a_556_n244# a_452_n200# VSUBS nfet_03v3 ad=0.88p pd=4.88u as=0.52p ps=2.52u w=2u l=2u
X2 a_n556_n200# a_n956_n244# a_n1044_n200# VSUBS nfet_03v3 ad=0.52p pd=2.52u as=0.88p ps=4.88u w=2u l=2u
X3 a_n52_n200# a_n452_n244# a_n556_n200# VSUBS nfet_03v3 ad=0.52p pd=2.52u as=0.52p ps=2.52u w=2u l=2u
C0 a_n556_n200# a_n1044_n200# 0.02133f
C1 a_n452_n244# a_n556_n200# 0.0587f
C2 a_556_n244# a_452_n200# 0.0587f
C3 a_52_n244# a_556_n244# 0.00519f
C4 a_956_n200# a_452_n200# 0.02133f
C5 a_n556_n200# a_n52_n200# 0.02133f
C6 a_n452_n244# a_n52_n200# 0.0587f
C7 a_n556_n200# a_n956_n244# 0.0587f
C8 a_n452_n244# a_52_n244# 0.00519f
C9 a_n1044_n200# a_n956_n244# 0.0587f
C10 a_n452_n244# a_n956_n244# 0.00519f
C11 a_n52_n200# a_452_n200# 0.02133f
C12 a_52_n244# a_n52_n200# 0.0587f
C13 a_956_n200# a_556_n244# 0.0587f
C14 a_52_n244# a_452_n200# 0.0587f
C15 a_956_n200# VSUBS 0.26162f
C16 a_452_n200# VSUBS 0.34773f
C17 a_n52_n200# VSUBS 0.34265f
C18 a_n556_n200# VSUBS 0.34773f
C19 a_n1044_n200# VSUBS 0.26162f
.ends

.subckt p_w4_l1_f4 a_252_n400# a_n556_n444# a_n644_n400# a_n252_n444# a_n356_n400#
+ a_n52_n400# a_356_n444# w_n730_n530# a_52_n444# a_556_n400# VSUBS
X0 a_n356_n400# a_n556_n444# a_n644_n400# w_n730_n530# pfet_03v3 ad=1.04p pd=4.52u as=1.76p ps=8.88u w=4u l=1u
X1 a_556_n400# a_356_n444# a_252_n400# w_n730_n530# pfet_03v3 ad=1.76p pd=8.88u as=1.04p ps=4.52u w=4u l=1u
X2 a_n52_n400# a_n252_n444# a_n356_n400# w_n730_n530# pfet_03v3 ad=1.04p pd=4.52u as=1.04p ps=4.52u w=4u l=1u
X3 a_252_n400# a_52_n444# a_n52_n400# w_n730_n530# pfet_03v3 ad=1.04p pd=4.52u as=1.04p ps=4.52u w=4u l=1u
C0 a_n356_n400# a_n644_n400# 0.07756f
C1 a_n252_n444# w_n730_n530# 0.12212f
C2 a_n556_n444# w_n730_n530# 0.12548f
C3 a_n52_n400# a_252_n400# 0.07756f
C4 w_n730_n530# a_n644_n400# 0.09518f
C5 a_252_n400# a_356_n444# 0.08505f
C6 a_n356_n400# a_n52_n400# 0.07756f
C7 a_52_n444# a_252_n400# 0.08505f
C8 a_52_n444# a_n52_n400# 0.08505f
C9 a_n252_n444# a_n556_n444# 0.00519f
C10 a_556_n400# a_252_n400# 0.07756f
C11 a_52_n444# a_356_n444# 0.00519f
C12 a_556_n400# a_356_n444# 0.08505f
C13 w_n730_n530# a_252_n400# 0.12997f
C14 a_n556_n444# a_n644_n400# 0.08505f
C15 w_n730_n530# a_n52_n400# 0.12997f
C16 w_n730_n530# a_356_n444# 0.12548f
C17 a_n356_n400# w_n730_n530# 0.12997f
C18 a_52_n444# w_n730_n530# 0.12212f
C19 a_556_n400# w_n730_n530# 0.09518f
C20 a_n252_n444# a_n52_n400# 0.08505f
C21 a_n252_n444# a_n356_n400# 0.08505f
C22 a_52_n444# a_n252_n444# 0.00519f
C23 a_n356_n400# a_n556_n444# 0.08505f
C24 a_556_n400# VSUBS 0.17216f
C25 a_252_n400# VSUBS 0.0696f
C26 a_n52_n400# VSUBS 0.06619f
C27 a_n356_n400# VSUBS 0.0696f
C28 a_n644_n400# VSUBS 0.17216f
C29 w_n730_n530# VSUBS 4.6428f
.ends

.subckt n_w4_l2_f2 a_n52_n400# a_452_n400# a_n452_n444# a_n540_n400# a_52_n444# VSUBS
X0 a_n52_n400# a_n452_n444# a_n540_n400# VSUBS nfet_03v3 ad=1.04p pd=4.52u as=1.76p ps=8.88u w=4u l=2u
X1 a_452_n400# a_52_n444# a_n52_n400# VSUBS nfet_03v3 ad=1.76p pd=8.88u as=1.04p ps=4.52u w=4u l=2u
C0 a_52_n444# a_n452_n444# 0.00519f
C1 a_n540_n400# a_n52_n400# 0.04287f
C2 a_52_n444# a_452_n400# 0.11799f
C3 a_n452_n444# a_n52_n400# 0.11799f
C4 a_452_n400# a_n52_n400# 0.04287f
C5 a_52_n444# a_n52_n400# 0.11799f
C6 a_n452_n444# a_n540_n400# 0.11799f
C7 a_452_n400# VSUBS 0.33857f
C8 a_n52_n400# VSUBS 0.35281f
C9 a_n540_n400# VSUBS 0.33857f
.ends

.subckt p_w1_l0p5 a_n138_n100# a_50_n100# a_n50_n144# w_n224_n230# VSUBS
X0 a_50_n100# a_n50_n144# a_n138_n100# w_n224_n230# pfet_03v3 ad=0.44p pd=2.88u as=0.44p ps=2.88u w=1u l=0.5u
C0 a_n50_n144# a_n138_n100# 0.01275f
C1 a_n50_n144# w_n224_n230# 0.07993f
C2 a_n138_n100# a_50_n100# 0.03085f
C3 w_n224_n230# a_50_n100# 0.0205f
C4 a_n50_n144# a_50_n100# 0.01275f
C5 w_n224_n230# a_n138_n100# 0.0205f
C6 a_50_n100# VSUBS 0.06546f
C7 a_n138_n100# VSUBS 0.06546f
C8 w_n224_n230# VSUBS 0.61824f
.ends

.subckt p_w4_l2 w_n374_n530# a_n288_n400# a_200_n400# a_n200_n444# VSUBS
X0 a_200_n400# a_n200_n444# a_n288_n400# w_n374_n530# pfet_03v3 ad=1.76p pd=8.88u as=1.76p ps=8.88u w=4u l=2u
C0 a_n200_n444# a_n288_n400# 0.11799f
C1 a_n200_n444# w_n374_n530# 0.22666f
C2 a_n288_n400# a_200_n400# 0.04287f
C3 w_n374_n530# a_200_n400# 0.12268f
C4 a_n200_n444# a_200_n400# 0.11799f
C5 w_n374_n530# a_n288_n400# 0.12268f
C6 a_200_n400# VSUBS 0.20173f
C7 a_n288_n400# VSUBS 0.20173f
C8 w_n374_n530# VSUBS 2.37864f
.ends

.subckt n_w4_l2 a_n288_n400# a_200_n400# a_n200_n444# VSUBS
X0 a_200_n400# a_n200_n444# a_n288_n400# VSUBS nfet_03v3 ad=1.76p pd=8.88u as=1.76p ps=8.88u w=4u l=2u
C0 a_n288_n400# a_200_n400# 0.04287f
C1 a_n288_n400# a_n200_n444# 0.11799f
C2 a_n200_n444# a_200_n400# 0.11799f
C3 a_200_n400# VSUBS 0.34365f
C4 a_n288_n400# VSUBS 0.34365f
.ends

.subckt p_w4_l1 a_n188_n400# a_100_n400# a_n100_n444# w_n274_n530# VSUBS
X0 a_100_n400# a_n100_n444# a_n188_n400# w_n274_n530# pfet_03v3 ad=1.76p pd=8.88u as=1.76p ps=8.88u w=4u l=1u
C0 a_n100_n444# a_n188_n400# 0.08505f
C1 a_n100_n444# w_n274_n530# 0.12884f
C2 a_n188_n400# a_100_n400# 0.07756f
C3 w_n274_n530# a_100_n400# 0.09518f
C4 a_n100_n444# a_100_n400# 0.08505f
C5 w_n274_n530# a_n188_n400# 0.09518f
C6 a_100_n400# VSUBS 0.17557f
C7 a_n188_n400# VSUBS 0.17557f
C8 w_n274_n530# VSUBS 1.74264f
.ends

.subckt r_w1_l14p19 a_n100_1419# a_n100_n1541# VSUBS
X0 a_n100_1419# a_n100_n1541# VSUBS ppolyf_u_1k r_width=1u r_length=14.19u
C0 a_n100_n1541# VSUBS 0.27003f
C1 a_n100_1419# VSUBS 0.27003f
.ends

.subckt p_w0p5_l4 a_n488_n50# a_400_n50# a_n400_n94# w_n574_n180# VSUBS
X0 a_400_n50# a_n400_n94# a_n488_n50# w_n574_n180# pfet_03v3 ad=0.22p pd=1.88u as=0.22p ps=1.88u w=0.5u l=4u
C0 a_n400_n94# a_n488_n50# 0.01702f
C1 a_n400_n94# w_n574_n180# 0.42229f
C2 a_n488_n50# a_400_n50# 0.0026f
C3 w_n574_n180# a_400_n50# 0.01856f
C4 a_n400_n94# a_400_n50# 0.01702f
C5 w_n574_n180# a_n488_n50# 0.01856f
C6 a_400_n50# VSUBS 0.14084f
C7 a_n488_n50# VSUBS 0.14084f
C8 w_n574_n180# VSUBS 1.23984f
.ends

.subckt bias_vi en vglp vgln vth_cmp vth_ref m1_5388_6960# m1_8646_1098# vreset_src
+ m1_942_738# m1_4894_1238# iint m1_8042_6360# m1_7102_850# ib_x2 m1_7440_2050# a_5712_1328#
+ a_2102_5152# m1_4546_7560# m1_502_738# m1_1276_6360# m1_1382_738# vbn_prb vdd a_4976_1528#
+ m1_8332_7080# el a_864_6450# vss ib_r1
XPP vdd vdd vbn_prb a_864_6450# vss p_w0p8_l2
XMO vdd a_864_6450# a_864_6450# vdd m1_1276_6360# a_864_6450# m1_1276_6360# a_864_6450#
+ vdd vdd vss p_w4_l2_f4
XPS vdd m1_7102_850# vdd vgln vss p_w0p5_l10
XOR vss ib_r1 vbn_prb ib_r1 vbn_prb vss vss vbn_prb vbn_prb vss n_w2_l2_f4
XKO a_4976_1528# vglp m1_1276_6360# vglp a_4976_1528# m1_1276_6360# vglp vdd vglp
+ m1_1276_6360# vss p_w4_l1_f4
XMR vdd a_864_6450# a_864_6450# vdd m1_5388_6960# a_864_6450# m1_5388_6960# a_864_6450#
+ vdd vdd vss p_w4_l2_f4
XP1 vdd a_2102_5152# a_2102_5152# vdd vss p_w2_l2
XNS vss m1_7102_850# a_5712_1328# m1_7102_850# a_5712_1328# vss n_w4_l2_f2
XPOFF vdd a_864_6450# en vdd vss p_w1_l0p5
XP2 vdd a_864_6450# a_2102_5152# vdd vss p_w2_l2
XMS2 vss en m1_8646_1098# vss n_w0p5_l1
XMS1 m1_8646_1098# m1_7102_850# a_864_6450# vss n_w0p5_l1
XNT vss m1_4894_1238# a_5712_1328# vss n_w2_l2
XMT vdd vdd m1_8332_7080# a_864_6450# vss p_w4_l2
XKR vreset_src vglp m1_5388_6960# vglp vreset_src m1_5388_6960# vglp vdd vglp m1_5388_6960#
+ vss p_w4_l1_f4
XN1 m1_4894_1238# a_864_6450# vglp vss n_w4_l2
XN2 m1_4894_1238# a_2102_5152# a_4976_1528# vss n_w4_l2
XKT m1_8332_7080# vth_ref vglp vdd vss p_w4_l1
XOX vss m1_7440_2050# vbn_prb m1_7440_2050# vbn_prb vss vss vbn_prb vbn_prb vss n_w2_l2_f4
XXR00 a_4976_1528# m1_502_738# vss r_w1_l14p19
XXR01 m1_502_738# m1_942_738# vss r_w1_l14p19
XXR03 m1_1382_738# vss vss r_w1_l14p19
XXR02 m1_942_738# m1_1382_738# vss r_w1_l14p19
XPB vdd a_5712_1328# a_864_6450# vdd vss p_w0p5_l4
XNB vss a_5712_1328# a_5712_1328# vss n_w2_l2
XMC vdd a_864_6450# a_864_6450# vdd m1_8042_6360# a_864_6450# m1_8042_6360# a_864_6450#
+ vdd vdd vss p_w4_l2_f4
XKC vth_cmp vglp m1_8042_6360# vglp vth_cmp m1_8042_6360# vglp vdd vglp m1_8042_6360#
+ vss p_w4_l1_f4
XME vdd a_864_6450# a_864_6450# vdd m1_4546_7560# a_864_6450# m1_4546_7560# a_864_6450#
+ vdd vdd vss p_w4_l2_f4
XPI vdd vdd iint a_864_6450# vss p_w0p8_l2
XSX2 m1_7440_2050# ib_r1 ib_x2 vss n_w4_l0p5
XKE el vglp m1_4546_7560# vglp el m1_4546_7560# vglp vdd vglp m1_4546_7560# vss p_w4_l1_f4
XDB vss vbn_prb vbn_prb vss n_w2_l2
C0 vdd m1_7102_850# 0.12129f
C1 vdd vreset_src 0.46224f
C2 m1_5388_6960# vreset_src 0.26696f
C3 a_5712_1328# ib_x2 0.10242f
C4 m1_8042_6360# m1_8332_7080# 0.13476f
C5 m1_8042_6360# vth_cmp 0.21651f
C6 m1_4894_1238# vbn_prb 0.02997f
C7 vdd vth_ref 0.31053f
C8 m1_5388_6960# vth_ref 0
C9 m1_8042_6360# vglp 0.2232f
C10 a_5712_1328# m1_4546_7560# 0
C11 iint vbn_prb 0.08998f
C12 vdd m1_1276_6360# 0.61385f
C13 en m1_7102_850# 0.14198f
C14 m1_8646_1098# m1_7440_2050# 0.00687f
C15 vgln m1_7102_850# 0.08937f
C16 a_2102_5152# a_5712_1328# 0.15699f
C17 vgln vreset_src 0
C18 vdd iint 0.18374f
C19 m1_7440_2050# vbn_prb 0.36218f
C20 a_4976_1528# m1_4894_1238# 0.17878f
C21 a_4976_1528# m1_1276_6360# 0.30906f
C22 en m1_4894_1238# 0
C23 m1_8332_7080# vreset_src 0.01543f
C24 m1_7102_850# vglp 0.18545f
C25 vth_cmp vreset_src 0.14964f
C26 a_4976_1528# iint 0
C27 a_5712_1328# vbn_prb 0.18056f
C28 en iint 0.17194f
C29 vgln iint 0.12915f
C30 m1_8332_7080# vth_ref 0.06042f
C31 vreset_src vglp 0.54612f
C32 m1_4546_7560# el 0.12283f
C33 vth_cmp vth_ref 0.05697f
C34 a_2102_5152# ib_x2 0.01217f
C35 vdd a_5712_1328# 0.56694f
C36 m1_8042_6360# a_864_6450# 0.5698f
C37 vth_ref vglp 0.06719f
C38 m1_5388_6960# a_5712_1328# 0.00317f
C39 a_2102_5152# m1_4546_7560# 0.0186f
C40 m1_4894_1238# vglp 0.286f
C41 en m1_7440_2050# 0.05869f
C42 m1_1276_6360# vglp 0.16358f
C43 vgln m1_7440_2050# 0
C44 m1_8646_1098# ib_x2 0.01147f
C45 iint vglp 0.04831f
C46 a_4976_1528# a_5712_1328# 0.0106f
C47 en a_5712_1328# 0.05214f
C48 vgln a_5712_1328# 0.3298f
C49 ib_x2 vbn_prb 0.06125f
C50 a_864_6450# m1_7102_850# 0.14649f
C51 m1_7440_2050# vglp 0.05819f
C52 vdd ib_x2 0
C53 vdd el 0.94055f
C54 a_864_6450# vreset_src 0.08448f
C55 m1_5388_6960# el 0
C56 a_2102_5152# vbn_prb 0.11077f
C57 vdd m1_4546_7560# 0.40586f
C58 a_864_6450# vth_ref 0.00723f
C59 m1_5388_6960# m1_4546_7560# 0.09335f
C60 a_5712_1328# vglp 0.16841f
C61 vdd a_2102_5152# 1.73077f
C62 m1_4894_1238# a_864_6450# 0.3222f
C63 m1_1276_6360# a_864_6450# 0.39666f
C64 a_4976_1528# ib_x2 0.04795f
C65 ib_r1 m1_7102_850# 0.03826f
C66 m1_8646_1098# vbn_prb 0
C67 a_4976_1528# el 0.00185f
C68 en ib_x2 0.14421f
C69 vgln ib_x2 0.26925f
C70 a_864_6450# iint 0.13343f
C71 a_4976_1528# m1_4546_7560# 0.00278f
C72 a_4976_1528# a_2102_5152# 0.4055f
C73 en a_2102_5152# 0.04646f
C74 vgln a_2102_5152# 0.08399f
C75 m1_4894_1238# ib_r1 0.16682f
C76 m1_8332_7080# el 0.00199f
C77 a_864_6450# m1_7440_2050# 0.06786f
C78 vth_cmp el 0.048f
C79 vdd vbn_prb 0.24855f
C80 ib_x2 vglp 0.10572f
C81 el vglp 0.41693f
C82 ib_r1 iint 0.10242f
C83 m1_8646_1098# en 0.001f
C84 m1_1382_738# ib_x2 0
C85 vdd m1_5388_6960# 0.62183f
C86 m1_4546_7560# vglp 0.73349f
C87 a_864_6450# a_5712_1328# 0.04659f
C88 a_4976_1528# vbn_prb 0.11005f
C89 a_2102_5152# vglp 0.09855f
C90 ib_r1 m1_7440_2050# 0.00546f
C91 en vbn_prb 0.26578f
C92 vgln vbn_prb 0.23038f
C93 m1_1382_738# a_2102_5152# 0
C94 a_4976_1528# vdd 1.4633f
C95 vdd en 0.32674f
C96 m1_8646_1098# vglp 0
C97 vgln vdd 2.2258f
C98 vgln m1_5388_6960# 0.00536f
C99 ib_r1 a_5712_1328# 0.15887f
C100 vbn_prb vglp 0.48983f
C101 a_864_6450# ib_x2 0.02181f
C102 m1_8332_7080# vdd 0.82484f
C103 a_864_6450# el 0.02982f
C104 vth_cmp vdd 0.17797f
C105 a_4976_1528# en 0.05046f
C106 a_4976_1528# vgln 0
C107 vth_cmp m1_5388_6960# 0.00607f
C108 m1_1382_738# vbn_prb 0
C109 vgln en 0.06792f
C110 vdd vglp 5.25107f
C111 a_864_6450# m1_4546_7560# 0.73f
C112 m1_5388_6960# vglp 0.15331f
C113 m1_8042_6360# vreset_src 0.26401f
C114 m1_942_738# vdd 0.00344f
C115 a_2102_5152# a_864_6450# 0.40639f
C116 vdd m1_1382_738# 0.0035f
C117 m1_8042_6360# vth_ref 0.00285f
C118 ib_r1 ib_x2 0.20298f
C119 a_4976_1528# vglp 0.38892f
C120 m1_8646_1098# a_864_6450# 0.03779f
C121 en vglp 0.59159f
C122 vgln vglp 0
C123 m1_942_738# a_4976_1528# 0.00922f
C124 a_4976_1528# m1_1382_738# 0.00776f
C125 m1_8042_6360# iint 0
C126 m1_942_738# en 0.00966f
C127 m1_1382_738# en 0.14813f
C128 a_2102_5152# ib_r1 0.11035f
C129 vth_cmp m1_8332_7080# 0.00111f
C130 a_864_6450# vbn_prb 0.59172f
C131 m1_8332_7080# vglp 0.0652f
C132 vth_cmp vglp 0.28484f
C133 vdd a_864_6450# 10.38485f
C134 m1_5388_6960# a_864_6450# 0.32262f
C135 m1_4894_1238# m1_7102_850# 0
C136 vth_ref vreset_src 0.1174f
C137 m1_1382_738# vglp 0.00131f
C138 m1_7102_850# iint 0.3658f
C139 ib_r1 vbn_prb 0.81062f
C140 m1_942_738# m1_1382_738# 0.08765f
C141 a_4976_1528# a_864_6450# 0.73462f
C142 en a_864_6450# 0.33221f
C143 vdd ib_r1 0
C144 vgln a_864_6450# 0.12647f
C145 m1_7440_2050# m1_7102_850# 0.02863f
C146 m1_4894_1238# iint 0.00172f
C147 m1_8332_7080# a_864_6450# 0.09337f
C148 vth_cmp a_864_6450# 0.02777f
C149 a_4976_1528# ib_r1 0.24273f
C150 a_5712_1328# m1_7102_850# 0.54324f
C151 en ib_r1 0.13773f
C152 vgln ib_r1 0.04275f
C153 a_864_6450# vglp 0.83998f
C154 vdd m1_502_738# 0.00342f
C155 m1_7440_2050# iint 0
C156 m1_4894_1238# a_5712_1328# 0.16211f
C157 ib_r1 vglp 0.44719f
C158 a_4976_1528# m1_502_738# 0.04144f
C159 a_5712_1328# iint 0.29607f
C160 m1_7102_850# ib_x2 0.07339f
C161 en m1_502_738# 0.01007f
C162 vreset_src el 0.03609f
C163 a_5712_1328# m1_7440_2050# 0.03242f
C164 m1_8042_6360# vbn_prb 0
C165 vth_ref el 0.71135f
C166 vreset_src m1_4546_7560# 0.00447f
C167 m1_4894_1238# ib_x2 0.06226f
C168 m1_8042_6360# vdd 0.53891f
C169 m1_1276_6360# el 0.00217f
C170 m1_8042_6360# m1_5388_6960# 0.11312f
C171 m1_8646_1098# m1_7102_850# -0.00509f
C172 iint ib_x2 0.04728f
C173 m1_942_738# m1_502_738# 0.42104f
C174 m1_1276_6360# m1_4546_7560# 0.14038f
C175 m1_1382_738# m1_502_738# 0
C176 m1_4894_1238# a_2102_5152# 0.06382f
C177 m1_1276_6360# a_2102_5152# 0.00961f
C178 ib_r1 a_864_6450# 0.24976f
C179 m1_7102_850# vbn_prb 0.11192f
C180 a_2102_5152# iint 0
C181 m1_7440_2050# ib_x2 0.08935f
C182 m1_8042_6360# en 0
C183 m1_8042_6360# vss -0.29705f
C184 vbn_prb vss 3.71278f
C185 el vss 0.65712f
C186 m1_4546_7560# vss -0.26802f
C187 ib_x2 vss 3.37258f
C188 iint vss 1.91268f
C189 vth_cmp vss 0.07828f
C190 m1_1382_738# vss 1.13003f
C191 m1_942_738# vss 0.5126f
C192 m1_502_738# vss 0.71186f
C193 m1_7440_2050# vss 0.52223f
C194 vth_ref vss 0.57598f
C195 m1_8332_7080# vss -0.04322f
C196 a_2102_5152# vss 0.19991f
C197 a_4976_1528# vss 1.61618f
C198 a_864_6450# vss -0.98223f
C199 m1_4894_1238# vss 0.33472f
C200 vglp vss 1.49743f
C201 vreset_src vss 0.10863f
C202 m1_5388_6960# vss -0.271f
C203 a_5712_1328# vss 1.81802f
C204 m1_8646_1098# vss 0.01901f
C205 en vss 2.7871f
C206 m1_7102_850# vss 0.68137f
C207 m1_1276_6360# vss -0.17835f
C208 ib_r1 vss 1.6597f
C209 vgln vss 0.40803f
C210 vdd vss 64.84496f
.ends

.subckt bias_b1 vth_ref vreset_src ib_r1 ua0 vbn_leak vbn_ref vbp_syn vbp_st vbn_prb
+ el vth_cmp vbn_ax vbp_w ua0_stim_out r0_b0 r0_b1 r0_b2 r0_b3 r0_b4 r2_b0 r2_b1 r2_b2
+ r2_b3 r2_b4 r1_b0 r1_b1 r1_b2 r1_b3 r1_b4 i2_b0 i4_b0 i2_b1 i4_b1 i2_b2 i4_b2 i2_b3
+ i4_b3 i2_b4 i4_b4 i0_b0 i1_b0 i3_b0 i0_b1 i1_b1 i3_b1 i0_b2 i1_b2 i3_b2 i0_b3 i1_b3
+ i3_b3 i0_b4 i1_b4 i3_b4 v0_c0 v0_c1 v0_c2 v0_c3 v0_c4 v0_c5 bias_en ib_x2 ua0_s0
+ ua0_s1 ua0_stim ua0_int vdd vss
XXx0 vbn_leak vdd vss rx_n4
XXx1 vbn_ref vdd vss rx_n2
XXx2 vss vdd vbp_syn rx_p24
XXx3 vdd vss vbn_ax rx_n1
XXx4 vbp_w vdd vss rx_p05
XXg Xm/in_n Xi1/g Xg/m1_4760_1320# Xg/m1_6020_10200# Xg/m1_3298_2050# Xg/m1_5022_10210#
+ Xg/m1_3530_1930# Xg/m1_3898_9610# Xg/a_7580_5314# vss Xi0/g Xg/m1_4906_9490# vdd
+ Xg/m1_6282_1450# Xg/a_1580_5314# Xg/m1_3666_9610# Xg/m1_5516_1920# Xg/a_4580_5314#
+ Xg/m1_4538_1930# Xi4/g Xg/a_5188_4156# Xi2/g Xr/vsp Xr/vsn Xr/vglp Xi3/g Xg/a_3036_4156#
+ Xr/vgln Xm/in_p bias_ladder
XXi0 i0_b0 i0_b1 i0_b2 i0_b3 i0_b4 vbn_leak vdd vss Xi0/a_1582_4572# Xi0/m1_988_3644#
+ Xi0/m1_988_2984# Xi0/a_528_4572# Xi0/a_1378_4572# Xi0/a_3078_4572# Xi0/m1_988_1168#
+ Xi0/a_2228_4572# vss Xi0/m1_650_4492# Xi0/g Xr/vsp Xi0/a_3928_4572# Xi0/a_4132_4572#
+ Xi0/a_2432_4572# Xi0/m1_1460_4102# Xi0/a_732_4572# Xr/vgln Xi0/a_3282_4572# idac_p
XXi1 i1_b0 i1_b1 i1_b2 i1_b3 i1_b4 vbn_ref vdd vss Xi1/a_1582_4572# Xi1/m1_988_3644#
+ Xi1/m1_988_2984# Xi1/a_528_4572# Xi1/a_1378_4572# Xi1/a_3078_4572# Xi1/m1_988_1168#
+ Xi1/a_2228_4572# vss Xi1/m1_650_4492# Xi1/g Xr/vsp Xi1/a_3928_4572# Xi1/a_4132_4572#
+ Xi1/a_2432_4572# Xi1/m1_1460_4102# Xi1/a_732_4572# Xr/vgln Xi1/a_3282_4572# idac_p
XXm ua0 ua0_s0 ua0_s1 ua0_stim ua0_int bias_en Xm/in_n Xm/in_p Xm/iint Xr/en_b vbp_st
+ ua0_stim_out Xm/a_1744_9182# vss vdd Xm/a_1764_11418# Xm/a_1744_10100# Xm/a_2240_11218#
+ Xm/a_736_5516# Xm/a_420_700# Xm/a_736_7228# bias_master
XXi2 i2_b0 i2_b1 i2_b2 i2_b3 i2_b4 vbp_syn Xr/vgln vdd vss Xi2/m1_988_3644# Xi2/a_3928_4510#
+ Xi2/m1_988_2984# Xi2/a_732_4510# Xi2/a_1582_4510# Xi2/a_4132_4510# Xi2/a_3282_4510#
+ Xi2/m1_988_1168# Xi2/g Xi2/a_2432_4510# Xi2/m1_640_4420# Xi2/a_1378_4510# Xi2/a_528_4510#
+ vdd Xi2/m1_1500_4102# Xi2/a_2228_4510# Xr/vsn Xi2/a_3078_4510# idac_n
XXi3 i3_b0 i3_b1 i3_b2 i3_b3 i3_b4 vbn_ax vdd vss Xi3/a_1582_4572# Xi3/m1_988_3644#
+ Xi3/m1_988_2984# Xi3/a_528_4572# Xi3/a_1378_4572# Xi3/a_3078_4572# Xi3/m1_988_1168#
+ Xi3/a_2228_4572# vss Xi3/m1_650_4492# Xi3/g Xr/vsp Xi3/a_3928_4572# Xi3/a_4132_4572#
+ Xi3/a_2432_4572# Xi3/m1_1460_4102# Xi3/a_732_4572# Xr/vgln Xi3/a_3282_4572# idac_p
XXxst vbp_st vdd vss rx_p05
XXi4 i4_b0 i4_b1 i4_b2 i4_b3 i4_b4 vbp_w Xr/vgln vdd vss Xi4/m1_988_3644# Xi4/a_3928_4510#
+ Xi4/m1_988_2984# Xi4/a_732_4510# Xi4/a_1582_4510# Xi4/a_4132_4510# Xi4/a_3282_4510#
+ Xi4/m1_988_1168# Xi4/g Xi4/a_2432_4510# Xi4/m1_640_4420# Xi4/a_1378_4510# Xi4/a_528_4510#
+ vdd Xi4/m1_1500_4102# Xi4/a_2228_4510# Xr/vsn Xi4/a_3078_4510# idac_n
XXd0 r0_b0 r0_b1 r0_b2 r0_b3 r0_b4 vdd Xd0/a_2392_3416# Xd0/a_3576_3416# Xd0/m1_942_4048#
+ Xd0/a_1800_3416# Xd0/m1_2262_4048# Xd0/m1_3342_4048# Xd0/m1_4094_3010# Xd0/m1_1382_4048#
+ Xd0/a_2984_3416# el Xd0/a_4168_3416# Xd0/m1_2760_3412# Xd0/m1_4222_4048# Xd0/m1_1822_4048#
+ vss Xd0/m1_502_4048# vdacr_el
XXd1 r1_b0 r1_b1 r1_b2 r1_b3 r1_b4 vdd vreset_src Xd1/m1_3782_4048# Xd1/a_2392_3416#
+ Xd1/a_3576_3416# Xd1/m1_942_4048# Xd1/m1_502_4048# Xd1/a_1800_3416# Xd1/m1_2318_2410#
+ Xd1/m1_3492_2640# Xd1/m1_3662_2290# vss Xd1/a_2984_3416# Xd1/a_4168_3416# Xd1/m1_2910_2650#
+ Xd1/m1_1716_2640# vdacr_vr
XXr Xr/vsp Xr/vgln Xr/en_b vdd Xr/m1_782_438# Xr/m1_3422_438# Xr/m1_3862_3522# vss
+ Xr/m1_1222_3522# Xr/m1_342_438# Xr/vsn Xr/m1_1662_438# Xr/vglp Xr/m1_2542_438# bias_rails
XXd2 r2_b0 r2_b1 r2_b2 r2_b3 r2_b4 vdd vth_cmp Xd2/a_2392_3416# Xd2/a_3576_3416# Xd2/m1_942_4048#
+ Xd2/a_1800_3416# Xd2/m1_1822_4048# Xd2/m1_3542_4048# Xd2/m1_2900_3120# Xd2/a_2984_3416#
+ Xd2/a_4168_3416# Xd2/m1_2156_3240# Xd2/m1_3982_4048# Xd2/m1_1382_4048# vss Xd2/m1_502_4048#
+ vdacr_vc
XXd3 v0_c0 v0_c1 v0_c2 v0_c3 v0_c4 v0_c5 vdd Xd3/m1_3342_4448# Xd3/a_3228_3816# Xd3/m1_5982_4448#
+ Xd3/m1_502_4448# Xd3/a_3820_3816# Xd3/m1_942_4448# Xd3/m1_1970_3610# vth_ref Xd3/a_2636_3816#
+ Xd3/a_5004_3816# Xd3/m1_1822_4448# vss Xd3/m1_4328_3000# Xd3/a_4412_3816# Xd3/m1_4488_3600#
+ Xd3/m1_4648_4446# Xd3/m1_3600_4920# Xd3/m1_5542_4448# Xd3/a_2044_3816# Xd3/m1_2702_4448#
+ Xd3/m1_1382_4448# vdacr_vt
XXvi bias_en Xr/vglp Xr/vgln vth_cmp vth_ref Xvi/m1_5388_6960# Xvi/m1_8646_1098# vreset_src
+ Xvi/m1_942_738# Xvi/m1_4894_1238# Xm/iint Xvi/m1_8042_6360# Xvi/m1_7102_850# ib_x2
+ Xvi/m1_7440_2050# Xvi/a_5712_1328# Xvi/a_2102_5152# Xvi/m1_4546_7560# Xvi/m1_502_738#
+ Xvi/m1_1276_6360# Xvi/m1_1382_738# vbn_prb vdd Xvi/a_4976_1528# Xvi/m1_8332_7080#
+ el Xvi/a_864_6450# vss ib_r1 bias_vi
C0 Xi4/a_1582_4510# vdd 0.00124f
C1 r2_b0 i4_b2 0.03975f
C2 i0_b3 ib_x2 0.43126f
C3 i0_b1 Xi1/a_528_4572# 0
C4 Xi3/g Xi1/a_1378_4572# 0
C5 Xd3/a_2636_3816# ua0_s1 0
C6 Xi3/g i4_b2 0.66533f
C7 Xm/in_p vdd 0.4149f
C8 Xd0/m1_1822_4048# r1_b1 0.00239f
C9 i2_b3 Xr/vsp 0
C10 Xi3/a_3928_4572# i3_b4 0.0021f
C11 i1_b2 i0_b2 0.01132f
C12 Xr/m1_1662_438# Xm/iint 0.02263f
C13 i4_b2 Xi4/g 0.33882f
C14 Xr/vglp vbn_ref 0.34763f
C15 vbp_st Xd0/a_1800_3416# 0.00455f
C16 vbp_st Xd0/m1_4222_4048# 0.04687f
C17 Xi3/a_1378_4572# i1_b1 0.00146f
C18 i4_b3 vth_ref 0
C19 Xg/a_1580_5314# Xg/a_3036_4156# -0.01873f
C20 v0_c2 Xd3/a_5004_3816# 0.05852f
C21 Xd3/m1_4648_4446# v0_c3 0.00267f
C22 i2_b2 Xr/vgln 0.24339f
C23 Xvi/m1_1276_6360# Xr/vglp -0
C24 i4_b1 vbn_ref 1.49642f
C25 Xi3/a_3078_4572# vdd 0.09479f
C26 Xm/a_736_7228# Xm/iint 0.07463f
C27 Xr/en_b ua0_s1 0.27379f
C28 Xi1/g Xr/vsn 0.57197f
C29 i1_b3 Xi3/m1_988_2984# 0.41426f
C30 i0_b2 Xr/vgln 0.37241f
C31 i4_b3 i2_b2 0
C32 Xvi/a_4976_1528# Xr/vgln 0.14338f
C33 Xg/a_3036_4156# Xg/a_4580_5314# -0.00257f
C34 Xd1/a_2392_3416# Xd1/a_1800_3416# -0.0041f
C35 Xg/a_7580_5314# Xg/a_5188_4156# -0.01406f
C36 v0_c3 vdd 0.50515f
C37 Xi4/a_2432_4510# vreset_src 0.05762f
C38 i4_b3 Xvi/a_4976_1528# 0.04036f
C39 vbp_st Xm/iint 0.03627f
C40 Xi1/a_4132_4572# i0_b3 0.01197f
C41 Xr/vglp r1_b3 0.36491f
C42 vth_ref Xr/vsp 1.00943f
C43 Xvi/m1_5388_6960# Xvi/a_864_6450# -0.02159f
C44 r2_b0 r0_b1 0.00485f
C45 vbp_w i4_b1 0.04318f
C46 Xi1/m1_988_1168# vth_ref 0.16784f
C47 Xd1/m1_3662_2290# vbn_ref 0.17316f
C48 Xg/m1_3666_9610# Xr/vsp 0.01088f
C49 r2_b0 r1_b1 0.04306f
C50 r1_b1 r1_b4 0.1032f
C51 r0_b1 r1_b4 0.34943f
C52 i4_b1 r1_b3 0.01769f
C53 r2_b0 r2_b4 0.05398f
C54 Xvi/m1_8332_7080# Xr/vgln 0
C55 i4_b2 Xg/m1_3298_2050# 0.00703f
C56 r2_b4 r1_b4 0.17275f
C57 i1_b2 Xi3/a_3282_4572# 0
C58 i3_b3 vdd 0.04153f
C59 Xvi/m1_942_738# Xr/vsn 0.0449f
C60 Xi3/g r2_b4 0.18653f
C61 i2_b1 i4_b0 0.17901f
C62 Xg/a_3036_4156# Xg/m1_6020_10200# -0.00106f
C63 i2_b2 Xr/vsp 0.03344f
C64 Xi1/m1_650_4492# i0_b3 0.01141f
C65 ib_r1 Xvi/m1_7440_2050# 0.04725f
C66 r2_b0 r1_b0 0.14208f
C67 r1_b0 r1_b4 0.13398f
C68 bias_en Xi0/g 0.11772f
C69 bias_en Xi0/m1_988_3644# 0.00371f
C70 Xi3/g r1_b0 0
C71 i0_b2 Xr/vsp 0.39396f
C72 Xg/m1_4906_9490# vdd -0.00836f
C73 Xi3/a_3282_4572# Xr/vgln 0.01206f
C74 Xi1/m1_988_1168# i0_b2 0.25202f
C75 Xi1/a_2432_4572# Xi1/m1_1460_4102# -0
C76 ua0_stim_out Xr/vglp 0.19737f
C77 r0_b2 r2_b0 0
C78 Xi4/m1_988_2984# Xi4/m1_1500_4102# -0.00132f
C79 Xvi/a_864_6450# r2_b3 0
C80 r2_b2 vbn_ax 0.30145f
C81 r0_b2 r1_b4 0.02389f
C82 r2_b0 vth_cmp 0.03475f
C83 vbn_ax vbn_prb 0.01089f
C84 Xd1/m1_3662_2290# r1_b3 -0.00428f
C85 el Xd1/m1_3782_4048# 0
C86 vbp_w Xi2/m1_988_1168# 0
C87 Xi1/m1_988_3644# vdd 0.15077f
C88 ua0_stim_out i4_b1 0.14382f
C89 Xi2/a_4132_4510# Xr/vgln -0.00123f
C90 i0_b2 i1_b1 0.16016f
C91 vbn_leak Xi0/g 0.2013f
C92 Xi1/g i0_b4 0.16263f
C93 i2_b4 Xi0/g 0.05264f
C94 ua0 ua0_s1 0.11437f
C95 Xi4/a_2228_4510# vreset_src 0.05258f
C96 Xi4/g vth_cmp 0.06915f
C97 Xm/a_420_700# vdd -0.03938f
C98 Xd0/a_3576_3416# r1_b1 0.06184f
C99 Xi2/m1_988_3644# Xi2/m1_988_2984# -0.00713f
C100 Xg/a_7580_5314# r1_b4 0.04905f
C101 v0_c2 v0_c5 0.01172f
C102 r1_b1 Xd1/a_2392_3416# 0.08758f
C103 i4_b2 vbn_ref 0.32008f
C104 Xi3/g Xg/a_7580_5314# -0.04952f
C105 i1_b2 Xm/in_p 0.05396f
C106 Xi1/a_3928_4572# i0_b3 0
C107 r2_b2 Xd0/a_4168_3416# 0.05357f
C108 i4_b4 vbn_ax 0.40699f
C109 vth_ref vbp_st 0.19529f
C110 vreset_src Xr/vglp 0.61132f
C111 r2_b2 r1_b2 0.04587f
C112 v0_c0 v0_c1 0.20721f
C113 Xi3/m1_650_4492# vdd 0.09343f
C114 vbp_syn Xi2/a_528_4510# 0.036f
C115 Xvi/m1_1276_6360# i4_b2 0.03037f
C116 r2_b1 Xi2/g 0.22332f
C117 Xr/vsn i1_b3 0.0014f
C118 vbp_syn vdd 0.97515f
C119 Xi0/a_3078_4572# vreset_src 0.02958f
C120 Xm/a_2240_11218# ua0_stim 0
C121 Xvi/m1_1382_738# ib_x2 0
C122 Xi3/a_4132_4572# Xm/in_p 0
C123 i4_b1 vreset_src 0.0046f
C124 Xi4/a_1582_4510# Xr/vgln 0.00128f
C125 Xd1/a_3576_3416# vbn_ax 0.09397f
C126 Xi2/g vdd 0.32531f
C127 r2_b2 r0_b3 0.97353f
C128 i1_b2 Xi3/a_3078_4572# 0
C129 Xm/in_p Xr/vgln 0.01231f
C130 r2_b2 Xd0/m1_2262_4048# 0
C131 Xd3/m1_1382_4448# v0_c0 0.00103f
C132 Xr/vglp Xi1/a_528_4572# 0
C133 vbn_prb Xd0/m1_2262_4048# 0
C134 ua0_s0 Xd3/m1_5982_4448# 0.00202f
C135 Xd3/m1_4328_3000# Xd3/a_5004_3816# -0
C136 r0_b4 vbp_syn 0.13674f
C137 r2_b1 Xm/in_n 0.01239f
C138 Xr/vsn Xg/m1_6282_1450# 0.02435f
C139 ua0_stim_out Xi2/m1_988_1168# 0.24692f
C140 r0_b2 Xd0/a_3576_3416# 0.01242f
C141 Xr/en_b Xr/vglp 0.77149f
C142 vdd i3_b0 -0.00503f
C143 i3_b1 i0_b1 0
C144 i4_b3 Xm/in_p 0.06941f
C145 Xd3/m1_2702_4448# Xd3/m1_1970_3610# -0.00421f
C146 r0_b4 Xi2/g 0
C147 Xi3/a_4132_4572# Xi3/a_3078_4572# 0
C148 vbp_st i0_b2 0.03431f
C149 Xi0/a_1582_4572# vdd 0.02674f
C150 Xd1/a_2392_3416# vth_cmp 0.00348f
C151 Xm/in_n vdd 0.53404f
C152 Xi3/a_3078_4572# Xr/vgln 0.12483f
C153 bias_en Xvi/m1_8646_1098# -0
C154 vdd Xi0/a_1378_4572# 0.03134f
C155 Xd3/m1_5982_4448# ib_x2 0.00194f
C156 ua0_s0 bias_en 0.91351f
C157 Xd1/m1_3662_2290# vreset_src 0.00104f
C158 Xr/vsn Xi2/m1_988_3644# -0.01295f
C159 r2_b2 i2_b0 0.18723f
C160 Xi0/a_528_4572# Xi0/g 0.01327f
C161 r1_b1 vbn_ref 0.05799f
C162 i4_b4 Xg/a_4580_5314# 0.12555f
C163 Xd3/m1_3342_4448# ua0_stim_out 0
C164 bias_en Xi0/a_2432_4572# 0.05556f
C165 Xd1/a_2984_3416# vbn_leak 0
C166 Xi1/g Xi1/m1_988_2984# -0.19433f
C167 Xi1/a_3282_4572# vdd 0.04522f
C168 r2_b4 vbn_ref 0.27864f
C169 i1_b2 i3_b3 0.05023f
C170 bias_en ib_x2 0.81863f
C171 ua0_s0 Xd3/a_3820_3816# 0.01207f
C172 Xi1/g Xg/a_3036_4156# 0.00352f
C173 Xvi/a_2102_5152# Xi4/g 0.11956f
C174 Xvi/m1_5388_6960# Xr/vglp -0.00278f
C175 Xm/in_p Xr/vsp 0.02099f
C176 ua0_stim_out i4_b2 0.04676f
C177 r1_b0 vbn_ref 0.28654f
C178 Xi3/a_3928_4572# Xm/in_p 0.00192f
C179 i1_b3 i0_b4 0
C180 Xd3/m1_3342_4448# Xd3/a_2636_3816# -0
C181 bias_en Xd3/a_3228_3816# 0.0946f
C182 i3_b3 Xr/vgln 0.0456f
C183 i2_b4 i4_b0 0.03691f
C184 vbn_ax r0_b0 0.01627f
C185 Xm/in_p i1_b1 0.04301f
C186 vbn_leak ib_x2 0.13164f
C187 i4_b0 vbn_leak 0.32146f
C188 r0_b1 vbp_w 0.06554f
C189 vreset_src Xd1/a_1800_3416# 0.04546f
C190 vbn_ref vth_cmp 0.05608f
C191 vbp_w r1_b1 0.2173f
C192 Xi4/g Xm/iint 0.00118f
C193 r1_b1 r1_b3 0.04121f
C194 r1_b2 Xi2/m1_640_4420# 0.05594f
C195 Xvi/m1_7440_2050# Xr/vgln 0
C196 vbp_w r2_b4 0.25607f
C197 vth_cmp Xd0/m1_942_4048# 0
C198 Xd3/a_3228_3816# Xd3/a_3820_3816# -0.0065f
C199 r2_b4 r1_b3 0.23448f
C200 Xvi/m1_1276_6360# vth_cmp 0
C201 Xg/a_7580_5314# vbn_ref 0.03357f
C202 i4_b2 vreset_src 0.03668f
C203 Xm/a_2240_11218# ua0_stim_out 0
C204 Xd0/a_4168_3416# r0_b0 0.04741f
C205 r0_b3 Xi2/m1_640_4420# 0.0974f
C206 Xr/vglp r2_b3 0.45938f
C207 r2_b0 i2_b3 0.05857f
C208 i2_b1 r1_b2 0.03764f
C209 r1_b4 i2_b3 0.03193f
C210 vbp_w r1_b0 0.42231f
C211 i1_b4 i1_b3 0.00176f
C212 i1_b2 Xi3/m1_650_4492# 0.00241f
C213 Xi3/g i2_b3 0
C214 r1_b0 r1_b3 0.3016f
C215 Xi1/m1_988_3644# Xr/vgln 0.02685f
C216 r1_b2 r0_b0 0
C217 Xm/in_p Xd3/m1_502_4448# 0.03934f
C218 i4_b1 r2_b3 0.04169f
C219 ib_r1 Xi0/m1_988_3644# 0
C220 ib_r1 Xi0/g 0.72628f
C221 Xvi/m1_4546_7560# el -0.01191f
C222 Xi1/a_3078_4572# vdd 0.07372f
C223 Xd3/m1_2702_4448# ua0_stim_out 0
C224 i2_b1 r0_b3 0.06331f
C225 Xi0/m1_988_3644# vdd -0.00433f
C226 r0_b2 vbp_w 0.00798f
C227 vdd Xi0/g 1.82773f
C228 vbp_w vth_cmp 0.03579f
C229 Xd0/m1_2262_4048# r0_b0 0
C230 r0_b3 r0_b0 0.03813f
C231 Xr/vsn el 0.16228f
C232 r1_b3 vth_cmp 0
C233 Xi3/m1_1460_4102# vdd 0.00372f
C234 ua0_stim_out r1_b1 0.1404f
C235 Xd2/a_4168_3416# vreset_src 0.02269f
C236 Xm/in_p vbp_st 0.15787f
C237 r0_b1 ua0_stim_out 0.1875f
C238 vbp_syn Xr/vgln 0.15018f
C239 r1_b1 Xd1/a_4168_3416# 0.06833f
C240 Xr/vsn Xi4/m1_988_1168# 0.24016f
C241 ua0_int ua0_stim 2.5916f
C242 ua0_stim_out r2_b4 0.15625f
C243 Xg/a_7580_5314# r1_b3 0.04018f
C244 Xi3/a_3928_4572# i3_b3 0
C245 Xd3/m1_2702_4448# Xd3/a_2636_3816# -0.04242f
C246 Xi2/g Xr/vgln 0.32686f
C247 i1_b0 vbn_ax 0.16761f
C248 Xr/vsn Xi2/m1_988_2984# -0.01323f
C249 Xr/vglp Xi1/m1_1460_4102# 0.01047f
C250 Xi0/a_528_4572# ib_x2 0.0144f
C251 Xg/m1_4906_9490# Xr/vsp 0.00183f
C252 ua0_s0 v0_c4 0.04325f
C253 Xd0/m1_2760_3412# r1_b1 0.00591f
C254 ua0_stim_out r1_b0 0.30615f
C255 Xd0/m1_4222_4048# vbn_ref 0.04925f
C256 i2_b1 i2_b0 0.38491f
C257 v0_c0 i0_b4 0
C258 i4_b3 Xi2/g 0.50398f
C259 Xm/a_2240_11218# Xr/en_b -0.04617f
C260 i2_b0 r0_b0 0.3817f
C261 Xr/vsn Xg/m1_4538_1930# 0.03919f
C262 Xm/in_n Xr/vgln 0.65154f
C263 Xi0/a_1582_4572# Xr/vgln 0.03328f
C264 vth_ref Xi4/g 0.0904f
C265 r0_b2 ua0_stim_out 0.17396f
C266 v0_c4 ib_x2 0.05233f
C267 Xi0/a_1378_4572# Xr/vgln 0.04282f
C268 Xi1/m1_988_3644# Xr/vsp -0.01223f
C269 Xd3/m1_5542_4448# v0_c1 0.04951f
C270 r2_b0 i2_b2 0.04559f
C271 r1_b4 i2_b2 0.04101f
C272 ua0_int Xm/a_1764_11418# 0
C273 Xvi/m1_502_738# r2_b1 0
C274 r2_b4 vreset_src 0.17497f
C275 Xi3/g i2_b2 0.00399f
C276 i4_b3 Xm/in_n 0.2334f
C277 Xvi/m1_1276_6360# Xvi/a_2102_5152# -0
C278 ua0_stim Xm/iint 0.11464f
C279 ua0_s0 Xd3/m1_4648_4446# 0.00602f
C280 ua0_stim_out Xg/a_7580_5314# 0.04282f
C281 v0_c0 i1_b4 0.1382f
C282 r1_b0 vreset_src 0.06986f
C283 Xr/m1_342_438# vreset_src 0.00647f
C284 Xi1/a_3282_4572# Xr/vgln 0.0048f
C285 Xi3/m1_650_4492# Xr/vsp -0.02886f
C286 ib_r1 Xvi/m1_8646_1098# 0
C287 r2_b0 Xvi/a_4976_1528# 0.04794f
C288 Xd1/a_2984_3416# vdd -0.06504f
C289 i4_b2 Xg/m1_5516_1920# 0
C290 Xi3/g i0_b2 0.07108f
C291 r0_b3 Xi2/a_2228_4510# 0.00718f
C292 vbp_w Xd0/a_1800_3416# 0.07897f
C293 vbp_w Xd0/m1_4222_4048# 0
C294 Xr/vsn Xvi/m1_4546_7560# 0.0178f
C295 r1_b1 Xd1/m1_2318_2410# -0.00265f
C296 Xd3/a_5004_3816# Xd3/m1_5982_4448# -0.00289f
C297 Xvi/a_4976_1528# Xi4/g 0.07485f
C298 vreset_src vth_cmp 0.91573f
C299 vth_ref i0_b0 0.07748f
C300 Xi1/g i4_b4 0.07076f
C301 ua0_s0 vdd 0.54144f
C302 Xi3/m1_650_4492# i1_b1 0.28683f
C303 i4_b2 r2_b3 0.07517f
C304 Xm/a_1764_11418# Xm/iint 0.08035f
C305 Xr/m1_342_438# Xr/en_b 0
C306 vdd Xi0/a_2432_4572# 0.03005f
C307 vbn_leak vbn_ax 0.00436f
C308 i0_b1 Xr/vglp 0.08745f
C309 Xi1/g i0_b3 0.25998f
C310 i4_b0 r2_b1 0.08063f
C311 i1_b4 Xi3/m1_988_2984# 0.00124f
C312 i3_b0 Xr/vsp 0
C313 i1_b0 Xi3/a_732_4572# 0
C314 ib_r1 ib_x2 0.13397f
C315 Xr/vglp Xvi/a_864_6450# -0.08674f
C316 Xm/in_n Xr/vsp 0.3689f
C317 Xi2/m1_1500_4102# r1_b2 0.00121f
C318 ua0_stim_out Xi3/a_1582_4572# 0.0011f
C319 vdd ib_x2 1.17223f
C320 i4_b0 vdd 0.87155f
C321 Xvi/m1_942_738# vbn_prb 0.01038f
C322 Xi0/a_3928_4572# Xr/vglp 0
C323 Xm/a_420_700# Xm/a_736_7228# -0.18123f
C324 Xi1/m1_988_1168# Xm/in_n 0.04384f
C325 bias_en Xd3/a_5004_3816# 0.18892f
C326 i1_b4 v0_c1 0
C327 Xi2/m1_1500_4102# r0_b3 0.02689f
C328 Xd3/m1_3600_4920# Xd3/m1_3342_4448# -0.00904f
C329 i1_b1 i3_b0 0.05615f
C330 ua0_int ua0_stim_out 0.01508f
C331 i0_b2 i0_b0 0.00114f
C332 Xd1/m1_2318_2410# vth_cmp 0.20225f
C333 Xd3/a_3228_3816# vdd 0.01466f
C334 i2_b4 r1_b2 0.03364f
C335 vbn_leak r1_b2 0
C336 Xi1/a_3282_4572# Xr/vsp 0
C337 v0_c2 v0_c0 0.04116f
C338 Xi0/g Xi0/m1_988_1168# 0.1579f
C339 i1_b2 Xi3/m1_1460_4102# 0.06976f
C340 i2_b4 r0_b3 0.04295f
C341 Xi0/g Xr/vgln 0.1719f
C342 Xi1/a_3078_4572# Xr/vgln 0.03133f
C343 vbp_syn vbp_st 0.23792f
C344 r0_b3 Xi2/a_2432_4510# 0.0094f
C345 Xd3/m1_4488_3600# v0_c3 0.03836f
C346 r1_b3 i2_b3 0.03247f
C347 Xr/m1_1222_3522# Xr/vsn -0
C348 Xi4/a_2228_4510# Xi4/a_2432_4510# -0
C349 ua0_int Xd3/a_2636_3816# 0
C350 r1_b1 Xd1/m1_1716_2640# -0.01742f
C351 bias_en Xi0/a_732_4572# 0.06118f
C352 bias_en Xi0/a_4132_4572# 0.07187f
C353 Xvi/m1_5388_6960# vth_cmp -0
C354 vbp_st Xi2/g 0.10377f
C355 i4_b3 Xi0/g 0.15995f
C356 Xi4/a_1378_4510# vreset_src 0.06032f
C357 Xvi/m1_8332_7080# i0_b0 0
C358 Xi1/a_4132_4572# vdd 0.00233f
C359 r1_b1 r2_b3 0.1583f
C360 r2_b4 r2_b3 0.2959f
C361 ua0_stim_out Xm/iint 0.16154f
C362 Xr/vsn i0_b4 0.12036f
C363 v0_c2 v0_c1 1.09151f
C364 i1_b0 Xi3/a_528_4572# 0.00246f
C365 Xi0/g Xi0/a_2228_4572# 0
C366 vreset_src Xvi/a_2102_5152# 0.17663f
C367 vbp_st Xm/in_n 0
C368 Xi4/m1_988_3644# Xi4/m1_988_2984# -0.02702f
C369 ua0_stim_out Xi3/a_1378_4572# 0
C370 Xg/m1_3898_9610# Xr/vsp 0
C371 i2_b1 Xi1/g 0
C372 Xm/in_p r1_b4 0.03184f
C373 r2_b0 Xm/in_p 0
C374 ua0_int Xr/en_b 0.01952f
C375 vbn_leak Xi0/a_732_4572# 0
C376 i3_b4 ua0_stim_out 0.00209f
C377 r1_b0 r2_b3 0.1618f
C378 Xi3/g Xm/in_p 0
C379 i3_b2 i3_b1 0.00529f
C380 Xi1/m1_650_4492# vdd -0.00189f
C381 i0_b2 vbn_ref 0.08284f
C382 vbn_ax Xd0/m1_3342_4048# 0.06226f
C383 Xd1/m1_1716_2640# vth_cmp 0.14331f
C384 i1_b3 i0_b3 0.12418f
C385 r2_b3 vth_cmp 0.10978f
C386 vreset_src Xm/iint 0.13224f
C387 Xi1/a_3078_4572# Xr/vsp 0
C388 Xg/m1_4906_9490# Xg/a_5188_4156# -0
C389 Xi0/g Xr/vsp 0.6417f
C390 Xi0/m1_988_3644# Xr/vsp -0.00631f
C391 Xr/vsn i1_b4 0.00486f
C392 Xg/m1_3666_9610# r1_b3 0
C393 Xvi/m1_1276_6360# Xvi/a_4976_1528# -0.00114f
C394 Xg/m1_3530_1930# Xi2/g 0.00729f
C395 Xd3/m1_942_4448# Xm/in_p 0.04265f
C396 i4_b4 Xg/m1_6282_1450# 0
C397 Xg/a_7580_5314# r2_b3 0
C398 Xi3/m1_1460_4102# Xr/vsp -0.00275f
C399 r2_b2 Xi2/m1_988_3644# 0.00779f
C400 Xm/iint Xi0/m1_1460_4102# 0.09301f
C401 i4_b2 Xvi/a_864_6450# 0.00957f
C402 bias_en v0_c5 0.09436f
C403 r1_b3 i2_b2 0.0564f
C404 vbn_prb Xd1/m1_3782_4048# 0.0302f
C405 i4_b1 Xg/m1_4760_1320# 0
C406 Xg/m1_3530_1930# Xm/in_n 0.07387f
C407 Xr/en_b Xm/iint 0.13121f
C408 v0_c4 Xd3/a_5004_3816# 0.00953f
C409 Xi1/a_3928_4572# vdd 0.01049f
C410 Xi3/m1_1460_4102# i1_b1 0.00223f
C411 Xm/in_p i0_b0 0.09529f
C412 Xm/a_1744_9182# bias_en 0.12665f
C413 r2_b1 vbn_ax 0.07099f
C414 Xi0/a_2432_4572# Xr/vgln 0.06417f
C415 Xd1/m1_502_4048# vth_cmp 0.00114f
C416 Xd2/m1_3542_4048# Xd2/m1_3982_4048# -0
C417 Xd1/m1_3492_2640# vbn_ax 0.0122f
C418 vth_ref ua0_stim_out 0.69891f
C419 vbp_st Xd0/m1_4094_3010# 0.06315f
C420 Xr/vsn Xi1/m1_988_2984# 0.06244f
C421 ib_x2 Xr/vgln 2.53949f
C422 vbn_ax vdd 0.66588f
C423 i4_b0 Xr/vgln 0.06588f
C424 Xi2/g Xg/a_5188_4156# -0.06536f
C425 bias_en Xi0/m1_650_4492# 0.00173f
C426 Xi0/a_3078_4572# Xr/vglp 0.00416f
C427 r2_b1 Xi4/m1_988_2984# 0.02586f
C428 Xg/a_3036_4156# Xr/vsn 0
C429 i4_b1 Xr/vglp 0.14252f
C430 i0_b2 Xi1/a_732_4572# 0.01558f
C431 Xd3/m1_4328_3000# v0_c0 0
C432 r2_b1 r1_b2 0.05503f
C433 ua0_int ua0 0.00584f
C434 Xm/a_2240_11218# ua0_s1 0.92495f
C435 Xi4/m1_988_2984# vdd -0
C436 Xm/in_n Xg/a_5188_4156# 0
C437 Xd0/a_4168_3416# vdd -0.00727f
C438 Xi1/a_3078_4572# vbp_st 0
C439 vbp_st Xi0/g 0.31863f
C440 r2_b1 Xg/a_1580_5314# 0.25556f
C441 Xg/m1_4906_9490# r1_b4 0.02043f
C442 Xi4/a_2432_4510# i4_b2 0.00232f
C443 vth_ref vreset_src 0.41793f
C444 ua0_s0 Xm/a_1744_10100# 0
C445 Xi3/g Xg/m1_4906_9490# -0
C446 vdd r1_b2 1.00901f
C447 ua0_stim_out i0_b2 0.30102f
C448 Xg/a_1580_5314# vdd -0.18933f
C449 Xi0/a_2228_4572# ib_x2 0.01566f
C450 i1_b4 i0_b4 0.34065f
C451 Xd3/a_5004_3816# vdd -0.00837f
C452 v0_c0 i0_b3 0.00228f
C453 Xvi/m1_942_738# Xvi/m1_1382_738# 0
C454 r0_b3 Xi2/a_528_4510# 0.00163f
C455 vdd Xd0/m1_2262_4048# -0
C456 r0_b3 vdd 0.47238f
C457 Xi1/g bias_en 0
C458 Xm/in_p Xd3/m1_1970_3610# 0.00567f
C459 Xi3/m1_988_3644# vdd -0.00788f
C460 r2_b2 el 0.13429f
C461 Xi1/a_4132_4572# Xr/vgln 0.00432f
C462 Xd3/m1_1822_4448# ua0_stim_out 0.06421f
C463 el vbn_prb 0.25143f
C464 Xg/a_4580_5314# vdd -0.0906f
C465 vth_ref Xr/en_b 0.0139f
C466 r0_b4 r0_b3 0.4129f
C467 Xd3/m1_4328_3000# v0_c1 0.1596f
C468 ib_x2 Xr/vsp 0.61664f
C469 v0_c2 Xd3/m1_5542_4448# 0.01808f
C470 i4_b0 Xr/vsp 0.1052f
C471 i0_b2 vreset_src 0.03659f
C472 vbp_syn r1_b4 0.04573f
C473 Xi2/m1_988_3644# Xi2/m1_640_4420# -0
C474 Xi3/g Xi3/m1_650_4492# -0.06101f
C475 Xi4/m1_988_1168# vbn_prb 0.18056f
C476 vreset_src Xvi/a_4976_1528# 0.14147f
C477 Xi1/m1_988_1168# ib_x2 0.31449f
C478 r2_b2 Xi2/m1_988_2984# 0.0206f
C479 r2_b1 i2_b0 0.03942f
C480 Xvi/m1_7102_850# Xvi/a_5712_1328# 0
C481 i4_b2 Xg/m1_4760_1320# 0.00429f
C482 i2_b4 Xi1/g 0.12344f
C483 Xi1/g vbn_leak 0
C484 Xi2/g r1_b4 0.42492f
C485 r2_b0 Xi2/g 0.03543f
C486 ib_r1 Xi0/a_4132_4572# 0.01011f
C487 Xd1/m1_942_4048# el 0.00248f
C488 i4_b4 el 1.31665f
C489 vdd i2_b0 0.0528f
C490 vdd Xi0/a_732_4572# 0.03384f
C491 Xi0/a_4132_4572# vdd -0.00179f
C492 Xi1/m1_650_4492# Xr/vgln 0.00224f
C493 i0_b2 Xi1/a_528_4572# 0.06682f
C494 ua0_stim v0_c3 0.00371f
C495 v0_c4 v0_c5 1.14997f
C496 Xi2/g Xi4/g 0.14498f
C497 vbn_ax Xd0/a_2392_3416# 0.00827f
C498 v0_c2 i0_b4 0
C499 bias_en Xvi/m1_942_738# 0.00382f
C500 ua0_s0 Xd3/m1_502_4448# 0.00784f
C501 vbp_w Xi4/a_1582_4510# 0
C502 Xd1/a_3576_3416# el 0.00329f
C503 ua0_stim_out Xi3/a_3282_4572# 0
C504 r0_b4 i2_b0 0.45831f
C505 r2_b3 i2_b3 0.05274f
C506 Xm/in_p r1_b3 0.11955f
C507 Xi4/a_2228_4510# i4_b2 0.00562f
C508 ua0_s0 Xm/a_736_7228# 0.42909f
C509 vdd Xg/m1_6020_10200# -0.03273f
C510 Xvi/m1_8332_7080# vreset_src 0.20033f
C511 vth_ref Xvi/m1_5388_6960# 0.00357f
C512 Xm/in_n Xi4/g 0.09602f
C513 r0_b1 Xi2/a_3282_4510# 0
C514 r1_b1 Xi2/a_3282_4510# 0.05395f
C515 Xd2/m1_502_4048# vbn_prb 0.00898f
C516 Xr/vsn Xi4/m1_1500_4102# -0.00114f
C517 i4_b2 Xr/vglp 0.47756f
C518 Xi1/a_4132_4572# Xr/vsp 0
C519 ua0_s0 vbp_st 0.0871f
C520 r1_b1 Xi2/a_732_4510# 0.04006f
C521 i1_b2 vbn_ax 0.06987f
C522 Xi0/g Xg/a_5188_4156# -0.06998f
C523 v0_c2 i1_b4 0.00118f
C524 Xi3/m1_988_1168# i1_b3 0.31204f
C525 Xi1/a_3928_4572# Xr/vgln 0.01043f
C526 Xg/m1_5022_10210# vdd -0.00514f
C527 i4_b1 i4_b2 0.05868f
C528 Xd1/a_2984_3416# Xd1/m1_2910_2650# -0
C529 Xi2/g i0_b0 0
C530 vbp_st ib_x2 0.04206f
C531 i4_b0 vbp_st 0.20506f
C532 r2_b2 Xr/vsn 0
C533 Xr/vsn vbn_prb 0.57729f
C534 v0_c5 vdd 0.23348f
C535 vbn_ax Xr/vgln 0.67832f
C536 Xi3/a_1378_4572# i3_b1 0
C537 Xi2/g Xg/m1_3298_2050# 0.00433f
C538 Xi1/m1_650_4492# Xr/vsp -0.0081f
C539 Xm/in_p ua0_stim_out 0.47195f
C540 r0_b2 Xi2/a_3282_4510# 0
C541 Xi1/g Xi0/a_528_4572# 0
C542 Xg/m1_3666_9610# r2_b3 0
C543 i0_b0 i3_b0 0
C544 i0_b0 Xm/in_n 0.04228f
C545 i4_b4 Xvi/m1_4546_7560# 0
C546 Xm/a_420_700# ua0_stim 0.19765f
C547 i4_b3 vbn_ax 0.42796f
C548 r0_b2 Xi2/a_732_4510# 0
C549 Xvi/a_864_6450# Xvi/a_2102_5152# -0.01253f
C550 Xm/a_1744_9182# vdd -0.00844f
C551 i4_b4 Xr/vsn 0.30794f
C552 ua0_int ua0_s1 0.66138f
C553 Xm/in_n Xg/m1_3298_2050# 0.0137f
C554 ua0_stim_out Xi3/a_3078_4572# 0.0171f
C555 r2_b3 i2_b2 0.04142f
C556 Xi2/m1_988_2984# Xi2/m1_640_4420# -0
C557 Xr/vsn i0_b3 0.41566f
C558 r1_b2 Xr/vgln 0.09355f
C559 i1_b2 Xi3/m1_988_3644# 0.0372f
C560 Xg/m1_3898_9610# r1_b4 0.00257f
C561 ib_r1 Xi0/m1_650_4492# 0.12404f
C562 Xm/in_p Xd3/a_2636_3816# 0
C563 Xi4/a_1582_4510# vreset_src 0.05832f
C564 Xi0/m1_650_4492# vdd -0.00613f
C565 Xg/a_1580_5314# Xr/vgln -0
C566 r1_b1 Xr/vglp 0.19282f
C567 Xr/m1_782_438# Xr/m1_342_438# -0.00576f
C568 Xvi/a_4976_1528# r2_b3 0
C569 i0_b1 Xm/iint 0
C570 r0_b3 Xr/vgln 0.03608f
C571 r2_b4 Xr/vglp 0.46882f
C572 Xvi/a_864_6450# Xm/iint 0.07532f
C573 vbp_syn vbn_ref 0.06499f
C574 Xi1/a_3928_4572# Xr/vsp 0
C575 ua0_s0 Xd3/a_2044_3816# 0.0244f
C576 Xd3/m1_3600_4920# vth_ref -0.00168f
C577 Xg/m1_4906_9490# r1_b3 0.06053f
C578 Xd2/a_3576_3416# vreset_src 0
C579 Xi0/a_3928_4572# Xm/iint 0.06782f
C580 i4_b3 Xg/a_1580_5314# 0.00102f
C581 Xi0/g r1_b4 0.01051f
C582 i4_b1 r2_b4 0.01963f
C583 Xg/a_4580_5314# Xr/vgln 0
C584 Xi2/g vbn_ref 0.32882f
C585 Xr/m1_342_438# Xr/vglp 0.28652f
C586 Xi3/g Xi0/g 0.24569f
C587 vbn_ax Xr/vsp 0.28927f
C588 r1_b0 Xr/vglp 0.23346f
C589 Xm/in_p Xr/en_b 0.09709f
C590 ua0_s0 Xd3/m1_4488_3600# 0.08001f
C591 Xi3/g Xi3/m1_1460_4102# -0.02591f
C592 Xi1/g r2_b1 0.17005f
C593 Xr/vglp vth_cmp 0.00649f
C594 Xi1/g ib_r1 0
C595 Xm/in_n vbn_ref 0.0018f
C596 i4_b3 Xg/a_4580_5314# 0.29567f
C597 ua0_stim_out i3_b3 0
C598 Xi1/g vdd 1.12046f
C599 vbn_ax i1_b1 0.23501f
C600 i2_b0 Xr/vgln 0.4269f
C601 Xi0/a_732_4572# Xr/vgln 0.03499f
C602 i0_b2 Xi1/m1_1460_4102# 0.00201f
C603 vbp_syn vbp_w 0.33716f
C604 i4_b0 Xg/a_5188_4156# 0.19343f
C605 Xd1/m1_3662_2290# r1_b1 0
C606 vbp_syn r1_b3 0.06147f
C607 Xg/a_7580_5314# Xr/vglp 0.07954f
C608 r1_b2 Xr/vsp 0.47417f
C609 i4_b1 vth_cmp 0.059f
C610 Xr/vsn Xi2/m1_640_4420# -0.00467f
C611 r0_b1 Xi2/m1_988_1168# 0.11804f
C612 r1_b1 Xi2/m1_988_1168# 0.00165f
C613 vbn_ax Xd0/m1_502_4048# 0.0012f
C614 vbp_w Xi2/g 0.5484f
C615 bias_en v0_c0 0.12663f
C616 Xg/a_1580_5314# Xr/vsp -0.06729f
C617 Xi2/m1_988_1168# r2_b4 0
C618 Xi3/m1_988_1168# Xi3/m1_988_2984# -0.00315f
C619 Xi2/g r1_b3 0.03636f
C620 i4_b1 Xg/a_7580_5314# 0.13476f
C621 i3_b1 i0_b2 0.14782f
C622 i0_b0 Xi0/g 0.29016f
C623 Xd3/m1_3600_4920# Xd3/m1_1822_4448# -0.00559f
C624 Xd3/m1_2702_4448# Xd3/m1_3342_4448# -0.0147f
C625 Xi3/a_2228_4572# i3_b2 0
C626 i0_b4 i0_b3 0.96348f
C627 Xi3/m1_988_3644# Xr/vsp -0
C628 Xd3/m1_5982_4448# v0_c1 0.07008f
C629 Xvi/m1_942_738# r2_b1 0
C630 Xvi/m1_502_738# r2_b0 0.05391f
C631 r1_b0 Xi2/m1_988_1168# 0.29826f
C632 Xm/a_420_700# ua0_stim_out -0.03266f
C633 vth_ref i0_b1 0.05136f
C634 Xi1/a_3928_4572# vbp_st 0
C635 vbn_ax Xd0/a_2984_3416# 0.0045f
C636 Xg/a_4580_5314# Xr/vsp -0.00386f
C637 Xr/m1_2542_438# Xm/iint 0.00843f
C638 Xi2/a_3078_4510# r1_b1 0.05432f
C639 Xvi/m1_502_738# Xi4/g 0.04473f
C640 r1_b1 Xd1/a_1800_3416# -0.00806f
C641 vbp_st vbn_ax 0.40511f
C642 Xi3/m1_988_3644# i1_b1 0.15121f
C643 ua0_stim_out Xi3/m1_650_4492# 0.15186f
C644 vbp_syn ua0_stim_out 0.13711f
C645 r2_b2 Xd2/a_2984_3416# 0.04172f
C646 vbn_ax Xd0/m1_1382_4048# 0.07499f
C647 i1_b4 i0_b3 0.67574f
C648 bias_en v0_c1 0.12212f
C649 i2_b0 Xr/vsp 0
C650 Xd2/a_2984_3416# vbn_prb 0
C651 Xi0/a_4132_4572# Xr/vsp 0.0262f
C652 Xd0/m1_4094_3010# vbn_ref 0.05937f
C653 ua0_stim_out Xi2/g 0.53271f
C654 i2_b3 Xi2/a_3282_4510# 0.00121f
C655 Xm/in_p r2_b3 0.17177f
C656 Xi3/a_732_4572# i1_b1 0.16291f
C657 r1_b0 Xd1/a_1800_3416# 0.003f
C658 vbp_st Xd0/a_4168_3416# 0
C659 i0_b1 i0_b2 0.38237f
C660 Xd3/a_3820_3816# v0_c1 0.0064f
C661 i4_b0 r2_b0 0.0517f
C662 vbp_st r1_b2 0.04749f
C663 Xd1/m1_2910_2650# vbn_ax 0.00323f
C664 Xg/m1_6020_10200# Xr/vsp -0.00114f
C665 i4_b0 r1_b4 0.3505f
C666 Xr/vglp Xvi/a_2102_5152# -0.02074f
C667 Xvi/a_864_6450# Xvi/a_4976_1528# -0.00859f
C668 Xi3/g ib_x2 0
C669 Xi3/g i4_b0 0.12408f
C670 Xi4/a_1378_4510# i4_b1 0.00114f
C671 Xg/a_1580_5314# vbp_st 0.14534f
C672 Xi4/g ib_x2 0.23836f
C673 vth_cmp Xd1/a_1800_3416# 0.02405f
C674 Xr/m1_782_438# Xm/iint 0.01022f
C675 i4_b0 Xi4/g 0
C676 vbn_leak el 0.01537f
C677 ua0_s0 Xd3/m1_942_4448# 0.00654f
C678 Xr/vsn Xvi/m1_1382_738# 0.52485f
C679 Xi1/a_3078_4572# vbn_ref -0
C680 Xi0/g vbn_ref 0.06262f
C681 Xd3/m1_4328_3000# v0_c2 0.07038f
C682 bias_en Xvi/a_5712_1328# 0.08441f
C683 Xi0/m1_650_4492# Xr/vgln 0
C684 vbp_st Xd0/m1_2262_4048# 0.0213f
C685 Xg/m1_3530_1930# vbn_ax 0.01001f
C686 Xi2/a_3928_4510# Xi2/a_3282_4510# -0.00437f
C687 vbp_w Xd0/m1_4094_3010# 0.08669f
C688 vdd i1_b3 0.94665f
C689 Xd2/a_4168_3416# r2_b4 0.00121f
C690 i0_b3 Xi1/m1_988_2984# 0.00333f
C691 Xr/vglp Xm/iint 0.53631f
C692 i4_b2 vth_cmp 0.33225f
C693 Xd1/m1_2910_2650# r1_b2 -0
C694 vbp_st Xg/a_4580_5314# 0.05637f
C695 Xg/m1_5022_10210# Xr/vsp 0
C696 Xi0/a_3078_4572# Xm/iint 0.23223f
C697 Xg/m1_3898_9610# r1_b3 0.00219f
C698 v0_c2 i0_b3 0.00222f
C699 Xvi/m1_8332_7080# Xvi/a_864_6450# -0.03174f
C700 Xd3/m1_3600_4920# Xm/in_p 0.12471f
C701 Xvi/a_5712_1328# vbn_leak 0
C702 Xi0/a_1582_4572# vreset_src 0.02605f
C703 vdd Xg/m1_6282_1450# -0.01029f
C704 Xg/a_7580_5314# i4_b2 0.10453f
C705 vreset_src Xi0/a_1378_4572# 0.0295f
C706 Xi3/a_528_4572# Xr/vsp 0
C707 r0_b1 r1_b1 0.10231f
C708 i0_b0 ib_x2 0.08199f
C709 Xm/in_n Xi1/a_528_4572# 0
C710 Xi0/g r1_b3 0.17716f
C711 Xi2/a_3282_4510# i2_b2 0.06882f
C712 Xr/vglp i2_b3 0
C713 Xm/in_p i3_b1 0.0397f
C714 r1_b1 r2_b4 0.2395f
C715 Xi1/g Xr/vgln 0.38069f
C716 vbn_ax Xg/a_5188_4156# 0.20592f
C717 Xr/en_b Xm/in_n 0.06447f
C718 Xi3/a_528_4572# i1_b1 0.03175f
C719 i4_b1 i2_b3 0.10693f
C720 bias_en Xr/vsn 0.04691f
C721 r0_b1 r1_b0 0.00997f
C722 Xr/vsn Xi4/m1_640_4420# -0.02193f
C723 Xi0/m1_650_4492# Xr/vsp 0.00643f
C724 Xi4/a_732_4510# vreset_src 0.054f
C725 r1_b0 r1_b1 0.47303f
C726 Xi1/g i4_b3 0.09246f
C727 Xd0/m1_1822_4048# vbn_ax 0.08065f
C728 Xd3/m1_3600_4920# v0_c3 -0.00136f
C729 vbn_leak Xvi/m1_4546_7560# 0.0907f
C730 r1_b0 r2_b4 0.59196f
C731 Xr/m1_3422_438# Xm/iint 0.00148f
C732 ua0_s0 ua0_stim 0.00326f
C733 Xr/m1_782_438# vth_ref 0.00119f
C734 Xd1/a_2984_3416# vbn_ref 0.1446f
C735 r0_b2 r0_b1 0.36376f
C736 Xr/vsn vbn_leak 0.08565f
C737 r0_b2 r1_b1 0.10733f
C738 r1_b1 Xi2/a_1582_4510# 0.04758f
C739 v0_c4 v0_c1 0.12382f
C740 r1_b1 vth_cmp 0.25647f
C741 ua0_s0 Xd3/m1_1970_3610# 0.05491f
C742 Xd3/m1_4488_3600# Xd3/a_5004_3816# -0.00881f
C743 r2_b4 vth_cmp 0.03308f
C744 el Xd0/m1_3342_4048# 0.00263f
C745 ua0_stim_out Xi0/g 0.18238f
C746 Xm/in_p i0_b1 0.05305f
C747 Xm/a_420_700# ua0 0.01181f
C748 Xi0/m1_988_2984# Xm/iint 0.13372f
C749 vth_ref Xr/vglp 0.6209f
C750 v0_c0 vdd 0.53879f
C751 Xi2/g Xg/m1_5516_1920# 0.00672f
C752 Xg/a_7580_5314# r2_b4 0.02754f
C753 Xg/m1_3666_9610# Xr/vglp -0.02179f
C754 ua0_int Xd3/a_4412_3816# 0
C755 ua0_stim_out Xi3/m1_1460_4102# 0.03404f
C756 bias_en Xd3/m1_5542_4448# 0
C757 r1_b0 vth_cmp 0.03033f
C758 i4_b0 vbn_ref 0.05731f
C759 vbn_ref ib_x2 0
C760 ua0_s0 Xm/a_1764_11418# 0.00828f
C761 Xg/a_4580_5314# Xg/a_5188_4156# -0.00628f
C762 Xi3/m1_988_1168# i0_b4 0.0326f
C763 Xd3/m1_4648_4446# v0_c1 0.14052f
C764 Xi1/g Xr/vsp 0.34069f
C765 Xr/vglp i2_b2 0.0736f
C766 r2_b2 vbn_prb 0.00342f
C767 Xi1/m1_988_1168# Xi1/g -0.12277f
C768 ua0_int Xm/a_2240_11218# -0.05365f
C769 Xm/in_n Xg/m1_5516_1920# 0.075f
C770 r0_b2 Xi2/a_1582_4510# 0
C771 Xd1/a_2984_3416# r1_b3 -0.03165f
C772 Xi2/g r2_b3 0.03394f
C773 r1_b1 Xi2/a_1378_4510# 0.04518f
C774 vreset_src Xi0/g 0.08298f
C775 vdd Xi3/m1_988_2984# 0.16885f
C776 Xi0/m1_988_3644# vreset_src 0
C777 r2_b0 vbn_ax 0.03991f
C778 vbn_ax r1_b4 0.02153f
C779 i4_b1 i2_b2 0.08906f
C780 i0_b2 Xr/vglp 0.24763f
C781 Xi3/g vbn_ax 0.14431f
C782 Xi2/a_3078_4510# i2_b3 0
C783 i1_b2 i1_b3 0.31133f
C784 Xr/vglp Xvi/a_4976_1528# -0.00896f
C785 Xi1/m1_988_3644# Xi1/m1_1460_4102# -0.00552f
C786 r2_b1 el 0.0722f
C787 bias_en i0_b4 0.14654f
C788 Xvi/m1_8042_6360# i4_b4 0
C789 vbn_ax Xi4/g 0.08376f
C790 Xr/vsn Xi4/m1_988_3644# -0.01246f
C791 Xi0/g Xi0/m1_1460_4102# 0.0049f
C792 Xm/in_n r2_b3 0.0102f
C793 vdd v0_c1 0.3358f
C794 Xd1/m1_942_4048# vbn_prb 0.07565f
C795 Xd1/m1_3492_2640# el 0.01405f
C796 Xi3/m1_988_1168# i1_b4 0.00481f
C797 r2_b1 Xi4/m1_988_1168# 0.32918f
C798 el vdd 0.06874f
C799 r2_b0 Xi4/m1_988_2984# 0.01292f
C800 i4_b0 vbp_w 0.09887f
C801 Xi3/a_4132_4572# i1_b3 0
C802 Xd3/m1_1382_4448# vdd 0.20519f
C803 r1_b1 Xd0/a_1800_3416# 0.07616f
C804 r0_b1 Xd0/a_1800_3416# -0.00763f
C805 i4_b0 r1_b3 0.87433f
C806 Xg/a_5188_4156# Xg/m1_6020_10200# -0.00171f
C807 i1_b3 Xr/vgln 0.27124f
C808 r2_b0 r1_b2 0.18566f
C809 i4_b2 i2_b3 0.06103f
C810 Xd1/a_3576_3416# r2_b2 0.04499f
C811 r1_b4 r1_b2 0.39613f
C812 Xi4/m1_988_2984# Xi4/g -0.02849f
C813 Xm/a_2240_11218# Xm/iint 0.02053f
C814 r2_b0 Xg/a_1580_5314# 0.00474f
C815 Xi3/g r1_b2 0.04632f
C816 v0_c3 ua0_s1 0.02965f
C817 Xg/a_1580_5314# r1_b4 0.12918f
C818 Xi2/m1_988_2984# vdd -0.00236f
C819 Xvi/m1_8332_7080# Xr/vglp -0
C820 Xi3/g Xg/a_1580_5314# -0.00196f
C821 r2_b0 r0_b3 0.20738f
C822 r0_b3 r1_b4 0
C823 Xg/m1_6282_1450# Xr/vgln -0
C824 ib_r1 Xvi/a_5712_1328# 0.27631f
C825 r2_b2 Xd2/m1_2156_3240# 0
C826 Xg/a_1580_5314# Xi4/g -0
C827 i0_b2 Xi1/a_1582_4572# 0.00277f
C828 Xd2/m1_2156_3240# vbn_prb 0.04681f
C829 Xi4/a_732_4510# r2_b3 0.00129f
C830 Xvi/a_5712_1328# vdd -0.01607f
C831 i3_b4 i3_b2 0
C832 Xd0/a_3576_3416# vbn_ax 0.00468f
C833 Xi3/g Xi3/m1_988_3644# -0.01937f
C834 vbn_ax i0_b0 0.36667f
C835 vbn_ax Xd1/a_2392_3416# 0.01386f
C836 Xi1/g vbp_st 0.14366f
C837 ua0_s0 ua0_stim_out 0.29459f
C838 Xg/m1_5022_10210# Xg/a_5188_4156# -0
C839 Xvi/m1_502_738# vreset_src 0.00333f
C840 Xm/in_n Xi1/m1_1460_4102# 0.01512f
C841 i4_b3 Xg/m1_6282_1450# 0.18075f
C842 Xi3/g Xg/a_4580_5314# 0.00204f
C843 vbn_ax Xg/m1_3298_2050# 0.01302f
C844 Xd0/m1_4222_4048# vth_cmp 0
C845 v0_c2 Xd3/m1_5982_4448# 0.08812f
C846 ua0_stim_out ib_x2 0.24546f
C847 i4_b0 ua0_stim_out 0.07993f
C848 i3_b1 i3_b0 0.00606f
C849 Xi2/a_3078_4510# i2_b2 0.03623f
C850 r1_b4 i2_b0 0.06189f
C851 r2_b0 i2_b0 0.03746f
C852 vth_ref i4_b2 0.00932f
C853 ua0_s0 Xd3/a_2636_3816# 0.10546f
C854 Xd1/a_2392_3416# r1_b2 0
C855 i1_b3 Xr/vsp 0.28396f
C856 r2_b2 Xi2/m1_640_4420# 0.02125f
C857 Xvi/m1_4546_7560# vdd -0.00127f
C858 Xr/m1_342_438# Xm/iint 0.0559f
C859 r2_b1 Xr/vsn 0.39911f
C860 r0_b1 i2_b3 0.03705f
C861 vreset_src Xi0/a_2432_4572# 0.02859f
C862 Xi3/a_3928_4572# i1_b3 0
C863 r1_b1 i2_b3 0.0536f
C864 bias_en v0_c2 0.45368f
C865 r1_b4 Xg/m1_6020_10200# 0.01855f
C866 i4_b2 i2_b2 0.0801f
C867 r2_b4 i2_b3 0.03201f
C868 Xr/vsn vdd 1.33038f
C869 i2_b1 r2_b2 0.08211f
C870 Xi3/g Xg/m1_6020_10200# -0.00105f
C871 i4_b0 vreset_src 0.0043f
C872 vreset_src ib_x2 0.19824f
C873 r2_b2 r0_b0 0.73272f
C874 i1_b3 i1_b1 0.00278f
C875 Xm/a_420_700# ua0_s1 0.16891f
C876 Xi2/g i0_b1 0
C877 ua0_s0 Xr/en_b 0.11924f
C878 i0_b2 Xi1/a_1378_4572# 0.00407f
C879 Xm/in_p Xr/vglp 0.20617f
C880 r1_b0 i2_b3 0.02833f
C881 Xd3/a_3228_3816# Xd3/a_2636_3816# -0.00193f
C882 i1_b2 Xi3/m1_988_2984# 0.06391f
C883 v0_c2 Xd3/a_3820_3816# 0.08094f
C884 Xd2/m1_1822_4048# vbn_prb 0.04373f
C885 i4_b2 Xvi/a_4976_1528# 0.02521f
C886 vbn_ax vbn_ref 0.51257f
C887 i0_b1 i3_b0 0.09271f
C888 i4_b1 Xi4/a_1582_4510# 0.00277f
C889 i0_b1 Xm/in_n 0.04426f
C890 vbn_ax Xd0/m1_942_4048# 0.01724f
C891 Xg/m1_5022_10210# r1_b4 0.0149f
C892 r0_b1 Xi2/a_3928_4510# 0
C893 Xi2/a_3928_4510# r1_b1 0.09025f
C894 Xm/in_p i4_b1 0.04156f
C895 r0_b2 i2_b3 0
C896 i3_b2 i0_b2 0.01346f
C897 Xi1/g Xg/a_5188_4156# 0.3395f
C898 r1_b2 vbn_ref 0.07623f
C899 Xi1/a_3078_4572# Xi1/m1_1460_4102# -0
C900 Xg/a_1580_5314# vbn_ref 0.04067f
C901 vbp_st i1_b3 0.0638f
C902 Xg/m1_3666_9610# r2_b4 0.115f
C903 el Xr/vgln 0.04149f
C904 vbp_w vbn_ax 0.27653f
C905 i4_b0 Xi4/a_528_4510# 0
C906 vbn_ax r1_b3 0.19624f
C907 r0_b1 i2_b2 0.05238f
C908 Xd0/m1_2262_4048# vbn_ref 0
C909 vth_ref Xr/m1_342_438# 0.29046f
C910 r1_b1 i2_b2 0.12017f
C911 Xvi/m1_1382_738# vbn_prb 0.01566f
C912 r2_b4 i2_b2 0.03812f
C913 Xvi/m1_502_738# r2_b3 0
C914 Xg/m1_3666_9610# r1_b0 0.0032f
C915 i4_b3 el 0.19085f
C916 ib_r1 i0_b4 0.00145f
C917 ua0_int Xm/iint 0.00421f
C918 Xi2/m1_988_2984# Xr/vgln 0.00174f
C919 vbp_syn Xi2/a_3282_4510# -0.00152f
C920 r2_b2 Xi2/a_2228_4510# 0.04476f
C921 Xg/a_4580_5314# vbn_ref 0.02942f
C922 vdd i0_b4 0.73284f
C923 vbp_w Xi4/m1_988_2984# -0.00969f
C924 vbp_w Xd0/a_4168_3416# 0.07708f
C925 vth_ref vth_cmp 0.25997f
C926 bias_en Xm/a_736_5516# 0.00645f
C927 vbp_syn Xi2/a_732_4510# 0.03048f
C928 Xvi/a_5712_1328# Xr/vgln 0.06611f
C929 vbp_w r1_b2 0.0962f
C930 r1_b0 i2_b2 0.03592f
C931 Xg/m1_4538_1930# Xr/vgln -0.00829f
C932 r1_b3 r1_b2 0.31478f
C933 Xi3/a_528_4572# i0_b0 0
C934 i4_b4 i1_b0 0.0045f
C935 ua0_s0 ua0 0.02638f
C936 Xg/a_1580_5314# r1_b3 0.29793f
C937 Xi3/m1_988_2984# Xr/vsp -0.04967f
C938 Xvi/m1_7440_2050# Xr/vglp 0
C939 r0_b3 vbp_w 0.00482f
C940 Xd3/m1_3342_4448# Xm/in_p 0
C941 Xi2/a_1582_4510# i2_b2 0
C942 r0_b2 i2_b2 0
C943 vbp_w Xd0/m1_2262_4048# 0.07251f
C944 Xg/m1_4906_9490# Xr/vglp -0.02191f
C945 bias_en Xvi/m1_7102_850# 0.04652f
C946 i4_b3 Xg/m1_4538_1930# 0.00208f
C947 ua0_stim_out vbn_ax 0.11172f
C948 vbn_ax Xd1/a_4168_3416# 0.08183f
C949 i1_b4 vdd 0.40238f
C950 v0_c4 v0_c2 0
C951 bias_en Xvi/m1_8042_6360# 0
C952 Xi2/g Xg/m1_4760_1320# 0.00455f
C953 r2_b2 Xi2/m1_1500_4102# 0.00345f
C954 i4_b0 r2_b3 0.03877f
C955 Xi1/g r2_b0 0.00437f
C956 Xi3/m1_988_2984# i1_b1 0.1121f
C957 i2_b1 r0_b0 0
C958 bias_en vbn_prb 0.30929f
C959 Xi1/m1_988_3644# Xr/vglp 0.13585f
C960 Xg/a_4580_5314# r1_b3 0.00397f
C961 Xi1/g r1_b4 0.50389f
C962 Xm/in_p Xi3/a_2228_4572# 0
C963 Xm/in_p i4_b2 0.0434f
C964 Xvi/a_4976_1528# vth_cmp 0
C965 i0_b1 Xi0/g 0.0039f
C966 Xi1/g Xi3/g 0.42611f
C967 vbn_prb Xi4/m1_640_4420# 0
C968 Xvi/a_864_6450# Xi0/g 0.00142f
C969 Xvi/m1_4546_7560# Xr/vgln 0.04037f
C970 Xd0/m1_2760_3412# vbn_ax 0.07718f
C971 ua0_stim_out Xd0/a_4168_3416# 0.03119f
C972 bias_en Xd3/m1_4328_3000# 0.11506f
C973 Xm/in_n Xg/m1_4760_1320# 0.06185f
C974 r2_b2 Xd2/a_2392_3416# 0.03521f
C975 ua0_stim_out r1_b2 0.25267f
C976 Xd3/m1_4648_4446# v0_c2 0
C977 Xvi/m1_8042_6360# vbn_leak 0.2092f
C978 Xr/vsn Xr/vgln 2.3652f
C979 Xi2/a_1378_4510# i2_b2 0
C980 i2_b4 r2_b2 0.04266f
C981 r1_b3 i2_b0 0.06367f
C982 Xd2/a_2392_3416# vbn_prb 0.01132f
C983 r2_b2 vbn_leak 0.13757f
C984 Xg/a_1580_5314# ua0_stim_out 0.22702f
C985 vbn_leak vbn_prb 0.07343f
C986 ua0_s0 Xd3/m1_3600_4920# 0.05742f
C987 ua0_stim v0_c5 0.00457f
C988 r2_b2 Xi2/a_2432_4510# 0.04239f
C989 r0_b3 ua0_stim_out 0.12173f
C990 bias_en i0_b3 0.02689f
C991 el Xd0/m1_502_4048# 0.00188f
C992 Xi2/g Xr/vglp 0.06136f
C993 Xm/in_p i3_b2 0.05545f
C994 i4_b3 Xr/vsn 0.33277f
C995 vdd Xi1/m1_988_2984# 0.07616f
C996 r2_b1 Xg/a_3036_4156# 0.01516f
C997 Xi2/a_4132_4510# r1_b1 0.06449f
C998 Xi2/a_4132_4510# r0_b1 0
C999 Xvi/m1_942_738# r2_b0 0
C1000 Xi0/a_3282_4572# i0_b3 0.00293f
C1001 ua0_stim_out Xi3/m1_988_3644# 0.02284f
C1002 Xi4/m1_988_2984# vreset_src 0.01294f
C1003 r1_b3 Xg/m1_6020_10200# 0.00377f
C1004 i2_b4 i4_b4 0.11816f
C1005 v0_c2 vdd 0.28672f
C1006 ua0_stim_out Xg/a_4580_5314# 0.093f
C1007 Xg/a_3036_4156# vdd -0.01773f
C1008 Xd1/m1_942_4048# vbn_leak 0.01091f
C1009 i4_b4 vbn_leak 0.29325f
C1010 i4_b1 Xi2/g 0.15086f
C1011 Xvi/m1_942_738# Xi4/g 0.04437f
C1012 Xm/in_n Xr/vglp 0.23966f
C1013 Xd3/m1_2702_4448# Xm/in_p 0.00925f
C1014 Xi4/m1_988_3644# Xi4/m1_1500_4102# -0
C1015 Xi1/g i0_b0 0.07461f
C1016 Xd3/m1_3600_4920# Xd3/a_3228_3816# -0.0047f
C1017 ua0_stim_out Xi3/a_732_4572# 0
C1018 i4_b1 Xm/in_n 0
C1019 vbp_st el 0.03839f
C1020 Xd3/a_4412_3816# v0_c3 0.07807f
C1021 i2_b1 Xi2/a_2228_4510# 0.00223f
C1022 Xm/in_p r1_b1 0.12911f
C1023 Xg/m1_5022_10210# r1_b3 0.02558f
C1024 r0_b2 Xi2/a_4132_4510# 0
C1025 vth_ref Xm/iint 0.17753f
C1026 Xr/m1_1222_3522# Xr/vgln -0
C1027 Xm/in_p r2_b4 0.04195f
C1028 el Xd0/m1_1382_4048# 0.00207f
C1029 Xr/vsn Xr/vsp 0.15913f
C1030 Xvi/m1_8646_1098# Xvi/a_864_6450# -0.00369f
C1031 Xi1/m1_988_1168# Xr/vsn 0.0488f
C1032 Xvi/a_4976_1528# Xvi/a_2102_5152# -0.01745f
C1033 Xd3/a_2044_3816# v0_c0 0.18352f
C1034 Xi2/g Xi2/m1_988_1168# -0.17789f
C1035 Xd2/a_3576_3416# r2_b4 0.00471f
C1036 Xm/in_p r1_b0 0.21143f
C1037 Xd1/m1_2910_2650# el 0.0412f
C1038 Xi3/a_4132_4572# i0_b4 0.00394f
C1039 Xi0/a_4132_4572# vreset_src 0
C1040 i0_b4 Xr/vgln 0.2105f
C1041 vreset_src Xi0/a_732_4572# 0.02883f
C1042 Xi3/g i1_b3 0.56624f
C1043 Xd3/m1_4488_3600# v0_c0 0.0052f
C1044 i3_b2 i3_b3 0.00532f
C1045 Xr/m1_3422_438# Xm/in_n 0.06957f
C1046 i0_b2 Xm/iint 0.00707f
C1047 i0_b1 ib_x2 0.08363f
C1048 vbn_ax Xg/m1_5516_1920# 0.00884f
C1049 Xvi/a_864_6450# ib_x2 0.28749f
C1050 r2_b2 Xd0/m1_3342_4048# 0
C1051 ua0_s0 ua0_s1 0.03001f
C1052 vbn_prb Xd0/m1_3342_4048# 0.04441f
C1053 Xi1/g vbn_ref 0.05813f
C1054 Xi3/a_1378_4572# i0_b2 0
C1055 i2_b3 i2_b2 0.11285f
C1056 Xg/m1_3898_9610# Xr/vglp -0.00158f
C1057 Xi3/a_4132_4572# i1_b4 0
C1058 i1_b4 Xr/vgln 0.22095f
C1059 Xd3/a_2044_3816# v0_c1 0
C1060 ua0_stim_out Xi3/a_528_4572# 0
C1061 vbn_ax r2_b3 0.03821f
C1062 Xr/m1_1222_3522# Xr/vsp 0.04527f
C1063 i2_b4 i2_b1 0.01974f
C1064 i2_b1 Xi2/a_2432_4510# 0
C1065 i2_b4 r0_b0 0
C1066 Xi2/g i4_b2 0.2522f
C1067 Xd3/m1_1382_4448# Xd3/a_2044_3816# -0.0031f
C1068 Xi1/a_3078_4572# Xr/vglp 0
C1069 Xr/vsn vbp_st 0.65626f
C1070 Xr/vglp Xi0/g 0.83869f
C1071 Xd3/m1_4488_3600# v0_c1 0.06239f
C1072 Xvi/m1_7102_850# ib_r1 0.07184f
C1073 Xi4/m1_988_2984# r2_b3 0.11957f
C1074 Xi0/a_3078_4572# Xi0/g -0
C1075 Xvi/m1_7102_850# vdd 0
C1076 Xi2/a_3928_4510# i2_b2 0.04665f
C1077 r2_b2 r2_b1 0.15314f
C1078 i0_b4 Xr/vsp 0.9567f
C1079 r2_b1 vbn_prb 0.90431f
C1080 Xvi/m1_8042_6360# vdd 0.03572f
C1081 r2_b2 Xd1/m1_3492_2640# 0.00492f
C1082 i4_b2 Xm/in_n 0.03802f
C1083 r2_b3 r1_b2 0.06036f
C1084 Xm/in_p Xi3/a_1582_4572# 0
C1085 Xi1/g r1_b3 0.38211f
C1086 ib_r1 vbn_prb 0.10622f
C1087 Xi1/m1_988_1168# i0_b4 0.08218f
C1088 Xg/a_1580_5314# r2_b3 0.11496f
C1089 Xg/m1_4906_9490# r2_b4 0.00222f
C1090 r2_b2 Xi2/a_528_4510# 0.02087f
C1091 r2_b2 vdd 2.09941f
C1092 i4_b1 Xi0/g 0.7141f
C1093 Xi3/a_3928_4572# i0_b4 0.00274f
C1094 vbn_prb vdd 0.14241f
C1095 Xd1/m1_3492_2640# vbn_prb 0.02983f
C1096 bias_en Xvi/m1_1382_738# -0.06792f
C1097 Xi1/m1_988_2984# Xr/vgln 0.06982f
C1098 Xd3/m1_4328_3000# vdd 0
C1099 r2_b2 r0_b4 0.13209f
C1100 Xvi/m1_4894_1238# ib_x2 0.0015f
C1101 r2_b1 i4_b4 0.07723f
C1102 vth_ref i0_b2 0.07579f
C1103 i1_b4 Xr/vsp 0.47231f
C1104 Xi0/m1_650_4492# vreset_src 0
C1105 i4_b4 vdd 0.28409f
C1106 vbn_ax i3_b1 0
C1107 vbp_syn r0_b1 0.16223f
C1108 vbp_syn r1_b1 0.54447f
C1109 Xi3/a_3928_4572# i1_b4 0
C1110 Xd2/m1_942_4048# vbn_prb 0.04939f
C1111 Xr/vsn Xg/m1_3530_1930# 0.08403f
C1112 bias_en Xd3/m1_5982_4448# 0
C1113 vdd i0_b3 0.36123f
C1114 Xd2/m1_3982_4048# vth_cmp 0.00464f
C1115 vbp_syn r2_b4 0
C1116 i2_b4 i1_b0 0
C1117 Xi1/g ua0_stim_out 0.14275f
C1118 r0_b1 Xi2/g 0.77499f
C1119 Xd1/a_3576_3416# vdd -0.00355f
C1120 r1_b1 Xi2/g 0.0028f
C1121 r2_b3 i2_b0 0.04806f
C1122 Xi2/g r2_b4 0.18306f
C1123 Xi2/a_2432_4510# Xi2/a_2228_4510# -0
C1124 Xi2/a_4132_4510# i2_b3 0
C1125 Xi3/g Xi3/m1_988_2984# -0.19163f
C1126 Xm/in_p Xm/iint 0.03952f
C1127 vbp_syn r1_b0 0.23301f
C1128 ua0_int v0_c3 0.06756f
C1129 Xvi/m1_8332_7080# vth_ref -0.00547f
C1130 Xvi/m1_8646_1098# Xr/vglp 0.01502f
C1131 Xi0/m1_988_2984# Xi0/g -0.01007f
C1132 Xi0/m1_988_2984# Xi0/m1_988_3644# -0.00242f
C1133 vbp_st i0_b4 0.05869f
C1134 Xd0/m1_3342_4048# r0_b0 0
C1135 Xm/in_p Xi3/a_1378_4572# 0
C1136 r2_b0 el 0.02781f
C1137 Xi1/m1_988_2984# Xr/vsp -0.03101f
C1138 r1_b0 Xi2/g 0.56384f
C1139 r0_b2 vbp_syn 0.04968f
C1140 bias_en Xi0/a_3282_4572# 0.05774f
C1141 vbn_ref Xg/m1_6282_1450# 0
C1142 vbp_syn vth_cmp 0.04685f
C1143 Xi1/g vreset_src 0.00478f
C1144 i3_b4 Xm/in_p 0.19763f
C1145 r2_b0 Xi4/m1_988_1168# 0.46643f
C1146 el Xi4/g 0.08003f
C1147 Xr/vsn Xg/a_5188_4156# -0.05833f
C1148 vbn_ax i0_b1 0.33614f
C1149 Xm/in_p i2_b3 0.56318f
C1150 Xg/a_3036_4156# Xr/vsp -0
C1151 bias_en Xd3/a_3820_3816# 0.18402f
C1152 Xi2/a_4132_4510# Xi2/a_3928_4510# -0.00209f
C1153 Xr/m1_342_438# Xm/in_n 0.04414f
C1154 Xi2/m1_988_2984# r1_b4 0
C1155 bias_en vbn_leak 0.10045f
C1156 Xi4/m1_988_1168# Xi4/g 0.01691f
C1157 Xr/vglp ib_x2 1.02344f
C1158 r2_b2 Xd0/a_2392_3416# 0.04828f
C1159 i4_b0 Xr/vglp 0.32679f
C1160 Xi2/g Xg/a_7580_5314# -0.00846f
C1161 vbp_st i1_b4 0.0863f
C1162 i4_b2 Xi0/g 0.47406f
C1163 i3_b4 Xi3/a_3078_4572# 0
C1164 vdd Xi2/m1_640_4420# 0
C1165 Xm/in_n vth_cmp 0
C1166 Xd3/m1_942_4448# Xd3/m1_1382_4448# -0.12608f
C1167 i4_b0 i4_b1 0.61002f
C1168 i2_b1 r2_b1 0.0562f
C1169 vbn_ref Xd1/m1_3782_4048# 0.04772f
C1170 Xvi/a_5712_1328# Xi4/g 0.09975f
C1171 Xd1/m1_3662_2290# Xd1/a_2984_3416# -0.00312f
C1172 vbp_syn Xi2/a_1378_4510# 0
C1173 Xg/a_7580_5314# Xm/in_n 0
C1174 Xi4/g Xg/m1_4538_1930# -0.00738f
C1175 i2_b1 vdd 0.59034f
C1176 Xvi/m1_942_738# vreset_src 0.00448f
C1177 Xd3/m1_4488_3600# Xd3/m1_5542_4448# -0
C1178 Xi2/a_4132_4510# i2_b2 0.05889f
C1179 Xr/vgln Xi4/m1_1500_4102# 0
C1180 vdd r0_b0 0.43514f
C1181 el Xd1/a_2392_3416# 0.11386f
C1182 i0_b0 el 0
C1183 ua0_int Xm/a_420_700# 0.06289f
C1184 ua0_stim v0_c0 0.06954f
C1185 Xvi/m1_7102_850# Xr/vgln 0.0474f
C1186 v0_c0 Xd3/m1_1970_3610# 0.191f
C1187 i2_b1 r0_b4 0.58881f
C1188 r1_b1 Xd0/m1_4094_3010# 0.01326f
C1189 vth_ref Xm/in_p 0.40276f
C1190 r0_b4 r0_b0 0.20056f
C1191 Xvi/m1_7440_2050# Xm/iint 0.0033f
C1192 ua0_stim_out i1_b3 0.0979f
C1193 r2_b2 Xr/vgln 0.04012f
C1194 Xg/m1_3898_9610# r2_b4 0.05087f
C1195 Xd3/a_5004_3816# ua0_s1 0.00758f
C1196 i3_b4 i3_b3 0.03644f
C1197 vbn_prb Xr/vgln 0.04126f
C1198 r2_b0 Xr/vsn 0.2534f
C1199 Xvi/m1_4546_7560# Xi4/g 0.00335f
C1200 Xr/vsn r1_b4 0.23425f
C1201 Xi4/m1_988_3644# Xi4/m1_640_4420# -0.00186f
C1202 Xi3/g Xr/vsn -0.00692f
C1203 Xg/a_3036_4156# vbp_st 0.26981f
C1204 Xm/in_p i2_b2 0.65631f
C1205 i1_b2 i0_b3 0
C1206 bias_en Xi0/a_528_4572# 0.06029f
C1207 Xg/m1_3898_9610# r1_b0 0
C1208 Xr/vsn Xi4/g 1.10636f
C1209 ua0_s0 Xd3/m1_3342_4448# 0.07483f
C1210 Xm/in_p i0_b2 0.32414f
C1211 i4_b4 Xr/vgln 0.1087f
C1212 Xm/a_420_700# Xm/iint 0.0528f
C1213 ua0_stim v0_c1 0
C1214 Xi1/m1_650_4492# Xr/vglp 0.07809f
C1215 Xd0/m1_4094_3010# vth_cmp 0
C1216 Xd3/m1_1970_3610# v0_c1 0.01386f
C1217 Xi3/a_4132_4572# i0_b3 0
C1218 bias_en v0_c4 0.17498f
C1219 i0_b3 Xr/vgln 0.24007f
C1220 vbn_leak Xi0/a_528_4572# 0
C1221 i4_b3 i4_b4 0.71559f
C1222 Xi1/g r2_b3 0.13533f
C1223 vbn_ax Xg/m1_4760_1320# 0.00794f
C1224 Xd3/m1_1822_4448# Xm/in_p 0.08491f
C1225 el vbn_ref 0.16787f
C1226 i1_b0 vdd 0.20109f
C1227 ua0_stim_out Xi2/m1_988_3644# 0.01135f
C1228 vdd Xi2/a_2228_4510# 0.19227f
C1229 el Xd0/m1_942_4048# 0.00188f
C1230 Xd3/m1_3342_4448# Xd3/a_3228_3816# -0.00356f
C1231 v0_c4 Xd3/a_3820_3816# -0.01282f
C1232 i4_b0 i4_b2 0
C1233 Xvi/m1_1276_6360# el -0
C1234 r0_b3 Xi2/a_3282_4510# 0.00631f
C1235 r2_b2 Xr/vsp 0
C1236 Xr/vsn i0_b0 0.044f
C1237 Xd3/m1_4648_4446# bias_en 0
C1238 ua0_s0 Xd3/a_4412_3816# 0.00541f
C1239 Xi3/m1_988_1168# vdd 0.27933f
C1240 Xd0/a_2392_3416# r0_b0 0.04255f
C1241 Xg/a_7580_5314# Xi0/g 0.03182f
C1242 r0_b3 Xi2/a_732_4510# 0.00348f
C1243 vbp_syn i2_b3 -0.00384f
C1244 Xi1/a_3928_4572# Xr/vglp 0
C1245 Xm/in_n Xm/iint 0.17163f
C1246 Xi0/a_1582_4572# Xm/iint 0.00778f
C1247 Xm/a_736_7228# Xm/a_736_5516# -0.04981f
C1248 Xr/vsn Xg/m1_3298_2050# 0.05461f
C1249 Xm/a_2240_11218# ua0_s0 0
C1250 Xi0/a_1378_4572# Xm/iint 0.00682f
C1251 vbn_ref Xg/m1_4538_1930# 0
C1252 v0_c2 Xd3/a_2044_3816# 0.00124f
C1253 Xi3/a_528_4572# i0_b1 0.00286f
C1254 vbp_w el 0.03406f
C1255 Xvi/m1_942_738# r2_b3 0
C1256 vbn_ax Xr/vglp 0.08613f
C1257 i4_b4 Xr/vsp 0.06284f
C1258 v0_c0 ua0_stim_out 0.16542f
C1259 Xm/in_p Xi3/a_3282_4572# 0
C1260 bias_en ib_r1 0.23698f
C1261 el r1_b3 0
C1262 r2_b1 Xi4/m1_640_4420# 0.09955f
C1263 Xd1/a_2984_3416# r1_b1 0.04226f
C1264 Xi1/g Xi1/m1_1460_4102# -0.01367f
C1265 ua0_s0 Xd3/m1_2702_4448# 0.04416f
C1266 bias_en vdd 3.45952f
C1267 Xi3/g i0_b4 0.01936f
C1268 ib_r1 Xi0/a_3282_4572# 0
C1269 i0_b3 Xr/vsp 0.49229f
C1270 Xd3/m1_4488_3600# v0_c2 0.06176f
C1271 vdd Xi4/m1_640_4420# -0
C1272 Xi0/a_3282_4572# vdd 0.01793f
C1273 vbn_prb Xd0/m1_502_4048# 0.04769f
C1274 Xi2/m1_640_4420# Xr/vgln 0.03078f
C1275 vdd Xi4/a_3078_4510# 0.00124f
C1276 Xi1/m1_988_1168# i0_b3 0.27678f
C1277 vbn_ax i4_b1 0.3282f
C1278 Xg/a_3036_4156# Xg/a_5188_4156# -0
C1279 Xg/m1_4906_9490# i2_b2 0
C1280 Xi3/a_3928_4572# i0_b3 0
C1281 i2_b4 r2_b1 0.08358f
C1282 v0_c5 ua0_s1 0.36464f
C1283 r2_b1 vbn_leak 0.09076f
C1284 Xd3/a_3820_3816# vdd -0.00622f
C1285 Xi2/a_732_4510# i2_b0 0
C1286 Xd2/a_2392_3416# vdd -0.00934f
C1287 ib_r1 vbn_leak 0.00652f
C1288 Xd1/m1_3492_2640# vbn_leak 0
C1289 vbn_leak vdd 2.44752f
C1290 v0_c0 Xd3/a_2636_3816# 0.36398f
C1291 ua0_stim_out Xi3/m1_988_2984# 0.29725f
C1292 Xr/vglp r1_b2 0.74891f
C1293 i2_b1 Xr/vgln 0.17493f
C1294 i2_b4 vdd 0.59781f
C1295 r2_b2 Xd0/a_2984_3416# 0.03427f
C1296 vdd Xi2/a_2432_4510# 0.01386f
C1297 Xr/vgln r0_b0 0.00258f
C1298 Xg/a_1580_5314# Xr/vglp 0.32636f
C1299 Xi3/g i1_b4 0.08225f
C1300 Xm/a_1744_9182# ua0_s1 0.05933f
C1301 Xd3/m1_2702_4448# Xd3/a_3228_3816# -0.00954f
C1302 Xvi/m1_1276_6360# Xvi/m1_4546_7560# -0.0071f
C1303 Xr/vsn vbn_ref 0.56954f
C1304 r2_b2 vbp_st 0.05427f
C1305 i4_b0 r2_b4 0.43002f
C1306 vth_ref Xi2/g 0
C1307 Xd1/a_2984_3416# vth_cmp 0
C1308 i0_b2 Xi1/m1_988_3644# 0.13742f
C1309 i2_b4 r0_b4 0
C1310 vbp_st vbn_prb 0.3194f
C1311 Xg/a_1580_5314# i4_b1 0.09677f
C1312 r0_b4 Xi2/a_2432_4510# 0
C1313 Xd1/m1_3662_2290# vbn_ax 0.02533f
C1314 Xvi/m1_1276_6360# Xr/vsn 0.12466f
C1315 vbp_syn i2_b2 0
C1316 Xg/a_4580_5314# Xr/vglp 0.1403f
C1317 vbn_prb Xd0/m1_1382_4048# 0.05036f
C1318 Xr/m1_342_438# ib_x2 0.63984f
C1319 Xd3/m1_1382_4448# ua0_stim_out 0.04564f
C1320 i4_b0 r1_b0 0
C1321 vth_ref Xm/in_n 0.09441f
C1322 ua0_stim_out Xi2/m1_988_2984# 0.18629f
C1323 Xi3/m1_650_4492# i0_b2 0.01092f
C1324 Xi2/g i2_b2 0
C1325 r2_b2 Xd2/a_1800_3416# 0
C1326 i4_b4 vbp_st 0.05078f
C1327 Xd2/a_1800_3416# vbn_prb 0.28083f
C1328 Xd3/a_2636_3816# v0_c1 0.0415f
C1329 i4_b1 Xg/a_4580_5314# 0.13807f
C1330 Xm/in_p Xi3/a_3078_4572# 0
C1331 Xi3/a_3282_4572# i3_b3 0
C1332 r2_b2 Xd1/m1_2910_2650# 0.01036f
C1333 Xi1/g i0_b1 0.07814f
C1334 i4_b0 vth_cmp 0.31812f
C1335 Xd1/m1_2910_2650# vbn_prb 0.00307f
C1336 vbp_st i0_b3 0.20616f
C1337 Xr/vsn vbp_w -0.01671f
C1338 Xi0/a_4132_4572# Xr/vglp 0
C1339 el vreset_src 0.58585f
C1340 Xi0/m1_988_3644# Xm/iint 0.17451f
C1341 Xi0/g Xm/iint 0.72242f
C1342 Xr/vsn r1_b3 0.14179f
C1343 Xi2/m1_988_1168# r1_b2 0.52172f
C1344 Xi4/m1_988_3644# vdd -0
C1345 Xg/a_3036_4156# r1_b4 0.02812f
C1346 i2_b1 Xr/vsp 0
C1347 Xi4/m1_988_1168# vreset_src 0.02607f
C1348 Xi3/g Xg/a_3036_4156# -0.00818f
C1349 i4_b0 Xg/a_7580_5314# 0.0217f
C1350 Xm/in_p v0_c3 0.02684f
C1351 i0_b2 i3_b0 0.24611f
C1352 i0_b2 Xm/in_n 0.08581f
C1353 r0_b3 Xi2/m1_988_1168# 0.04764f
C1354 Xr/vglp Xg/m1_6020_10200# -0.02252f
C1355 Xi0/a_528_4572# vdd 0.03306f
C1356 Xi3/m1_988_1168# i1_b2 0.13004f
C1357 Xi2/a_2228_4510# Xr/vgln 0.00191f
C1358 Xvi/a_5712_1328# vreset_src 0
C1359 vbn_ax i4_b2 0.31971f
C1360 Xi0/g i2_b3 0
C1361 i4_b1 Xg/m1_6020_10200# 0
C1362 el Xd1/m1_2318_2410# 0.10335f
C1363 Xd1/a_3576_3416# Xd1/m1_2910_2650# -0
C1364 Xd3/m1_1382_4448# Xr/en_b 0
C1365 Xi3/m1_988_1168# Xr/vgln 0
C1366 v0_c4 vdd 0.19796f
C1367 Xm/in_p i3_b3 0.18627f
C1368 vbn_ref i0_b4 0.00264f
C1369 r0_b3 Xi2/a_3078_4510# 0.00948f
C1370 Xg/m1_5022_10210# Xr/vglp -0.00538f
C1371 ua0_int ua0_s0 0.00232f
C1372 Xr/vsn ua0_stim_out 0.23069f
C1373 Xi3/a_3078_4572# i3_b3 0
C1374 bias_en Xr/vgln 0.9325f
C1375 Xg/a_1580_5314# i4_b2 0.0534f
C1376 Xi2/a_4132_4510# vbp_syn -0
C1377 Xi0/a_3282_4572# Xr/vgln 0.00137f
C1378 el Xvi/m1_5388_6960# -0
C1379 Xvi/m1_4546_7560# vreset_src 0.26134f
C1380 Xd0/m1_1822_4048# r2_b2 0
C1381 Xd0/a_2984_3416# r0_b0 0.03185f
C1382 Xd0/m1_1822_4048# vbn_prb 0
C1383 Xi2/a_4132_4510# Xi2/g -0.00117f
C1384 Xvi/m1_8646_1098# Xm/iint 0.03583f
C1385 Xi4/a_3078_4510# Xr/vgln 0.03289f
C1386 i1_b0 Xr/vsp 0.47266f
C1387 Xr/vsn vreset_src 0.15121f
C1388 vth_ref Xi0/g 0.0868f
C1389 vbp_st r0_b0 0.00648f
C1390 Xvi/a_2102_5152# ib_x2 0.03234f
C1391 i4_b4 Xg/a_5188_4156# 0.00477f
C1392 r2_b1 vdd 1.24782f
C1393 i4_b2 Xg/a_4580_5314# 0.038f
C1394 i2_b4 Xr/vgln 0.10037f
C1395 ib_r1 vdd 0.54073f
C1396 vbn_leak Xr/vgln 0.14959f
C1397 Xd1/m1_3492_2640# vdd -0.00524f
C1398 Xi2/a_528_4510# vdd 0.11858f
C1399 Xi0/m1_650_4492# Xr/vglp 0.02709f
C1400 i4_b3 Xi4/a_3078_4510# 0
C1401 ua0_s0 Xm/iint 0.08691f
C1402 vbn_ax r1_b1 0.3683f
C1403 Xi2/a_2432_4510# Xr/vgln -0.00389f
C1404 r2_b2 Xd2/m1_3542_4048# 0.00115f
C1405 bias_en Xi0/a_2228_4572# 0.04954f
C1406 i1_b0 i1_b1 0.20584f
C1407 Xi3/m1_988_1168# Xr/vsp 0.02185f
C1408 vbn_ax r2_b4 0.15918f
C1409 r0_b4 r2_b1 0.00104f
C1410 Xd2/m1_3542_4048# vbn_prb 0.05708f
C1411 Xi0/m1_650_4492# Xi0/a_3078_4572# -0.00108f
C1412 Xi0/a_2432_4572# Xm/iint 0.05471f
C1413 Xi0/g i2_b2 0.00346f
C1414 i2_b4 i4_b3 0.15928f
C1415 r2_b0 Xi4/m1_1500_4102# 0
C1416 Xr/vsn Xi1/a_528_4572# 0
C1417 Xm/iint ib_x2 0.22865f
C1418 el Xd1/m1_1716_2640# 0.14444f
C1419 i4_b3 vbn_leak 0.49193f
C1420 bias_en Xm/a_1744_10100# 0.08788f
C1421 Xr/vsn Xr/en_b 0
C1422 r0_b4 Xi2/a_528_4510# 0
C1423 Xd3/m1_3600_4920# v0_c0 0.05821f
C1424 r0_b4 vdd 0.29068f
C1425 i0_b2 Xi0/g 0
C1426 el r2_b3 0.03116f
C1427 v0_c2 ua0_stim 0
C1428 r1_b0 vbn_ax 0.04701f
C1429 Xi4/g Xi4/m1_1500_4102# -0.00685f
C1430 r2_b1 Xi4/a_4132_4510# 0
C1431 vbn_ref Xi1/m1_988_2984# -0
C1432 Xi3/m1_988_1168# i1_b1 0.37903f
C1433 Xd0/a_4168_3416# r1_b1 0.04311f
C1434 v0_c2 Xd3/m1_1970_3610# 0.00109f
C1435 Xi4/m1_988_1168# r2_b3 0.04345f
C1436 bias_en Xr/vsp 0.09488f
C1437 r0_b1 r1_b2 0.06725f
C1438 r1_b1 r1_b2 0.10261f
C1439 Xm/in_p i3_b0 0.04077f
C1440 r2_b2 r2_b0 0.41646f
C1441 Xi4/a_4132_4510# vdd 0.00227f
C1442 Xg/a_3036_4156# vbn_ref 0.10653f
C1443 Xi3/m1_1460_4102# i0_b2 0
C1444 Xvi/m1_7102_850# Xi4/g 0
C1445 Xi0/a_3282_4572# Xr/vsp 0
C1446 r2_b2 r1_b4 0.09209f
C1447 ua0_stim_out i0_b4 0.04954f
C1448 r2_b4 r1_b2 0.31689f
C1449 r2_b0 vbn_prb 0.28505f
C1450 i4_b0 i2_b3 0.06531f
C1451 Xvi/m1_8042_6360# Xi4/g 0.01418f
C1452 vbn_ax vth_cmp 0.1105f
C1453 Xg/a_1580_5314# r2_b4 0.18664f
C1454 r0_b3 r0_b1 0.63838f
C1455 r0_b3 r1_b1 0.10685f
C1456 r1_b1 Xd0/m1_2262_4048# 0.01542f
C1457 Xi1/g Xr/vglp 1.37514f
C1458 vbn_prb Xi4/g 0.58545f
C1459 vbn_ax Xg/a_7580_5314# 0.07948f
C1460 r1_b0 r1_b2 0.33748f
C1461 i2_b4 Xr/vsp 0.6268f
C1462 vbn_leak Xr/vsp 0.00161f
C1463 Xvi/m1_8332_7080# Xi0/g 0.07834f
C1464 vbp_st i1_b0 0.0344f
C1465 bias_en Xr/m1_1662_438# 0.02814f
C1466 Xd3/m1_3600_4920# v0_c1 0.03842f
C1467 r0_b2 Xd0/a_4168_3416# 0.03094f
C1468 Xi1/g i4_b1 0.29233f
C1469 r2_b0 i4_b4 0.03105f
C1470 ua0_stim_out i1_b4 0.03864f
C1471 Xi3/g i4_b4 0.15702f
C1472 Xi0/a_528_4572# Xr/vgln 0.0507f
C1473 vreset_src i0_b4 0.32383f
C1474 r1_b2 vth_cmp 0.00205f
C1475 i4_b4 Xi4/g 0.05518f
C1476 Xi3/m1_988_1168# vbp_st 0.00393f
C1477 Xi3/g i0_b3 0
C1478 Xi0/m1_650_4492# Xi0/m1_988_2984# -0.00248f
C1479 Xd1/a_3576_3416# r1_b4 -0.01304f
C1480 Xr/vsn Xg/m1_5516_1920# 0.05499f
C1481 Xg/a_3036_4156# r1_b3 0.20541f
C1482 r0_b1 i2_b0 0.36052f
C1483 bias_en Xm/a_736_7228# 0.09953f
C1484 r0_b2 r0_b3 0.20961f
C1485 Xg/a_7580_5314# r1_b2 0
C1486 r1_b1 i2_b0 0.19207f
C1487 r0_b3 Xi2/a_1582_4510# 0.00177f
C1488 r2_b4 i2_b0 0.03127f
C1489 r2_b2 Xd0/a_3576_3416# 0.04115f
C1490 r2_b2 Xd1/a_2392_3416# 0.19799f
C1491 vbn_leak Xd0/m1_502_4048# 0
C1492 vdd Xd0/a_2392_3416# -0.02844f
C1493 vth_ref ib_x2 0.11585f
C1494 Xd3/a_4412_3816# v0_c5 -0.01551f
C1495 Xr/vsn r2_b3 0.48632f
C1496 bias_en vbp_st 0.06062f
C1497 r1_b0 i2_b0 0.0651f
C1498 ua0_stim Xm/a_736_5516# 0.00608f
C1499 v0_c0 ua0_s1 0.16099f
C1500 vbn_ax Xd0/a_1800_3416# 0.14544f
C1501 Xg/a_7580_5314# Xg/a_4580_5314# -0.02424f
C1502 vbn_ax Xd0/m1_4222_4048# 0.0459f
C1503 i4_b0 i2_b2 0.049f
C1504 i4_b4 i0_b0 0.80625f
C1505 r0_b2 i2_b0 0.0707f
C1506 Xg/a_3036_4156# ua0_stim_out 0.05635f
C1507 r0_b3 Xi2/a_1378_4510# 0.0014f
C1508 i1_b2 vdd 0.46338f
C1509 ib_r1 Xi0/m1_988_1168# 0.43663f
C1510 i0_b2 ib_x2 0.16053f
C1511 Xm/a_1744_9182# Xm/a_2240_11218# -0.04415f
C1512 Xvi/a_4976_1528# ib_x2 0.06976f
C1513 vdd Xi0/m1_988_1168# -0.03955f
C1514 r2_b1 Xr/vgln 0.1013f
C1515 ua0_s0 Xd3/m1_1822_4448# 0.00653f
C1516 r1_b4 Xi2/m1_640_4420# 0
C1517 r2_b4 Xg/m1_5022_10210# 0.00144f
C1518 Xm/in_p Xi0/g 0
C1519 ib_r1 Xr/vgln 0.08904f
C1520 vbn_leak Xd0/m1_1382_4048# 0
C1521 Xi3/a_4132_4572# vdd 0.00392f
C1522 el Xvi/a_864_6450# -0.01441f
C1523 Xi1/m1_988_3644# Xm/in_n 0.00471f
C1524 Xi2/a_528_4510# Xr/vgln -0
C1525 vdd Xr/vgln 4.70298f
C1526 i2_b1 r2_b0 0.12102f
C1527 vdd Xi4/a_3928_4510# 0.00346f
C1528 Xr/vsn Xi1/m1_1460_4102# 0.10228f
C1529 vbp_syn Xi2/g 0.03842f
C1530 ua0_int Xd3/a_5004_3816# 0
C1531 i4_b3 r2_b1 0.04124f
C1532 i2_b1 r1_b4 0.0446f
C1533 v0_c1 ua0_s1 0.00152f
C1534 v0_c2 Xd3/a_2636_3816# 0.03931f
C1535 r1_b4 r0_b0 0.16017f
C1536 Xd1/m1_2910_2650# vbn_leak 0
C1537 r2_b2 vbn_ref 0.03268f
C1538 Xi1/g i4_b2 0.09569f
C1539 i4_b3 vdd 1.99594f
C1540 r0_b4 Xr/vgln 0.00727f
C1541 vbn_prb vbn_ref 1.45638f
C1542 Xvi/m1_8332_7080# ib_x2 0.03325f
C1543 Xi3/a_3078_4572# Xi3/m1_1460_4102# -0
C1544 vbn_prb Xd0/m1_942_4048# 0.04403f
C1545 bias_en Xd3/a_2044_3816# 0.06072f
C1546 vbp_w Xi4/m1_1500_4102# -0.00311f
C1547 Xi4/a_4132_4510# Xr/vgln 0.06398f
C1548 vdd Xi0/a_2228_4572# 0.0293f
C1549 vth_ref Xi1/m1_650_4492# 0.00206f
C1550 Xi2/g Xm/in_n 0.661f
C1551 i4_b4 vbn_ref 0.06756f
C1552 Xi3/a_2432_4572# i1_b3 0.01968f
C1553 i4_b3 Xi4/a_4132_4510# 0
C1554 bias_en Xd3/m1_4488_3600# 0.08507f
C1555 r2_b1 Xr/vsp 0.09878f
C1556 ib_r1 Xr/vsp 0.71533f
C1557 r2_b2 vbp_w 0.08668f
C1558 Xd1/a_3576_3416# vbn_ref 0.14924f
C1559 r2_b2 r1_b3 0.03241f
C1560 vdd Xr/vsp 1.52928f
C1561 Xi1/m1_988_1168# vdd -0.04537f
C1562 r1_b2 i2_b3 0.06216f
C1563 Xvi/m1_4546_7560# Xvi/a_864_6450# -0.01738f
C1564 Xi1/m1_650_4492# i0_b2 0.13506f
C1565 Xd0/a_3576_3416# r0_b0 0.03741f
C1566 Xi3/a_3928_4572# vdd 0.01024f
C1567 Xr/vsn i0_b1 0.04706f
C1568 vbp_st Xd0/m1_3342_4048# 0.04285f
C1569 vdd i1_b1 0.34145f
C1570 Xr/vsn Xvi/a_864_6450# 0.18013f
C1571 ua0_s0 Xm/in_p 0.13042f
C1572 r0_b3 i2_b3 0.07859f
C1573 Xi1/g r1_b1 0
C1574 Xvi/m1_1382_738# Xi4/g 0.04703f
C1575 ib_r1 Xr/m1_1662_438# 0
C1576 Xi3/g i1_b0 0.17681f
C1577 Xi1/g r2_b4 0.16451f
C1578 Xi0/a_4132_4572# Xm/iint 0.0869f
C1579 Xm/in_p ib_x2 0.0742f
C1580 i4_b0 Xm/in_p 0.02876f
C1581 Xvi/a_5712_1328# Xvi/m1_4894_1238# -0
C1582 i4_b0 Xi4/a_1582_4510# 0
C1583 Xd1/a_3576_3416# r1_b3 -0.00481f
C1584 Xi1/g r1_b0 0
C1585 r2_b2 ua0_stim_out 0.17845f
C1586 Xi3/g Xi3/m1_988_1168# -0.25073f
C1587 Xd2/a_2984_3416# r2_b3 0
C1588 r2_b2 Xd1/a_4168_3416# 0.05558f
C1589 Xd3/m1_502_4448# vdd 0.03512f
C1590 Xm/a_736_7228# vdd -0.00928f
C1591 ua0_int v0_c5 0.06766f
C1592 vreset_src Xi4/m1_1500_4102# 0.01158f
C1593 r0_b3 Xi2/a_3928_4510# 0
C1594 Xi3/a_2228_4572# i1_b3 0.00524f
C1595 i2_b0 i2_b3 1.32746f
C1596 i1_b2 Xr/vgln 0.33381f
C1597 r2_b1 vbp_st 0.07332f
C1598 ua0_s0 v0_c3 0.04639f
C1599 Xg/m1_3666_9610# r1_b2 0.04794f
C1600 vbn_ax i0_b2 0.06473f
C1601 r2_b2 Xd0/m1_2760_3412# 0
C1602 i4_b4 ua0_stim_out 0.0355f
C1603 Xm/a_1744_9182# ua0_int -0
C1604 Xd0/m1_2760_3412# vbn_prb 0
C1605 Xi3/m1_1460_4102# Xi3/m1_650_4492# -0
C1606 vbp_st vdd 2.25616f
C1607 r2_b0 Xi4/m1_640_4420# 0.01151f
C1608 Xvi/m1_8042_6360# vreset_src 0.01679f
C1609 Xi2/g Xi0/g 0.01601f
C1610 Xi1/g Xg/a_7580_5314# 0.31225f
C1611 i1_b0 i0_b0 0.09791f
C1612 r2_b2 vreset_src 0.45552f
C1613 i4_b2 Xg/m1_6282_1450# 0
C1614 Xi3/a_4132_4572# Xr/vgln 0.07825f
C1615 v0_c3 ib_x2 0.99093f
C1616 ua0_stim_out i0_b3 0.04418f
C1617 bias_en Xi4/g 0.54769f
C1618 vbn_prb vreset_src 0.17266f
C1619 el Xr/vglp -0.008f
C1620 r1_b2 i2_b2 0.03328f
C1621 Xi4/g Xi4/m1_640_4420# -0.01626f
C1622 Xi4/a_3928_4510# Xr/vgln 0.05691f
C1623 i3_b2 i1_b3 0.07541f
C1624 Xm/in_n Xi0/g 0.04014f
C1625 i2_b4 r2_b0 0.04221f
C1626 r2_b0 vbn_leak 0.03031f
C1627 Xd1/a_3576_3416# Xd1/a_4168_3416# -0.0016f
C1628 Xi1/a_3078_4572# Xm/in_n 0.00148f
C1629 i2_b4 r1_b4 0.03567f
C1630 Xi0/a_1582_4572# Xi0/g 0
C1631 Xr/m1_2542_438# Xr/vsn -0.0015f
C1632 r0_b3 i2_b2 0.04797f
C1633 i2_b4 Xi3/g 0.04473f
C1634 i4_b1 el 0.03297f
C1635 Xi0/g Xi0/a_1378_4572# 0
C1636 Xi4/a_3282_4510# vdd 0.00285f
C1637 i4_b3 Xr/vgln 0.39664f
C1638 Xd3/a_3228_3816# v0_c3 0
C1639 Xd1/m1_942_4048# vreset_src 0.12782f
C1640 vbn_leak Xi4/g 0.09361f
C1641 i4_b4 vreset_src 0.01912f
C1642 Xi1/m1_988_2984# Xi1/m1_1460_4102# -0.00944f
C1643 r2_b2 Xd2/m1_2900_3120# 0
C1644 Xi0/a_3928_4572# i0_b4 0.00181f
C1645 Xvi/a_5712_1328# Xr/vglp 0.00973f
C1646 Xd2/m1_2900_3120# vbn_prb 0.02322f
C1647 i2_b1 r1_b3 0.03988f
C1648 vreset_src i0_b3 0.06367f
C1649 r2_b2 Xd1/m1_2318_2410# 0.02457f
C1650 Xm/a_1744_9182# Xm/iint 0.00274f
C1651 vbp_w r0_b0 0.16953f
C1652 Xd3/m1_3600_4920# v0_c2 0.14558f
C1653 Xi0/a_2228_4572# Xr/vgln 0.04464f
C1654 vbn_prb Xd1/m1_2318_2410# 0
C1655 Xi3/m1_988_3644# i0_b2 0.00338f
C1656 Xd3/m1_3342_4448# v0_c0 0.01181f
C1657 i1_b2 Xr/vsp 0.23726f
C1658 bias_en i0_b0 0.01078f
C1659 Xr/vsn Xg/m1_4760_1320# 0.0294f
C1660 Xi0/m1_650_4492# Xm/iint 0.06347f
C1661 Xr/vsp Xi0/m1_988_1168# 0
C1662 i4_b0 Xg/m1_4906_9490# 0
C1663 i2_b0 i2_b2 0.00248f
C1664 Xd1/m1_3662_2290# el 0.00454f
C1665 Xm/a_420_700# ua0_s0 1.03552f
C1666 Xi3/a_732_4572# i0_b2 0.00574f
C1667 Xd3/a_2044_3816# vdd 0.14967f
C1668 i1_b2 i1_b1 0.03021f
C1669 i1_b0 vbn_ref 0.04912f
C1670 ua0_stim_out Xi2/m1_640_4420# 0.05462f
C1671 Xr/vsp Xr/vgln 0.41623f
C1672 i2_b4 i0_b0 0.00971f
C1673 r2_b0 Xi4/m1_988_3644# 0
C1674 vbn_leak i0_b0 0.15239f
C1675 vbn_leak Xd1/a_2392_3416# 0.00121f
C1676 Xi1/m1_988_1168# Xr/vgln 0.11766f
C1677 Xi3/a_3928_4572# Xr/vgln 0.08279f
C1678 Xvi/m1_4546_7560# Xr/vglp -0.03223f
C1679 i4_b3 Xr/vsp 0.09774f
C1680 Xd3/m1_4488_3600# vdd 0
C1681 ua0_stim_out r0_b0 0.13693f
C1682 Xi4/m1_988_3644# Xi4/g -0.02842f
C1683 vbp_st Xd0/a_2392_3416# 0.00136f
C1684 Xr/vsn Xr/vglp 1.36966f
C1685 Xd3/m1_3342_4448# v0_c1 0.21594f
C1686 i1_b1 Xr/vgln 0.15649f
C1687 r2_b3 Xi4/m1_1500_4102# 0.05779f
C1688 vdd Xg/a_5188_4156# -0.05505f
C1689 r0_b1 Xi2/m1_988_3644# 0.17638f
C1690 Xi1/g Xm/iint 0.01643f
C1691 r1_b1 Xi2/m1_988_3644# 0
C1692 el Xd1/a_1800_3416# 0.00914f
C1693 bias_en ua0_stim 1.9165f
C1694 Xm/in_p vbn_ax 0.04846f
C1695 Xr/vsn i4_b1 0.28749f
C1696 ua0_s0 Xm/in_n 0.02415f
C1697 i4_b0 Xi2/g 0.04624f
C1698 bias_en Xd3/m1_1970_3610# 0.0124f
C1699 r2_b2 Xd1/m1_1716_2640# 0.04889f
C1700 Xd0/m1_2760_3412# r0_b0 0.00167f
C1701 Xi2/a_4132_4510# r0_b3 0.00138f
C1702 r2_b2 r2_b3 0.12279f
C1703 vbn_prb Xd1/m1_1716_2640# 0
C1704 Xi0/m1_988_3644# Xi0/g 0.07503f
C1705 el i4_b2 0.19021f
C1706 i1_b2 vbp_st 0.09154f
C1707 Xd3/m1_2702_4448# v0_c0 0.34082f
C1708 i4_b4 Xg/m1_5516_1920# 0
C1709 Xm/in_n ib_x2 0.24107f
C1710 Xi3/a_3078_4572# vbn_ax -0
C1711 Xi0/a_1582_4572# ib_x2 0.01091f
C1712 Xi1/g i2_b3 0
C1713 Xi0/a_1378_4572# ib_x2 0.01149f
C1714 Xm/in_p r1_b2 0.19857f
C1715 bias_en Xm/a_1764_11418# 0.04644f
C1716 Xi1/m1_988_1168# Xr/vsp 0.02005f
C1717 v0_c2 ua0_s1 0.0013f
C1718 Xd3/a_4412_3816# v0_c1 0
C1719 Xi3/a_528_4572# i0_b2 0.01764f
C1720 vbn_leak vbn_ref 0.01914f
C1721 vbp_st Xr/vgln 0.68758f
C1722 Xm/in_p r0_b3 0
C1723 i4_b4 r2_b3 0.03599f
C1724 Xr/vsn Xr/m1_3422_438# -0.00328f
C1725 Xr/m1_1222_3522# Xr/vglp 0.00113f
C1726 Xr/vsn Xi2/m1_988_1168# -0.03361f
C1727 vbn_leak Xd0/m1_942_4048# 0
C1728 i1_b1 Xr/vsp 0.20859f
C1729 Xvi/m1_1276_6360# vbn_leak 0.13703f
C1730 r2_b1 r2_b0 0.68669f
C1731 i4_b2 Xg/m1_4538_1930# 0.0095f
C1732 Xi1/m1_650_4492# Xi1/m1_988_3644# -0
C1733 r2_b1 r1_b4 0.04267f
C1734 Xd1/m1_502_4048# vbn_prb 0.05699f
C1735 i4_b3 vbp_st 0.045f
C1736 ua0_stim_out i1_b0 0.06699f
C1737 Xd3/m1_2702_4448# v0_c1 0.24862f
C1738 Xi3/g r2_b1 0
C1739 i4_b0 Xi4/a_732_4510# 0
C1740 vdd r1_b4 1.15593f
C1741 r2_b0 vdd 0.82591f
C1742 Xi4/a_3282_4510# Xr/vgln 0.07873f
C1743 r2_b1 Xi4/g 0.47317f
C1744 Xi3/g vdd 1.19976f
C1745 ib_r1 Xi4/g 0
C1746 Xr/vglp i0_b4 0.08734f
C1747 Xm/in_p Xi3/a_732_4572# 0
C1748 Xi0/a_3078_4572# i0_b4 0
C1749 Xi1/g vth_ref 0.59072f
C1750 vdd Xi4/g 0.68685f
C1751 Xi3/m1_988_1168# ua0_stim_out 0.07003f
C1752 r0_b4 r2_b0 0.09433f
C1753 r0_b4 r1_b4 0
C1754 vbp_w vbn_leak 0.17748f
C1755 Xi1/a_4132_4572# Xm/in_n 0
C1756 i2_b4 r1_b3 0.0324f
C1757 Xm/in_p i2_b0 0
C1758 Xvi/m1_1382_738# vreset_src 0.00303f
C1759 Xi4/a_3282_4510# i4_b3 0
C1760 r1_b1 el 0.2886f
C1761 Xd3/a_5004_3816# v0_c3 0.16636f
C1762 el r2_b4 0.03497f
C1763 Xvi/m1_4546_7560# i4_b2 0.04844f
C1764 Xg/m1_3530_1930# Xr/vgln -0.0094f
C1765 Xd3/m1_942_4448# vdd 0.55304f
C1766 Xi1/g i2_b2 0.00998f
C1767 Xr/vsn i4_b2 0.51282f
C1768 vbp_st Xr/vsp 1.10241f
C1769 Xi2/m1_1500_4102# ua0_stim_out 0
C1770 r1_b1 Xi2/m1_988_2984# 0
C1771 r0_b1 Xi2/m1_988_2984# 0.16381f
C1772 bias_en ua0_stim_out 0.07277f
C1773 r1_b0 el 0.03557f
C1774 Xi1/m1_650_4492# Xm/in_n 0.12105f
C1775 Xi1/g i0_b2 0.56391f
C1776 Xi0/g Xi0/a_2432_4572# 0
C1777 v0_c4 ua0_stim 0.08008f
C1778 vbp_st i1_b1 0.04493f
C1779 Xd0/a_3576_3416# vdd 0
C1780 i0_b0 vdd 0.4126f
C1781 i3_b4 i1_b3 0.01509f
C1782 Xi0/g ib_x2 0.05255f
C1783 vdd Xd1/a_2392_3416# -0.00498f
C1784 ua0_s1 Xm/a_736_5516# 0.4059f
C1785 Xi1/a_3078_4572# ib_x2 0.00192f
C1786 Xg/m1_4906_9490# r1_b2 0.02872f
C1787 i4_b0 Xi0/g 0.50355f
C1788 Xvi/m1_7102_850# Xvi/a_864_6450# -0
C1789 el vth_cmp 2.56515f
C1790 Xi3/m1_650_4492# vbn_ax -0.00601f
C1791 i2_b1 r2_b3 0.03875f
C1792 vbp_syn vbn_ax 0.24025f
C1793 Xvi/m1_8042_6360# Xvi/a_864_6450# -0
C1794 Xg/a_5188_4156# Xr/vgln -0.00103f
C1795 bias_en Xd3/a_2636_3816# 0.07149f
C1796 Xd0/m1_3342_4048# vbn_ref 0.05414f
C1797 bias_en vreset_src 0.47971f
C1798 vbp_st Xd0/m1_502_4048# 0.13788f
C1799 r0_b4 Xd0/a_3576_3416# 0
C1800 vbn_prb Xvi/a_864_6450# -0.03169f
C1801 Xi0/a_3282_4572# vreset_src 0.04433f
C1802 ua0_int v0_c0 0.0723f
C1803 vreset_src Xi4/m1_640_4420# 0.01203f
C1804 Xr/vglp Xi1/m1_988_2984# 0.36847f
C1805 vbn_ax Xi2/g 1.17173f
C1806 Xd3/m1_502_4448# vbp_st 0.15302f
C1807 Xm/in_p Xi3/a_528_4572# 0
C1808 vreset_src Xi4/a_3078_4510# 0.05422f
C1809 Xi1/a_3928_4572# Xm/in_n 0
C1810 i4_b3 Xg/a_5188_4156# 0.08031f
C1811 bias_en Xi0/m1_1460_4102# 0.00205f
C1812 Xd3/a_2636_3816# Xd3/a_3820_3816# -0
C1813 Xg/a_3036_4156# Xr/vglp 0.08544f
C1814 vbp_syn Xd0/a_4168_3416# 0.00554f
C1815 i4_b4 i0_b1 0
C1816 vbp_st Xd0/a_2984_3416# 0
C1817 vbn_ax i3_b0 0.06806f
C1818 vbn_leak vreset_src 0.692f
C1819 vbn_ax Xm/in_n 0.09144f
C1820 bias_en Xr/en_b 0.05269f
C1821 vbp_syn r1_b2 0.20493f
C1822 Xr/vsn r0_b1 0.39446f
C1823 Xr/vsn r1_b1 0
C1824 ua0_stim vdd 0.50845f
C1825 Xr/vsn r2_b4 0.05033f
C1826 Xg/a_3036_4156# i4_b1 0.22321f
C1827 vbp_w Xd0/m1_3342_4048# 0.09957f
C1828 Xi1/a_3078_4572# Xi1/a_4132_4572# 0
C1829 Xi2/g r1_b2 0.64356f
C1830 vbp_syn r0_b3 0.45964f
C1831 r2_b1 vbn_ref 0.05141f
C1832 Xd3/m1_1970_3610# vdd 0.00544f
C1833 Xd1/m1_3492_2640# vbn_ref 0.02009f
C1834 vbp_st Xd0/m1_1382_4048# 0.0549f
C1835 Xi3/m1_988_3644# Xi3/m1_650_4492# -0.06116f
C1836 vdd vbn_ref 0.97031f
C1837 ua0_int v0_c1 0.06454f
C1838 Xr/vsn Xr/m1_342_438# 0.12138f
C1839 r0_b3 Xi2/g 0.09315f
C1840 Xi3/g i1_b2 0.39101f
C1841 v0_c3 v0_c5 0.25199f
C1842 Xr/vsn r1_b0 0.29075f
C1843 Xg/a_5188_4156# Xr/vsp -0.00363f
C1844 Xvi/m1_4546_7560# vth_cmp 0.00305f
C1845 Xg/m1_4906_9490# Xg/m1_6020_10200# -0.00284f
C1846 Xvi/m1_1276_6360# vdd 0.1056f
C1847 vbn_leak Xd1/m1_2318_2410# 0.02073f
C1848 Xg/a_1580_5314# Xm/in_n 0.00286f
C1849 el Xd0/m1_4222_4048# 0.01003f
C1850 Xi2/g Xg/a_4580_5314# -0.0053f
C1851 r2_b0 Xr/vgln 0.39096f
C1852 vdd Xm/a_1764_11418# -0
C1853 i3_b4 v0_c0 0.01674f
C1854 bias_en Xvi/m1_5388_6960# 0.00216f
C1855 Xr/vsn vth_cmp 0.16988f
C1856 r1_b4 Xr/vgln 0.05185f
C1857 Xi3/g Xr/vgln 0.00749f
C1858 r2_b2 Xi2/a_3282_4510# 0.06853f
C1859 ua0_s0 ib_x2 0.03252f
C1860 vbp_syn i2_b0 0.07776f
C1861 Xi4/m1_988_3644# vreset_src 0.02417f
C1862 Xi4/g Xr/vgln -0.01158f
C1863 Xr/vsn Xg/a_7580_5314# -0
C1864 i4_b3 r2_b0 0.03438f
C1865 Xi0/a_2432_4572# ib_x2 0
C1866 Xm/in_n Xg/a_4580_5314# 0.00333f
C1867 r2_b1 r1_b3 0.0452f
C1868 r2_b2 Xi2/a_732_4510# 0.02297f
C1869 vbp_w vdd 0.7165f
C1870 Xi1/g Xm/in_p 0
C1871 Xi3/g i4_b3 0.18906f
C1872 vdd r1_b3 1.40474f
C1873 ua0_s0 Xd3/a_3228_3816# 0.01388f
C1874 vbn_ax Xd0/m1_4094_3010# 0.07217f
C1875 Xi0/a_528_4572# vreset_src 0.03167f
C1876 vbn_leak Xvi/m1_5388_6960# 0.12023f
C1877 i4_b3 Xi4/g 0.08987f
C1878 Xvi/a_5712_1328# Xvi/a_2102_5152# -0.0245f
C1879 r0_b4 vbp_w 0.00438f
C1880 Xr/m1_1222_3522# Xr/m1_342_438# -0
C1881 i3_b4 v0_c1 0.00315f
C1882 Xd3/m1_3342_4448# v0_c2 0.09891f
C1883 bias_en ua0 0.22573f
C1884 r2_b3 Xi4/m1_640_4420# 0.20341f
C1885 Xi4/a_3078_4510# r2_b3 0.00153f
C1886 vbn_ax Xi0/g 0.19803f
C1887 i0_b0 Xr/vgln 0.1114f
C1888 vbp_st Xg/a_5188_4156# 0.05337f
C1889 vth_ref v0_c0 0.04061f
C1890 Xvi/m1_7102_850# Xr/vglp 0.01235f
C1891 Xvi/a_5712_1328# Xm/iint 0.04685f
C1892 Xr/m1_342_438# i0_b4 0
C1893 r2_b0 Xr/vsp 0.00114f
C1894 r2_b1 ua0_stim_out 0.091f
C1895 r1_b4 Xr/vsp 0.40718f
C1896 Xg/m1_3898_9610# r1_b2 0.04779f
C1897 vbn_leak Xd1/m1_1716_2640# 0.09243f
C1898 Xi3/g Xr/vsp 0.6086f
C1899 vbn_leak r2_b3 0.03351f
C1900 ua0_stim_out Xi2/a_528_4510# 0
C1901 Xi3/m1_1460_4102# vbn_ax -0
C1902 ua0_stim_out vdd 2.88798f
C1903 i2_b4 r2_b3 0.03589f
C1904 Xvi/m1_8042_6360# Xr/vglp -0
C1905 vdd Xd1/a_4168_3416# 0.0049f
C1906 Xg/m1_3298_2050# Xr/vgln -0.00167f
C1907 Xi3/a_3282_4572# i1_b3 0.00124f
C1908 i4_b3 i0_b0 0.00998f
C1909 Xd0/m1_1822_4048# vbp_st 0.03583f
C1910 r2_b2 Xr/vglp 0.00661f
C1911 vbn_prb Xr/vglp -0
C1912 r0_b4 ua0_stim_out 0.11027f
C1913 Xi3/g i1_b1 0.61504f
C1914 v0_c2 Xd3/a_4412_3816# 0.075f
C1915 Xr/vsn Xvi/a_2102_5152# 0.14635f
C1916 Xg/a_1580_5314# Xi0/g -0.0583f
C1917 Xd0/m1_2760_3412# vdd -0
C1918 bias_en Xd3/m1_3600_4920# 0.17741f
C1919 r2_b1 vreset_src 0.0472f
C1920 ib_r1 vreset_src 0.22389f
C1921 Xd3/a_2636_3816# vdd 0.14723f
C1922 vdd vreset_src 3.3633f
C1923 Xd1/m1_3492_2640# vreset_src 0.00636f
C1924 i4_b4 Xr/vglp 0.06596f
C1925 Xi1/m1_650_4492# ib_x2 0.0444f
C1926 vth_ref el 0.79805f
C1927 Xr/vglp i0_b3 0.15555f
C1928 vbp_w Xd0/a_2392_3416# 0.08133f
C1929 Xd3/m1_2702_4448# v0_c2 0.00939f
C1930 Xd3/m1_3600_4920# Xd3/a_3820_3816# -0
C1931 Xi1/g Xg/m1_4906_9490# 0.04599f
C1932 ib_r1 Xi0/m1_1460_4102# 0.00125f
C1933 Xr/vsn Xm/iint 0
C1934 i1_b0 i0_b1 0.53243f
C1935 Xg/a_4580_5314# Xi0/g 0.09211f
C1936 i4_b4 i4_b1 0.01104f
C1937 Xi0/a_3078_4572# i0_b3 0.00749f
C1938 i0_b0 Xr/vsp 0.13615f
C1939 Xd3/m1_1822_4448# v0_c0 0.00908f
C1940 Xi3/m1_988_3644# Xi3/m1_1460_4102# -0
C1941 i2_b1 Xi2/a_3282_4510# 0
C1942 Xm/in_p i1_b3 0.03192f
C1943 vdd Xi1/a_528_4572# 0
C1944 vbn_ref Xr/vgln 0.12605f
C1945 Xi4/m1_988_3644# r2_b3 0.12541f
C1946 r2_b2 Xd1/m1_3662_2290# 0.00237f
C1947 Xi1/g Xi1/m1_988_3644# -0.10012f
C1948 Xr/en_b vdd 0.4348f
C1949 Xd2/m1_2900_3120# vdd -0
C1950 Xd1/m1_3662_2290# vbn_prb 0.03919f
C1951 Xd1/a_2984_3416# vbn_ax 0.16426f
C1952 r2_b2 Xi2/m1_988_1168# 0.05123f
C1953 r2_b0 vbp_st 0.04529f
C1954 Xvi/m1_1276_6360# Xr/vgln 0.15846f
C1955 vbp_st r1_b4 0.06739f
C1956 Xg/a_3036_4156# r2_b4 0
C1957 Xi4/a_4132_4510# vreset_src 0.03553f
C1958 Xi3/g vbp_st 0.20882f
C1959 Xi0/g Xi0/a_732_4572# 0.01447f
C1960 vdd Xd1/m1_2318_2410# -0.0012f
C1961 i4_b3 vbn_ref 0.31432f
C1962 vbp_st Xi4/g 0.03812f
C1963 Xi3/a_3078_4572# i1_b3 0.05183f
C1964 Xi2/m1_988_2984# i2_b2 0
C1965 el Xvi/a_4976_1528# -0
C1966 i4_b3 Xvi/m1_1276_6360# 0.02457f
C1967 Xi0/g Xg/m1_6020_10200# 0.00366f
C1968 bias_en i0_b1 0.0313f
C1969 vbp_w Xr/vgln 0.01428f
C1970 Xd1/a_2984_3416# r1_b2 -0.01651f
C1971 Xi1/g Xi2/g 0.34626f
C1972 Xd3/m1_942_4448# vbp_st 0
C1973 r2_b2 Xi2/a_3078_4510# 0.04001f
C1974 Xi4/a_528_4510# vdd 0.00116f
C1975 i4_b0 vbn_ax 0.16299f
C1976 r1_b3 Xr/vgln 0.0465f
C1977 bias_en Xvi/a_864_6450# 0.37552f
C1978 r2_b2 Xd1/a_1800_3416# 0.15103f
C1979 Xd1/a_3576_3416# Xd1/m1_3662_2290# -0.01272f
C1980 bias_en Xi0/a_3928_4572# 0.05828f
C1981 vdd Xvi/m1_5388_6960# 0.01095f
C1982 Xvi/a_5712_1328# Xvi/a_4976_1528# -0
C1983 Xvi/m1_8332_7080# el -0
C1984 Xi1/g Xm/in_n 0.46135f
C1985 i2_b4 i0_b1 0
C1986 Xm/a_2240_11218# Xm/a_736_5516# -0.15536f
C1987 bias_en ua0_s1 0.25485f
C1988 vbn_ref Xr/vsp 0
C1989 vbn_leak i0_b1 0.12473f
C1990 Xi1/g Xi0/a_1378_4572# 0
C1991 vbp_st Xd0/a_3576_3416# 0
C1992 ua0_s0 Xd3/a_5004_3816# 0.04722f
C1993 vbp_st i0_b0 0.04746f
C1994 vbn_leak Xvi/a_864_6450# 0.63819f
C1995 i1_b2 ua0_stim_out 0.063f
C1996 i2_b1 Xr/vglp 0
C1997 i4_b0 r1_b2 0
C1998 vth_ref Xr/vsn 0.45443f
C1999 i3_b3 i1_b3 0.54456f
C2000 i0_b4 Xm/iint 0.17752f
C2001 Xg/m1_3530_1930# Xi4/g -0.03787f
C2002 i4_b0 Xg/a_1580_5314# 0.10265f
C2003 i2_b1 i4_b1 0.06532f
C2004 vbn_ref i1_b1 0.15388f
C2005 Xm/in_p v0_c0 1.02106f
C2006 r2_b1 r2_b3 0.77942f
C2007 vdd Xd1/m1_1716_2640# -0.00344f
C2008 Xi3/a_4132_4572# ua0_stim_out 0.00568f
C2009 ua0_stim_out Xr/vgln 0.12234f
C2010 i4_b4 i4_b2 0.14139f
C2011 i3_b4 i0_b4 0.12837f
C2012 vdd ua0 -0.0053f
C2013 vdd r2_b3 0.90977f
C2014 r2_b2 Xd2/a_4168_3416# 0.05274f
C2015 Xvi/m1_4546_7560# Xvi/a_4976_1528# -0
C2016 Xm/a_736_7228# ua0_stim 0.10466f
C2017 Xd0/m1_502_4048# vbn_ref 0.04553f
C2018 i4_b0 Xg/a_4580_5314# 0.10635f
C2019 Xr/vsn i0_b2 0.03239f
C2020 r1_b4 Xg/a_5188_4156# 0.02545f
C2021 r1_b3 Xr/vsp 0.21229f
C2022 i4_b3 ua0_stim_out 0.05345f
C2023 Xi3/g Xg/a_5188_4156# -0.00302f
C2024 Xr/vsn Xvi/a_4976_1528# 0.16031f
C2025 bias_en Xvi/m1_4894_1238# 0
C2026 Xi0/m1_650_4492# Xi0/m1_988_3644# -0
C2027 Xi0/m1_650_4492# Xi0/g 0.04378f
C2028 bias_en Xr/m1_2542_438# 0.03118f
C2029 ua0_int v0_c2 0.04758f
C2030 i4_b0 i2_b0 0.04859f
C2031 vreset_src Xr/vgln 1.15128f
C2032 i3_b4 i1_b4 0.09047f
C2033 vreset_src Xi4/a_3928_4510# 0.07197f
C2034 Xi4/a_4132_4510# r2_b3 0.00174f
C2035 ib_x2 Xi0/a_732_4572# 0.0118f
C2036 Xr/m1_1222_3522# vth_ref 0.0243f
C2037 Xi3/m1_650_4492# i1_b3 0.00243f
C2038 v0_c3 v0_c0 0.12521f
C2039 i3_b2 i0_b3 0.02165f
C2040 Xm/in_p v0_c1 0.02265f
C2041 r2_b2 r0_b1 0.11235f
C2042 r2_b2 r1_b1 1.67141f
C2043 vbp_st vbn_ref 0.39466f
C2044 r2_b2 r2_b4 0.10511f
C2045 i0_b1 Xi0/a_528_4572# 0.00173f
C2046 Xr/m1_3862_3522# vbp_st 0
C2047 i4_b3 vreset_src 0.00725f
C2048 i1_b0 Xr/vglp 0
C2049 vbp_st Xd0/m1_942_4048# 0.06304f
C2050 Xd3/m1_3600_4920# vdd -0.00509f
C2051 i2_b4 Xi2/a_3282_4510# 0
C2052 vdd Xi1/m1_1460_4102# 0.10947f
C2053 vbn_ref Xd0/m1_1382_4048# 0.0478f
C2054 Xd3/m1_1382_4448# Xm/in_p 0.04397f
C2055 Xi2/a_3282_4510# Xi2/a_2432_4510# -0
C2056 i4_b0 Xg/m1_6020_10200# 0.11384f
C2057 vth_ref i0_b4 0.03684f
C2058 Xr/en_b Xr/vgln 0.00372f
C2059 ua0_stim_out Xr/vsp 0.59762f
C2060 r2_b2 r1_b0 0.2383f
C2061 vbp_st Xm/a_1764_11418# 0
C2062 Xi1/a_732_4572# i1_b1 0.00114f
C2063 vreset_src Xi0/a_2228_4572# 0.02884f
C2064 Xi3/a_3928_4572# ua0_stim_out 0.00754f
C2065 Xi1/g Xi0/g 0.33142f
C2066 Xi2/g Xg/m1_6282_1450# 0.00438f
C2067 vbp_w Xd0/a_2984_3416# 0.07023f
C2068 Xd1/m1_2910_2650# vbn_ref 0.00362f
C2069 vdd Xi1/a_2432_4572# 0.0063f
C2070 Xvi/m1_8042_6360# vth_cmp 0.0026f
C2071 Xr/m1_782_438# bias_en 0.05465f
C2072 r0_b2 r2_b2 0.25022f
C2073 r2_b2 Xi2/a_1582_4510# 0.03069f
C2074 ua0_s0 v0_c5 0.05988f
C2075 r2_b2 vth_cmp 0.03819f
C2076 ua0_stim_out i1_b1 0.32608f
C2077 vbn_prb vth_cmp 0.0909f
C2078 Xd1/a_3576_3416# r1_b1 0.08858f
C2079 vbp_w vbp_st 0.04965f
C2080 v0_c3 v0_c1 0.20743f
C2081 r2_b0 r1_b4 0.05318f
C2082 vbp_st r1_b3 0.26284f
C2083 Xm/in_n Xg/m1_6282_1450# 0.02744f
C2084 v0_c4 ua0_s1 0.19813f
C2085 v0_c5 ib_x2 0.15171f
C2086 Xi4/a_528_4510# Xr/vgln 0
C2087 vreset_src Xr/vsp 0.18759f
C2088 Xg/m1_3530_1930# vbn_ref 0
C2089 vbp_w Xd0/m1_1382_4048# 0
C2090 Xi3/g r1_b4 0.22654f
C2091 i0_b2 i0_b4 0
C2092 bias_en Xr/vglp 0.43126f
C2093 Xr/m1_342_438# i0_b3 0
C2094 Xi1/m1_988_1168# vreset_src 0
C2095 Xm/a_1744_9182# ua0_s0 0.01101f
C2096 r2_b0 Xi4/g 0.7356f
C2097 ua0_stim Xd3/a_2044_3816# 0
C2098 Xi2/g Xi2/m1_988_3644# -0.03488f
C2099 bias_en Xi0/a_3078_4572# 0.01521f
C2100 Xd3/a_2044_3816# Xd3/m1_1970_3610# -0
C2101 Xd1/m1_942_4048# vth_cmp 0.00605f
C2102 Xd3/m1_502_4448# ua0_stim_out 0.13916f
C2103 Xi4/a_2228_4510# vbn_leak 0.00269f
C2104 i4_b4 vth_cmp 0.81902f
C2105 Xm/a_736_7228# ua0_stim_out -0.00504f
C2106 Xi1/a_528_4572# Xr/vsp 0
C2107 Xd0/a_4168_3416# vbn_ax 0.02246f
C2108 r2_b1 Xvi/a_864_6450# 0
C2109 ua0_int Xm/a_736_5516# 0.06914f
C2110 vbp_st Xi1/a_732_4572# 0
C2111 r2_b2 Xi2/a_1378_4510# 0.01791f
C2112 vbn_ax r1_b2 0.23656f
C2113 Xr/en_b Xr/vsp 0.33473f
C2114 i0_b1 vdd 0.25873f
C2115 i2_b4 Xr/vglp 0.1192f
C2116 ib_r1 Xvi/a_864_6450# 0.04871f
C2117 vbn_leak Xr/vglp 0.18411f
C2118 Xg/m1_5516_1920# Xr/vgln -0.01546f
C2119 ib_r1 Xi0/a_3928_4572# 0.00567f
C2120 vdd Xvi/a_864_6450# 0.70128f
C2121 Xg/a_1580_5314# vbn_ax 0.04607f
C2122 Xi0/a_3928_4572# vdd 0.0135f
C2123 vbp_st ua0_stim_out 0.27934f
C2124 Xi1/a_528_4572# i1_b1 0.00409f
C2125 vbn_leak i4_b1 0.3591f
C2126 vbp_st Xd1/a_4168_3416# 0.01086f
C2127 vbn_ref Xg/a_5188_4156# 0.09587f
C2128 vbn_ax Xd0/m1_2262_4048# 0.0902f
C2129 i2_b4 i4_b1 0.04109f
C2130 Xd2/m1_1382_4048# vbn_prb 0.07782f
C2131 vth_ref Xi1/m1_988_2984# 0.00493f
C2132 i4_b3 Xg/m1_5516_1920# 0.01137f
C2133 r0_b1 Xi2/m1_640_4420# 0.13947f
C2134 r1_b1 Xi2/m1_640_4420# 0
C2135 Xi3/m1_988_3644# vbn_ax -0.00218f
C2136 r2_b3 Xr/vgln 0.08194f
C2137 vdd Xi1/a_2228_4572# 0.00733f
C2138 vdd ua0_s1 1.3382f
C2139 vbn_ax Xg/a_4580_5314# 0.50205f
C2140 Xi3/g i0_b0 0.06703f
C2141 Xi4/a_3928_4510# r2_b3 0.00185f
C2142 bias_en Xr/m1_3422_438# 0.04153f
C2143 r2_b2 Xd0/a_1800_3416# 0.05192f
C2144 Xd0/m1_1822_4048# vbn_ref 0.00114f
C2145 Xi3/m1_650_4492# Xi3/m1_988_2984# -0.02533f
C2146 i2_b1 r0_b1 0.12444f
C2147 Xd0/m1_2760_3412# vbp_st 0.08287f
C2148 vbn_prb Xd0/m1_4222_4048# 0.07993f
C2149 Xg/a_1580_5314# r1_b2 0.0052f
C2150 i2_b1 r1_b1 0.03443f
C2151 r0_b1 r0_b0 0.43402f
C2152 Xi3/a_3282_4572# i0_b4 0
C2153 i2_b1 r2_b4 0.03551f
C2154 i4_b3 r2_b3 0.04352f
C2155 r0_b3 r1_b2 0.00717f
C2156 r1_b1 r0_b0 0.48638f
C2157 r1_b0 Xi2/m1_640_4420# 0.01554f
C2158 Xi3/a_732_4572# vbn_ax 0.0142f
C2159 Xd3/m1_502_4448# Xr/en_b 0.0071f
C2160 Xd0/m1_2760_3412# Xd0/m1_1382_4048# -0
C2161 Xi4/g Xg/m1_3298_2050# -0.00447f
C2162 Xm/a_736_7228# Xr/en_b -0
C2163 i0_b2 Xi1/m1_988_2984# 0.19762f
C2164 Xi1/g ib_x2 0.3164f
C2165 vbp_syn el 0.19318f
C2166 Xi1/g i4_b0 0.34417f
C2167 i2_b1 r1_b0 0.0331f
C2168 r1_b3 Xg/a_5188_4156# 0.019f
C2169 Xvi/m1_7102_850# Xm/iint 0.03472f
C2170 Xi3/m1_1460_4102# i1_b3 0.06767f
C2171 Xi4/a_2432_4510# vdd 0.00323f
C2172 vbp_st Xi1/a_528_4572# 0
C2173 Xg/a_1580_5314# Xg/a_4580_5314# -0.03082f
C2174 bias_en Xd3/m1_3342_4448# 0.21204f
C2175 Xi2/g el 0.10012f
C2176 i1_b2 i3_b1 0.01517f
C2177 ib_r1 Xvi/m1_4894_1238# 0.07678f
C2178 Xi4/a_3282_4510# vreset_src 0.05438f
C2179 Xd0/m1_1822_4048# vbp_w 0.08501f
C2180 vbp_st Xr/en_b 0.81989f
C2181 vbp_syn Xi2/m1_988_2984# -0.0067f
C2182 i2_b1 Xi2/a_1582_4510# 0
C2183 i2_b1 r0_b2 0
C2184 Xd1/m1_2910_2650# vreset_src 0
C2185 Xi1/m1_1460_4102# Xr/vgln 0.0871f
C2186 vbn_prb Xm/iint 0.00364f
C2187 r0_b2 r0_b0 0.97077f
C2188 vdd Xi2/a_3282_4510# 0.00745f
C2189 r1_b2 i2_b0 0.06112f
C2190 Xd3/a_2044_3816# ua0_stim_out 0
C2191 el Xm/in_n 0.0112f
C2192 Xd3/m1_3342_4448# Xd3/a_3820_3816# -0.0055f
C2193 Xi2/g Xi2/m1_988_2984# -0.05796f
C2194 i2_b4 Xi2/a_3078_4510# 0.00147f
C2195 r2_b0 vbn_ref 0.04311f
C2196 Xm/in_p i0_b4 0.05869f
C2197 Xi2/a_528_4510# Xi2/a_732_4510# -0
C2198 r2_b3 Xr/vsp 0.17554f
C2199 r1_b4 vbn_ref 0.01391f
C2200 Xi2/a_732_4510# vdd 0.04811f
C2201 i3_b1 Xr/vgln 0.00183f
C2202 Xi3/g vbn_ref 0.00609f
C2203 r0_b3 i2_b0 0.16618f
C2204 r0_b4 Xi2/a_3282_4510# 0
C2205 vbn_leak Xd1/a_1800_3416# 0.04137f
C2206 Xi1/a_2432_4572# Xr/vgln 0.04318f
C2207 Xi2/g Xg/m1_4538_1930# 0.00693f
C2208 Xi4/g vbn_ref 0.27729f
C2209 r2_b2 i2_b3 0.04437f
C2210 v0_c3 Xd3/m1_5542_4448# 0.0105f
C2211 ua0_stim_out Xg/a_5188_4156# 0.04687f
C2212 Xi3/a_3078_4572# i0_b4 0.00533f
C2213 r0_b4 Xi2/a_732_4510# 0
C2214 i0_b3 Xm/iint 0.0524f
C2215 Xd3/a_2044_3816# Xd3/a_2636_3816# -0.04783f
C2216 bias_en Xd3/a_4412_3816# 0.14719f
C2217 r0_b1 Xi2/a_2228_4510# 0
C2218 r1_b1 Xi2/a_2228_4510# 0.04421f
C2219 i2_b4 i4_b2 0.06989f
C2220 vbn_leak i4_b2 0.18709f
C2221 Xr/vsn Xi1/m1_988_3644# 0.05357f
C2222 Xi3/a_528_4572# vbn_ax 0.03496f
C2223 Xm/in_p i1_b4 0.05992f
C2224 Xm/in_n Xg/m1_4538_1930# 0.06019f
C2225 Xm/a_2240_11218# bias_en 0.043f
C2226 Xr/m1_782_438# ib_r1 0.00549f
C2227 i4_b4 i2_b3 0
C2228 i3_b4 i0_b3 0.10194f
C2229 vbp_w r1_b4 0.05513f
C2230 Xg/m1_5022_10210# r1_b2 0.02951f
C2231 r2_b0 r1_b3 0.04384f
C2232 Xi1/m1_1460_4102# Xr/vsp -0.00404f
C2233 r2_b2 Xi2/a_3928_4510# 0.02548f
C2234 r1_b4 r1_b3 0.63726f
C2235 Xi4/a_2228_4510# vdd 0.02303f
C2236 Xi1/g Xi1/m1_650_4492# -0.02818f
C2237 bias_en Xd3/m1_2702_4448# 0.0279f
C2238 vbp_syn Xr/vsn 0.08543f
C2239 Xi3/g r1_b3 0.24495f
C2240 vbp_w Xi4/g -0.03334f
C2241 Xd3/a_2044_3816# Xr/en_b 0
C2242 Xi3/a_3078_4572# i1_b4 0
C2243 r2_b1 Xr/vglp 0.21837f
C2244 ib_r1 Xr/vglp 0.56738f
C2245 i0_b1 Xr/vgln 0.06359f
C2246 i0_b0 vbn_ref 0.10826f
C2247 Xvi/a_864_6450# Xr/vgln 0.53027f
C2248 vth_ref Xvi/m1_8042_6360# 0
C2249 vdd Xr/vglp 1.54711f
C2250 ib_r1 Xi0/a_3078_4572# 0.05642f
C2251 Xr/vsn Xi2/g 0.24464f
C2252 Xi2/m1_1500_4102# r0_b1 0.05921f
C2253 Xd3/a_5004_3816# v0_c5 0.02625f
C2254 Xi0/a_3928_4572# Xr/vgln 0
C2255 Xi0/a_3078_4572# vdd -0.00123f
C2256 r2_b1 i4_b1 0.04631f
C2257 Xd0/a_1800_3416# r0_b0 0.00605f
C2258 Xi2/m1_1500_4102# r1_b1 0
C2259 el Xd0/m1_4094_3010# 0
C2260 Xd3/m1_2702_4448# Xd3/a_3820_3816# -0
C2261 vbp_st r2_b3 0.0447f
C2262 i3_b3 i0_b4 0.0213f
C2263 vbn_ref Xg/m1_3298_2050# 0
C2264 i4_b3 Xvi/a_864_6450# 0.00492f
C2265 i4_b1 vdd 1.06701f
C2266 Xr/vsn Xm/in_n 1.95564f
C2267 Xi1/a_2228_4572# Xr/vgln 0.01733f
C2268 r2_b2 i2_b2 0.05453f
C2269 i3_b1 i1_b1 0.10487f
C2270 Xi3/m1_1460_4102# Xi3/m1_988_2984# -0.05498f
C2271 r2_b0 ua0_stim_out 0.10229f
C2272 v0_c2 Xm/in_p 0.06585f
C2273 bias_en Xr/m1_342_438# 0.09571f
C2274 i2_b4 r0_b1 0.03979f
C2275 i2_b4 r1_b1 0.71513f
C2276 vbn_leak r1_b1 0.20725f
C2277 vth_ref i4_b4 0.02252f
C2278 ua0_stim_out r1_b4 0.43578f
C2279 el Xi0/g 0
C2280 Xd1/a_4168_3416# r1_b4 0.01038f
C2281 vbp_w Xd0/a_3576_3416# 0.07799f
C2282 Xi3/g ua0_stim_out 1.04609f
C2283 r0_b1 Xi2/a_2432_4510# 0
C2284 r1_b1 Xi2/a_2432_4510# 0.04977f
C2285 Xi3/a_2432_4572# vdd 0.00149f
C2286 i2_b4 r2_b4 0.04028f
C2287 Xi4/a_3282_4510# r2_b3 0.00177f
C2288 vth_ref i0_b3 0.08801f
C2289 vbn_leak r2_b4 0.16956f
C2290 vdd Xi1/a_1582_4572# 0.00694f
C2291 Xi1/a_3282_4572# Xr/vsn 0.00566f
C2292 Xi1/g vbn_ax 0.14169f
C2293 Xg/m1_5022_10210# Xg/m1_6020_10200# -0.0182f
C2294 i2_b4 r1_b0 0.03572f
C2295 i0_b1 Xr/vsp 0.62431f
C2296 r1_b0 vbn_leak 0.11338f
C2297 Xd1/m1_3662_2290# vdd -0
C2298 Xi4/a_2432_4510# Xr/vgln 0.00805f
C2299 Xd3/m1_942_4448# ua0_stim_out 0.03369f
C2300 Xm/a_1744_10100# ua0_s1 0.00157f
C2301 i4_b4 i0_b2 0
C2302 r2_b0 vreset_src 0.04902f
C2303 Xi0/a_3928_4572# Xr/vsp 0.00123f
C2304 Xi3/m1_650_4492# i0_b4 0.03226f
C2305 i2_b1 i2_b3 1.22525f
C2306 i2_b4 r0_b2 0
C2307 Xvi/m1_8332_7080# Xvi/m1_8042_6360# -0
C2308 i4_b4 Xvi/a_4976_1528# 0
C2309 vbn_leak vth_cmp 2.77087f
C2310 vbn_ref Xd0/m1_942_4048# 0.04001f
C2311 v0_c2 v0_c3 1.55845f
C2312 i2_b3 r0_b0 0
C2313 r0_b2 Xi2/a_2432_4510# 0
C2314 Xi2/a_3282_4510# Xr/vgln -0
C2315 ib_r1 Xi0/m1_988_2984# 0.18365f
C2316 i0_b2 i0_b3 0
C2317 vreset_src Xi4/g 0.27198f
C2318 i0_b1 i1_b1 0.02645f
C2319 Xi1/g r1_b2 0.16416f
C2320 Xi0/m1_988_2984# vdd -0.00954f
C2321 Xr/m1_1222_3522# Xm/in_n 0.00217f
C2322 ua0_s0 v0_c0 0.16119f
C2323 v0_c4 Xd3/a_4412_3816# -0
C2324 Xi1/a_2228_4572# Xr/vsp 0
C2325 vbp_st Xi1/a_2432_4572# 0
C2326 Xi1/g Xg/a_1580_5314# -0.05581f
C2327 ua0_stim_out Xd0/a_3576_3416# 0
C2328 ua0_stim_out i0_b0 0.03821f
C2329 Xi3/g Xi1/a_528_4572# 0
C2330 Xd3/m1_3342_4448# vdd -0.00101f
C2331 Xi2/a_3078_4510# vdd 0.00512f
C2332 v0_c0 ib_x2 0.76032f
C2333 vdd Xd1/a_1800_3416# 0
C2334 Xm/in_n i0_b4 0.04435f
C2335 Xi1/g Xg/a_4580_5314# 0.2903f
C2336 Xi3/m1_650_4492# i1_b4 0.00182f
C2337 r2_b1 i4_b2 0.06076f
C2338 vbp_w vbn_ref 0.36679f
C2339 r1_b3 vbn_ref 0.96571f
C2340 Xi3/a_2228_4572# vdd 0
C2341 Xd1/a_2984_3416# el 0.01087f
C2342 ua0_int bias_en 0.35075f
C2343 vdd Xi1/a_1378_4572# 0.00737f
C2344 Xd3/a_3228_3816# v0_c0 0.00931f
C2345 i4_b2 vdd 1.81486f
C2346 i4_b3 Xg/m1_4760_1320# 0
C2347 Xi1/a_3078_4572# Xr/vsn 0.07215f
C2348 Xd3/m1_942_4448# Xr/en_b 0.00165f
C2349 r2_b2 Xi2/a_4132_4510# 0.01485f
C2350 i0_b0 vreset_src 0.06978f
C2351 vreset_src Xd1/a_2392_3416# 0
C2352 Xr/vsn Xi0/g 0.02202f
C2353 ua0_s0 v0_c1 0.16419f
C2354 Xg/m1_4906_9490# Xg/a_3036_4156# -0
C2355 Xi1/m1_988_3644# Xi1/m1_988_2984# -0.0232f
C2356 r1_b1 Xd0/m1_3342_4048# 0.00931f
C2357 vbp_st i0_b1 0.05333f
C2358 Xi1/a_3282_4572# i0_b4 0.00256f
C2359 Xi1/g i2_b0 0
C2360 Xr/vglp Xi0/m1_988_1168# 0.41432f
C2361 Xi4/a_2228_4510# Xr/vgln 0.10529f
C2362 Xm/a_736_7228# ua0_s1 0.24098f
C2363 i1_b4 Xm/in_n 0
C2364 bias_en Xvi/a_2102_5152# 0.14159f
C2365 Xi1/a_732_4572# vbn_ref 0
C2366 ua0_s0 Xd3/m1_1382_4448# 0.00718f
C2367 Xd3/a_4412_3816# vdd 0
C2368 ib_x2 v0_c1 0.20071f
C2369 i2_b1 i2_b2 0.08235f
C2370 Xi3/a_3282_4572# i0_b3 0
C2371 ua0_stim ua0_stim_out 0
C2372 i0_b0 Xi1/a_528_4572# 0
C2373 i4_b0 el 0.41573f
C2374 Xm/a_2240_11218# vdd -0.1184f
C2375 Xd3/m1_1970_3610# ua0_stim_out 0.01298f
C2376 Xr/vglp Xr/vgln 0.89425f
C2377 Xi1/g Xg/m1_6020_10200# 0.13299f
C2378 i2_b2 r0_b0 0
C2379 i3_b2 vdd 0
C2380 vbp_w r1_b3 0.0363f
C2381 Xd2/a_4168_3416# vdd 0.00175f
C2382 Xi4/a_4132_4510# i4_b2 0
C2383 Xi0/a_3078_4572# Xr/vgln 0.00927f
C2384 Xvi/m1_5388_6960# Xi4/g 0.20549f
C2385 vbn_ax i1_b3 0.06781f
C2386 vbp_st ua0_s1 0
C2387 r2_b2 Xm/in_p 0.12968f
C2388 vbp_st Xi1/a_2228_4572# 0.00205f
C2389 Xd1/m1_2318_2410# Xd1/a_2392_3416# -0
C2390 Xd1/a_4168_3416# vbn_ref 0.08796f
C2391 i4_b1 Xr/vgln 0.06116f
C2392 Xd3/a_3228_3816# v0_c1 0.12997f
C2393 i1_b2 Xi3/a_2432_4572# 0.07932f
C2394 vbn_leak Xvi/a_2102_5152# 0.00223f
C2395 bias_en Xm/iint 1.66871f
C2396 i4_b3 Xr/vglp 0.10711f
C2397 Xd3/m1_2702_4448# vdd 0
C2398 Xd0/m1_3342_4048# vth_cmp 0
C2399 Xd3/m1_4328_3000# Xm/in_p 0.0018f
C2400 r2_b2 Xd2/a_3576_3416# 0.0551f
C2401 Xi0/a_3282_4572# Xm/iint 0.0261f
C2402 Xi4/g Xg/m1_5516_1920# -0.00678f
C2403 vbn_ax Xg/m1_6282_1450# 0.0035f
C2404 ua0_stim Xd3/a_2636_3816# 0
C2405 r2_b1 r1_b1 0.19494f
C2406 Xvi/a_5712_1328# ib_x2 0.04825f
C2407 ua0_stim_out Xm/a_1764_11418# 0
C2408 Xd3/a_2636_3816# Xd3/m1_1970_3610# -0
C2409 i4_b3 i4_b1 0
C2410 Xi1/g Xg/m1_5022_10210# 0.02654f
C2411 i4_b4 Xm/in_p 0.0478f
C2412 r2_b0 r2_b3 1.22257f
C2413 Xd1/m1_3492_2640# r1_b1 0
C2414 Xm/in_n Xi1/m1_988_2984# 0.12777f
C2415 Xd0/m1_2760_3412# vbn_ref 0.01212f
C2416 r2_b1 r2_b4 0.22944f
C2417 r2_b3 r1_b4 0.42271f
C2418 r1_b1 Xi2/a_528_4510# 0.04038f
C2419 r0_b1 vdd 0.37917f
C2420 Xi3/g r2_b3 0.00208f
C2421 r1_b1 vdd 1.30015f
C2422 Xvi/m1_502_738# Xr/vsn 0.04846f
C2423 Xi1/a_1582_4572# Xr/vgln 0.00431f
C2424 r2_b4 vdd 1.84799f
C2425 Xm/in_p i0_b3 0.35623f
C2426 vbn_leak Xm/iint 0.10521f
C2427 Xi4/g r2_b3 0.5451f
C2428 r2_b1 r1_b0 0.17333f
C2429 vbp_w ua0_stim_out 0.11986f
C2430 r0_b4 r0_b1 0.22539f
C2431 Xvi/m1_1276_6360# vreset_src 0.01431f
C2432 ib_r1 Xr/m1_342_438# 0
C2433 ua0_stim_out r1_b3 0.31941f
C2434 r0_b4 r1_b1 0.11581f
C2435 Xd1/a_4168_3416# r1_b3 -0.00323f
C2436 ua0_stim Xr/en_b 0.94702f
C2437 Xi1/a_3078_4572# i0_b4 0.04353f
C2438 Xr/m1_342_438# vdd -0
C2439 Xi3/m1_988_3644# i1_b3 0.00541f
C2440 Xi2/m1_988_1168# Xr/vgln 0.02267f
C2441 Xr/vglp Xr/vsp 1.41274f
C2442 r1_b0 vdd 1.62989f
C2443 Xi1/a_528_4572# vbn_ref 0.00342f
C2444 Xd3/m1_4328_3000# v0_c3 0.0017f
C2445 Xi3/a_3078_4572# i0_b3 0
C2446 r2_b1 vth_cmp 0.04441f
C2447 Xi0/m1_988_2984# Xi0/m1_988_1168# -0.00806f
C2448 Xi0/a_3078_4572# Xr/vsp 0.03039f
C2449 Xi1/m1_988_1168# Xr/vglp 0.03454f
C2450 i2_b4 i2_b3 0.02984f
C2451 Xd1/m1_3492_2640# vth_cmp 0
C2452 Xr/m1_3862_3522# Xr/en_b 0.00155f
C2453 Xd0/m1_2760_3412# vbp_w 0.07972f
C2454 r0_b2 vdd 0.43186f
C2455 vdd Xi2/a_1582_4510# 0.04124f
C2456 i2_b2 Xi2/a_2228_4510# 0.05365f
C2457 i4_b1 Xr/vsp 0.11867f
C2458 vdd vth_cmp 0.34781f
C2459 Xd3/a_2044_3816# ua0_s1 0.00443f
C2460 vbp_w vreset_src 0.10793f
C2461 i4_b0 Xr/vsn 0.23422f
C2462 Xr/vsn ib_x2 0.28411f
C2463 i1_b0 i0_b2 0.49041f
C2464 Xi1/a_3078_4572# i1_b4 0
C2465 Xg/a_7580_5314# vdd -0.02283f
C2466 i1_b2 Xi3/a_2228_4572# 0.11253f
C2467 Xm/a_420_700# Xm/a_736_5516# -0.08508f
C2468 Xr/en_b Xm/a_1764_11418# 0
C2469 r0_b2 r0_b4 1.33889f
C2470 ua0_int v0_c4 0.17723f
C2471 i2_b1 Xi2/a_4132_4510# 0
C2472 r0_b4 Xi2/a_1582_4510# 0
C2473 bias_en vth_ref 0.09879f
C2474 r0_b3 Xi2/m1_988_3644# 0.07875f
C2475 r2_b2 Xd2/m1_3982_4048# 0.00319f
C2476 i2_b4 Xi2/a_3928_4510# 0.09365f
C2477 Xd2/m1_3982_4048# vbn_prb 0.08589f
C2478 i4_b2 Xr/vgln 0.44904f
C2479 Xi1/a_1378_4572# Xr/vgln 0.00355f
C2480 Xi2/m1_1500_4102# i2_b2 0
C2481 Xi2/a_1378_4510# vdd 0.04219f
C2482 ua0_s0 Xd3/m1_5542_4448# 0.01187f
C2483 i3_b3 i0_b3 0.07198f
C2484 vth_ref vbn_leak 0.00665f
C2485 vbn_ax Xi3/m1_988_2984# -0
C2486 i1_b2 i3_b2 0.19397f
C2487 i2_b1 Xm/in_p 0.63222f
C2488 r1_b1 Xd0/a_2392_3416# 0.0376f
C2489 r0_b1 Xd0/a_2392_3416# 0.00588f
C2490 bias_en i0_b2 0.04764f
C2491 Xd3/a_2636_3816# ua0_stim_out 0.00239f
C2492 i4_b3 i4_b2 0.84718f
C2493 vbn_ref Xg/m1_5516_1920# 0
C2494 vbp_st Xr/vglp 0.37793f
C2495 Xd3/m1_5542_4448# ib_x2 0
C2496 bias_en Xvi/a_4976_1528# 0.06725f
C2497 Xi0/m1_988_2984# Xr/vsp -0.00709f
C2498 vbn_ax el 0.22705f
C2499 Xi1/a_4132_4572# Xr/vsn 0.01565f
C2500 r2_b2 vbp_syn 0.55339f
C2501 i2_b4 i2_b2 1.05611f
C2502 vbp_syn vbn_prb 0.11242f
C2503 ua0_stim ua0 0.0303f
C2504 Xi4/a_528_4510# vbp_w -0
C2505 i2_b2 Xi2/a_2432_4510# 0.07231f
C2506 i3_b2 Xr/vgln 0.02561f
C2507 vbp_st i4_b1 0.44716f
C2508 Xg/a_3036_4156# Xi0/g -0.00144f
C2509 ua0_int vdd 0.94923f
C2510 vdd Xd0/a_1800_3416# -0.02869f
C2511 r2_b2 Xi2/g 0.00419f
C2512 Xi4/a_1378_4510# vdd 0.00268f
C2513 r2_b3 vbn_ref 0.05649f
C2514 r2_b0 Xvi/a_864_6450# 0
C2515 Xi3/g i0_b1 0.04003f
C2516 ib_r1 Xvi/a_2102_5152# 0.01274f
C2517 vbn_leak Xvi/a_4976_1528# 0.07461f
C2518 ua0_stim_out Xr/en_b 0.07809f
C2519 vdd Xvi/a_2102_5152# -0.07509f
C2520 bias_en Xvi/m1_8332_7080# 0
C2521 i0_b4 ib_x2 0.03712f
C2522 Xi1/m1_650_4492# Xr/vsn 0.06641f
C2523 r0_b2 Xd0/a_2392_3416# -0.00464f
C2524 Xvi/a_864_6450# Xi4/g 0.31493f
C2525 el r1_b2 0.04303f
C2526 Xi3/m1_988_3644# Xi3/m1_988_2984# -0.01951f
C2527 i4_b2 Xr/vsp 0.10559f
C2528 vbn_ax Xg/m1_4538_1930# 0.0086f
C2529 r0_b1 Xr/vgln 0.28074f
C2530 i4_b4 Xi2/g 0.39691f
C2531 r1_b1 Xr/vgln 0.0776f
C2532 ib_r1 Xm/iint 0.59344f
C2533 r2_b4 Xr/vgln 0.04497f
C2534 Xi2/m1_988_2984# r1_b2 0.20307f
C2535 vdd Xm/iint 1.52401f
C2536 i4_b4 i3_b0 0
C2537 Xvi/m1_8332_7080# vbn_leak 0.05659f
C2538 vbp_w r2_b3 0.10061f
C2539 i4_b4 Xm/in_n 0.07402f
C2540 i1_b4 ib_x2 0.3156f
C2541 Xm/in_p i1_b0 0.05191f
C2542 Xg/m1_3530_1930# i4_b1 0
C2543 Xr/m1_342_438# Xr/vgln -0.00346f
C2544 r0_b3 Xi2/m1_988_2984# 0.05822f
C2545 r2_b3 r1_b3 0.04476f
C2546 r1_b0 Xr/vgln 0.10096f
C2547 vreset_src Xd1/m1_2318_2410# 0.0064f
C2548 Xm/in_n i0_b3 0.03867f
C2549 vbn_ref Xi1/m1_1460_4102# -0.02594f
C2550 r2_b1 i2_b3 0.03542f
C2551 i0_b1 i0_b0 0.82194f
C2552 Xg/a_1580_5314# Xg/m1_4538_1930# -0
C2553 i3_b4 vdd 0.00383f
C2554 Xi1/a_3928_4572# Xr/vsn 0.01258f
C2555 r0_b2 Xr/vgln 0
C2556 vdd i2_b3 0.36812f
C2557 vth_cmp Xr/vgln 0.04296f
C2558 Xi1/a_4132_4572# i0_b4 0.02066f
C2559 i3_b2 i1_b1 0
C2560 Xr/vsn vbn_ax 0.46399f
C2561 Xi4/a_528_4510# vreset_src 0.05768f
C2562 Xr/vglp Xg/a_5188_4156# 0.07268f
C2563 vbn_ref Xi1/a_2432_4572# 0
C2564 r0_b4 i2_b3 0.00265f
C2565 i2_b4 Xi2/a_4132_4510# 0.011f
C2566 i4_b3 vth_cmp 0.07038f
C2567 ua0_s0 v0_c2 0.34326f
C2568 Xvi/m1_5388_6960# vreset_src 0.03838f
C2569 r2_b2 Xd0/m1_4094_3010# 0
C2570 vbp_syn Xi2/m1_640_4420# 0.01502f
C2571 r1_b1 Xr/vsp 0.14912f
C2572 Xi1/m1_988_2984# ib_x2 0.14942f
C2573 i4_b1 Xg/a_5188_4156# 0.27065f
C2574 vbn_prb Xd0/m1_4094_3010# 0.05131f
C2575 Xr/vsn Xi4/m1_988_2984# -0.00386f
C2576 Xi1/g Xg/m1_6282_1450# 0.00327f
C2577 bias_en Xm/in_p -0.03813f
C2578 vbp_st i4_b2 0.05681f
C2579 vbp_st Xi1/a_1378_4572# 0
C2580 ua0_stim_out r2_b3 0.28228f
C2581 r2_b4 Xr/vsp 0.23589f
C2582 Xi1/m1_650_4492# i0_b4 0.09892f
C2583 i4_b3 Xg/a_7580_5314# 0.00751f
C2584 v0_c2 ib_x2 0.21694f
C2585 Xi1/a_4132_4572# i1_b4 0
C2586 Xi2/g Xi2/m1_640_4420# -0.01163f
C2587 Xr/vsn r1_b2 0.20586f
C2588 Xi2/a_3928_4510# vdd 0.00236f
C2589 i1_b2 Xi3/a_1582_4572# 0.01049f
C2590 Xm/a_2240_11218# Xm/a_736_7228# -0.05653f
C2591 i4_b0 Xg/a_3036_4156# 0.29824f
C2592 i2_b1 vbp_syn 0.00162f
C2593 Xg/a_1580_5314# Xr/vsn -0.01407f
C2594 v0_c3 Xd3/m1_5982_4448# 0.10757f
C2595 vbp_syn r0_b0 0.05943f
C2596 Xr/m1_342_438# Xr/vsp 0.04312f
C2597 r1_b0 Xr/vsp 0.20453f
C2598 ib_r1 vth_ref 0.07859f
C2599 Xr/vsn r0_b3 0.01719f
C2600 vth_ref vdd 0.62774f
C2601 i2_b4 Xm/in_p 0.23987f
C2602 Xi4/g Xg/m1_4760_1320# -0.00991f
C2603 v0_c2 Xd3/a_3228_3816# 0.19558f
C2604 i0_b1 vbn_ref 0.08332f
C2605 Xi4/a_3282_4510# i4_b2 0
C2606 vreset_src Xd1/m1_1716_2640# 0.01919f
C2607 v0_c5 v0_c1 0.03391f
C2608 vreset_src r2_b3 0.21905f
C2609 Xr/vsn Xg/a_4580_5314# 0.0386f
C2610 r2_b1 i2_b2 0.03433f
C2611 ua0_stim ua0_s1 0.95752f
C2612 bias_en v0_c3 0.07168f
C2613 vdd i2_b2 0.75307f
C2614 Xvi/m1_1276_6360# Xvi/a_864_6450# -0.07613f
C2615 Xr/m1_1662_438# Xr/m1_342_438# -0
C2616 Xi1/a_3928_4572# i0_b4 0.00886f
C2617 Xg/a_7580_5314# Xr/vsp -0
C2618 Xi4/a_1378_4510# Xr/vgln 0.00119f
C2619 i4_b4 Xi0/g 0.38258f
C2620 Xd3/m1_3600_4920# ua0_stim_out 0.00264f
C2621 r2_b1 Xvi/a_4976_1528# 0
C2622 Xg/m1_3530_1930# i4_b2 0.10117f
C2623 r1_b1 Xd0/a_2984_3416# 0.03422f
C2624 Xr/vglp r1_b4 0.41891f
C2625 i0_b2 vdd 1.34427f
C2626 ib_r1 Xvi/a_4976_1528# 0.03205f
C2627 Xi1/a_3078_4572# i0_b3 0.00173f
C2628 Xi3/g Xr/vglp 0.10078f
C2629 vbn_ax i0_b4 0.00138f
C2630 r0_b4 i2_b2 0
C2631 Xvi/a_2102_5152# Xr/vgln 0.11918f
C2632 vdd Xvi/a_4976_1528# 0.06482f
C2633 v0_c3 Xd3/a_3820_3816# 0
C2634 Xr/vglp Xi4/g 0.24404f
C2635 Xd1/m1_1716_2640# Xd1/m1_2318_2410# -0
C2636 vbp_st r1_b1 0.06403f
C2637 Xd3/a_5004_3816# Xd3/m1_5542_4448# -0.00569f
C2638 r2_b0 i4_b1 0.04841f
C2639 i4_b1 r1_b4 0
C2640 Xd1/m1_502_4048# vreset_src 0.05014f
C2641 Xm/a_1764_11418# ua0_s1 0
C2642 Xd0/m1_502_4048# vth_cmp 0
C2643 vbp_st r2_b4 0.43776f
C2644 Xi3/g i4_b1 0.37278f
C2645 Xm/iint Xi0/m1_988_1168# 0.01893f
C2646 i1_b2 Xi3/a_1378_4572# 0.00835f
C2647 ua0_s0 Xm/a_736_5516# 0.23308f
C2648 Xi1/m1_650_4492# Xi1/m1_988_2984# -0
C2649 Xi1/a_3928_4572# i1_b4 0.00216f
C2650 Xd3/m1_1822_4448# vdd 0.00326f
C2651 i3_b4 i1_b2 0
C2652 i4_b1 Xi4/g 0.24061f
C2653 Xm/iint Xr/vgln 0.16663f
C2654 vbp_syn Xi2/a_2228_4510# 0
C2655 Xvi/m1_502_738# vbn_prb 0.02762f
C2656 vbp_st r1_b0 0.057f
C2657 vbp_st Xr/m1_342_438# 0.01214f
C2658 r0_b2 Xd0/a_2984_3416# 0.00838f
C2659 Xi4/a_528_4510# r2_b3 0
C2660 Xd1/m1_2910_2650# r1_b1 0
C2661 Xvi/m1_8332_7080# vdd 0.05923f
C2662 i4_b2 Xg/a_5188_4156# 0.13565f
C2663 r2_b2 Xd1/a_2984_3416# 0.05466f
C2664 vbp_st vth_cmp 0.06271f
C2665 Xi3/a_1582_4572# i1_b1 0
C2666 i3_b4 Xr/vgln 0.14958f
C2667 i1_b0 i3_b0 0.01795f
C2668 i0_b0 Xr/vglp 0.22671f
C2669 Xi2/m1_988_1168# r1_b4 0.22795f
C2670 Xm/a_420_700# bias_en 0.11078f
C2671 Xd0/m1_4094_3010# r0_b0 0
C2672 i2_b4 Xg/m1_4906_9490# 0
C2673 i2_b3 Xr/vgln 0.34193f
C2674 ua0_stim_out i0_b1 0.04248f
C2675 Xvi/m1_7102_850# ib_x2 0.0503f
C2676 Xi1/g el 0.01335f
C2677 vbp_st Xg/a_7580_5314# 0.13564f
C2678 vth_cmp Xd0/m1_1382_4048# 0
C2679 Xd3/m1_2702_4448# Xd3/a_2044_3816# -0
C2680 Xi3/a_3282_4572# vdd 0.04156f
C2681 Xi0/a_2228_4572# Xm/iint 0.01951f
C2682 ua0_s0 Xd3/m1_4328_3000# 0.04f
C2683 Xvi/m1_8042_6360# ib_x2 0.00148f
C2684 i4_b3 i2_b3 0.04063f
C2685 Xm/a_1744_10100# Xm/iint 0.16018f
C2686 vbn_prb ib_x2 0.47524f
C2687 Xd1/m1_2910_2650# vth_cmp 0
C2688 vbn_ref Xg/m1_4760_1320# 0
C2689 Xi2/a_4132_4510# vdd 0.00486f
C2690 i4_b1 Xg/m1_3298_2050# 0
C2691 i2_b1 Xi0/g 0.00287f
C2692 ua0_stim_out ua0_s1 0.00222f
C2693 Xd1/a_3576_3416# Xd1/a_2984_3416# -0.00482f
C2694 Xd3/m1_4648_4446# Xm/in_p 0
C2695 Xm/iint Xr/vsp 0.52703f
C2696 Xg/a_3036_4156# vbn_ax 0.00675f
C2697 Xi2/a_3928_4510# Xr/vgln -0.01041f
C2698 i0_b1 vreset_src 0.02165f
C2699 r0_b4 Xi2/a_4132_4510# 0
C2700 vbp_syn vbn_leak 0
C2701 vreset_src Xvi/a_864_6450# 0.45271f
C2702 ua0_int Xm/a_736_7228# 0.13092f
C2703 i4_b0 i4_b4 0.00569f
C2704 bias_en Xm/in_n 0.30828f
C2705 v0_c4 v0_c3 0.39354f
C2706 bias_en Xi0/a_1582_4572# 0.04367f
C2707 Xi0/a_3928_4572# vreset_src 0.08893f
C2708 r2_b1 Xm/in_p 0.1786f
C2709 bias_en Xi0/a_1378_4572# 0.06348f
C2710 vth_ref Xr/vgln 0.51351f
C2711 Xvi/m1_8042_6360# vss -0.3353f
C2712 vbn_prb vss -0.94191f
C2713 el vss 2.06623f
C2714 Xvi/m1_4546_7560# vss -0.34515f
C2715 ib_x2 vss 1.53785f
C2716 Xm/iint vss 2.20127f
C2717 vth_cmp vss 2.93463f
C2718 Xvi/m1_1382_738# vss -0.2714f
C2719 Xvi/m1_942_738# vss -0.31088f
C2720 Xvi/m1_502_738# vss -0.25555f
C2721 Xvi/m1_7440_2050# vss -0.41505f
C2722 vth_ref vss 1.73502f
C2723 Xvi/m1_8332_7080# vss -0.17243f
C2724 Xvi/a_2102_5152# vss -0.51082f
C2725 Xvi/a_4976_1528# vss -0.86552f
C2726 Xvi/a_864_6450# vss -2.60594f
C2727 Xvi/m1_4894_1238# vss -0.72383f
C2728 Xr/vglp vss -2.3568f
C2729 vreset_src vss 5.67207f
C2730 Xvi/m1_5388_6960# vss -0.33944f
C2731 Xvi/a_5712_1328# vss -1.70467f
C2732 Xvi/m1_8646_1098# vss -0.08242f
C2733 bias_en vss 0.1284f
C2734 Xvi/m1_7102_850# vss -0.71446f
C2735 Xvi/m1_1276_6360# vss -0.32612f
C2736 ib_r1 vss 0.45979f
C2737 vdd vss -0.29969p
C2738 Xd3/m1_4488_3600# vss -0.77844f
C2739 Xd3/m1_4328_3000# vss -0.96429f
C2740 Xd3/m1_1382_4448# vss -0.30877f
C2741 Xd3/m1_1822_4448# vss -0.25231f
C2742 Xd3/m1_3342_4448# vss -0.8437f
C2743 Xd3/m1_2702_4448# vss -1.00828f
C2744 Xd3/m1_3600_4920# vss -0.83263f
C2745 Xd3/m1_942_4448# vss -0.30655f
C2746 Xd3/m1_1970_3610# vss -0.6554f
C2747 Xd3/m1_502_4448# vss -0.26332f
C2748 Xd3/m1_5982_4448# vss -0.25516f
C2749 Xd3/m1_5542_4448# vss -0.25598f
C2750 Xd3/a_2044_3816# vss -0.15626f
C2751 v0_c0 vss 0.66219f
C2752 Xd3/a_2636_3816# vss -0.35314f
C2753 v0_c1 vss 0.94507f
C2754 Xd3/a_3228_3816# vss -0.4744f
C2755 v0_c2 vss 0.70391f
C2756 Xd3/a_3820_3816# vss -0.32799f
C2757 v0_c3 vss 0.77014f
C2758 v0_c5 vss 2.99161f
C2759 Xd3/a_4412_3816# vss -0.37157f
C2760 v0_c4 vss 1.59345f
C2761 Xd3/a_5004_3816# vss -0.24003f
C2762 Xd3/m1_4648_4446# vss -0.24968f
C2763 Xd2/m1_3982_4048# vss -0.60739f
C2764 Xd2/m1_1382_4048# vss -0.28523f
C2765 Xd2/m1_2900_3120# vss -0.81256f
C2766 Xd2/m1_3542_4048# vss -0.74574f
C2767 Xd2/m1_942_4048# vss -0.3056f
C2768 Xd2/m1_2156_3240# vss -0.84458f
C2769 Xd2/m1_1822_4048# vss -0.60885f
C2770 Xd2/m1_502_4048# vss -0.23947f
C2771 Xd2/a_1800_3416# vss -0.26363f
C2772 r2_b0 vss 2.19311f
C2773 Xd2/a_2392_3416# vss -0.34211f
C2774 r2_b1 vss 1.65192f
C2775 Xd2/a_2984_3416# vss -0.32395f
C2776 r2_b2 vss 0.98079f
C2777 r2_b4 vss 1.61679f
C2778 Xd2/a_3576_3416# vss -0.39293f
C2779 r2_b3 vss 1.02766f
C2780 Xd2/a_4168_3416# vss -0.25706f
C2781 Xr/m1_3862_3522# vss -0.25117f
C2782 Xr/m1_3422_438# vss -0.23682f
C2783 Xr/m1_2542_438# vss -0.23682f
C2784 Xr/m1_1662_438# vss -0.23682f
C2785 Xr/m1_1222_3522# vss -0.25114f
C2786 Xr/m1_782_438# vss -0.23682f
C2787 Xr/m1_342_438# vss -0.93463f
C2788 Xd1/m1_3662_2290# vss -0.70839f
C2789 Xd1/m1_2910_2650# vss -0.74367f
C2790 Xd1/m1_3492_2640# vss -0.75377f
C2791 Xd1/m1_942_4048# vss -0.3022f
C2792 Xd1/m1_2318_2410# vss -0.86047f
C2793 Xd1/m1_1716_2640# vss -0.62336f
C2794 Xd1/m1_502_4048# vss -0.29259f
C2795 Xd1/a_1800_3416# vss -0.25097f
C2796 r1_b0 vss 1.04477f
C2797 Xd1/a_2392_3416# vss -0.33895f
C2798 r1_b1 vss 0.57987f
C2799 Xd1/a_2984_3416# vss -0.38894f
C2800 r1_b2 vss 1.07623f
C2801 r1_b4 vss 1.0663f
C2802 Xd1/a_3576_3416# vss -0.38025f
C2803 r1_b3 vss 0.59394f
C2804 Xd1/a_4168_3416# vss -0.24688f
C2805 Xd1/m1_3782_4048# vss -0.26394f
C2806 Xd0/m1_4094_3010# vss -0.71691f
C2807 Xd0/m1_1382_4048# vss -0.28101f
C2808 Xd0/m1_2760_3412# vss -0.66789f
C2809 Xd0/m1_3342_4048# vss -0.75904f
C2810 Xd0/m1_942_4048# vss -0.30017f
C2811 Xd0/m1_2262_4048# vss -0.80692f
C2812 Xd0/m1_1822_4048# vss -0.63866f
C2813 Xd0/m1_502_4048# vss -0.23529f
C2814 Xd0/a_1800_3416# vss -0.24587f
C2815 r0_b0 vss 0.24018f
C2816 Xd0/a_2392_3416# vss -0.34447f
C2817 r0_b1 vss -0.36857f
C2818 Xd0/a_2984_3416# vss -0.36764f
C2819 r0_b2 vss -0.03545f
C2820 r0_b4 vss -0.57552f
C2821 Xd0/a_3576_3416# vss -0.34676f
C2822 r0_b3 vss 0.51232f
C2823 Xd0/a_4168_3416# vss -0.25734f
C2824 Xd0/m1_4222_4048# vss -0.27971f
C2825 Xi4/m1_988_1168# vss -1.40865f
C2826 Xr/vsn vss -10.42078f
C2827 Xi4/g vss -12.36136f
C2828 Xi4/a_3928_4510# vss -0.18392f
C2829 Xi4/a_3078_4510# vss -0.17856f
C2830 Xi4/a_1378_4510# vss -0.1807f
C2831 Xi4/a_2432_4510# vss -0.26774f
C2832 Xi4/a_2228_4510# vss -0.18452f
C2833 vbp_w vss 1.57445f
C2834 Xi4/a_528_4510# vss -0.16942f
C2835 Xi4/m1_640_4420# vss -0.51116f
C2836 Xi4/m1_1500_4102# vss -0.13305f
C2837 Xi4/m1_988_3644# vss -0.36806f
C2838 Xi4/a_4132_4510# vss -0.26888f
C2839 i4_b4 vss 2.43396f
C2840 i4_b2 vss 1.09017f
C2841 Xi4/a_3282_4510# vss -0.27427f
C2842 i4_b3 vss 1.17204f
C2843 Xi4/a_1582_4510# vss -0.27141f
C2844 i4_b1 vss 1.57336f
C2845 Xi4/a_732_4510# vss -0.26584f
C2846 i4_b0 vss 1.29405f
C2847 Xr/vgln vss -8.81852f
C2848 Xi4/m1_988_2984# vss -0.73496f
C2849 vbp_st vss 3.0136f
C2850 Xi3/m1_988_1168# vss -0.00605f
C2851 Xi3/g vss -4.85611f
C2852 Xi3/a_4132_4572# vss -0.1234f
C2853 Xi3/a_3928_4572# vss -0.20784f
C2854 Xi3/a_3282_4572# vss -0.12262f
C2855 Xi3/a_3078_4572# vss -0.20837f
C2856 Xi3/a_1582_4572# vss -0.11178f
C2857 Xi3/a_1378_4572# vss -0.15272f
C2858 Xi3/a_2432_4572# vss -0.12293f
C2859 Xi3/a_2228_4572# vss -0.20421f
C2860 vbn_ax vss 2.20731f
C2861 Xi3/a_732_4572# vss -0.1036f
C2862 Xi3/a_528_4572# vss -0.21011f
C2863 Xi3/m1_650_4492# vss -0.08138f
C2864 Xi3/m1_1460_4102# vss -0.02286f
C2865 Xi3/m1_988_3644# vss 0.04118f
C2866 i3_b4 vss 0.44817f
C2867 i3_b3 vss 0.33482f
C2868 i3_b2 vss 0.45263f
C2869 i3_b1 vss 0.30991f
C2870 i3_b0 vss -0.02054f
C2871 Xi3/m1_988_2984# vss 0.02643f
C2872 Xi2/m1_988_1168# vss -1.375f
C2873 Xi2/g vss -13.04354f
C2874 Xi2/a_3928_4510# vss -0.18392f
C2875 Xi2/a_3078_4510# vss -0.17856f
C2876 Xi2/a_1378_4510# vss -0.1807f
C2877 Xi2/a_2432_4510# vss -0.26833f
C2878 Xi2/a_2228_4510# vss -0.1841f
C2879 vbp_syn vss 1.43673f
C2880 Xi2/a_528_4510# vss -0.18161f
C2881 Xi2/m1_640_4420# vss -0.52246f
C2882 Xi2/m1_1500_4102# vss -0.13305f
C2883 Xi2/m1_988_3644# vss -0.36806f
C2884 Xi2/a_4132_4510# vss -0.27112f
C2885 i2_b4 vss 0.23779f
C2886 i2_b2 vss 0.24943f
C2887 Xi2/a_3282_4510# vss -0.28408f
C2888 i2_b3 vss -0.66445f
C2889 Xi2/a_1582_4510# vss -0.27145f
C2890 i2_b1 vss 0.29356f
C2891 Xi2/a_732_4510# vss -0.27037f
C2892 i2_b0 vss -0.52174f
C2893 Xi2/m1_988_2984# vss -0.73496f
C2894 Xm/a_2240_11218# vss -0.72578f
C2895 ua0_int vss 1.73056f
C2896 Xm/a_736_7228# vss -7.58305f
C2897 Xr/en_b vss 0.38043f
C2898 ua0_stim_out vss 0.55256f
C2899 ua0_stim vss 0.38641f
C2900 Xm/a_1764_11418# vss -0.52693f
C2901 Xm/a_736_5516# vss -6.7117f
C2902 Xm/a_1744_9182# vss -0.51757f
C2903 Xm/a_420_700# vss -1.47972f
C2904 ua0_s0 vss 1.02529f
C2905 ua0_s1 vss 2.00525f
C2906 ua0 vss 1.07729f
C2907 Xm/a_1744_10100# vss -0.56388f
C2908 Xi1/m1_988_1168# vss 0.04449f
C2909 Xi1/g vss -4.74119f
C2910 Xi1/a_4132_4572# vss -0.12402f
C2911 Xi1/a_3928_4572# vss -0.2103f
C2912 Xi1/a_3282_4572# vss -0.12268f
C2913 Xi1/a_3078_4572# vss -0.20911f
C2914 Xi1/a_1582_4572# vss -0.08197f
C2915 Xi1/a_1378_4572# vss -0.16755f
C2916 Xi1/a_2432_4572# vss -0.12258f
C2917 Xi1/a_2228_4572# vss -0.20743f
C2918 vbn_ref vss 0.96684f
C2919 Xi1/a_732_4572# vss -0.0808f
C2920 Xi1/a_528_4572# vss -0.16411f
C2921 Xi1/m1_650_4492# vss -0.10382f
C2922 Xi1/m1_1460_4102# vss -0.03562f
C2923 Xi1/m1_988_3644# vss -0.04566f
C2924 i1_b4 vss 0.62326f
C2925 i1_b3 vss 0.41065f
C2926 i1_b2 vss 0.64029f
C2927 i1_b1 vss 1.31004f
C2928 i1_b0 vss 0.46347f
C2929 Xi1/m1_988_2984# vss -0.07753f
C2930 Xi0/m1_988_1168# vss -0.1391f
C2931 Xr/vsp vss -17.99076f
C2932 Xi0/g vss -3.54836f
C2933 Xi0/a_4132_4572# vss -0.12772f
C2934 Xi0/a_3928_4572# vss -0.21047f
C2935 Xi0/a_3282_4572# vss -0.12268f
C2936 Xi0/a_3078_4572# vss -0.21103f
C2937 Xi0/a_1582_4572# vss -0.1249f
C2938 Xi0/a_1378_4572# vss -0.20885f
C2939 Xi0/a_2432_4572# vss -0.12308f
C2940 Xi0/a_2228_4572# vss -0.20932f
C2941 vbn_leak vss -2.481f
C2942 Xi0/a_732_4572# vss -0.1247f
C2943 Xi0/a_528_4572# vss -0.21147f
C2944 Xi0/m1_650_4492# vss -0.09597f
C2945 Xi0/m1_1460_4102# vss -0.02889f
C2946 Xi0/m1_988_3644# vss -0.04434f
C2947 i0_b4 vss 0.93079f
C2948 i0_b3 vss 0.99243f
C2949 i0_b2 vss 0.81367f
C2950 i0_b1 vss 1.77599f
C2951 i0_b0 vss 0.99451f
C2952 Xi0/m1_988_2984# vss -0.07617f
C2953 Xg/a_1580_5314# vss -0.48033f
C2954 Xg/m1_4906_9490# vss -0.10125f
C2955 Xg/m1_3898_9610# vss -0.0928f
C2956 Xg/m1_3666_9610# vss -0.09243f
C2957 Xm/in_p vss 0.82059f
C2958 Xg/m1_4538_1930# vss -0.22289f
C2959 Xg/m1_3530_1930# vss -0.41746f
C2960 Xg/m1_3298_2050# vss -0.25646f
C2961 Xm/in_n vss 0.69567f
C2962 Xg/a_5188_4156# vss -0.90864f
C2963 Xg/a_7580_5314# vss -0.07977f
C2964 Xg/a_3036_4156# vss -0.8961f
C2965 Xg/a_4580_5314# vss -0.16567f
C2966 Xg/m1_6282_1450# vss -0.11967f
C2967 Xg/m1_5516_1920# vss -0.25072f
C2968 Xg/m1_4760_1320# vss -0.18804f
C2969 Xg/m1_6020_10200# vss -0.14796f
C2970 Xg/m1_5022_10210# vss -0.09562f
.ends
