* NGSPICE file created from bias_b1.ext - technology: gf180mcuD

.subckt n_w2_l4_f4 a_n52_n200# a_852_n200# a_n852_n244# a_n956_n200# a_52_n244# a_n1756_n244#
+ a_1756_n200# a_n1844_n200# a_956_n244# VSUBS
X0 a_852_n200# a_52_n244# a_n52_n200# VSUBS nfet_03v3 ad=0.52p pd=2.52u as=0.52p ps=2.52u w=2u l=4u
X1 a_1756_n200# a_956_n244# a_852_n200# VSUBS nfet_03v3 ad=0.88p pd=4.88u as=0.52p ps=2.52u w=2u l=4u
X2 a_n956_n200# a_n1756_n244# a_n1844_n200# VSUBS nfet_03v3 ad=0.52p pd=2.52u as=0.88p ps=4.88u w=2u l=4u
X3 a_n52_n200# a_n852_n244# a_n956_n200# VSUBS nfet_03v3 ad=0.52p pd=2.52u as=0.52p ps=2.52u w=2u l=4u
C0 a_n52_n200# a_852_n200# 0.01073f
C1 a_n1844_n200# a_n1756_n244# 0.07019f
C2 a_52_n244# a_n52_n200# 0.07019f
C3 a_n852_n244# a_n1756_n244# 0.00519f
C4 a_852_n200# a_1756_n200# 0.01073f
C5 a_52_n244# a_852_n200# 0.07019f
C6 a_n1844_n200# a_n956_n200# 0.01073f
C7 a_n956_n200# a_n852_n244# 0.07019f
C8 a_n956_n200# a_n1756_n244# 0.07019f
C9 a_n52_n200# a_n852_n244# 0.07019f
C10 a_956_n244# a_852_n200# 0.07019f
C11 a_52_n244# a_n852_n244# 0.00519f
C12 a_956_n244# a_1756_n200# 0.07019f
C13 a_52_n244# a_956_n244# 0.00519f
C14 a_n956_n200# a_n52_n200# 0.01073f
C15 a_1756_n200# VSUBS 0.41176f
C16 a_852_n200# VSUBS 0.648f
C17 a_n52_n200# VSUBS 0.64292f
C18 a_n956_n200# VSUBS 0.648f
C19 a_n1844_n200# VSUBS 0.41176f
.ends

.subckt rx_n4 line vdd vss
XD vss line line line line line vss vss line vss n_w2_l4_f4
C0 vdd vss 0.06604f
C1 line vss 2.16208f
.ends

.subckt n_w2_l4_f2 a_n52_n200# a_852_n200# a_n852_n244# a_n940_n200# a_52_n244# VSUBS
X0 a_852_n200# a_52_n244# a_n52_n200# VSUBS nfet_03v3 ad=0.88p pd=4.88u as=0.52p ps=2.52u w=2u l=4u
X1 a_n52_n200# a_n852_n244# a_n940_n200# VSUBS nfet_03v3 ad=0.52p pd=2.52u as=0.88p ps=4.88u w=2u l=4u
C0 a_n52_n200# a_n940_n200# 0.01073f
C1 a_852_n200# a_n52_n200# 0.01073f
C2 a_n52_n200# a_n852_n244# 0.07019f
C3 a_852_n200# a_52_n244# 0.07019f
C4 a_52_n244# a_n852_n244# 0.00519f
C5 a_n940_n200# a_n852_n244# 0.07019f
C6 a_n52_n200# a_52_n244# 0.07019f
C7 a_852_n200# VSUBS 0.41176f
C8 a_n52_n200# VSUBS 0.65308f
C9 a_n940_n200# VSUBS 0.41176f
.ends

.subckt rx_n2 line vdd vss
XD line vss line vss line vss n_w2_l4_f2
C0 vdd line 0.00181f
C1 vdd vss 0.06098f
C2 line vss 1.08247f
.ends

.subckt p_w2_l4 a_400_n200# a_n400_n244# w_n574_n330# a_n488_n200# VSUBS
X0 a_400_n200# a_n400_n244# a_n488_n200# w_n574_n330# pfet_03v3 ad=0.88p pd=4.88u as=0.88p ps=4.88u w=2u l=4u
C0 w_n574_n330# a_400_n200# 0.07409f
C1 w_n574_n330# a_n400_n244# 0.42229f
C2 w_n574_n330# a_n488_n200# 0.07409f
C3 a_n400_n244# a_400_n200# 0.07019f
C4 a_n488_n200# a_400_n200# 0.01073f
C5 a_n400_n244# a_n488_n200# 0.07019f
C6 a_400_n200# VSUBS 0.18936f
C7 a_n488_n200# VSUBS 0.18936f
C8 w_n574_n330# VSUBS 2.27304f
.ends

.subckt rx_p24 vss vdd line
XD line line vdd vdd vss p_w2_l4
C0 vdd line 0.78494f
C1 line vss -0.06364f
C2 vdd vss 5.17939f
.ends

.subckt n_w2_l4 a_400_n200# a_n400_n244# a_n488_n200# VSUBS
X0 a_400_n200# a_n400_n244# a_n488_n200# VSUBS nfet_03v3 ad=0.88p pd=4.88u as=0.88p ps=4.88u w=2u l=4u
C0 a_400_n200# a_n400_n244# 0.07019f
C1 a_n488_n200# a_n400_n244# 0.07019f
C2 a_n488_n200# a_400_n200# 0.01073f
C3 a_400_n200# VSUBS 0.41684f
C4 a_n488_n200# VSUBS 0.41684f
.ends

.subckt rx_n1 line vdd vss
XD line line vss vss n_w2_l4
C0 vdd line 0.00323f
C1 vdd vss 0.05846f
C2 line vss 0.60968f
.ends

.subckt p_w1_l4 a_n488_n100# a_400_n100# a_n400_n144# w_n574_n230# VSUBS
X0 a_400_n100# a_n400_n144# a_n488_n100# w_n574_n230# pfet_03v3 ad=0.44p pd=2.88u as=0.44p ps=2.88u w=1u l=4u
C0 w_n574_n230# a_n488_n100# 0.03707f
C1 a_n488_n100# a_n400_n144# 0.03474f
C2 w_n574_n230# a_n400_n144# 0.42229f
C3 a_400_n100# a_n488_n100# 0.00531f
C4 a_400_n100# w_n574_n230# 0.03707f
C5 a_400_n100# a_n400_n144# 0.03474f
C6 a_400_n100# VSUBS 0.15701f
C7 a_n488_n100# VSUBS 0.15701f
C8 w_n574_n230# VSUBS 1.58424f
.ends

.subckt rx_p05 line vdd vss
XD vdd line line vdd vss p_w1_l4
C0 vdd line 0.81576f
C1 line vss 0.00304f
C2 vdd vss 5.0752f
.ends

.subckt p_w4_l2_f5 a_n304_n400# a_704_n400# a_n704_n444# a_n808_n400# a_304_n444#
+ a_n1208_n444# a_n1296_n400# a_1208_n400# w_n1382_n530# a_200_n400# a_808_n444# a_n200_n444#
+ VSUBS
X0 a_1208_n400# a_808_n444# a_704_n400# w_n1382_n530# pfet_03v3 ad=1.76p pd=8.88u as=1.04p ps=4.52u w=4u l=2u
X1 a_704_n400# a_304_n444# a_200_n400# w_n1382_n530# pfet_03v3 ad=1.04p pd=4.52u as=1.04p ps=4.52u w=4u l=2u
X2 a_n808_n400# a_n1208_n444# a_n1296_n400# w_n1382_n530# pfet_03v3 ad=1.04p pd=4.52u as=1.76p ps=8.88u w=4u l=2u
X3 a_n304_n400# a_n704_n444# a_n808_n400# w_n1382_n530# pfet_03v3 ad=1.04p pd=4.52u as=1.04p ps=4.52u w=4u l=2u
X4 a_200_n400# a_n200_n444# a_n304_n400# w_n1382_n530# pfet_03v3 ad=1.04p pd=4.52u as=1.04p ps=4.52u w=4u l=2u
C0 a_704_n400# a_1208_n400# 0.04287f
C1 a_200_n400# a_n200_n444# 0.11799f
C2 a_704_n400# a_808_n444# 0.11799f
C3 a_n304_n400# w_n1382_n530# 0.18497f
C4 a_304_n444# a_n200_n444# 0.00519f
C5 w_n1382_n530# a_n1296_n400# 0.12268f
C6 w_n1382_n530# a_n1208_n444# 0.2233f
C7 a_704_n400# w_n1382_n530# 0.18497f
C8 a_n704_n444# a_n200_n444# 0.00519f
C9 a_n1296_n400# a_n1208_n444# 0.11799f
C10 a_n704_n444# a_n808_n400# 0.11799f
C11 a_304_n444# a_808_n444# 0.00519f
C12 a_200_n400# w_n1382_n530# 0.18497f
C13 a_200_n400# a_n304_n400# 0.04287f
C14 a_704_n400# a_200_n400# 0.04287f
C15 a_304_n444# w_n1382_n530# 0.21994f
C16 w_n1382_n530# a_n200_n444# 0.21994f
C17 a_n304_n400# a_n200_n444# 0.11799f
C18 a_n704_n444# w_n1382_n530# 0.21994f
C19 a_n704_n444# a_n304_n400# 0.11799f
C20 a_1208_n400# a_808_n444# 0.11799f
C21 w_n1382_n530# a_n808_n400# 0.18497f
C22 a_n304_n400# a_n808_n400# 0.04287f
C23 a_304_n444# a_704_n400# 0.11799f
C24 a_n1296_n400# a_n808_n400# 0.04287f
C25 a_n704_n444# a_n1208_n444# 0.00519f
C26 a_n1208_n444# a_n808_n400# 0.11799f
C27 a_1208_n400# w_n1382_n530# 0.12268f
C28 a_808_n444# w_n1382_n530# 0.2233f
C29 a_304_n444# a_200_n400# 0.11799f
C30 a_1208_n400# VSUBS 0.19832f
C31 a_704_n400# VSUBS 0.12191f
C32 a_200_n400# VSUBS 0.11851f
C33 a_n304_n400# VSUBS 0.11851f
C34 a_n808_n400# VSUBS 0.12191f
C35 a_n1296_n400# VSUBS 0.19832f
C36 w_n1382_n530# VSUBS 8.78952f
.ends

.subckt p_w2_l1 a_100_n200# a_n100_n244# w_n274_n330# a_n188_n200# VSUBS
X0 a_100_n200# a_n100_n244# a_n188_n200# w_n274_n330# pfet_03v3 ad=0.88p pd=4.88u as=0.88p ps=4.88u w=2u l=1u
C0 a_100_n200# a_n100_n244# 0.04231f
C1 a_n188_n200# w_n274_n330# 0.04851f
C2 a_100_n200# a_n188_n200# 0.03858f
C3 a_100_n200# w_n274_n330# 0.04851f
C4 a_n188_n200# a_n100_n244# 0.04231f
C5 w_n274_n330# a_n100_n244# 0.12884f
C6 a_100_n200# VSUBS 0.11088f
C7 a_n188_n200# VSUBS 0.11088f
C8 w_n274_n330# VSUBS 1.08504f
.ends

.subckt n_w4_l2_f6 a_n956_n444# a_1060_n444# a_556_n444# a_n52_n400# a_n1548_n400#
+ a_n1060_n400# a_452_n400# a_n452_n444# a_n556_n400# a_n1460_n444# a_1460_n400# a_52_n444#
+ a_956_n400# VSUBS
X0 a_n556_n400# a_n956_n444# a_n1060_n400# VSUBS nfet_03v3 ad=1.04p pd=4.52u as=1.04p ps=4.52u w=4u l=2u
X1 a_n52_n400# a_n452_n444# a_n556_n400# VSUBS nfet_03v3 ad=1.04p pd=4.52u as=1.04p ps=4.52u w=4u l=2u
X2 a_452_n400# a_52_n444# a_n52_n400# VSUBS nfet_03v3 ad=1.04p pd=4.52u as=1.04p ps=4.52u w=4u l=2u
X3 a_n1060_n400# a_n1460_n444# a_n1548_n400# VSUBS nfet_03v3 ad=1.04p pd=4.52u as=1.76p ps=8.88u w=4u l=2u
X4 a_956_n400# a_556_n444# a_452_n400# VSUBS nfet_03v3 ad=1.04p pd=4.52u as=1.04p ps=4.52u w=4u l=2u
X5 a_1460_n400# a_1060_n444# a_956_n400# VSUBS nfet_03v3 ad=1.76p pd=8.88u as=1.04p ps=4.52u w=4u l=2u
C0 a_556_n444# a_1060_n444# 0.00519f
C1 a_452_n400# a_n52_n400# 0.04287f
C2 a_n1060_n400# a_n1460_n444# 0.11799f
C3 a_n556_n400# a_n956_n444# 0.11799f
C4 a_956_n400# a_1460_n400# 0.04287f
C5 a_52_n444# a_n52_n400# 0.11799f
C6 a_556_n444# a_452_n400# 0.11799f
C7 a_1060_n444# a_1460_n400# 0.11799f
C8 a_n556_n400# a_n52_n400# 0.04287f
C9 a_956_n400# a_1060_n444# 0.11799f
C10 a_52_n444# a_n452_n444# 0.00519f
C11 a_52_n444# a_452_n400# 0.11799f
C12 a_556_n444# a_52_n444# 0.00519f
C13 a_n556_n400# a_n1060_n400# 0.04287f
C14 a_n556_n400# a_n452_n444# 0.11799f
C15 a_n1060_n400# a_n1548_n400# 0.04287f
C16 a_n1460_n444# a_n1548_n400# 0.11799f
C17 a_n1060_n400# a_n956_n444# 0.11799f
C18 a_n452_n444# a_n956_n444# 0.00519f
C19 a_n1460_n444# a_n956_n444# 0.00519f
C20 a_956_n400# a_452_n400# 0.04287f
C21 a_556_n444# a_956_n400# 0.11799f
C22 a_n452_n444# a_n52_n400# 0.11799f
C23 a_1460_n400# VSUBS 0.33857f
C24 a_956_n400# VSUBS 0.34773f
C25 a_452_n400# VSUBS 0.34265f
C26 a_n52_n400# VSUBS 0.34265f
C27 a_n556_n400# VSUBS 0.34265f
C28 a_n1060_n400# VSUBS 0.34773f
C29 a_n1548_n400# VSUBS 0.33857f
.ends

.subckt n_w2_l2_f2 a_n52_n200# a_452_n200# a_n452_n244# a_n540_n200# a_52_n244# VSUBS
X0 a_452_n200# a_52_n244# a_n52_n200# VSUBS nfet_03v3 ad=0.88p pd=4.88u as=0.52p ps=2.52u w=2u l=2u
X1 a_n52_n200# a_n452_n244# a_n540_n200# VSUBS nfet_03v3 ad=0.52p pd=2.52u as=0.88p ps=4.88u w=2u l=2u
C0 a_n52_n200# a_n540_n200# 0.02133f
C1 a_52_n244# a_452_n200# 0.0587f
C2 a_n452_n244# a_n52_n200# 0.0587f
C3 a_52_n244# a_n452_n244# 0.00519f
C4 a_52_n244# a_n52_n200# 0.0587f
C5 a_452_n200# a_n52_n200# 0.02133f
C6 a_n452_n244# a_n540_n200# 0.0587f
C7 a_452_n200# VSUBS 0.26162f
C8 a_n52_n200# VSUBS 0.35281f
C9 a_n540_n200# VSUBS 0.26162f
.ends

.subckt n_w2_l1 a_100_n200# a_n100_n244# a_n188_n200# VSUBS
X0 a_100_n200# a_n100_n244# a_n188_n200# VSUBS nfet_03v3 ad=0.88p pd=4.88u as=0.88p ps=4.88u w=2u l=1u
C0 a_n188_n200# a_100_n200# 0.03858f
C1 a_n188_n200# a_n100_n244# 0.04231f
C2 a_n100_n244# a_100_n200# 0.04231f
C3 a_100_n200# VSUBS 0.19164f
C4 a_n188_n200# VSUBS 0.19164f
.ends

.subckt p_w2_l2_f8 a_n52_n200# a_n1060_n200# a_452_n200# a_1564_n244# a_n452_n244#
+ w_n2138_n330# a_n556_n200# a_n1460_n244# a_1460_n200# a_52_n244# a_n1564_n200# a_956_n200#
+ a_n2052_n200# a_n956_n244# a_1060_n244# a_n1964_n244# a_556_n244# a_1964_n200# VSUBS
X0 a_1964_n200# a_1564_n244# a_1460_n200# w_n2138_n330# pfet_03v3 ad=0.88p pd=4.88u as=0.52p ps=2.52u w=2u l=2u
X1 a_452_n200# a_52_n244# a_n52_n200# w_n2138_n330# pfet_03v3 ad=0.52p pd=2.52u as=0.52p ps=2.52u w=2u l=2u
X2 a_956_n200# a_556_n244# a_452_n200# w_n2138_n330# pfet_03v3 ad=0.52p pd=2.52u as=0.52p ps=2.52u w=2u l=2u
X3 a_1460_n200# a_1060_n244# a_956_n200# w_n2138_n330# pfet_03v3 ad=0.52p pd=2.52u as=0.52p ps=2.52u w=2u l=2u
X4 a_n1564_n200# a_n1964_n244# a_n2052_n200# w_n2138_n330# pfet_03v3 ad=0.52p pd=2.52u as=0.88p ps=4.88u w=2u l=2u
X5 a_n1060_n200# a_n1460_n244# a_n1564_n200# w_n2138_n330# pfet_03v3 ad=0.52p pd=2.52u as=0.52p ps=2.52u w=2u l=2u
X6 a_n556_n200# a_n956_n244# a_n1060_n200# w_n2138_n330# pfet_03v3 ad=0.52p pd=2.52u as=0.52p ps=2.52u w=2u l=2u
X7 a_n52_n200# a_n452_n244# a_n556_n200# w_n2138_n330# pfet_03v3 ad=0.52p pd=2.52u as=0.52p ps=2.52u w=2u l=2u
C0 a_n452_n244# a_n556_n200# 0.0587f
C1 a_n556_n200# a_n52_n200# 0.02133f
C2 a_n956_n244# a_n1460_n244# 0.00519f
C3 a_1564_n244# a_1060_n244# 0.00519f
C4 a_n1060_n200# w_n2138_n330# 0.09155f
C5 a_1964_n200# w_n2138_n330# 0.0618f
C6 w_n2138_n330# a_n2052_n200# 0.0618f
C7 a_n1964_n244# a_n1564_n200# 0.0587f
C8 a_n452_n244# a_52_n244# 0.00519f
C9 a_52_n244# a_n52_n200# 0.0587f
C10 w_n2138_n330# a_n956_n244# 0.21994f
C11 a_n1060_n200# a_n956_n244# 0.0587f
C12 a_1564_n244# w_n2138_n330# 0.2233f
C13 a_1964_n200# a_1564_n244# 0.0587f
C14 a_n452_n244# a_n52_n200# 0.0587f
C15 a_52_n244# a_452_n200# 0.0587f
C16 a_556_n244# a_52_n244# 0.00519f
C17 a_n52_n200# a_452_n200# 0.02133f
C18 a_n1964_n244# a_n1460_n244# 0.00519f
C19 a_956_n200# a_1460_n200# 0.02133f
C20 a_n556_n200# w_n2138_n330# 0.09155f
C21 a_n556_n200# a_n1060_n200# 0.02133f
C22 a_452_n200# a_956_n200# 0.02133f
C23 a_556_n244# a_956_n200# 0.0587f
C24 a_n1460_n244# a_n1564_n200# 0.0587f
C25 a_556_n244# a_452_n200# 0.0587f
C26 a_n556_n200# a_n956_n244# 0.0587f
C27 a_n1964_n244# w_n2138_n330# 0.2233f
C28 a_1460_n200# a_1060_n244# 0.0587f
C29 a_52_n244# w_n2138_n330# 0.21994f
C30 a_956_n200# a_1060_n244# 0.0587f
C31 a_n1964_n244# a_n2052_n200# 0.0587f
C32 a_n452_n244# w_n2138_n330# 0.21994f
C33 a_556_n244# a_1060_n244# 0.00519f
C34 w_n2138_n330# a_n1564_n200# 0.09155f
C35 a_n1060_n200# a_n1564_n200# 0.02133f
C36 a_n52_n200# w_n2138_n330# 0.09155f
C37 a_n2052_n200# a_n1564_n200# 0.02133f
C38 a_1460_n200# w_n2138_n330# 0.09155f
C39 a_956_n200# w_n2138_n330# 0.09155f
C40 a_1964_n200# a_1460_n200# 0.02133f
C41 a_452_n200# w_n2138_n330# 0.09155f
C42 a_n452_n244# a_n956_n244# 0.00519f
C43 a_556_n244# w_n2138_n330# 0.21994f
C44 a_1564_n244# a_1460_n200# 0.0587f
C45 w_n2138_n330# a_n1460_n244# 0.21994f
C46 a_n1060_n200# a_n1460_n244# 0.0587f
C47 a_1060_n244# w_n2138_n330# 0.21994f
C48 a_1964_n200# VSUBS 0.13364f
C49 a_1460_n200# VSUBS 0.12191f
C50 a_956_n200# VSUBS 0.11851f
C51 a_452_n200# VSUBS 0.11851f
C52 a_n52_n200# VSUBS 0.11851f
C53 a_n556_n200# VSUBS 0.11851f
C54 a_n1060_n200# VSUBS 0.11851f
C55 a_n1564_n200# VSUBS 0.12191f
C56 a_n2052_n200# VSUBS 0.13364f
C57 w_n2138_n330# VSUBS 8.46648f
.ends

.subckt n_w2_l2_f8 a_n52_n200# a_n1060_n200# a_452_n200# a_1564_n244# a_n452_n244#
+ a_n556_n200# a_n1460_n244# a_1460_n200# a_52_n244# a_n1564_n200# a_956_n200# a_n2052_n200#
+ a_n956_n244# a_1060_n244# a_n1964_n244# a_556_n244# a_1964_n200# VSUBS
X0 a_1964_n200# a_1564_n244# a_1460_n200# VSUBS nfet_03v3 ad=0.88p pd=4.88u as=0.52p ps=2.52u w=2u l=2u
X1 a_452_n200# a_52_n244# a_n52_n200# VSUBS nfet_03v3 ad=0.52p pd=2.52u as=0.52p ps=2.52u w=2u l=2u
X2 a_956_n200# a_556_n244# a_452_n200# VSUBS nfet_03v3 ad=0.52p pd=2.52u as=0.52p ps=2.52u w=2u l=2u
X3 a_1460_n200# a_1060_n244# a_956_n200# VSUBS nfet_03v3 ad=0.52p pd=2.52u as=0.52p ps=2.52u w=2u l=2u
X4 a_n1564_n200# a_n1964_n244# a_n2052_n200# VSUBS nfet_03v3 ad=0.52p pd=2.52u as=0.88p ps=4.88u w=2u l=2u
X5 a_n1060_n200# a_n1460_n244# a_n1564_n200# VSUBS nfet_03v3 ad=0.52p pd=2.52u as=0.52p ps=2.52u w=2u l=2u
X6 a_n556_n200# a_n956_n244# a_n1060_n200# VSUBS nfet_03v3 ad=0.52p pd=2.52u as=0.52p ps=2.52u w=2u l=2u
X7 a_n52_n200# a_n452_n244# a_n556_n200# VSUBS nfet_03v3 ad=0.52p pd=2.52u as=0.52p ps=2.52u w=2u l=2u
C0 a_956_n200# a_452_n200# 0.02133f
C1 a_n1964_n244# a_n1460_n244# 0.00519f
C2 a_n1564_n200# a_n2052_n200# 0.02133f
C3 a_1460_n200# a_956_n200# 0.02133f
C4 a_1964_n200# a_1564_n244# 0.0587f
C5 a_556_n244# a_452_n200# 0.0587f
C6 a_n1060_n200# a_n556_n200# 0.02133f
C7 a_1564_n244# a_1060_n244# 0.00519f
C8 a_n556_n200# a_n452_n244# 0.0587f
C9 a_n1964_n244# a_n2052_n200# 0.0587f
C10 a_n1060_n200# a_n1460_n244# 0.0587f
C11 a_n556_n200# a_n956_n244# 0.0587f
C12 a_n52_n200# a_n556_n200# 0.02133f
C13 a_n1060_n200# a_n956_n244# 0.0587f
C14 a_n1460_n244# a_n956_n244# 0.00519f
C15 a_n452_n244# a_52_n244# 0.00519f
C16 a_n956_n244# a_n452_n244# 0.00519f
C17 a_n52_n200# a_52_n244# 0.0587f
C18 a_n52_n200# a_n452_n244# 0.0587f
C19 a_956_n200# a_1060_n244# 0.0587f
C20 a_n1964_n244# a_n1564_n200# 0.0587f
C21 a_1964_n200# a_1460_n200# 0.02133f
C22 a_556_n244# a_1060_n244# 0.00519f
C23 a_1460_n200# a_1564_n244# 0.0587f
C24 a_556_n244# a_52_n244# 0.00519f
C25 a_52_n244# a_452_n200# 0.0587f
C26 a_n1060_n200# a_n1564_n200# 0.02133f
C27 a_1460_n200# a_1060_n244# 0.0587f
C28 a_n1460_n244# a_n1564_n200# 0.0587f
C29 a_n52_n200# a_452_n200# 0.02133f
C30 a_556_n244# a_956_n200# 0.0587f
C31 a_1964_n200# VSUBS 0.26162f
C32 a_1460_n200# VSUBS 0.34773f
C33 a_956_n200# VSUBS 0.34265f
C34 a_452_n200# VSUBS 0.34265f
C35 a_n52_n200# VSUBS 0.34265f
C36 a_n556_n200# VSUBS 0.34265f
C37 a_n1060_n200# VSUBS 0.34265f
C38 a_n1564_n200# VSUBS 0.34773f
C39 a_n2052_n200# VSUBS 0.26162f
.ends

.subckt p_w2_l2 a_n288_n200# a_200_n200# a_n200_n244# w_n374_n330# VSUBS
X0 a_200_n200# a_n200_n244# a_n288_n200# w_n374_n330# pfet_03v3 ad=0.88p pd=4.88u as=0.88p ps=4.88u w=2u l=2u
C0 a_n288_n200# a_n200_n244# 0.0587f
C1 a_200_n200# w_n374_n330# 0.0618f
C2 a_200_n200# a_n288_n200# 0.02133f
C3 a_200_n200# a_n200_n244# 0.0587f
C4 w_n374_n330# a_n288_n200# 0.0618f
C5 w_n374_n330# a_n200_n244# 0.22666f
C6 a_200_n200# VSUBS 0.13704f
C7 a_n288_n200# VSUBS 0.13704f
C8 w_n374_n330# VSUBS 1.48104f
.ends

.subckt n_w2_l2 a_n288_n200# a_200_n200# a_n200_n244# VSUBS
X0 a_200_n200# a_n200_n244# a_n288_n200# VSUBS nfet_03v3 ad=0.88p pd=4.88u as=0.88p ps=4.88u w=2u l=2u
C0 a_200_n200# a_n288_n200# 0.02133f
C1 a_n200_n244# a_200_n200# 0.0587f
C2 a_n200_n244# a_n288_n200# 0.0587f
C3 a_200_n200# VSUBS 0.2667f
C4 a_n288_n200# VSUBS 0.2667f
.ends

.subckt p_w2_l2_f2 a_n52_n200# a_452_n200# a_n452_n244# a_n540_n200# w_n626_n330#
+ a_52_n244# VSUBS
X0 a_452_n200# a_52_n244# a_n52_n200# w_n626_n330# pfet_03v3 ad=0.88p pd=4.88u as=0.52p ps=2.52u w=2u l=2u
X1 a_n52_n200# a_n452_n244# a_n540_n200# w_n626_n330# pfet_03v3 ad=0.52p pd=2.52u as=0.88p ps=4.88u w=2u l=2u
C0 a_52_n244# a_n452_n244# 0.00519f
C1 a_n540_n200# w_n626_n330# 0.0618f
C2 a_n540_n200# a_n452_n244# 0.0587f
C3 a_n52_n200# w_n626_n330# 0.09155f
C4 a_n52_n200# a_52_n244# 0.0587f
C5 a_n52_n200# a_452_n200# 0.02133f
C6 a_n52_n200# a_n452_n244# 0.0587f
C7 w_n626_n330# a_52_n244# 0.2233f
C8 a_n52_n200# a_n540_n200# 0.02133f
C9 w_n626_n330# a_452_n200# 0.0618f
C10 w_n626_n330# a_n452_n244# 0.2233f
C11 a_52_n244# a_452_n200# 0.0587f
C12 a_452_n200# VSUBS 0.13364f
C13 a_n52_n200# VSUBS 0.12532f
C14 a_n540_n200# VSUBS 0.13364f
C15 w_n626_n330# VSUBS 2.47896f
.ends

.subckt bias_ladder in_n vgp3 m1_6020_10200# m1_3298_2050# m1_4760_1320# m1_5022_10210#
+ m1_3530_1930# m1_4906_9490# m1_3898_9610# a_7580_5314# a_1580_5314# vss vgp5 vdd
+ m1_6282_1450# m1_5516_1920# a_4580_5314# m1_4538_1930# vgn3 a_5188_4156# vgn5 m1_3666_9610#
+ vsp vsn vglp vgp6 a_3036_4156# vgln in_p
XnpSE m1_3898_9610# m1_4906_9490# vglp m1_3666_9610# vglp vglp in_p m1_6020_10200#
+ vdd m1_5022_10210# vglp vglp vss p_w4_l2_f5
XFP3 vgp3 a_1580_5314# vgp3 vss vss p_w2_l1
XnnSE vgln vgln vgln m1_4760_1320# in_n m1_3298_2050# m1_4538_1930# vgln m1_3530_1930#
+ vgln m1_6282_1450# vgln m1_5516_1920# vss n_w4_l2_f6
XnnSH6T m1_6282_1450# vdd vgln a_7580_5314# vgln vss n_w2_l2_f2
XFP5 vgp5 a_4580_5314# vgp5 vss vss p_w2_l1
XFN3 vgn3 a_3036_4156# vdd vss n_w2_l1
XDP3 vsp vsp a_1580_5314# vgp3 vgp3 vdd a_1580_5314# vgp3 a_1580_5314# vgp3 a_1580_5314#
+ vsp vsp vgp3 vgp3 vgp3 vgp3 vsp vss p_w2_l2_f8
XFP6 vgp6 a_7580_5314# vgp6 vss vss p_w2_l1
XFN5 vgn5 a_5188_4156# vdd vss n_w2_l1
XDP5 vsp vsp a_4580_5314# vgp5 vgp5 vdd a_4580_5314# vgp5 a_4580_5314# vgp5 a_4580_5314#
+ vsp vsp vgp5 vgp5 vgp5 vgp5 vsp vss p_w2_l2_f8
XDN3 vsn vsn a_3036_4156# vgn3 vgn3 a_3036_4156# vgn3 a_3036_4156# vgn3 a_3036_4156#
+ vsn vsn vgn3 vgn3 vgn3 vgn3 vsn vss n_w2_l2_f8
XDP6 vsp vsp a_7580_5314# vgp6 vgp6 vdd a_7580_5314# vgp6 a_7580_5314# vgp6 a_7580_5314#
+ vsp vsp vgp6 vgp6 vgp6 vgp6 vsp vss p_w2_l2_f8
XBP3 vsp vgp3 vgp6 vdd vss p_w2_l2
XDN5 vsn vsn a_5188_4156# vgn5 vgn5 a_5188_4156# vgn5 a_5188_4156# vgn5 a_5188_4156#
+ vsn vsn vgn5 vgn5 vgn5 vgn5 vsn vss n_w2_l2_f8
XBP5 vsp vgp5 vgp6 vdd vss p_w2_l2
XBN3 vgn3 vsn vgn5 vss n_w2_l2
XnnSH01 vdd m1_3298_2050# vgln in_n vgln vss n_w2_l2_f2
XBP6 vsp vgp6 vgp6 vdd vss p_w2_l2
XnnSH24 vdd m1_4538_1930# vgln m1_3530_1930# vgln vss n_w2_l2_f2
XBN5 vgn5 vsn vgn5 vss n_w2_l2
XnpSH3 m1_5022_10210# a_3036_4156# vglp vdd vss p_w2_l2
XnpSH5T m1_6020_10200# vss vglp a_5188_4156# vdd vglp vss p_w2_l2_f2
XnpSH01 vss m1_3666_9610# vglp in_p vdd vglp vss p_w2_l2_f2
XnpSH24 vss m1_4906_9490# vglp m1_3898_9610# vdd vglp vss p_w2_l2_f2
XnnSH3 m1_4760_1320# a_1580_5314# vgln vss n_w2_l2
XnnSH5 m1_5516_1920# a_4580_5314# vgln vss n_w2_l2
C0 m1_3666_9610# m1_3898_9610# 0.08953f
C1 m1_5516_1920# a_7580_5314# 0
C2 m1_4906_9490# a_5188_4156# 0
C3 m1_4538_1930# vgn3 0.08119f
C4 vsn m1_3530_1930# 0.01898f
C5 m1_4760_1320# vsn 0
C6 m1_4538_1930# vgln 0.37308f
C7 vgn3 vgn5 0.06099f
C8 vgn5 vgln 0.02641f
C9 vglp a_1580_5314# 0
C10 m1_3298_2050# vsn 0.01482f
C11 a_4580_5314# a_1580_5314# 0.06015f
C12 m1_3898_9610# m1_4906_9490# 0.00256f
C13 in_n vsn 0.17665f
C14 m1_5022_10210# a_5188_4156# 0
C15 vgp5 a_1580_5314# 0.16694f
C16 vgn3 vdd 0.17852f
C17 vgln vdd 2.28298f
C18 vglp vgp3 0.48996f
C19 m1_5022_10210# m1_4906_9490# 0.22756f
C20 m1_4538_1930# m1_6282_1450# 0
C21 m1_6020_10200# vdd 0.18314f
C22 m1_6282_1450# vgn5 0
C23 vgp5 vgp3 0.00867f
C24 m1_3666_9610# vgp3 0
C25 m1_4538_1930# m1_5516_1920# 0.04505f
C26 a_1580_5314# a_5188_4156# 0.12061f
C27 m1_5516_1920# vgn5 0.00187f
C28 m1_5022_10210# m1_3898_9610# 0
C29 vglp vgp6 0.49335f
C30 a_4580_5314# vgp6 0.58598f
C31 vgn3 vgln 0.47992f
C32 vgp5 vgp6 0.35193f
C33 in_p vgp3 0.0017f
C34 m1_4538_1930# m1_4760_1320# 0.16397f
C35 m1_3666_9610# vgp6 0.00881f
C36 a_5188_4156# vgp3 0.00485f
C37 a_4580_5314# vsn 0.36645f
C38 m1_6282_1450# vdd 0.04143f
C39 vglp vsp 0.34417f
C40 m1_4906_9490# vgp3 0.0279f
C41 vsp a_4580_5314# 0.80414f
C42 vgp5 vsn 0.17915f
C43 vglp a_7580_5314# 0
C44 m1_5516_1920# vdd 0.03975f
C45 a_7580_5314# a_4580_5314# 0.29998f
C46 in_p vgp6 0
C47 vsp vgp5 0.78845f
C48 a_5188_4156# vgp6 0.14378f
C49 vsp m1_3666_9610# 0.00336f
C50 a_7580_5314# vgp5 0.32553f
C51 m1_3898_9610# vgp3 0.04635f
C52 m1_4906_9490# vgp6 0.01016f
C53 vdd m1_3530_1930# 0.05235f
C54 m1_4760_1320# vdd 0.02112f
C55 m1_6282_1450# vgln 0.19109f
C56 a_5188_4156# vsn 0.39706f
C57 m1_5516_1920# vgn3 0.00897f
C58 m1_5022_10210# vgp3 0.00919f
C59 m1_5516_1920# vgln 0.29348f
C60 vsp in_p 0.13384f
C61 vsp a_5188_4156# 0.36532f
C62 vglp a_3036_4156# 0.03135f
C63 m1_3898_9610# vgp6 0.01466f
C64 a_4580_5314# a_3036_4156# 0.1705f
C65 m1_3298_2050# vdd 0.05664f
C66 a_7580_5314# a_5188_4156# 0.41188f
C67 vsp m1_4906_9490# 0.00394f
C68 m1_4760_1320# vgn3 0.12142f
C69 vgn3 m1_3530_1930# 0.04819f
C70 vgp5 a_3036_4156# 0.72992f
C71 vgln m1_3530_1930# 0.4385f
C72 in_n vdd 0.07179f
C73 m1_4760_1320# vgln 0.22369f
C74 m1_5022_10210# vgp6 0.00778f
C75 a_1580_5314# vgp3 1.41665f
C76 vsp m1_3898_9610# 0.00217f
C77 m1_4538_1930# a_4580_5314# 0.00211f
C78 m1_3298_2050# vgn3 0.00878f
C79 a_4580_5314# vgn5 0.10109f
C80 m1_3298_2050# vgln 0.28259f
C81 m1_5516_1920# m1_6282_1450# 0.00546f
C82 a_5188_4156# a_3036_4156# 0.27107f
C83 in_n vgn3 0.00344f
C84 m1_5022_10210# vsp 0.00393f
C85 vgp5 vgn5 0.0996f
C86 in_n vgln 0.47579f
C87 a_1580_5314# vgp6 0.24833f
C88 m1_4906_9490# a_3036_4156# 0.00404f
C89 m1_4760_1320# m1_6282_1450# 0
C90 vglp vdd 5.16392f
C91 a_1580_5314# vsn 0.16559f
C92 vgp3 vgp6 0.38706f
C93 a_4580_5314# vdd 1.73154f
C94 a_5188_4156# vgn5 1.16612f
C95 m1_3898_9610# a_3036_4156# 0
C96 vsp a_1580_5314# 0.66577f
C97 vgp5 vdd 3.48321f
C98 a_7580_5314# a_1580_5314# 0.02594f
C99 m1_3666_9610# vdd 0.05802f
C100 m1_5022_10210# a_3036_4156# 0
C101 vsp vgp3 1.5721f
C102 m1_4760_1320# m1_3530_1930# 0
C103 a_4580_5314# vgn3 0
C104 a_4580_5314# vgln 0.49007f
C105 a_7580_5314# vgp3 0.20875f
C106 in_p vdd 1.4091f
C107 vgp5 vgn3 0
C108 a_5188_4156# vdd 0.39619f
C109 vsn vgp6 0.03394f
C110 vglp m1_6020_10200# 0.27284f
C111 m1_3298_2050# m1_3530_1930# 0.33404f
C112 m1_3298_2050# m1_4760_1320# -0
C113 vsp vgp6 1.5758f
C114 a_1580_5314# a_3036_4156# 0.14234f
C115 m1_4906_9490# vdd 0.08697f
C116 vgp5 m1_6020_10200# 0.01029f
C117 a_7580_5314# vgp6 1.8657f
C118 in_n m1_3530_1930# 0.00742f
C119 vgp3 a_3036_4156# 0.03477f
C120 a_5188_4156# vgln 0.06289f
C121 m1_3898_9610# vdd 0.15129f
C122 a_7580_5314# vsn 0.31213f
C123 m1_4538_1930# a_1580_5314# 0.00316f
C124 in_n m1_3298_2050# 0.02053f
C125 m1_6282_1450# a_4580_5314# 0.21332f
C126 a_1580_5314# vgn5 0.21481f
C127 a_7580_5314# vsp 0.4942f
C128 a_5188_4156# m1_6020_10200# 0.00728f
C129 m1_5022_10210# vdd 0.0596f
C130 m1_5516_1920# a_4580_5314# -0.00812f
C131 a_3036_4156# vgp6 0.42099f
C132 m1_4906_9490# m1_6020_10200# 0.00282f
C133 m1_4760_1320# a_4580_5314# 0
C134 a_3036_4156# vsn 0.14439f
C135 a_1580_5314# vdd 1.62506f
C136 m1_6282_1450# a_5188_4156# 0.00163f
C137 vsp a_3036_4156# 0.0883f
C138 vgp6 vgn5 0.00421f
C139 a_7580_5314# a_3036_4156# 0.0745f
C140 m1_5516_1920# a_5188_4156# 0
C141 m1_5022_10210# m1_6020_10200# 0.0182f
C142 vgp3 vdd 3.78758f
C143 a_1580_5314# vgn3 0.04478f
C144 vsn vgn5 1.27598f
C145 a_1580_5314# vgln 0.07765f
C146 a_7580_5314# vgn5 0.26387f
C147 vgp6 vdd 5.47456f
C148 vgp3 vgn3 0.00714f
C149 vsn vdd 0.58029f
C150 vsp vdd 3.61245f
C151 a_7580_5314# vdd 0.83515f
C152 vglp a_4580_5314# 0
C153 a_3036_4156# vgn5 0.11976f
C154 m1_6020_10200# vgp6 0.04538f
C155 vglp vgp5 0.1447f
C156 m1_5516_1920# a_1580_5314# 0.05179f
C157 vgn3 vsn 1.08253f
C158 vgp5 a_4580_5314# 1.87678f
C159 vglp m1_3666_9610# 0.38355f
C160 vsn vgln 0.48987f
C161 m1_4538_1930# vgn5 0.00106f
C162 a_7580_5314# vgln 0.10386f
C163 m1_4760_1320# a_1580_5314# -0.02087f
C164 vsp m1_6020_10200# 0.02019f
C165 vglp in_p 0.7203f
C166 a_3036_4156# vdd 1.03471f
C167 vglp a_5188_4156# 0.03121f
C168 a_4580_5314# a_5188_4156# 0.4945f
C169 vglp m1_4906_9490# 0.38823f
C170 vgp5 a_5188_4156# 0.18257f
C171 in_p m1_3666_9610# 0.0161f
C172 m1_4538_1930# vdd 0.27134f
C173 vgn3 a_3036_4156# 0.80773f
C174 a_3036_4156# vgln 0.00497f
C175 vgn5 vdd 0.10294f
C176 vglp m1_3898_9610# 0.4412f
C177 m1_6282_1450# a_7580_5314# 0.00102f
C178 m1_6020_10200# a_3036_4156# 0.00106f
C179 vglp m1_5022_10210# 0.22247f
C180 a_1580_5314# vss 1.70876f
C181 m1_4906_9490# vss -0.04028f
C182 m1_3898_9610# vss 0.09303f
C183 m1_3666_9610# vss -0.03204f
C184 in_p vss -0
C185 vglp vss -0.37909f
C186 m1_4538_1930# vss 0.07674f
C187 m1_3530_1930# vss 0.05197f
C188 vdd vss 86.64923f
C189 vgln vss 3.3753f
C190 vgn5 vss 4.03953f
C191 a_5188_4156# vss 1.44532f
C192 vsp vss -0.14973f
C193 a_7580_5314# vss 1.40837f
C194 vsn vss 4.2523f
C195 a_3036_4156# vss 1.80989f
C196 vgn3 vss 3.02208f
C197 vgp6 vss 2.43502f
C198 a_4580_5314# vss 3.24613f
C199 vgp5 vss 1.91603f
C200 m1_6282_1450# vss 0.17092f
C201 m1_5516_1920# vss -0.01345f
C202 m1_4760_1320# vss -0.06206f
C203 m1_3298_2050# vss 0.04402f
C204 in_n vss 1.35999f
C205 vgp3 vss 2.7134f
C206 m1_6020_10200# vss -0.16436f
C207 m1_5022_10210# vss -0.09509f
.ends

.subckt p_w1_l0p28_f2 a_n196_n100# a_n52_n100# w_n282_n230# a_108_n100# a_52_n144#
+ a_n108_n144# VSUBS
X0 a_n52_n100# a_n108_n144# a_n196_n100# w_n282_n230# pfet_03v3 ad=0.26p pd=1.52u as=0.44p ps=2.88u w=1u l=0.28u
X1 a_108_n100# a_52_n144# a_n52_n100# w_n282_n230# pfet_03v3 ad=0.44p pd=2.88u as=0.26p ps=1.52u w=1u l=0.28u
C0 a_n52_n100# a_108_n100# 0.04256f
C1 a_n52_n100# a_n196_n100# 0.04256f
C2 w_n282_n230# a_52_n144# 0.05505f
C3 a_n108_n144# a_n196_n100# 0.00769f
C4 a_n108_n144# a_n52_n100# 0.00769f
C5 a_108_n100# a_52_n144# 0.00769f
C6 a_n52_n100# a_52_n144# 0.00769f
C7 a_n108_n144# a_52_n144# 0.00519f
C8 w_n282_n230# a_108_n100# 0.01808f
C9 w_n282_n230# a_n196_n100# 0.01808f
C10 w_n282_n230# a_n52_n100# 0.01828f
C11 w_n282_n230# a_n108_n144# 0.05505f
C12 a_108_n100# VSUBS 0.0563f
C13 a_n52_n100# VSUBS 0.03533f
C14 a_n196_n100# VSUBS 0.0563f
C15 w_n282_n230# VSUBS 0.77832f
.ends

.subckt n_w0p5_l0p28_f2 a_n52_n50# a_n196_n50# a_52_n94# a_108_n50# a_n108_n94# VSUBS
X0 a_108_n50# a_52_n94# a_n52_n50# VSUBS nfet_03v3 ad=0.22p pd=1.88u as=0.13p ps=1.02u w=0.5u l=0.28u
X1 a_n52_n50# a_n108_n94# a_n196_n50# VSUBS nfet_03v3 ad=0.13p pd=1.02u as=0.22p ps=1.88u w=0.5u l=0.28u
C0 a_108_n50# a_n52_n50# 0.02085f
C1 a_n108_n94# a_n196_n50# 0.00377f
C2 a_52_n94# a_n52_n50# 0.00377f
C3 a_52_n94# a_108_n50# 0.00377f
C4 a_n52_n50# a_n196_n50# 0.02085f
C5 a_n108_n94# a_n52_n50# 0.00377f
C6 a_n108_n94# a_52_n94# 0.00519f
C7 a_108_n50# VSUBS 0.07479f
C8 a_n52_n50# VSUBS 0.09458f
C9 a_n196_n50# VSUBS 0.07479f
.ends

.subckt p_w2_l2_f7 a_n704_n244# a_n808_n200# a_304_n244# a_n1712_n244# a_1712_n200#
+ a_n1800_n200# a_n1208_n244# a_1208_n200# a_200_n200# a_1312_n244# a_808_n244# a_n200_n244#
+ a_n304_n200# w_n1886_n330# a_n1312_n200# a_704_n200# VSUBS
X0 a_n1312_n200# a_n1712_n244# a_n1800_n200# w_n1886_n330# pfet_03v3 ad=0.52p pd=2.52u as=0.88p ps=4.88u w=2u l=2u
X1 a_n304_n200# a_n704_n244# a_n808_n200# w_n1886_n330# pfet_03v3 ad=0.52p pd=2.52u as=0.52p ps=2.52u w=2u l=2u
X2 a_200_n200# a_n200_n244# a_n304_n200# w_n1886_n330# pfet_03v3 ad=0.52p pd=2.52u as=0.52p ps=2.52u w=2u l=2u
X3 a_1712_n200# a_1312_n244# a_1208_n200# w_n1886_n330# pfet_03v3 ad=0.88p pd=4.88u as=0.52p ps=2.52u w=2u l=2u
X4 a_1208_n200# a_808_n244# a_704_n200# w_n1886_n330# pfet_03v3 ad=0.52p pd=2.52u as=0.52p ps=2.52u w=2u l=2u
X5 a_n808_n200# a_n1208_n244# a_n1312_n200# w_n1886_n330# pfet_03v3 ad=0.52p pd=2.52u as=0.52p ps=2.52u w=2u l=2u
X6 a_704_n200# a_304_n244# a_200_n200# w_n1886_n330# pfet_03v3 ad=0.52p pd=2.52u as=0.52p ps=2.52u w=2u l=2u
C0 w_n1886_n330# a_n1312_n200# 0.09155f
C1 w_n1886_n330# a_1208_n200# 0.09155f
C2 a_n304_n200# a_200_n200# 0.02133f
C3 w_n1886_n330# a_704_n200# 0.09155f
C4 a_808_n244# a_304_n244# 0.00519f
C5 a_1312_n244# a_1208_n200# 0.0587f
C6 a_n200_n244# a_304_n244# 0.00519f
C7 a_n304_n200# a_n808_n200# 0.02133f
C8 w_n1886_n330# a_n304_n200# 0.09155f
C9 w_n1886_n330# a_1712_n200# 0.0618f
C10 a_n200_n244# a_n704_n244# 0.00519f
C11 a_n808_n200# a_n1208_n244# 0.0587f
C12 w_n1886_n330# a_n1208_n244# 0.21994f
C13 a_304_n244# a_704_n200# 0.0587f
C14 a_1712_n200# a_1312_n244# 0.0587f
C15 a_808_n244# a_1208_n200# 0.0587f
C16 w_n1886_n330# a_n1800_n200# 0.0618f
C17 a_808_n244# a_704_n200# 0.0587f
C18 a_n1712_n244# a_n1312_n200# 0.0587f
C19 w_n1886_n330# a_200_n200# 0.09155f
C20 a_n704_n244# a_n304_n200# 0.0587f
C21 w_n1886_n330# a_n808_n200# 0.09155f
C22 a_n704_n244# a_n1208_n244# 0.00519f
C23 a_704_n200# a_1208_n200# 0.02133f
C24 a_n200_n244# a_n304_n200# 0.0587f
C25 a_304_n244# a_200_n200# 0.0587f
C26 w_n1886_n330# a_1312_n244# 0.2233f
C27 a_n1712_n244# a_n1208_n244# 0.00519f
C28 a_n1312_n200# a_n1208_n244# 0.0587f
C29 a_1712_n200# a_1208_n200# 0.02133f
C30 w_n1886_n330# a_304_n244# 0.21994f
C31 a_n200_n244# a_200_n200# 0.0587f
C32 a_n704_n244# a_n808_n200# 0.0587f
C33 a_n1800_n200# a_n1712_n244# 0.0587f
C34 w_n1886_n330# a_n704_n244# 0.21994f
C35 a_n1800_n200# a_n1312_n200# 0.02133f
C36 w_n1886_n330# a_808_n244# 0.21994f
C37 w_n1886_n330# a_n200_n244# 0.21994f
C38 a_200_n200# a_704_n200# 0.02133f
C39 w_n1886_n330# a_n1712_n244# 0.2233f
C40 a_n808_n200# a_n1312_n200# 0.02133f
C41 a_1312_n244# a_808_n244# 0.00519f
C42 a_1712_n200# VSUBS 0.13364f
C43 a_1208_n200# VSUBS 0.12191f
C44 a_704_n200# VSUBS 0.11851f
C45 a_200_n200# VSUBS 0.11851f
C46 a_n304_n200# VSUBS 0.11851f
C47 a_n808_n200# VSUBS 0.11851f
C48 a_n1312_n200# VSUBS 0.12191f
C49 a_n1800_n200# VSUBS 0.13364f
C50 w_n1886_n330# VSUBS 7.46856f
.ends

.subckt p_w0p5_l0p5_f2 a_n52_n50# w_n326_n180# a_52_n94# a_152_n50# a_n240_n50# a_n152_n94#
+ VSUBS
X0 a_152_n50# a_52_n94# a_n52_n50# w_n326_n180# pfet_03v3 ad=0.22p pd=1.88u as=0.13p ps=1.02u w=0.5u l=0.5u
X1 a_n52_n50# a_n152_n94# a_n240_n50# w_n326_n180# pfet_03v3 ad=0.13p pd=1.02u as=0.22p ps=1.88u w=0.5u l=0.5u
C0 a_152_n50# a_52_n94# 0.00625f
C1 a_52_n94# w_n326_n180# 0.07657f
C2 a_n240_n50# a_n152_n94# 0.00625f
C3 a_52_n94# a_n152_n94# 0.00519f
C4 a_152_n50# a_n52_n50# 0.01511f
C5 w_n326_n180# a_n52_n50# 0.01225f
C6 a_152_n50# w_n326_n180# 0.01152f
C7 a_n52_n50# a_n152_n94# 0.00625f
C8 a_n240_n50# a_n52_n50# 0.01511f
C9 w_n326_n180# a_n152_n94# 0.07657f
C10 a_52_n94# a_n52_n50# 0.00625f
C11 a_n240_n50# w_n326_n180# 0.01152f
C12 a_152_n50# VSUBS 0.04588f
C13 a_n52_n50# VSUBS 0.04684f
C14 a_n240_n50# VSUBS 0.04588f
C15 w_n326_n180# VSUBS 0.70416f
.ends

.subckt idac_p b0 b1 b3 b4 out vss m1_988_3464# a_1582_4392# vdd m1_988_2804# a_528_4392#
+ a_2228_4392# a_1378_4392# a_3078_4392# a_3928_4392# a_3282_4392# b2 m1_988_888#
+ g m1_240_3480# dump a_4132_4392# m1_1500_4312# a_2432_4392# vcas a_732_4392# vsp
XU4b vsp vsp m1_988_888# g g vdd m1_988_888# g m1_988_888# g m1_988_888# vsp vsp g
+ g g g vsp vss p_w2_l2_f8
XU3 vsp vsp m1_988_2804# g g vdd m1_988_2804# g m1_988_2804# g m1_988_2804# vsp vsp
+ g g g g vsp vss p_w2_l2_f8
XIP0 a_528_4392# vdd vdd a_732_4392# a_528_4392# b0 vss p_w1_l0p28_f2
XIP1 a_1378_4392# vdd vdd a_1582_4392# a_1378_4392# b1 vss p_w1_l0p28_f2
XIN0 vcas a_528_4392# a_528_4392# a_732_4392# b0 vss n_w0p5_l0p28_f2
XIP2 a_2228_4392# vdd vdd a_2432_4392# a_2228_4392# b2 vss p_w1_l0p28_f2
XIN1 vcas a_1378_4392# a_1378_4392# a_1582_4392# b1 vss n_w0p5_l0p28_f2
XIP3 a_3078_4392# vdd vdd a_3282_4392# a_3078_4392# b3 vss p_w1_l0p28_f2
XIN3 vcas a_3078_4392# a_3078_4392# a_3282_4392# b3 vss n_w0p5_l0p28_f2
XIN2 vcas a_2228_4392# a_2228_4392# a_2432_4392# b2 vss n_w0p5_l0p28_f2
XIP4 a_3928_4392# vdd vdd a_4132_4392# a_3928_4392# b4 vss p_w1_l0p28_f2
XIN4 vcas a_3928_4392# a_3928_4392# a_4132_4392# b4 vss n_w0p5_l0p28_f2
XU210 g vsp g g m1_240_3480# vsp g vsp vsp g g g m1_988_3464# vdd m1_988_3464# m1_1500_4312#
+ vss p_w2_l2_f7
XSW0 m1_240_3480# vdd a_732_4392# dump out a_528_4392# vss p_w0p5_l0p5_f2
XSW2 m1_988_3464# vdd a_2432_4392# dump out a_2228_4392# vss p_w0p5_l0p5_f2
XSW1 m1_1500_4312# vdd a_1582_4392# dump out a_1378_4392# vss p_w0p5_l0p5_f2
XSW3 m1_988_2804# vdd a_3282_4392# dump out a_3078_4392# vss p_w0p5_l0p5_f2
XSW4 m1_988_888# vdd a_4132_4392# dump out a_3928_4392# vss p_w0p5_l0p5_f2
XU4a vsp vsp m1_988_888# g g vdd m1_988_888# g m1_988_888# g m1_988_888# vsp vsp g
+ g g g vsp vss p_w2_l2_f8
C0 vdd g 8.74367f
C1 vdd dump 1.00627f
C2 vdd a_4132_4392# 0.5253f
C3 a_2432_4392# out 0.03176f
C4 out a_3928_4392# 0.0039f
C5 m1_1500_4312# a_1378_4392# 0.01574f
C6 vdd m1_1500_4312# 0.16576f
C7 out b1 0.01042f
C8 m1_988_3464# a_2228_4392# 0.01383f
C9 a_2228_4392# a_3282_4392# 0
C10 m1_240_3480# a_732_4392# 0.00483f
C11 a_1378_4392# b2 0.00157f
C12 out b0 0.34956f
C13 vdd b2 0.206f
C14 m1_988_3464# a_732_4392# 0.00112f
C15 g m1_988_2804# 1.11336f
C16 m1_988_2804# dump 0.02557f
C17 a_4132_4392# m1_988_2804# 0
C18 out vcas 0.13451f
C19 g dump 0.05176f
C20 a_4132_4392# g 0
C21 a_4132_4392# dump 0.04726f
C22 m1_1500_4312# m1_988_2804# 0.11128f
C23 b3 a_3078_4392# 0.27358f
C24 a_528_4392# m1_240_3480# 0.0165f
C25 m1_1500_4312# g 0.40807f
C26 m1_1500_4312# dump 0.07029f
C27 m1_988_888# b4 0
C28 a_1582_4392# out 0.01339f
C29 g b2 0
C30 b2 dump 0.03612f
C31 a_2432_4392# a_3078_4392# 0.16749f
C32 a_3078_4392# a_3928_4392# 0.01001f
C33 m1_988_888# vsp 0.84877f
C34 b3 a_3282_4392# 0.02628f
C35 vdd m1_988_888# 1.79894f
C36 out vsp 0
C37 out a_1378_4392# 0.01469f
C38 m1_240_3480# a_3928_4392# 0.00167f
C39 vdd out 1.27153f
C40 a_3078_4392# vcas 0.04594f
C41 a_528_4392# a_732_4392# 0.11371f
C42 a_2432_4392# m1_988_3464# 0.0039f
C43 a_2432_4392# a_3282_4392# 0
C44 a_3928_4392# a_3282_4392# 0.05112f
C45 b3 a_2228_4392# 0.00173f
C46 m1_988_888# m1_988_2804# 0.20776f
C47 b0 m1_240_3480# 0.0015f
C48 g m1_988_888# 2.54331f
C49 m1_988_888# dump 0.05324f
C50 a_4132_4392# m1_988_888# 0.03507f
C51 out m1_988_2804# 0.06468f
C52 m1_1500_4312# m1_988_888# 0
C53 a_3078_4392# b4 0.00186f
C54 out g 0.69731f
C55 out dump 0.14997f
C56 a_2432_4392# a_2228_4392# 0.18456f
C57 vcas a_3282_4392# 0.02198f
C58 out m1_1500_4312# 0.15763f
C59 b1 a_2228_4392# 0
C60 m1_240_3480# b4 0
C61 out b2 0
C62 a_732_4392# b1 0.0505f
C63 vdd a_3078_4392# 0.51762f
C64 vcas a_2228_4392# 0.02559f
C65 a_3282_4392# b4 0
C66 m1_240_3480# vsp 0.29136f
C67 b0 a_732_4392# 0.02072f
C68 a_732_4392# vcas 0.07256f
C69 a_528_4392# b1 0.00327f
C70 m1_240_3480# a_1378_4392# 0
C71 m1_988_3464# vsp 0.09235f
C72 vdd m1_240_3480# 1.54226f
C73 a_1582_4392# a_2228_4392# 0.06282f
C74 a_3078_4392# m1_988_2804# 0.00631f
C75 m1_988_3464# a_1378_4392# 0.00387f
C76 a_2432_4392# b3 0
C77 b3 a_3928_4392# 0.00713f
C78 vdd m1_988_3464# 0.12699f
C79 a_528_4392# b0 0.35816f
C80 g a_3078_4392# 0.00203f
C81 a_3078_4392# dump 0.11788f
C82 a_4132_4392# a_3078_4392# 0
C83 a_528_4392# vcas 0.05572f
C84 vdd a_3282_4392# 0.51129f
C85 a_1582_4392# a_732_4392# 0
C86 m1_1500_4312# a_3078_4392# 0
C87 out m1_988_888# 0.03269f
C88 m1_240_3480# m1_988_2804# 0.46309f
C89 m1_240_3480# g 1.39137f
C90 m1_240_3480# dump 0.01325f
C91 a_4132_4392# m1_240_3480# 0
C92 a_1378_4392# a_2228_4392# 0.0019f
C93 b3 vcas 0.13187f
C94 a_3078_4392# b2 0.00848f
C95 m1_988_3464# m1_988_2804# 0.03356f
C96 vdd a_2228_4392# 0.45461f
C97 m1_988_2804# a_3282_4392# 0.00333f
C98 m1_240_3480# m1_1500_4312# 0.0068f
C99 m1_988_3464# g 0.69646f
C100 m1_988_3464# dump 0.03151f
C101 g a_3282_4392# 0.00215f
C102 a_3282_4392# dump 0.08877f
C103 a_732_4392# a_1378_4392# 0.07957f
C104 vdd a_732_4392# 0.42048f
C105 m1_988_3464# m1_1500_4312# 0.46191f
C106 a_2432_4392# vcas 0.00805f
C107 a_528_4392# vsp 0
C108 a_3928_4392# vcas 0.02838f
C109 b3 b4 0.00351f
C110 b0 b1 0.00796f
C111 m1_988_2804# a_2228_4392# 0
C112 a_528_4392# a_1378_4392# 0.00968f
C113 m1_988_3464# b2 0
C114 b1 vcas 0.16455f
C115 vdd a_528_4392# 0.44354f
C116 b2 a_3282_4392# 0
C117 g a_2228_4392# 0.00218f
C118 a_2228_4392# dump 0.22128f
C119 m1_1500_4312# a_2228_4392# 0
C120 b0 vcas 0.06096f
C121 g a_732_4392# 0.00258f
C122 a_732_4392# dump 0.11406f
C123 a_3928_4392# b4 0.20796f
C124 m1_1500_4312# a_732_4392# 0
C125 a_1582_4392# b1 0.02085f
C126 vdd b3 0.18861f
C127 out a_3078_4392# 0.01364f
C128 b2 a_2228_4392# 0.1815f
C129 a_528_4392# g 0.0015f
C130 a_528_4392# dump 0.01755f
C131 a_3928_4392# vsp 0
C132 a_1582_4392# b0 0
C133 m1_240_3480# m1_988_888# 0.04999f
C134 a_1582_4392# vcas 0.01431f
C135 vcas b4 0.21592f
C136 vdd a_2432_4392# 0.43511f
C137 vdd a_3928_4392# 0.65032f
C138 out m1_240_3480# 0.20558f
C139 b3 m1_988_2804# 0.0024f
C140 a_1378_4392# b1 0.276f
C141 g b3 0
C142 b3 dump 0
C143 vdd b1 0.16268f
C144 out m1_988_3464# 0.21869f
C145 out a_3282_4392# 0.01304f
C146 b0 a_1378_4392# 0.01025f
C147 vdd b0 0.15292f
C148 a_1378_4392# vcas 0.02974f
C149 a_2432_4392# m1_988_2804# 0
C150 vdd vcas 0.12325f
C151 m1_988_2804# a_3928_4392# 0
C152 a_2432_4392# g 0.00264f
C153 a_2432_4392# dump 0.12878f
C154 g a_3928_4392# 0.00474f
C155 a_3928_4392# dump 0.02728f
C156 a_4132_4392# a_3928_4392# 0.1229f
C157 b3 b2 0.09189f
C158 a_2432_4392# m1_1500_4312# 0.0018f
C159 out a_2228_4392# 0.01362f
C160 g b1 0
C161 vsp b4 0
C162 b1 dump 0.03413f
C163 a_1582_4392# a_1378_4392# 0.20351f
C164 vdd a_1582_4392# 0.31851f
C165 m1_1500_4312# b1 0
C166 out a_732_4392# 0.05477f
C167 vdd b4 0.36351f
C168 b0 g 0
C169 b0 dump 0
C170 a_2432_4392# b2 0.25812f
C171 vcas dump 0.09162f
C172 a_4132_4392# vcas 0.00535f
C173 b2 b1 0.00341f
C174 vdd vsp 1.94491f
C175 a_528_4392# out 0.16739f
C176 a_3078_4392# a_3282_4392# 0.17009f
C177 a_1582_4392# m1_988_2804# 0
C178 vdd a_1378_4392# 0.49318f
C179 a_1582_4392# g 0.00236f
C180 a_1582_4392# dump 0.29887f
C181 b2 vcas 0.29794f
C182 b4 dump 0
C183 a_4132_4392# b4 0.14194f
C184 a_1582_4392# m1_1500_4312# 0.0222f
C185 m1_988_3464# m1_240_3480# 0.00676f
C186 out b3 0
C187 a_3078_4392# a_2228_4392# 0.00233f
C188 m1_988_2804# vsp 0.24604f
C189 g vsp 4.05384f
C190 vsp dump 0.00712f
C191 m1_988_888# a_3928_4392# 0.01013f
C192 a_4132_4392# vsp 0
C193 a_1582_4392# b2 0
C194 vdd m1_988_2804# 0.36066f
C195 b2 b4 0
C196 g a_1378_4392# 0.00206f
C197 m1_1500_4312# vsp 0.21814f
C198 a_1378_4392# dump 0.12224f
C199 m1_988_888# vss 1.02294f
C200 vsp vss 0.2353f
C201 g vss -2.45698f
C202 vdd vss 23.98689f
C203 a_4132_4392# vss 0.12907f
C204 a_3928_4392# vss 0.16119f
C205 a_3282_4392# vss 0.00178f
C206 a_3078_4392# vss 0.11146f
C207 m1_1500_4312# vss -0.02333f
C208 a_1582_4392# vss 0.0096f
C209 a_1378_4392# vss 0.1291f
C210 a_2432_4392# vss 0.06008f
C211 a_2228_4392# vss 0.1444f
C212 dump vss 0.07406f
C213 m1_240_3480# vss 0.32442f
C214 out vss 0.5531f
C215 a_732_4392# vss -0.00313f
C216 a_528_4392# vss 0.1515f
C217 m1_988_3464# vss -0.03952f
C218 b4 vss 0.44872f
C219 b3 vss 0.20878f
C220 b2 vss 0.37183f
C221 vcas vss 1.54593f
C222 b1 vss 0.2684f
C223 b0 vss 0.41869f
C224 m1_988_2804# vss -0.01016f
.ends

.subckt r_w4_l3p97 a_n400_n519# a_n400_397# VSUBS
X0 a_n400_397# a_n400_n519# VSUBS ppolyf_u_1k r_width=4u r_length=3.97u
C0 a_n400_n519# a_n400_397# 0.02123f
C1 a_n400_n519# VSUBS 0.80683f
C2 a_n400_397# VSUBS 0.80683f
.ends

.subckt n_w8_l0p5 a_50_n800# a_n50_n844# a_n138_n800# VSUBS
X0 a_50_n800# a_n50_n844# a_n138_n800# VSUBS nfet_03v3 ad=3.52p pd=16.88u as=3.52p ps=16.88u w=8u l=0.5u
C0 a_n138_n800# a_50_n800# 0.25117f
C1 a_50_n800# a_n50_n844# 0.10385f
C2 a_n138_n800# a_n50_n844# 0.10385f
C3 a_50_n800# VSUBS 0.38495f
C4 a_n138_n800# VSUBS 0.38495f
.ends

.subckt n_w4_l0p5 a_n138_n400# a_50_n400# a_n50_n444# VSUBS
X0 a_50_n400# a_n50_n444# a_n138_n400# VSUBS nfet_03v3 ad=1.76p pd=8.88u as=1.76p ps=8.88u w=4u l=0.5u
C0 a_n138_n400# a_50_n400# 0.12527f
C1 a_50_n400# a_n50_n444# 0.05179f
C2 a_n138_n400# a_n50_n444# 0.05179f
C3 a_50_n400# VSUBS 0.23105f
C4 a_n138_n400# VSUBS 0.23105f
.ends

.subckt n_w0p5_l0p28 a_n28_n94# a_n116_n50# a_28_n50# VSUBS
X0 a_28_n50# a_n28_n94# a_n116_n50# VSUBS nfet_03v3 ad=0.22p pd=1.88u as=0.22p ps=1.88u w=0.5u l=0.28u
C0 a_n116_n50# a_28_n50# 0.02085f
C1 a_28_n50# a_n28_n94# 0.00377f
C2 a_n116_n50# a_n28_n94# 0.00377f
C3 a_28_n50# VSUBS 0.07987f
C4 a_n116_n50# VSUBS 0.07987f
.ends

.subckt p_w1_l0p28 w_n202_n230# a_28_n100# a_n28_n144# a_n116_n100# VSUBS
X0 a_28_n100# a_n28_n144# a_n116_n100# w_n202_n230# pfet_03v3 ad=0.44p pd=2.88u as=0.44p ps=2.88u w=1u l=0.28u
C0 a_n28_n144# a_n116_n100# 0.00769f
C1 a_n116_n100# w_n202_n230# 0.01808f
C2 a_28_n100# a_n116_n100# 0.04256f
C3 a_n28_n144# w_n202_n230# 0.05841f
C4 a_n28_n144# a_28_n100# 0.00769f
C5 a_28_n100# w_n202_n230# 0.01808f
C6 a_28_n100# VSUBS 0.0597f
C7 a_n116_n100# VSUBS 0.0597f
C8 w_n202_n230# VSUBS 0.55752f
.ends

.subckt p_w2_l2_f4 a_n52_n200# a_452_n200# a_n452_n244# a_n556_n200# a_52_n244# a_956_n200#
+ a_n1044_n200# w_n1130_n330# a_n956_n244# a_556_n244# VSUBS
X0 a_452_n200# a_52_n244# a_n52_n200# w_n1130_n330# pfet_03v3 ad=0.52p pd=2.52u as=0.52p ps=2.52u w=2u l=2u
X1 a_956_n200# a_556_n244# a_452_n200# w_n1130_n330# pfet_03v3 ad=0.88p pd=4.88u as=0.52p ps=2.52u w=2u l=2u
X2 a_n556_n200# a_n956_n244# a_n1044_n200# w_n1130_n330# pfet_03v3 ad=0.52p pd=2.52u as=0.88p ps=4.88u w=2u l=2u
X3 a_n52_n200# a_n452_n244# a_n556_n200# w_n1130_n330# pfet_03v3 ad=0.52p pd=2.52u as=0.52p ps=2.52u w=2u l=2u
C0 a_956_n200# w_n1130_n330# 0.0618f
C1 a_956_n200# a_556_n244# 0.0587f
C2 a_n1044_n200# a_n956_n244# 0.0587f
C3 a_956_n200# a_452_n200# 0.02133f
C4 a_n452_n244# a_n52_n200# 0.0587f
C5 a_n1044_n200# w_n1130_n330# 0.0618f
C6 a_n956_n244# a_n452_n244# 0.00519f
C7 a_n452_n244# w_n1130_n330# 0.21994f
C8 a_n1044_n200# a_n556_n200# 0.02133f
C9 a_52_n244# a_n452_n244# 0.00519f
C10 a_n452_n244# a_n556_n200# 0.0587f
C11 w_n1130_n330# a_n52_n200# 0.09155f
C12 a_52_n244# a_n52_n200# 0.0587f
C13 a_n956_n244# w_n1130_n330# 0.2233f
C14 a_n52_n200# a_n556_n200# 0.02133f
C15 a_556_n244# w_n1130_n330# 0.2233f
C16 a_52_n244# w_n1130_n330# 0.21994f
C17 a_n956_n244# a_n556_n200# 0.0587f
C18 a_556_n244# a_52_n244# 0.00519f
C19 a_452_n200# a_n52_n200# 0.02133f
C20 w_n1130_n330# a_n556_n200# 0.09155f
C21 a_452_n200# w_n1130_n330# 0.09155f
C22 a_556_n244# a_452_n200# 0.0587f
C23 a_452_n200# a_52_n244# 0.0587f
C24 a_956_n200# VSUBS 0.13364f
C25 a_452_n200# VSUBS 0.12191f
C26 a_n52_n200# VSUBS 0.11851f
C27 a_n556_n200# VSUBS 0.12191f
C28 a_n1044_n200# VSUBS 0.13364f
C29 w_n1130_n330# VSUBS 4.4748f
.ends

.subckt p_w2_l0p5 a_50_n200# a_n50_n244# w_n224_n330# a_n138_n200# VSUBS
X0 a_50_n200# a_n50_n244# a_n138_n200# w_n224_n330# pfet_03v3 ad=0.88p pd=4.88u as=0.88p ps=4.88u w=2u l=0.5u
C0 a_n50_n244# a_50_n200# 0.02577f
C1 w_n224_n330# a_n138_n200# 0.03848f
C2 a_n50_n244# w_n224_n330# 0.07993f
C3 a_n50_n244# a_n138_n200# 0.02577f
C4 a_50_n200# w_n224_n330# 0.03848f
C5 a_50_n200# a_n138_n200# 0.06232f
C6 a_50_n200# VSUBS 0.0978f
C7 a_n138_n200# VSUBS 0.0978f
C8 w_n224_n330# VSUBS 0.88704f
.ends

.subckt n_w2_l0p5 a_50_n200# a_n50_n244# a_n138_n200# VSUBS
X0 a_50_n200# a_n50_n244# a_n138_n200# VSUBS nfet_03v3 ad=0.88p pd=4.88u as=0.88p ps=4.88u w=2u l=0.5u
C0 a_n50_n244# a_50_n200# 0.02577f
C1 a_n138_n200# a_n50_n244# 0.02577f
C2 a_n138_n200# a_50_n200# 0.06232f
C3 a_50_n200# VSUBS 0.1541f
C4 a_n138_n200# VSUBS 0.1541f
.ends

.subckt p_w4_l0p5 a_n138_n400# a_50_n400# a_n50_n444# w_n224_n530# VSUBS
X0 a_50_n400# a_n50_n444# a_n138_n400# w_n224_n530# pfet_03v3 ad=1.76p pd=8.88u as=1.76p ps=8.88u w=4u l=0.5u
C0 a_n50_n444# a_50_n400# 0.05179f
C1 w_n224_n530# a_n138_n400# 0.07442f
C2 a_n50_n444# w_n224_n530# 0.07993f
C3 a_n50_n444# a_n138_n400# 0.05179f
C4 a_50_n400# w_n224_n530# 0.07442f
C5 a_50_n400# a_n138_n400# 0.12527f
C6 a_50_n400# VSUBS 0.16249f
C7 a_n138_n400# VSUBS 0.16249f
C8 w_n224_n530# VSUBS 1.42464f
.ends

.subckt bias_master pad s0 s1 stim intref en in_n in_p iint a_1744_10100# vbp_st en_b
+ ua0_stim a_1744_9182# vss vdd a_736_7228# a_1764_11418# a_2240_11218# a_420_700#
+ a_736_5516#
XOP vss a_1744_10100# a_736_7228# vss n_w2_l2
XRS pad a_420_700# vss r_w4_l3p97
XS1 a_736_5516# s1 a_420_700# vss n_w8_l0p5
XS0 a_420_700# a_736_7228# s0 vss n_w4_l0p5
XOS vss vbp_st a_736_7228# vss n_w2_l2
XIENn en vss en_b vss n_w0p5_l0p28
XIENp vdd en_b en vdd vss p_w1_l0p28
XQX a_1744_9182# vdd a_1744_9182# vdd a_1744_9182# a_736_7228# a_736_7228# vdd a_1744_9182#
+ a_1744_9182# vss p_w2_l2_f4
XDXa vss vss a_736_5516# a_736_5516# a_736_5516# a_736_5516# a_736_5516# a_736_5516#
+ a_736_5516# a_736_5516# vss vss a_736_5516# a_736_5516# a_736_5516# a_736_5516#
+ vss vss n_w2_l2_f8
XOX vss a_1744_9182# a_736_5516# vss n_w2_l2
XDXb vss vss a_736_5516# a_736_5516# a_736_5516# a_736_5516# a_736_5516# a_736_5516#
+ a_736_5516# a_736_5516# vss vss a_736_5516# a_736_5516# a_736_5516# a_736_5516#
+ vss vss n_w2_l2_f8
XISTn stim vss a_1764_11418# vss n_w0p5_l0p28
XISTp vdd a_1764_11418# stim vdd vss p_w1_l0p28
XSWI a_736_7228# a_2240_11218# vdd iint vss p_w2_l0p5
XPD vdd a_1744_10100# a_1744_10100# in_p a_1744_10100# vdd vdd vdd a_1744_10100# a_1744_10100#
+ vss p_w2_l2_f4
XSTN ua0_stim stim a_420_700# vss n_w2_l0p5
XSTP a_420_700# ua0_stim a_1764_11418# vdd vss p_w4_l0p5
XPDN a_736_7228# vss en_b vss n_w4_l0p5
XDa vss vss a_736_7228# a_736_7228# a_736_7228# a_736_7228# a_736_7228# a_736_7228#
+ a_736_7228# a_736_7228# vss vss a_736_7228# a_736_7228# a_736_7228# a_736_7228#
+ vss vss n_w2_l2_f8
XDb vss vss a_736_7228# a_736_7228# a_736_7228# a_736_7228# a_736_7228# a_736_7228#
+ a_736_7228# a_736_7228# vss vss a_736_7228# a_736_7228# a_736_7228# a_736_7228#
+ vss vss n_w2_l2_f8
XIIRn intref vss a_2240_11218# vss n_w0p5_l0p28
XIIRp vdd a_2240_11218# intref vdd vss p_w1_l0p28
XON vss in_n a_736_7228# vss n_w2_l2
D0 vss a_420_700# diode_nd2ps_03v3 pj=22u area=10p
D1 a_420_700# vdd diode_pd2nw_03v3 pj=22u area=10p
C0 a_736_7228# pad 0.00246f
C1 in_n vdd 0.93129f
C2 in_p en 0.1023f
C3 a_736_5516# s0 0.00164f
C4 vdd s1 0
C5 intref pad 0.04537f
C6 a_420_700# a_1744_10100# 0
C7 vbp_st a_1744_10100# 0.06941f
C8 stim a_2240_11218# 0.02672f
C9 a_1744_9182# a_1744_10100# 0.21634f
C10 en_b a_2240_11218# 0.55285f
C11 ua0_stim a_736_7228# 0.65944f
C12 iint a_2240_11218# 0.04705f
C13 s0 s1 0.37932f
C14 a_1764_11418# a_1744_10100# 0.20361f
C15 intref ua0_stim 0.38842f
C16 en a_1744_10100# 0
C17 a_736_7228# stim 0.67831f
C18 a_736_7228# en_b 0.01852f
C19 pad s1 0.04303f
C20 a_736_5516# ua0_stim 0.76166f
C21 intref stim 0.10135f
C22 a_736_7228# iint 0.07137f
C23 intref en_b 0.13348f
C24 in_p a_1744_10100# 0.1228f
C25 a_420_700# a_2240_11218# 0
C26 vdd pad 0.30131f
C27 vbp_st a_2240_11218# 0.09119f
C28 a_2240_11218# a_1744_9182# 0.04423f
C29 in_n ua0_stim 0.13986f
C30 ua0_stim s1 0
C31 a_1764_11418# a_2240_11218# 0.0155f
C32 a_736_5516# stim 0.46322f
C33 a_736_5516# en_b 0.10641f
C34 pad s0 0.04859f
C35 ua0_stim vdd 0.7438f
C36 a_736_7228# a_420_700# 0.60616f
C37 en a_2240_11218# 0.0689f
C38 vbp_st a_736_7228# 0.19283f
C39 in_n stim 0
C40 a_736_7228# a_1744_9182# 0.40049f
C41 stim s1 0.05023f
C42 en_b s1 0.04984f
C43 intref a_420_700# 0.08048f
C44 intref vbp_st 0.10375f
C45 intref a_1744_9182# 0.06003f
C46 ua0_stim s0 0
C47 in_p a_2240_11218# 0
C48 a_736_7228# a_1764_11418# 0.58069f
C49 vdd stim 0.43645f
C50 vdd en_b 1.53555f
C51 intref a_1764_11418# 0.13911f
C52 vdd iint 0.20167f
C53 a_736_5516# a_420_700# 0.22588f
C54 a_736_7228# en 0.06595f
C55 a_736_5516# vbp_st 0.01681f
C56 a_736_5516# a_1744_9182# 0.06682f
C57 stim s0 0
C58 en_b s0 0
C59 intref en 0.18747f
C60 a_736_7228# in_p 0.13123f
C61 a_736_5516# a_1764_11418# 0.29581f
C62 in_n a_420_700# 0.06513f
C63 in_n vbp_st 0
C64 a_420_700# s1 0.34537f
C65 in_n a_1744_9182# 0.05554f
C66 a_2240_11218# a_1744_10100# 0.00646f
C67 vdd a_420_700# 1.39245f
C68 a_736_5516# en 0.1206f
C69 in_n a_1764_11418# 0
C70 stim pad 0.03728f
C71 vbp_st vdd 1.24211f
C72 en_b pad 0.00118f
C73 vdd a_1744_9182# 1.89441f
C74 vdd a_1764_11418# 0.9203f
C75 in_n en 0.22085f
C76 s0 a_420_700# 0.23128f
C77 en s1 0.05296f
C78 ua0_stim stim 0.17275f
C79 a_736_7228# a_1744_10100# 0.21495f
C80 ua0_stim en_b 0.11556f
C81 ua0_stim iint 0.22215f
C82 intref a_1744_10100# 0.00123f
C83 in_n in_p 0.00893f
C84 vdd en 1.40435f
C85 vdd in_p 0.3992f
C86 en_b stim 0.09516f
C87 pad a_420_700# 0.54069f
C88 en s0 0.08622f
C89 stim iint 0
C90 en_b iint 0.00566f
C91 ua0_stim a_420_700# 0.27553f
C92 ua0_stim vbp_st 0.28759f
C93 in_n a_1744_10100# 0
C94 ua0_stim a_1744_9182# 0
C95 a_736_7228# a_2240_11218# 0.1092f
C96 en pad 0.07917f
C97 intref a_2240_11218# 0.51277f
C98 ua0_stim a_1764_11418# 0.39761f
C99 vdd a_1744_10100# 2.14231f
C100 stim a_420_700# 0.39449f
C101 en_b a_420_700# 0.00238f
C102 vbp_st stim 0.03538f
C103 vbp_st en_b 0.22396f
C104 stim a_1744_9182# 0.09507f
C105 ua0_stim en 0.04932f
C106 vbp_st iint 0.03426f
C107 a_736_5516# a_2240_11218# 0.20875f
C108 a_1764_11418# stim 0.89967f
C109 en_b a_1764_11418# 0.04298f
C110 intref a_736_7228# 1.05564f
C111 ua0_stim in_p 0.13299f
C112 a_1764_11418# iint 0.04831f
C113 en stim 0.16867f
C114 en_b en 0.16284f
C115 en iint 0.04364f
C116 a_736_5516# a_736_7228# 0.94834f
C117 vdd a_2240_11218# 1.56334f
C118 in_p stim 0
C119 vbp_st a_420_700# 0.00221f
C120 a_420_700# a_1744_9182# 0
C121 a_736_5516# intref 0.42454f
C122 vbp_st a_1744_9182# 0.27778f
C123 in_p iint 0
C124 in_n a_736_7228# 0.22106f
C125 a_1764_11418# a_420_700# 0.01871f
C126 a_736_7228# s1 0.26174f
C127 ua0_stim a_1744_10100# 0.0495f
C128 vbp_st a_1764_11418# 0.24107f
C129 a_1764_11418# a_1744_9182# 0.08433f
C130 intref s1 0.00169f
C131 vdd a_736_7228# 1.34623f
C132 en a_420_700# 1.35379f
C133 vbp_st en 0.4389f
C134 intref vdd 1.1637f
C135 en a_1744_9182# 0
C136 stim a_1744_10100# 0.5686f
C137 en_b a_1744_10100# 0
C138 in_p a_420_700# 0.14384f
C139 a_736_7228# s0 0.08339f
C140 a_1764_11418# en 0.00964f
C141 iint a_1744_10100# 0.0038f
C142 vbp_st in_p 0.01109f
C143 a_736_5516# s1 0.04485f
C144 in_p a_1744_9182# 0.0074f
C145 intref s0 0
C146 a_736_5516# vdd 0.03946f
C147 in_p a_1764_11418# 0.10845f
C148 ua0_stim a_2240_11218# 0.01891f
C149 in_n vss 0.4171f
C150 a_2240_11218# vss 1.12079f
C151 intref vss 1.56078f
C152 a_736_7228# vss 7.21627f
C153 en_b vss 2.84339f
C154 ua0_stim vss 1.3904f
C155 stim vss 1.68124f
C156 in_p vss 0.10852f
C157 iint vss -0.02046f
C158 a_1764_11418# vss 0.23987f
C159 a_736_5516# vss 5.14983f
C160 a_1744_9182# vss -0.31499f
C161 vdd vss 48.57603f
C162 en vss 2.99933f
C163 vbp_st vss 0.13312f
C164 a_420_700# vss 2.09001f
C165 s0 vss 0.69974f
C166 s1 vss 0.67954f
C167 pad vss 1.41208f
C168 a_1744_10100# vss -0.2385f
.ends

.subckt n_w2_l2_f7 a_n704_n244# a_n808_n200# a_304_n244# a_n1712_n244# a_1712_n200#
+ a_n1800_n200# a_n1208_n244# a_1208_n200# a_200_n200# a_1312_n244# a_808_n244# a_n200_n244#
+ a_n304_n200# a_n1312_n200# a_704_n200# VSUBS
X0 a_n304_n200# a_n704_n244# a_n808_n200# VSUBS nfet_03v3 ad=0.52p pd=2.52u as=0.52p ps=2.52u w=2u l=2u
X1 a_200_n200# a_n200_n244# a_n304_n200# VSUBS nfet_03v3 ad=0.52p pd=2.52u as=0.52p ps=2.52u w=2u l=2u
X2 a_1712_n200# a_1312_n244# a_1208_n200# VSUBS nfet_03v3 ad=0.88p pd=4.88u as=0.52p ps=2.52u w=2u l=2u
X3 a_1208_n200# a_808_n244# a_704_n200# VSUBS nfet_03v3 ad=0.52p pd=2.52u as=0.52p ps=2.52u w=2u l=2u
X4 a_704_n200# a_304_n244# a_200_n200# VSUBS nfet_03v3 ad=0.52p pd=2.52u as=0.52p ps=2.52u w=2u l=2u
X5 a_n1312_n200# a_n1712_n244# a_n1800_n200# VSUBS nfet_03v3 ad=0.52p pd=2.52u as=0.88p ps=4.88u w=2u l=2u
X6 a_n808_n200# a_n1208_n244# a_n1312_n200# VSUBS nfet_03v3 ad=0.52p pd=2.52u as=0.52p ps=2.52u w=2u l=2u
C0 a_n704_n244# a_n304_n200# 0.0587f
C1 a_n704_n244# a_n1208_n244# 0.00519f
C2 a_n704_n244# a_n808_n200# 0.0587f
C3 a_304_n244# a_704_n200# 0.0587f
C4 a_808_n244# a_304_n244# 0.00519f
C5 a_808_n244# a_704_n200# 0.0587f
C6 a_n1712_n244# a_n1312_n200# 0.0587f
C7 a_200_n200# a_n200_n244# 0.0587f
C8 a_1208_n200# a_1312_n244# 0.0587f
C9 a_n1208_n244# a_n1312_n200# 0.0587f
C10 a_1712_n200# a_1312_n244# 0.0587f
C11 a_n1312_n200# a_n808_n200# 0.02133f
C12 a_n1712_n244# a_n1208_n244# 0.00519f
C13 a_n704_n244# a_n200_n244# 0.00519f
C14 a_n808_n200# a_n304_n200# 0.02133f
C15 a_n1208_n244# a_n808_n200# 0.0587f
C16 a_1712_n200# a_1208_n200# 0.02133f
C17 a_n1312_n200# a_n1800_n200# 0.02133f
C18 a_304_n244# a_200_n200# 0.0587f
C19 a_808_n244# a_1312_n244# 0.00519f
C20 a_200_n200# a_704_n200# 0.02133f
C21 a_n1712_n244# a_n1800_n200# 0.0587f
C22 a_304_n244# a_n200_n244# 0.00519f
C23 a_704_n200# a_1208_n200# 0.02133f
C24 a_808_n244# a_1208_n200# 0.0587f
C25 a_200_n200# a_n304_n200# 0.02133f
C26 a_n200_n244# a_n304_n200# 0.0587f
C27 a_1712_n200# VSUBS 0.26162f
C28 a_1208_n200# VSUBS 0.34773f
C29 a_704_n200# VSUBS 0.34265f
C30 a_200_n200# VSUBS 0.34265f
C31 a_n304_n200# VSUBS 0.34265f
C32 a_n808_n200# VSUBS 0.34265f
C33 a_n1312_n200# VSUBS 0.34773f
C34 a_n1800_n200# VSUBS 0.26162f
.ends

.subckt n_w0p5_l0p5_f2 a_n52_n50# a_52_n94# a_152_n50# a_n240_n50# a_n152_n94# VSUBS
X0 a_152_n50# a_52_n94# a_n52_n50# VSUBS nfet_03v3 ad=0.22p pd=1.88u as=0.13p ps=1.02u w=0.5u l=0.5u
X1 a_n52_n50# a_n152_n94# a_n240_n50# VSUBS nfet_03v3 ad=0.13p pd=1.02u as=0.22p ps=1.88u w=0.5u l=0.5u
C0 a_n240_n50# a_n52_n50# 0.01511f
C1 a_152_n50# a_52_n94# 0.00625f
C2 a_152_n50# a_n52_n50# 0.01511f
C3 a_n152_n94# a_52_n94# 0.00519f
C4 a_n240_n50# a_n152_n94# 0.00625f
C5 a_n152_n94# a_n52_n50# 0.00625f
C6 a_n52_n50# a_52_n94# 0.00625f
C7 a_152_n50# VSUBS 0.09131f
C8 a_n52_n50# VSUBS 0.12761f
C9 a_n240_n50# VSUBS 0.09131f
.ends

.subckt idac_n b0 b1 b2 b3 b4 out vdd m1_988_3304# a_1378_4170# a_528_4170# a_2228_4170#
+ a_3928_4170# vcas a_732_4170# a_1582_4170# a_2432_4170# a_3282_4170# m1_988_2644#
+ a_4132_4170# m1_988_888# m1_260_2080# dump m1_1500_3762# a_3078_4170# vsn g vss
XU4b vsn vsn m1_988_888# g g m1_988_888# g m1_988_888# g m1_988_888# vsn vsn g g g
+ g vsn vss n_w2_l2_f8
XU3 vsn vsn m1_988_2644# g g m1_988_2644# g m1_988_2644# g m1_988_2644# vsn vsn g
+ g g g vsn vss n_w2_l2_f8
XIP0 a_732_4170# vcas vcas a_528_4170# a_732_4170# b0 vss p_w1_l0p28_f2
XIP1 a_1582_4170# vcas vcas a_1378_4170# a_1582_4170# b1 vss p_w1_l0p28_f2
XIP2 a_2432_4170# vcas vcas a_2228_4170# a_2432_4170# b2 vss p_w1_l0p28_f2
XIN0 vss a_732_4170# a_732_4170# a_528_4170# b0 vss n_w0p5_l0p28_f2
XIP3 a_3282_4170# vcas vcas a_3078_4170# a_3282_4170# b3 vss p_w1_l0p28_f2
XIN1 vss a_1582_4170# a_1582_4170# a_1378_4170# b1 vss n_w0p5_l0p28_f2
XIP4 a_4132_4170# vcas vcas a_3928_4170# a_4132_4170# b4 vss p_w1_l0p28_f2
XIN3 vss a_3282_4170# a_3282_4170# a_3078_4170# b3 vss n_w0p5_l0p28_f2
XIN2 vss a_2432_4170# a_2432_4170# a_2228_4170# b2 vss n_w0p5_l0p28_f2
XIN4 vss a_4132_4170# a_4132_4170# a_3928_4170# b4 vss n_w0p5_l0p28_f2
XU210 g vsn g g m1_260_2080# vsn g vsn vsn g g g m1_988_3304# m1_988_3304# m1_1500_3762#
+ vss n_w2_l2_f7
XSW0 m1_260_2080# a_732_4170# dump out a_528_4170# vss n_w0p5_l0p5_f2
XSW2 m1_988_3304# a_2432_4170# dump out a_2228_4170# vss n_w0p5_l0p5_f2
XSW1 m1_1500_3762# a_1582_4170# dump out a_1378_4170# vss n_w0p5_l0p5_f2
XSW3 m1_988_2644# a_3282_4170# dump out a_3078_4170# vss n_w0p5_l0p5_f2
XSW4 m1_988_888# a_4132_4170# dump out a_3928_4170# vss n_w0p5_l0p5_f2
XU4a vsn vsn m1_988_888# g g m1_988_888# g m1_988_888# g m1_988_888# vsn vsn g g g
+ g vsn vss n_w2_l2_f8
C0 m1_1500_3762# m1_988_3304# 0.11176f
C1 b3 a_3078_4170# 0.09671f
C2 b1 a_1582_4170# 0.27926f
C3 a_3282_4170# a_1378_4170# 0
C4 a_2228_4170# vcas 0.08842f
C5 m1_260_2080# a_3078_4170# 0.20065f
C6 a_2228_4170# m1_988_3304# 0.06446f
C7 a_3282_4170# b3 0.14389f
C8 m1_260_2080# vsn 0.30933f
C9 a_1378_4170# vcas 0.15514f
C10 a_3282_4170# b1 0
C11 b0 vcas 0.36918f
C12 a_1378_4170# m1_988_3304# 0
C13 a_3078_4170# vdd 0
C14 g a_1582_4170# 0.0036f
C15 g a_3078_4170# 0.13262f
C16 b3 vcas 0.48197f
C17 g vsn 4.12488f
C18 out a_4132_4170# 0.00472f
C19 dump a_3928_4170# 0.03528f
C20 b1 vcas 0.89272f
C21 a_3282_4170# vdd 0
C22 a_3282_4170# g 0.00339f
C23 out b2 0.01329f
C24 dump a_2432_4170# 0.04021f
C25 vdd vcas 0.00626f
C26 m1_988_888# a_4132_4170# 0.02826f
C27 a_3078_4170# vsn 0.01097f
C28 g vcas 0.00531f
C29 a_3282_4170# a_1582_4170# 0
C30 g m1_988_3304# 0.39585f
C31 a_3282_4170# a_3078_4170# 0.27925f
C32 b4 a_4132_4170# 0.25674f
C33 a_1582_4170# vcas 0.27006f
C34 m1_988_3304# a_1582_4170# 0
C35 a_3078_4170# vcas 0.73187f
C36 m1_1500_3762# b2 0
C37 m1_988_3304# vsn 0.0562f
C38 a_3282_4170# vcas 0.29204f
C39 dump m1_988_2644# 0.07098f
C40 a_2228_4170# b2 0.04686f
C41 a_1378_4170# b2 0.00837f
C42 b3 a_4132_4170# 0.00478f
C43 m1_988_2644# a_3928_4170# 0
C44 dump a_528_4170# 0.07429f
C45 m1_260_2080# a_4132_4170# 0
C46 b3 b2 0.01263f
C47 b1 b2 0.0021f
C48 dump a_732_4170# 0.02697f
C49 dump out 0.4373f
C50 g a_4132_4170# 0.00123f
C51 out a_3928_4170# 0.00435f
C52 dump m1_988_888# 0.1173f
C53 g b2 0
C54 a_2432_4170# out 0.02507f
C55 a_3078_4170# a_4132_4170# 0.06615f
C56 m1_988_888# a_3928_4170# 0.0651f
C57 dump b4 0.05108f
C58 dump m1_1500_3762# 0.09882f
C59 vsn a_4132_4170# 0
C60 a_1582_4170# b2 0.00172f
C61 a_3078_4170# b2 0
C62 a_3282_4170# a_4132_4170# 0.128f
C63 b4 a_3928_4170# 0.02632f
C64 dump a_2228_4170# 0.15915f
C65 a_3282_4170# b2 0
C66 dump a_1378_4170# 0.07506f
C67 m1_1500_3762# a_2432_4170# 0
C68 a_4132_4170# vcas 0.27886f
C69 b2 vcas 0.3849f
C70 dump b3 0.14989f
C71 m1_988_2644# out 0.06032f
C72 m1_988_3304# b2 0
C73 a_2228_4170# a_2432_4170# 0.14213f
C74 dump b1 0.0143f
C75 dump m1_260_2080# 0.05465f
C76 b3 a_3928_4170# 0
C77 a_1378_4170# a_2432_4170# 0.06027f
C78 m1_988_888# m1_988_2644# 0.44143f
C79 a_732_4170# a_528_4170# 0.1853f
C80 dump vdd 0.01049f
C81 out a_528_4170# 0.25397f
C82 m1_260_2080# a_3928_4170# 0
C83 b3 a_2432_4170# 0.00238f
C84 dump g 0.62788f
C85 a_732_4170# out 0.01797f
C86 b1 a_2432_4170# 0
C87 m1_1500_3762# m1_988_2644# 0.09258f
C88 g a_3928_4170# 0.00223f
C89 dump a_1582_4170# 0.01837f
C90 dump a_3078_4170# 0.52465f
C91 m1_988_888# out 0.00355f
C92 g a_2432_4170# 0.00286f
C93 dump vsn 0.45688f
C94 dump a_3282_4170# 0.04973f
C95 a_3078_4170# a_3928_4170# 0.27629f
C96 m1_1500_3762# out 0.38998f
C97 vsn a_3928_4170# 0
C98 a_2432_4170# a_1582_4170# 0.01867f
C99 b3 m1_988_2644# 0
C100 a_3078_4170# a_2432_4170# 0.0066f
C101 a_3282_4170# a_3928_4170# 0.0068f
C102 dump vcas 1.35686f
C103 a_2228_4170# out 0.02717f
C104 dump m1_988_3304# 0.34162f
C105 m1_260_2080# m1_988_2644# 0.24844f
C106 a_1378_4170# a_528_4170# 0.00677f
C107 b0 a_528_4170# 0.02165f
C108 m1_988_888# b4 0
C109 a_3282_4170# a_2432_4170# 0.01327f
C110 a_732_4170# a_1378_4170# 0.00239f
C111 a_1378_4170# out 0.04703f
C112 a_732_4170# b0 0.2484f
C113 b0 out 0.01654f
C114 vcas a_3928_4170# 0.08407f
C115 b1 a_528_4170# 0.04801f
C116 g m1_988_2644# 1.19317f
C117 m1_260_2080# a_528_4170# 0.05346f
C118 b3 out 0
C119 a_2432_4170# vcas 0.31499f
C120 a_2432_4170# m1_988_3304# 0.00578f
C121 b1 out 0.39281f
C122 a_732_4170# b1 0.00568f
C123 a_732_4170# m1_260_2080# 0.00987f
C124 m1_260_2080# out 0.07116f
C125 m1_1500_3762# a_2228_4170# 0.00184f
C126 g a_528_4170# 0.00771f
C127 a_3078_4170# m1_988_2644# 0.08059f
C128 m1_988_2644# vsn 0.25449f
C129 m1_1500_3762# a_1378_4170# 0.00998f
C130 a_732_4170# g 0.00276f
C131 g out 0.30711f
C132 m1_260_2080# m1_988_888# 0.55941f
C133 a_3282_4170# m1_988_2644# 0.00988f
C134 b3 b4 0.0097f
C135 a_528_4170# a_1582_4170# 0.0056f
C136 b3 m1_1500_3762# 0
C137 a_1378_4170# a_2228_4170# 0.00673f
C138 m1_1500_3762# b1 0
C139 g m1_988_888# 2.42837f
C140 a_732_4170# a_1582_4170# 0.00288f
C141 m1_260_2080# b4 0
C142 a_528_4170# vsn 0
C143 out a_1582_4170# 0.17521f
C144 m1_260_2080# m1_1500_3762# 0
C145 a_3078_4170# out 0.08761f
C146 b3 a_2228_4170# 0.00226f
C147 m1_988_2644# m1_988_3304# 0.00259f
C148 dump a_4132_4170# 0.04826f
C149 out vsn 0.01026f
C150 b1 a_2228_4170# 0
C151 vdd b4 0.0055f
C152 b3 a_1378_4170# 0.00218f
C153 dump b2 0.07018f
C154 a_3282_4170# out 0.02704f
C155 g b4 0
C156 g m1_1500_3762# 0.51943f
C157 b1 a_1378_4170# 0.03605f
C158 m1_988_888# a_3078_4170# 0.08147f
C159 a_4132_4170# a_3928_4170# 0.12544f
C160 b1 b0 0.02437f
C161 a_528_4170# vcas 0.09144f
C162 m1_260_2080# b0 0
C163 m1_988_888# vsn 0.75155f
C164 g a_2228_4170# 0.00553f
C165 a_732_4170# vcas 0.26007f
C166 out vcas 0.27597f
C167 m1_1500_3762# a_1582_4170# 0.02077f
C168 out m1_988_3304# 0.25145f
C169 a_3078_4170# b4 0.14552f
C170 m1_1500_3762# a_3078_4170# 0.00387f
C171 g a_1378_4170# 0.00374f
C172 a_2432_4170# b2 0.24144f
C173 g b0 0
C174 b4 vsn 0
C175 m1_1500_3762# vsn 0.02504f
C176 b3 vdd 0.00415f
C177 a_2228_4170# a_1582_4170# 0.00492f
C178 a_3282_4170# b4 0.0031f
C179 g b3 0
C180 a_3078_4170# a_2228_4170# 0.00113f
C181 g b1 0
C182 a_2228_4170# vsn 0
C183 a_1378_4170# a_1582_4170# 0.12904f
C184 b0 a_1582_4170# 0.00914f
C185 g m1_260_2080# 1.12515f
C186 a_1378_4170# a_3078_4170# 0
C187 a_3282_4170# a_2228_4170# 0.01488f
C188 b4 vcas 0.34586f
C189 m1_1500_3762# vcas 0.00146f
C190 vdd vss 0.03123f
C191 m1_988_888# vss 1.06123f
C192 vsn vss 1.84736f
C193 g vss 5.72892f
C194 a_3928_4170# vss 0.33427f
C195 a_3078_4170# vss 0.59741f
C196 m1_1500_3762# vss 0.27797f
C197 a_1378_4170# vss 0.34562f
C198 a_2228_4170# vss 0.17252f
C199 dump vss 1.82894f
C200 m1_260_2080# vss 2.17739f
C201 out vss 1.05553f
C202 a_528_4170# vss 0.28429f
C203 m1_988_3304# vss 0.09089f
C204 a_4132_4170# vss 0.41879f
C205 b4 vss 0.21281f
C206 a_2432_4170# vss 0.40441f
C207 b2 vss 0.19167f
C208 a_3282_4170# vss 0.41623f
C209 b3 vss 0.18821f
C210 a_1582_4170# vss 0.4013f
C211 b1 vss 0.38616f
C212 a_732_4170# vss 0.39599f
C213 b0 vss 0.34676f
C214 vcas vss 10.83517f
C215 m1_988_2644# vss 0.29815f
.ends

.subckt r_w1_l7p765 a_n100_n899# a_n100_777# VSUBS
X0 a_n100_777# a_n100_n899# VSUBS ppolyf_u_1k r_width=1u r_length=7.77u
C0 a_n100_n899# VSUBS 0.27003f
C1 a_n100_777# VSUBS 0.27003f
.ends

.subckt r_w2_l1p97 a_n200_n319# a_n200_197# VSUBS
X0 a_n200_197# a_n200_n319# VSUBS ppolyf_u_1k r_width=2u r_length=1.97u
C0 a_n200_197# a_n200_n319# 0.02096f
C1 a_n200_n319# VSUBS 0.42971f
C2 a_n200_197# VSUBS 0.42971f
.ends

.subckt r_w1_l1p94 a_n100_n316# a_n100_194# VSUBS
X0 a_n100_194# a_n100_n316# VSUBS ppolyf_u_1k r_width=1u r_length=1.94u
C0 a_n100_194# a_n100_n316# 0.01052f
C1 a_n100_n316# VSUBS 0.2541f
C2 a_n100_194# VSUBS 0.2541f
.ends

.subckt r_w1_l3p88 a_n100_n510# a_n100_388# VSUBS
X0 a_n100_388# a_n100_n510# VSUBS ppolyf_u_1k r_width=1u r_length=3.88u
C0 a_n100_388# a_n100_n510# 0.00535f
C1 a_n100_n510# VSUBS 0.26053f
C2 a_n100_388# VSUBS 0.26053f
.ends

.subckt n_w0p5_l1 a_100_n50# a_n100_n94# a_n188_n50# VSUBS
X0 a_100_n50# a_n100_n94# a_n188_n50# VSUBS nfet_03v3 ad=0.22p pd=1.88u as=0.22p ps=1.88u w=0.5u l=1u
C0 a_n100_n94# a_n188_n50# 0.01026f
C1 a_n100_n94# a_100_n50# 0.01026f
C2 a_100_n50# a_n188_n50# 0.00935f
C3 a_100_n50# VSUBS 0.13392f
C4 a_n188_n50# VSUBS 0.13392f
.ends

.subckt p_w1_l1 a_n188_n100# a_100_n100# a_n100_n144# w_n274_n230# VSUBS
X0 a_100_n100# a_n100_n144# a_n188_n100# w_n274_n230# pfet_03v3 ad=0.44p pd=2.88u as=0.44p ps=2.88u w=1u l=1u
C0 a_100_n100# a_n100_n144# 0.02094f
C1 w_n274_n230# a_n100_n144# 0.12884f
C2 a_100_n100# a_n188_n100# 0.0191f
C3 w_n274_n230# a_n188_n100# 0.02517f
C4 a_100_n100# w_n274_n230# 0.02517f
C5 a_n188_n100# a_n100_n144# 0.02094f
C6 a_100_n100# VSUBS 0.07854f
C7 a_n188_n100# VSUBS 0.07854f
C8 w_n274_n230# VSUBS 0.75624f
.ends

.subckt r_w1_l11p645 a_n100_1165# a_n100_n1287# VSUBS
X0 a_n100_1165# a_n100_n1287# VSUBS ppolyf_u_1k r_width=1u r_length=11.65u
C0 a_n100_n1287# VSUBS 0.27003f
C1 a_n100_1165# VSUBS 0.27003f
.ends

.subckt n_w4_l0p28_f2 a_n52_n400# a_52_n444# a_108_n400# a_n108_n444# a_n196_n400#
+ VSUBS
X0 a_108_n400# a_52_n444# a_n52_n400# VSUBS nfet_03v3 ad=1.76p pd=8.88u as=1.04p ps=4.52u w=4u l=0.28u
X1 a_n52_n400# a_n108_n444# a_n196_n400# VSUBS nfet_03v3 ad=1.04p pd=4.52u as=1.76p ps=8.88u w=4u l=0.28u
C0 a_n52_n400# a_52_n444# 0.03125f
C1 a_n108_n444# a_52_n444# 0.00519f
C2 a_108_n400# a_n52_n400# 0.17284f
C3 a_108_n400# a_52_n444# 0.03125f
C4 a_n52_n400# a_n196_n400# 0.17284f
C5 a_n108_n444# a_n196_n400# 0.03125f
C6 a_n52_n400# a_n108_n444# 0.03125f
C7 a_108_n400# VSUBS 0.20946f
C8 a_n52_n400# VSUBS 0.09458f
C9 a_n196_n400# VSUBS 0.20946f
.ends

.subckt vdacr_el b0 b1 b2 b3 b4 vdd out a_2224_3416# a_3408_3416# m1_822_4048# a_1632_3416#
+ m1_2242_4966# m1_2742_3250# m1_3310_2880# m1_1262_4048# a_1040_3416# vss a_2816_3416#
+ m1_617_3840# m1_3662_4048# m1_956_3000# m1_382_4048#
XXRS4_0 m1_3662_4048# m1_3310_2880# vss r_w1_l7p765
XXRS4_1 vss m1_3662_4048# vss r_w1_l7p765
XXRS0 m1_617_3840# m1_956_3000# vss r_w2_l1p97
XXRS1 m1_2242_4966# m1_617_3840# vss r_w1_l1p94
XXRS3 m1_3310_2880# m1_2742_3250# vss r_w1_l7p765
XXRS2 m1_2742_3250# m1_2242_4966# vss r_w1_l3p88
XIB4n a_3408_3416# b4 vss vss n_w0p5_l1
XIB3n a_2816_3416# b3 vss vss n_w0p5_l1
XIB4p vdd a_3408_3416# b4 vdd vss p_w1_l1
XIB2n a_2224_3416# b2 vss vss n_w0p5_l1
XIB3p vdd a_2816_3416# b3 vdd vss p_w1_l1
XIB2p vdd a_2224_3416# b2 vdd vss p_w1_l1
XIB1n a_1632_3416# b1 vss vss n_w0p5_l1
XIB0n a_1040_3416# b0 vss vss n_w0p5_l1
XIB1p vdd a_1632_3416# b1 vdd vss p_w1_l1
XIB0p vdd a_1040_3416# b0 vdd vss p_w1_l1
XXRB0 out m1_382_4048# vss r_w1_l11p645
XSW0 m1_617_3840# a_1040_3416# m1_956_3000# a_1040_3416# m1_956_3000# vss n_w4_l0p28_f2
XXRB1 m1_382_4048# m1_822_4048# vss r_w1_l11p645
XSW2 m1_2742_3250# a_2224_3416# m1_2242_4966# a_2224_3416# m1_2242_4966# vss n_w4_l0p28_f2
XSW1 m1_2242_4966# a_1632_3416# m1_617_3840# a_1632_3416# m1_617_3840# vss n_w4_l0p28_f2
XXRB3 m1_1262_4048# m1_956_3000# vss r_w1_l11p645
XXRB2 m1_822_4048# m1_1262_4048# vss r_w1_l11p645
XSW3 m1_3310_2880# a_2816_3416# m1_2742_3250# a_2816_3416# m1_2742_3250# vss n_w4_l0p28_f2
XSW4 vss a_3408_3416# m1_3310_2880# a_3408_3416# m1_3310_2880# vss n_w4_l0p28_f2
C0 m1_2742_3250# m1_617_3840# 0.01845f
C1 a_1632_3416# m1_1262_4048# 0.00132f
C2 m1_617_3840# a_2816_3416# 0
C3 a_3408_3416# a_2224_3416# 0
C4 a_1040_3416# m1_956_3000# 0.11081f
C5 m1_382_4048# m1_617_3840# 0.32274f
C6 m1_2242_4966# m1_3662_4048# 0
C7 m1_2742_3250# m1_956_3000# 0.00197f
C8 m1_822_4048# m1_1262_4048# 0.18781f
C9 b4 m1_3310_2880# 0.01127f
C10 m1_382_4048# m1_956_3000# 0.00423f
C11 m1_2742_3250# m1_3310_2880# 0.31172f
C12 a_2816_3416# m1_3310_2880# 0.20114f
C13 b3 m1_3310_2880# 0.02434f
C14 m1_617_3840# m1_3662_4048# 0
C15 b4 a_2224_3416# 0
C16 a_1040_3416# a_2224_3416# 0
C17 m1_2742_3250# a_2224_3416# 0.23293f
C18 a_2816_3416# a_2224_3416# 0.17309f
C19 m1_956_3000# m1_3662_4048# 0
C20 b3 a_2224_3416# 0.05038f
C21 a_3408_3416# b4 0.21422f
C22 a_3408_3416# m1_2742_3250# 0.01258f
C23 a_3408_3416# a_2816_3416# 0.03415f
C24 b0 a_1040_3416# 0.2598f
C25 a_3408_3416# b3 0
C26 vdd b1 0.48179f
C27 a_1632_3416# vdd 0.17222f
C28 m1_2242_4966# b1 0.00209f
C29 m1_3662_4048# m1_3310_2880# 0.3114f
C30 b1 b2 0.04707f
C31 m1_2242_4966# a_1632_3416# 0.15001f
C32 a_1632_3416# b2 0.02431f
C33 m1_2242_4966# m1_1262_4048# 0.01042f
C34 m1_617_3840# out 0.00314f
C35 m1_2242_4966# m1_822_4048# 0
C36 m1_617_3840# b1 0.00533f
C37 m1_617_3840# a_1632_3416# 0.15378f
C38 a_2816_3416# b4 0.05297f
C39 a_3408_3416# m1_3662_4048# 0
C40 m1_2742_3250# a_2816_3416# 0.2733f
C41 m1_617_3840# m1_1262_4048# 0.13358f
C42 b4 b3 0.04052f
C43 m1_2742_3250# b3 0.00105f
C44 a_2816_3416# b3 0.2249f
C45 m1_956_3000# b1 0
C46 m1_382_4048# a_1040_3416# 0
C47 a_1632_3416# m1_956_3000# 0.03269f
C48 m1_617_3840# m1_822_4048# 0.123f
C49 m1_956_3000# m1_1262_4048# 0.07066f
C50 a_1632_3416# m1_3310_2880# 0
C51 m1_822_4048# m1_956_3000# 0.03636f
C52 m1_2742_3250# m1_3662_4048# 0.03614f
C53 b1 a_2224_3416# 0
C54 a_1632_3416# a_2224_3416# 0.03245f
C55 m1_2242_4966# vdd 0.0033f
C56 vdd b2 0.46487f
C57 m1_2242_4966# b2 0.00331f
C58 b0 b1 0.02882f
C59 a_1632_3416# b0 0.00371f
C60 m1_617_3840# vdd 0
C61 m1_617_3840# m1_2242_4966# 0.32683f
C62 vdd m1_956_3000# 0.00146f
C63 m1_2242_4966# m1_956_3000# 0.15942f
C64 m1_956_3000# b2 0
C65 b1 b4 0.00115f
C66 a_1040_3416# b1 0.03315f
C67 a_1632_3416# a_1040_3416# 0.0443f
C68 m1_382_4048# out 0.02694f
C69 m1_2742_3250# a_1632_3416# 0.00921f
C70 a_2816_3416# b1 0
C71 a_1632_3416# a_2816_3416# 0.00123f
C72 a_1040_3416# m1_1262_4048# 0
C73 vdd m1_3310_2880# 0.00483f
C74 b1 b3 0
C75 m1_2242_4966# m1_3310_2880# 0
C76 a_1632_3416# b3 0.00127f
C77 m1_2742_3250# m1_1262_4048# 0.009f
C78 m1_822_4048# a_1040_3416# 0
C79 m1_617_3840# m1_956_3000# 0.75011f
C80 vdd a_2224_3416# 0.20102f
C81 m1_2242_4966# a_2224_3416# 0.17274f
C82 b2 a_2224_3416# 0.22771f
C83 m1_617_3840# m1_3310_2880# 0.00278f
C84 m1_382_4048# m1_822_4048# 0.39941f
C85 a_3408_3416# vdd 0.22664f
C86 b0 vdd 0.49326f
C87 b0 b2 0.00416f
C88 m1_956_3000# m1_3310_2880# 0
C89 m1_617_3840# a_2224_3416# 0.03861f
C90 m1_956_3000# a_2224_3416# 0
C91 m1_617_3840# b0 0
C92 vdd b4 0.59499f
C93 a_1040_3416# vdd 0.27317f
C94 b4 b2 0
C95 a_1040_3416# b2 0.00223f
C96 m1_2742_3250# vdd 0.00512f
C97 a_2816_3416# vdd 0.1469f
C98 m1_2742_3250# m1_2242_4966# 0.46801f
C99 m1_2742_3250# b2 0.01093f
C100 m1_2242_4966# a_2816_3416# 0
C101 a_2224_3416# m1_3310_2880# 0.05997f
C102 vdd b3 0.44294f
C103 b0 m1_956_3000# 0.00622f
C104 b3 b2 0.04135f
C105 out m1_1262_4048# 0.01147f
C106 m1_382_4048# m1_2242_4966# 0
C107 a_3408_3416# m1_3310_2880# 0.07699f
C108 a_1632_3416# b1 0.35929f
C109 m1_617_3840# a_1040_3416# 0.2193f
C110 m1_822_4048# out 0.02257f
C111 m1_3310_2880# vss 1.09895f
C112 m1_1262_4048# vss 0.55221f
C113 m1_2242_4966# vss 0.19454f
C114 m1_2742_3250# vss 0.65139f
C115 m1_822_4048# vss 0.24942f
C116 m1_617_3840# vss 2.00651f
C117 m1_956_3000# vss 0.55486f
C118 m1_382_4048# vss 0.33796f
C119 out vss 0.8541f
C120 vdd vss 10.07211f
C121 a_1040_3416# vss 1.07104f
C122 b0 vss 0.4933f
C123 a_1632_3416# vss 0.5138f
C124 b1 vss 0.49625f
C125 a_2224_3416# vss 0.54715f
C126 b2 vss 0.3102f
C127 a_2816_3416# vss 0.43096f
C128 b3 vss 0.35598f
C129 a_3408_3416# vss 1.10802f
C130 b4 vss 0.34471f
C131 m1_3662_4048# vss 0.38401f
.ends

.subckt r_w1_l13p91 a_n100_n1513# a_n100_1391# VSUBS
X0 a_n100_1391# a_n100_n1513# VSUBS ppolyf_u_1k r_width=1u r_length=13.91u
C0 a_n100_n1513# VSUBS 0.27003f
C1 a_n100_1391# VSUBS 0.27003f
.ends

.subckt vdacr_vr b0 b1 b2 b3 b4 vdd a_680_3416# vss a_2456_3416# m1_462_4048# m1_860_4046#
+ a_1864_3416# out a_3048_3416# m1_2372_2520# m1_2974_2650# m1_756_3120# a_1272_3416#
+ m1_2862_4048# m1_606_2410# m1_1780_5040#
XXRS4_0 m1_2862_4048# m1_2974_2650# vss r_w1_l7p765
XXRS4_1 vss m1_2862_4048# vss r_w1_l7p765
XXRS0 m1_756_3120# m1_606_2410# vss r_w2_l1p97
XXRS1 m1_1780_5040# m1_756_3120# vss r_w1_l1p94
XXRS3 m1_2974_2650# m1_2372_2520# vss r_w1_l7p765
XXRS2 m1_2372_2520# m1_1780_5040# vss r_w1_l3p88
XIB4n a_3048_3416# b4 vss vss n_w0p5_l1
XIB3n a_2456_3416# b3 vss vss n_w0p5_l1
XIB4p vdd a_3048_3416# b4 vdd vss p_w1_l1
XIB2n a_1864_3416# b2 vss vss n_w0p5_l1
XIB3p vdd a_2456_3416# b3 vdd vss p_w1_l1
XIB2p vdd a_1864_3416# b2 vdd vss p_w1_l1
XIB1n a_1272_3416# b1 vss vss n_w0p5_l1
XIB0n a_680_3416# b0 vss vss n_w0p5_l1
XIB1p vdd a_1272_3416# b1 vdd vss p_w1_l1
XIB0p vdd a_680_3416# b0 vdd vss p_w1_l1
XXRB0 m1_462_4048# out vss r_w1_l13p91
XSW0 m1_756_3120# a_680_3416# m1_606_2410# a_680_3416# m1_606_2410# vss n_w4_l0p28_f2
XXRB1 m1_860_4046# m1_462_4048# vss r_w1_l13p91
XSW2 m1_2372_2520# a_1864_3416# m1_1780_5040# a_1864_3416# m1_1780_5040# vss n_w4_l0p28_f2
XSW1 m1_1780_5040# a_1272_3416# m1_756_3120# a_1272_3416# m1_756_3120# vss n_w4_l0p28_f2
XXRB2 m1_606_2410# m1_860_4046# vss r_w1_l13p91
XSW3 m1_2974_2650# a_2456_3416# m1_2372_2520# a_2456_3416# m1_2372_2520# vss n_w4_l0p28_f2
XSW4 vss a_3048_3416# m1_2974_2650# a_3048_3416# m1_2974_2650# vss n_w4_l0p28_f2
C0 m1_756_3120# b0 0
C1 m1_1780_5040# vdd 0.0026f
C2 m1_462_4048# m1_2372_2520# 0
C3 m1_2372_2520# m1_860_4046# 0
C4 m1_756_3120# m1_2862_4048# 0
C5 m1_462_4048# m1_606_2410# 0.01332f
C6 m1_2974_2650# m1_2862_4048# 0.17897f
C7 m1_462_4048# a_680_3416# 0.00361f
C8 m1_1780_5040# out 0.00646f
C9 a_3048_3416# vdd 0.14688f
C10 m1_606_2410# m1_860_4046# 0.08949f
C11 a_1864_3416# vdd 0.23259f
C12 a_680_3416# m1_860_4046# 0
C13 m1_756_3120# b1 0.00539f
C14 m1_756_3120# a_2456_3416# 0
C15 b1 a_1272_3416# 0.24882f
C16 m1_2974_2650# a_2456_3416# 0.30479f
C17 m1_462_4048# m1_1780_5040# 0
C18 m1_756_3120# m1_2372_2520# 0.13736f
C19 a_2456_3416# a_1272_3416# 0.00297f
C20 m1_1780_5040# m1_860_4046# 0.08602f
C21 m1_2974_2650# m1_2372_2520# 0.5557f
C22 m1_2372_2520# a_1272_3416# 0.01394f
C23 b0 b1 0.0391f
C24 m1_2974_2650# b3 0.00379f
C25 m1_756_3120# m1_606_2410# 0.30895f
C26 b3 a_1272_3416# 0
C27 m1_756_3120# b2 0
C28 m1_756_3120# a_680_3416# 0.10755f
C29 m1_2974_2650# m1_606_2410# 0
C30 m1_606_2410# a_1272_3416# 0.01865f
C31 b2 a_1272_3416# 0.04419f
C32 m1_2974_2650# b4 0.03331f
C33 a_680_3416# a_1272_3416# 0.04759f
C34 a_2456_3416# m1_2862_4048# 0.00561f
C35 m1_2372_2520# m1_2862_4048# 0.02957f
C36 b0 m1_606_2410# 0.01272f
C37 b2 b0 0
C38 m1_756_3120# m1_1780_5040# 0.43379f
C39 b0 a_680_3416# 0.24565f
C40 m1_2974_2650# m1_1780_5040# 0.08507f
C41 m1_1780_5040# a_1272_3416# 0.152f
C42 m1_606_2410# m1_2862_4048# 0
C43 b1 b3 0.00301f
C44 m1_2372_2520# a_2456_3416# 0.13462f
C45 m1_756_3120# a_1864_3416# 0.0068f
C46 m1_2974_2650# a_3048_3416# 0.1083f
C47 b1 m1_606_2410# 0
C48 a_2456_3416# b3 0.21262f
C49 m1_2974_2650# a_1864_3416# 0.00495f
C50 b2 b1 0.05461f
C51 b1 a_680_3416# 0.03391f
C52 a_1864_3416# a_1272_3416# 0.02555f
C53 m1_2372_2520# b3 0.02027f
C54 m1_462_4048# out 0.08166f
C55 m1_1780_5040# m1_2862_4048# 0.00262f
C56 b2 a_2456_3416# 0
C57 a_2456_3416# b4 0.09406f
C58 out m1_860_4046# 0.01202f
C59 m1_2372_2520# m1_606_2410# 0
C60 b2 m1_2372_2520# 0.00692f
C61 b2 b3 0.03777f
C62 b1 m1_1780_5040# 0.00216f
C63 b4 b3 0.04752f
C64 m1_756_3120# vdd 0.00214f
C65 a_3048_3416# m1_2862_4048# 0.00491f
C66 m1_606_2410# a_680_3416# 0.28826f
C67 b2 a_680_3416# 0
C68 m1_1780_5040# a_2456_3416# 0.00741f
C69 m1_2974_2650# vdd 0.01155f
C70 m1_462_4048# m1_860_4046# 0.19198f
C71 b2 b4 0
C72 vdd a_1272_3416# 0.13505f
C73 m1_2372_2520# m1_1780_5040# 0.17871f
C74 a_1864_3416# b1 0
C75 b0 vdd 0.43014f
C76 m1_1780_5040# m1_606_2410# 0.12918f
C77 a_3048_3416# a_2456_3416# 0.11912f
C78 b2 m1_1780_5040# 0
C79 a_1864_3416# a_2456_3416# 0.02335f
C80 m1_2372_2520# a_3048_3416# 0
C81 a_1864_3416# m1_2372_2520# 0.27866f
C82 m1_756_3120# m1_462_4048# 0
C83 a_1864_3416# b3 0.04632f
C84 m1_756_3120# m1_860_4046# 0.01696f
C85 b2 a_3048_3416# 0
C86 a_1864_3416# m1_606_2410# 0.0027f
C87 a_1864_3416# b2 0.16397f
C88 a_1864_3416# a_680_3416# 0
C89 a_3048_3416# b4 0.26257f
C90 b1 vdd 0.41268f
C91 m1_860_4046# a_1272_3416# 0
C92 a_2456_3416# vdd 0.20273f
C93 m1_2372_2520# vdd 0.00451f
C94 a_1864_3416# m1_1780_5040# 0.42554f
C95 vdd b3 0.45194f
C96 b2 vdd 0.57544f
C97 vdd a_680_3416# 0.1904f
C98 m1_2974_2650# m1_756_3120# 0.0665f
C99 m1_2372_2520# out 0
C100 vdd b4 0.55146f
C101 m1_756_3120# a_1272_3416# 0.2354f
C102 a_1864_3416# a_3048_3416# 0
C103 m1_2974_2650# a_1272_3416# 0
C104 m1_2974_2650# vss 0.65248f
C105 m1_2372_2520# vss 0.45945f
C106 m1_1780_5040# vss 0.79973f
C107 m1_860_4046# vss 0.58374f
C108 m1_756_3120# vss 0.79001f
C109 m1_606_2410# vss 0.54107f
C110 m1_462_4048# vss 0.74869f
C111 out vss 0.66703f
C112 vdd vss 7.78061f
C113 a_680_3416# vss 0.76469f
C114 b0 vss 0.46453f
C115 a_1272_3416# vss 0.41953f
C116 b1 vss 0.31842f
C117 a_1864_3416# vss 0.56004f
C118 b2 vss 0.2832f
C119 b4 vss 0.38639f
C120 a_2456_3416# vss 0.64752f
C121 b3 vss 0.32156f
C122 a_3048_3416# vss 1.09158f
C123 m1_2862_4048# vss 0.49249f
.ends

.subckt r_w1_l14p555 a_n100_1456# a_n100_n1578# VSUBS
X0 a_n100_1456# a_n100_n1578# VSUBS ppolyf_u_1k r_width=1u r_length=14.56u
C0 a_n100_n1578# VSUBS 0.27003f
C1 a_n100_1456# VSUBS 0.27003f
.ends

.subckt p_w10_l10 w_n1174_n1130# a_n1000_n1044# a_1000_n1000# a_n1088_n1000# VSUBS
X0 a_1000_n1000# a_n1000_n1044# a_n1088_n1000# w_n1174_n1130# pfet_03v3 ad=4.4p pd=20.88u as=4.4p ps=20.88u w=10u l=10u
C0 a_n1088_n1000# a_n1000_n1044# 0.38624f
C1 a_n1000_n1044# w_n1174_n1130# 1.0092f
C2 a_1000_n1000# a_n1000_n1044# 0.38624f
C3 a_n1088_n1000# w_n1174_n1130# 0.41194f
C4 a_1000_n1000# w_n1174_n1130# 0.41194f
C5 a_1000_n1000# VSUBS 0.65771f
C6 a_n1088_n1000# VSUBS 0.65771f
C7 w_n1174_n1130# VSUBS 15.9194f
.ends

.subckt bias_rails vsp vgln en_b vdd m1_782_438# m1_3422_438# m1_3862_3522# m1_2542_438#
+ vss m1_1222_3522# m1_342_438# vsn m1_1662_438# vglp
XR0 vsp m1_342_438# vss r_w1_l14p555
XR1 vsp m1_782_438# vss r_w1_l14p555
XR2 m1_1222_3522# m1_782_438# vss r_w1_l14p555
XR3 m1_1222_3522# m1_1662_438# vss r_w1_l14p555
XR4 vgln m1_1662_438# vss r_w1_l14p555
XHDR vdd m1_342_438# en_b vdd vss p_w4_l0p5
XR5 vgln m1_2542_438# vss r_w1_l14p555
XR6 vglp m1_2542_438# vss r_w1_l14p555
XR7 vglp m1_3422_438# vss r_w1_l14p555
XR9 m1_3862_3522# vsn vss r_w1_l14p555
XR8 m1_3862_3522# m1_3422_438# vss r_w1_l14p555
XR10 vss vsn vss r_w1_l14p555
XC2 vsp vdd vsp vsp vss p_w10_l10
XC1 vss vsn vss vss vss p_w10_l10
C0 m1_2542_438# m1_1662_438# 0.00961f
C1 m1_1662_438# m1_782_438# 0.00961f
C2 m1_2542_438# vsn 0
C3 m1_2542_438# m1_3422_438# 0.00961f
C4 m1_2542_438# m1_342_438# 0.02465f
C5 m1_782_438# m1_342_438# 0.0401f
C6 vdd vsn 0.00661f
C7 m1_1662_438# m1_342_438# 0.02539f
C8 m1_1222_3522# vsn 0.063f
C9 vgln m1_1222_3522# 0.01049f
C10 vdd m1_342_438# 0.17301f
C11 vdd m1_3862_3522# 0.01537f
C12 vdd vsp 1.60715f
C13 vdd en_b 1.36198f
C14 m1_1222_3522# vsp 0.09037f
C15 vgln vsn 0.59161f
C16 m1_3422_438# vsn 0.03433f
C17 vdd vglp 0.06028f
C18 m1_342_438# vsn 0.18087f
C19 m1_342_438# m1_3422_438# 0.0285f
C20 vsn vsp 0.81189f
C21 en_b vsn 0.00115f
C22 vgln vsp 0.07625f
C23 en_b m1_342_438# 0.02808f
C24 m1_3862_3522# vsp 0.02981f
C25 en_b m1_3862_3522# 0.00238f
C26 vglp vsn 0.14758f
C27 vglp vgln 0.17255f
C28 en_b vsp 0.24632f
C29 vglp m1_3862_3522# 0.01054f
C30 vglp vsp 0.16572f
C31 vglp en_b 0.00265f
C32 m1_3862_3522# vss 0.01668f
C33 vsn vss 2.43428f
C34 m1_3422_438# vss 0.00649f
C35 vglp vss 0.71006f
C36 m1_2542_438# vss 0.04057f
C37 en_b vss 0.77429f
C38 vdd vss 2.40243f
C39 vgln vss 0.3466f
C40 m1_1662_438# vss 0.04061f
C41 m1_1222_3522# vss 0.03291f
C42 m1_782_438# vss 0.04119f
C43 m1_342_438# vss 1.80172f
C44 vsp vss 7.7207f
.ends

.subckt r_w2_l1p315 a_n200_n254# a_n200_132# VSUBS
X0 a_n200_132# a_n200_n254# VSUBS ppolyf_u_1k r_width=2u r_length=1.32u
C0 a_n200_132# a_n200_n254# 0.02982f
C1 a_n200_n254# VSUBS 0.42149f
C2 a_n200_132# VSUBS 0.42149f
.ends

.subckt r_w2_l2p625 a_n200_n385# a_n200_263# VSUBS
X0 a_n200_263# a_n200_n385# VSUBS ppolyf_u_1k r_width=2u r_length=2.63u
C0 a_n200_263# a_n200_n385# 0.01591f
C1 a_n200_n385# VSUBS 0.43549f
C2 a_n200_263# VSUBS 0.43549f
.ends

.subckt r_w1_l5p175 a_n100_518# a_n100_n640# VSUBS
X0 a_n100_518# a_n100_n640# VSUBS ppolyf_u_1k r_width=1u r_length=5.18u
C0 a_n100_518# a_n100_n640# 0.00399f
C1 a_n100_n640# VSUBS 0.26263f
C2 a_n100_518# VSUBS 0.26263f
.ends

.subckt r_w1_l2p59 a_n100_n381# a_n100_259# VSUBS
X0 a_n100_259# a_n100_n381# VSUBS ppolyf_u_1k r_width=1u r_length=2.59u
C0 a_n100_259# a_n100_n381# 0.00799f
C1 a_n100_n381# VSUBS 0.25697f
C2 a_n100_259# VSUBS 0.25697f
.ends

.subckt r_w1_l10p35 a_n100_n1157# a_n100_1035# VSUBS
X0 a_n100_1035# a_n100_n1157# VSUBS ppolyf_u_1k r_width=1u r_length=10.35u
C0 a_n100_n1157# VSUBS 0.27003f
C1 a_n100_1035# VSUBS 0.27003f
.ends

.subckt vdacr_vc b0 b1 b2 b3 b4 vdd out a_680_3416# m1_462_4048# m1_596_2880# a_1864_3416#
+ m1_1342_4048# a_3048_3416# m1_2382_2650# m1_1780_2760# a_2456_3416# a_1272_3416#
+ m1_902_4048# m1_756_3240# m1_2964_2640# vss
XXRS0 m1_756_3240# m1_596_2880# vss r_w2_l1p315
XXRS1 m1_1780_2760# m1_756_3240# vss r_w2_l2p625
XXRS3 m1_2382_2650# m1_2964_2640# vss r_w1_l5p175
XXRS2 m1_2382_2650# m1_1780_2760# vss r_w1_l2p59
XXRS4 vss m1_2964_2640# vss r_w1_l10p35
XIB4n a_3048_3416# b4 vss vss n_w0p5_l1
XIB3n a_2456_3416# b3 vss vss n_w0p5_l1
XIB4p vdd a_3048_3416# b4 vdd vss p_w1_l1
XIB2n a_1864_3416# b2 vss vss n_w0p5_l1
XIB3p vdd a_2456_3416# b3 vdd vss p_w1_l1
XIB2p vdd a_1864_3416# b2 vdd vss p_w1_l1
XIB1n a_1272_3416# b1 vss vss n_w0p5_l1
XIB0n a_680_3416# b0 vss vss n_w0p5_l1
XIB1p vdd a_1272_3416# b1 vdd vss p_w1_l1
XIB0p vdd a_680_3416# b0 vdd vss p_w1_l1
XXRB0 out m1_462_4048# vss r_w1_l14p555
XSW0 m1_756_3240# a_680_3416# m1_596_2880# a_680_3416# m1_596_2880# vss n_w4_l0p28_f2
XXRB1 m1_462_4048# m1_902_4048# vss r_w1_l14p555
XSW2 m1_2382_2650# a_1864_3416# m1_1780_2760# a_1864_3416# m1_1780_2760# vss n_w4_l0p28_f2
XSW1 m1_1780_2760# a_1272_3416# m1_756_3240# a_1272_3416# m1_756_3240# vss n_w4_l0p28_f2
XXRB3 m1_1342_4048# m1_596_2880# vss r_w1_l14p555
XXRB2 m1_902_4048# m1_1342_4048# vss r_w1_l14p555
XSW3 m1_2964_2640# a_2456_3416# m1_2382_2650# a_2456_3416# m1_2382_2650# vss n_w4_l0p28_f2
XSW4 vss a_3048_3416# m1_2964_2640# a_3048_3416# m1_2964_2640# vss n_w4_l0p28_f2
C0 m1_1342_4048# m1_596_2880# 0.05175f
C1 out m1_462_4048# 0.08186f
C2 b0 vdd 0.4728f
C3 m1_462_4048# m1_756_3240# 0.07243f
C4 m1_1342_4048# m1_902_4048# 0.59267f
C5 vdd b2 0.48541f
C6 b4 b3 0.05196f
C7 a_680_3416# m1_756_3240# 0.09138f
C8 m1_596_2880# m1_756_3240# 0.63405f
C9 a_1864_3416# b2 0.30281f
C10 m1_2964_2640# m1_1342_4048# 0
C11 m1_902_4048# out 0.00898f
C12 b0 b1 0.03223f
C13 m1_902_4048# m1_756_3240# 0.15859f
C14 vdd m1_756_3240# 0.00935f
C15 m1_2382_2650# b2 0.00779f
C16 m1_1342_4048# m1_2382_2650# 0.00106f
C17 b1 b2 0.03672f
C18 vdd b3 0.45495f
C19 a_1864_3416# m1_756_3240# 0.21894f
C20 m1_2964_2640# m1_756_3240# 0.03724f
C21 a_1864_3416# b3 0.03231f
C22 m1_2964_2640# b3 0
C23 m1_2382_2650# m1_756_3240# 0.18929f
C24 b1 m1_756_3240# 0.02481f
C25 m1_1780_2760# a_2456_3416# 0.02311f
C26 m1_2382_2650# b3 0.02078f
C27 m1_1780_2760# a_1272_3416# 0.20372f
C28 a_2456_3416# a_3048_3416# 0.03483f
C29 b0 m1_756_3240# 0
C30 m1_1342_4048# out 0.02845f
C31 m1_1342_4048# m1_756_3240# 0.02959f
C32 b3 b2 0.05389f
C33 m1_1780_2760# m1_462_4048# 0
C34 m1_1780_2760# a_680_3416# 0
C35 b4 a_3048_3416# 0.28941f
C36 m1_1780_2760# m1_596_2880# 0.13932f
C37 a_1272_3416# a_2456_3416# 0.01817f
C38 m1_1780_2760# m1_902_4048# 0.0028f
C39 m1_1780_2760# vdd 0.0024f
C40 m1_1780_2760# a_1864_3416# 0.45815f
C41 m1_2964_2640# m1_1780_2760# 0.00209f
C42 vdd a_3048_3416# 0.1443f
C43 b4 a_2456_3416# 0.08415f
C44 m1_1780_2760# m1_2382_2650# 0.57773f
C45 a_3048_3416# a_1864_3416# 0
C46 m1_2964_2640# a_3048_3416# 0.09007f
C47 b1 m1_1780_2760# 0
C48 m1_596_2880# a_2456_3416# 0
C49 a_1272_3416# a_680_3416# 0.0323f
C50 a_3048_3416# m1_2382_2650# 0.00307f
C51 m1_596_2880# a_1272_3416# 0.01859f
C52 vdd a_2456_3416# 0.22632f
C53 m1_902_4048# a_1272_3416# 0.00535f
C54 vdd a_1272_3416# 0.16599f
C55 a_2456_3416# a_1864_3416# 0.02091f
C56 m1_1342_4048# m1_1780_2760# 0.36407f
C57 m1_1780_2760# b2 0.01235f
C58 m1_2964_2640# a_2456_3416# 0.19022f
C59 a_1272_3416# a_1864_3416# 0.13668f
C60 m1_2964_2640# a_1272_3416# 0
C61 a_680_3416# m1_462_4048# 0.00344f
C62 a_2456_3416# m1_2382_2650# 0.29833f
C63 m1_596_2880# m1_462_4048# 0.10991f
C64 m1_1780_2760# out 0.00408f
C65 a_1272_3416# m1_2382_2650# 0.00845f
C66 m1_1780_2760# m1_756_3240# 0.31426f
C67 m1_596_2880# a_680_3416# 0.18443f
C68 b1 a_1272_3416# 0.24461f
C69 vdd b4 0.64298f
C70 m1_902_4048# m1_462_4048# 0.1067f
C71 b4 a_1864_3416# 0
C72 m1_2964_2640# b4 0.01478f
C73 m1_902_4048# a_680_3416# 0
C74 vdd a_680_3416# 0.29783f
C75 m1_596_2880# m1_902_4048# 0.04254f
C76 vdd m1_596_2880# 0
C77 b0 a_1272_3416# 0
C78 a_3048_3416# b3 0
C79 a_2456_3416# b2 0.00423f
C80 a_1864_3416# a_680_3416# 0.00213f
C81 m1_596_2880# a_1864_3416# 0.00298f
C82 m1_2964_2640# m1_596_2880# 0
C83 m1_2382_2650# m1_462_4048# 0
C84 a_1272_3416# b2 0.04376f
C85 m1_1342_4048# a_1272_3416# 0.00125f
C86 a_680_3416# m1_2382_2650# 0
C87 m1_596_2880# m1_2382_2650# 0.12127f
C88 m1_2964_2640# m1_902_4048# 0
C89 vdd a_1864_3416# 0.25499f
C90 m1_2964_2640# vdd 0.00309f
C91 b1 a_680_3416# 0.0311f
C92 a_2456_3416# m1_756_3240# 0.00946f
C93 a_1272_3416# m1_756_3240# 0.25178f
C94 m1_2964_2640# a_1864_3416# 0
C95 a_2456_3416# b3 0.20171f
C96 m1_902_4048# m1_2382_2650# 0
C97 vdd m1_2382_2650# 0.00156f
C98 a_1272_3416# b3 0
C99 b1 vdd 0.42955f
C100 b0 a_680_3416# 0.36752f
C101 b0 m1_596_2880# 0.00542f
C102 a_1864_3416# m1_2382_2650# 0.08407f
C103 m1_2964_2640# m1_2382_2650# 0.25078f
C104 b1 a_1864_3416# 0.01341f
C105 m1_2964_2640# vss 1.71738f
C106 m1_1342_4048# vss 0.20629f
C107 m1_2382_2650# vss 0.88559f
C108 m1_1780_2760# vss 0.55176f
C109 m1_902_4048# vss 0.29458f
C110 m1_756_3240# vss 0.82268f
C111 m1_596_2880# vss 0.7575f
C112 m1_462_4048# vss 0.72606f
C113 out vss 0.62102f
C114 vdd vss 7.67233f
C115 a_680_3416# vss 1.18414f
C116 b0 vss 0.36638f
C117 a_1272_3416# vss 0.4405f
C118 b1 vss 0.28315f
C119 a_1864_3416# vss 0.73889f
C120 b2 vss 0.31706f
C121 b4 vss 0.35606f
C122 a_2456_3416# vss 0.60405f
C123 b3 vss 0.35144f
C124 a_3048_3416# vss 1.11524f
.ends

.subckt r_w1_l9p86 a_n100_n1108# a_n100_986# VSUBS
X0 a_n100_986# a_n100_n1108# VSUBS ppolyf_u_1k r_width=1u r_length=9.86u
C0 a_n100_n1108# VSUBS 0.27003f
C1 a_n100_986# VSUBS 0.27003f
.ends

.subckt r_w2_l2p5 a_n200_250# a_n200_n372# VSUBS
X0 a_n200_250# a_n200_n372# VSUBS ppolyf_u_1k r_width=2u r_length=2.5u
C0 a_n200_n372# a_n200_250# 0.01672f
C1 a_n200_n372# VSUBS 0.4345f
C2 a_n200_250# VSUBS 0.4345f
.ends

.subckt r_w1_l2p465 a_n100_n369# a_n100_247# VSUBS
X0 a_n100_247# a_n100_n369# VSUBS ppolyf_u_1k r_width=1u r_length=2.47u
C0 a_n100_n369# a_n100_247# 0.00837f
C1 a_n100_n369# VSUBS 0.25651f
C2 a_n100_247# VSUBS 0.25651f
.ends

.subckt r_w1_l4p93 a_n100_n615# a_n100_493# VSUBS
X0 a_n100_493# a_n100_n615# VSUBS ppolyf_u_1k r_width=1u r_length=4.93u
C0 a_n100_n615# a_n100_493# 0.0042f
C1 a_n100_n615# VSUBS 0.2623f
C2 a_n100_493# VSUBS 0.2623f
.ends

.subckt r_w1_l13p145 a_n100_1315# a_n100_n1437# VSUBS
X0 a_n100_1315# a_n100_n1437# VSUBS ppolyf_u_1k r_width=1u r_length=13.15u
C0 a_n100_n1437# VSUBS 0.27003f
C1 a_n100_1315# VSUBS 0.27003f
.ends

.subckt r_w1_l13p39 a_n100_n1461# a_n100_1339# VSUBS
X0 a_n100_1339# a_n100_n1461# VSUBS ppolyf_u_1k r_width=1u r_length=13.39u
C0 a_n100_n1461# VSUBS 0.27003f
C1 a_n100_1339# VSUBS 0.27003f
.ends

.subckt n_w6_l0p28_f2 a_52_n644# a_108_n600# a_n108_n644# a_n196_n600# a_n52_n600#
+ VSUBS
X0 a_108_n600# a_52_n644# a_n52_n600# VSUBS nfet_03v3 ad=2.64p pd=12.88u as=1.56p ps=6.52u w=6u l=0.28u
X1 a_n52_n600# a_n108_n644# a_n196_n600# VSUBS nfet_03v3 ad=1.56p pd=6.52u as=2.64p ps=12.88u w=6u l=0.28u
C0 a_n52_n600# a_n108_n644# 0.04695f
C1 a_108_n600# a_n52_n600# 0.2597f
C2 a_52_n644# a_n52_n600# 0.04695f
C3 a_52_n644# a_n108_n644# 0.00519f
C4 a_52_n644# a_108_n600# 0.04695f
C5 a_n52_n600# a_n196_n600# 0.2597f
C6 a_n196_n600# a_n108_n644# 0.04695f
C7 a_108_n600# VSUBS 0.28641f
C8 a_n52_n600# VSUBS 0.09458f
C9 a_n196_n600# VSUBS 0.28641f
.ends

.subckt vdacr_vt b0 b1 b2 b3 b4 b5 vdd m1_2720_2760# a_4584_3816# m1_5422_4448# m1_382_4448#
+ m1_822_4448# a_3992_3816# out a_1624_3816# a_3400_3816# a_2808_3816# m1_1702_4448#
+ vss m1_1523_3480# m1_3908_2760# m1_4078_3250# m1_4102_4448# m1_3222_4448# a_2216_3816#
+ m1_4982_4448# m1_1262_4448# m1_2408_3600#
XXRS4_0 m1_4102_4448# m1_3908_2760# vss r_w1_l9p86
XXRS4_1 m1_4078_3250# m1_4102_4448# vss r_w1_l9p86
XXRS0 m1_1523_3480# m1_2408_3600# vss r_w2_l2p5
XXRS1 m1_2720_2760# m1_2408_3600# vss r_w1_l2p465
XXRS3 m1_3908_2760# m1_3222_4448# vss r_w1_l9p86
XXRS2 m1_3222_4448# m1_2720_2760# vss r_w1_l4p93
XIB5n a_4584_3816# b5 vss vss n_w0p5_l1
XIB4n a_3992_3816# b4 vss vss n_w0p5_l1
XIB5p vdd a_4584_3816# b5 vdd vss p_w1_l1
XIB3n a_3400_3816# b3 vss vss n_w0p5_l1
XIB4p vdd a_3992_3816# b4 vdd vss p_w1_l1
XIB2n a_2808_3816# b2 vss vss n_w0p5_l1
XIB3p vdd a_3400_3816# b3 vdd vss p_w1_l1
XIB2p vdd a_2808_3816# b2 vdd vss p_w1_l1
XIB1n a_2216_3816# b1 vss vss n_w0p5_l1
XIB0n a_1624_3816# b0 vss vss n_w0p5_l1
XIB1p vdd a_2216_3816# b1 vdd vss p_w1_l1
XIB0p vdd a_1624_3816# b0 vdd vss p_w1_l1
XXRS5_0 m1_4078_3250# m1_4982_4448# vss r_w1_l13p145
XXRS5_1 m1_4982_4448# m1_5422_4448# vss r_w1_l13p145
XXRB0 m1_382_4448# out vss r_w1_l13p39
XSW0 a_1624_3816# m1_1523_3480# a_1624_3816# m1_1523_3480# m1_2408_3600# vss n_w6_l0p28_f2
XXRS5_2 m1_5422_4448# vss vss r_w1_l13p145
XXRB1 m1_822_4448# m1_382_4448# vss r_w1_l13p39
XSW2 a_2808_3816# m1_2720_2760# a_2808_3816# m1_2720_2760# m1_3222_4448# vss n_w6_l0p28_f2
XSW1 a_2216_3816# m1_2408_3600# a_2216_3816# m1_2408_3600# m1_2720_2760# vss n_w6_l0p28_f2
XXRB3 m1_1702_4448# m1_1262_4448# vss r_w1_l13p39
XXRB2 m1_1262_4448# m1_822_4448# vss r_w1_l13p39
XSW3 a_3400_3816# m1_3222_4448# a_3400_3816# m1_3222_4448# m1_3908_2760# vss n_w6_l0p28_f2
XXRB4 m1_1523_3480# m1_1702_4448# vss r_w1_l13p39
XSW4 a_3992_3816# m1_3908_2760# a_3992_3816# m1_3908_2760# m1_4078_3250# vss n_w6_l0p28_f2
XSW5 a_4584_3816# m1_4078_3250# a_4584_3816# m1_4078_3250# vss vss n_w6_l0p28_f2
C0 m1_4102_4448# a_3992_3816# 0.00406f
C1 b1 vdd 0.57997f
C2 m1_1262_4448# m1_2408_3600# 0
C3 m1_2720_2760# m1_3222_4448# 0.29322f
C4 b3 a_2808_3816# 0.06713f
C5 m1_2720_2760# m1_2408_3600# 0.46666f
C6 a_3992_3816# b5 0.04355f
C7 m1_2720_2760# m1_1262_4448# 0
C8 vdd b5 0.43768f
C9 b0 m1_2408_3600# 0
C10 m1_4102_4448# m1_1523_3480# 0
C11 b4 m1_4078_3250# 0.00389f
C12 a_2808_3816# m1_3222_4448# 0.33661f
C13 a_2808_3816# m1_2408_3600# 0.00831f
C14 m1_5422_4448# m1_4982_4448# 0.22446f
C15 b4 b2 0
C16 a_4584_3816# m1_3222_4448# 0
C17 m1_2720_2760# a_2808_3816# 0.18059f
C18 m1_3908_2760# a_3400_3816# 0.22332f
C19 m1_3908_2760# m1_5422_4448# 0
C20 m1_4102_4448# m1_4982_4448# 0
C21 a_2808_3816# b0 0
C22 a_1624_3816# m1_2408_3600# 0.06776f
C23 b3 vdd 0.48325f
C24 a_2216_3816# a_3400_3816# 0
C25 a_1624_3816# m1_1262_4448# 0.01883f
C26 m1_2720_2760# a_1624_3816# 0
C27 m1_3908_2760# m1_4102_4448# 0.13034f
C28 out m1_822_4448# 0.03993f
C29 a_3992_3816# m1_3222_4448# 0.00131f
C30 m1_382_4448# m1_1523_3480# 0
C31 a_2216_3816# b1 0.2531f
C32 vdd m1_3222_4448# 0
C33 a_1624_3816# b0 0.15697f
C34 vdd m1_2408_3600# 0.00431f
C35 m1_2720_2760# a_3992_3816# 0
C36 m1_382_4448# m1_822_4448# 0.24532f
C37 a_2808_3816# a_1624_3816# 0
C38 m1_2720_2760# vdd 0.00518f
C39 m1_1523_3480# m1_3222_4448# 0.00589f
C40 m1_1523_3480# m1_2408_3600# 0.469f
C41 out m1_1702_4448# 0.0205f
C42 m1_1523_3480# m1_1262_4448# 0
C43 vdd b0 0.93369f
C44 m1_2720_2760# m1_1523_3480# 0.1053f
C45 m1_822_4448# m1_2408_3600# 0
C46 a_2808_3816# a_3992_3816# 0
C47 m1_822_4448# m1_1262_4448# 0.1481f
C48 m1_382_4448# m1_1702_4448# 0
C49 m1_3908_2760# b3 0.00485f
C50 b4 a_3400_3816# 0.05013f
C51 a_2808_3816# vdd 0.27798f
C52 m1_4078_3250# a_3400_3816# 0.02137f
C53 m1_1523_3480# b0 0.00106f
C54 m1_4078_3250# m1_5422_4448# 0.00347f
C55 a_4584_3816# a_3992_3816# 0.07047f
C56 a_4584_3816# vdd 0.20323f
C57 a_2808_3816# m1_1523_3480# 0
C58 m1_3222_4448# m1_1702_4448# 0.01015f
C59 a_2216_3816# b3 0
C60 a_3400_3816# b2 0.0044f
C61 m1_2408_3600# m1_1702_4448# 0.06983f
C62 m1_3908_2760# m1_3222_4448# 0.79372f
C63 vdd a_1624_3816# 0.18717f
C64 m1_3908_2760# m1_2408_3600# 0.00121f
C65 m1_4102_4448# m1_4078_3250# 0.24673f
C66 m1_1262_4448# m1_1702_4448# 0.26271f
C67 m1_2720_2760# m1_1702_4448# 0
C68 b1 b2 0.03795f
C69 b4 b5 0.04472f
C70 m1_4078_3250# b5 0.00647f
C71 m1_3908_2760# m1_2720_2760# 0.00425f
C72 m1_1523_3480# a_1624_3816# 0.24354f
C73 a_2216_3816# m1_3222_4448# 0.00993f
C74 vdd a_3992_3816# 0.2529f
C75 a_2216_3816# m1_2408_3600# 0.39348f
C76 a_2216_3816# m1_2720_2760# 0.18569f
C77 a_4584_3816# m1_4982_4448# 0.00404f
C78 m1_3908_2760# a_2808_3816# 0.05146f
C79 m1_1523_3480# vdd 0.00181f
C80 a_2216_3816# b0 0
C81 b4 b3 0.0464f
C82 m1_3908_2760# a_4584_3816# 0.00224f
C83 a_2216_3816# a_2808_3816# 0.04827f
C84 a_1624_3816# m1_1702_4448# 0.00126f
C85 b3 b2 0.04625f
C86 m1_1523_3480# m1_822_4448# 0
C87 m1_4078_3250# m1_3222_4448# 0.00268f
C88 m1_3908_2760# a_3992_3816# 0.28733f
C89 a_2216_3816# a_1624_3816# 0.04096f
C90 m1_2720_2760# m1_4078_3250# 0
C91 m1_3908_2760# vdd 0.00273f
C92 b2 m1_3222_4448# 0.02027f
C93 m1_1523_3480# m1_1702_4448# 0.11064f
C94 m1_4102_4448# m1_5422_4448# 0
C95 m1_3908_2760# m1_1523_3480# 0
C96 m1_2720_2760# b2 0.00703f
C97 a_2216_3816# vdd 0.16862f
C98 b2 b0 0
C99 a_2216_3816# m1_1523_3480# 0.06767f
C100 a_4584_3816# m1_4078_3250# 0.111f
C101 a_2808_3816# b2 0.15545f
C102 m1_3908_2760# m1_4982_4448# 0
C103 m1_3908_2760# m1_1702_4448# 0
C104 b3 a_3400_3816# 0.22216f
C105 b4 a_3992_3816# 0.14825f
C106 m1_4078_3250# a_3992_3816# 0.46129f
C107 b1 b3 0
C108 b4 vdd 0.42881f
C109 m1_4078_3250# vdd 0
C110 a_3400_3816# m1_3222_4448# 0.21689f
C111 b2 vdd 0.50217f
C112 m1_2720_2760# a_3400_3816# 0.00201f
C113 b1 m1_2408_3600# 0.03027f
C114 m1_4102_4448# m1_3222_4448# 0.00515f
C115 m1_4102_4448# m1_2408_3600# 0
C116 b1 m1_2720_2760# 0
C117 m1_2720_2760# m1_4102_4448# 0
C118 a_2808_3816# a_3400_3816# 0.12718f
C119 m1_4078_3250# m1_4982_4448# 0.28435f
C120 m1_382_4448# out 0.05592f
C121 b1 b0 0.07045f
C122 a_4584_3816# a_3400_3816# 0.00726f
C123 b4 m1_3908_2760# 0.01955f
C124 b1 a_2808_3816# 0
C125 m1_3908_2760# m1_4078_3250# 0.30336f
C126 out m1_2408_3600# 0.00379f
C127 out m1_1262_4448# 0.01815f
C128 b3 m1_3222_4448# 0.02397f
C129 b1 a_1624_3816# 0.07746f
C130 a_3400_3816# a_3992_3816# 0.06572f
C131 a_4584_3816# b5 0.25028f
C132 m1_382_4448# m1_1262_4448# 0
C133 a_3400_3816# vdd 0.23735f
C134 a_2216_3816# b2 0.05886f
C135 m1_3222_4448# m1_2408_3600# 0.04242f
C136 m1_4078_3250# vss 1.0193f
C137 m1_3908_2760# vss 0.6176f
C138 m1_1262_4448# vss 0.46622f
C139 m1_1702_4448# vss 0.50469f
C140 m1_3222_4448# vss 0.36281f
C141 m1_2720_2760# vss 0.22391f
C142 m1_822_4448# vss 0.40669f
C143 m1_2408_3600# vss 0.34795f
C144 m1_1523_3480# vss 0.30041f
C145 m1_382_4448# vss 0.76813f
C146 out vss 0.89235f
C147 m1_5422_4448# vss 0.76804f
C148 m1_4982_4448# vss 0.40392f
C149 vdd vss 15.03409f
C150 a_1624_3816# vss 1.18395f
C151 b0 vss 0.66386f
C152 a_2216_3816# vss 0.49587f
C153 b1 vss 0.50743f
C154 b2 vss 0.53627f
C155 a_2808_3816# vss 0.53292f
C156 a_3400_3816# vss 0.52169f
C157 b3 vss 0.32078f
C158 a_3992_3816# vss 0.54027f
C159 b4 vss 0.29907f
C160 a_4584_3816# vss 0.98136f
C161 b5 vss 0.41509f
C162 m1_4102_4448# vss 0.36138f
.ends

.subckt p_w0p8_l2 w_n374_n210# a_n288_n80# a_200_n80# a_n200_n124# VSUBS
X0 a_200_n80# a_n200_n124# a_n288_n80# w_n374_n210# pfet_03v3 ad=0.352p pd=2.48u as=0.352p ps=2.48u w=0.8u l=2u
C0 w_n374_n210# a_200_n80# 0.02527f
C1 a_n200_n124# a_200_n80# 0.02312f
C2 w_n374_n210# a_n288_n80# 0.02527f
C3 a_n288_n80# a_n200_n124# 0.02312f
C4 a_n288_n80# a_200_n80# 0.0084f
C5 w_n374_n210# a_n200_n124# 0.22666f
C6 a_200_n80# VSUBS 0.09823f
C7 a_n288_n80# VSUBS 0.09823f
C8 w_n374_n210# VSUBS 0.94248f
.ends

.subckt p_w4_l2_f4 w_n1130_n530# a_n956_n444# a_556_n444# a_n52_n400# a_452_n400#
+ a_n452_n444# a_n556_n400# a_52_n444# a_956_n400# a_n1044_n400# VSUBS
X0 a_n556_n400# a_n956_n444# a_n1044_n400# w_n1130_n530# pfet_03v3 ad=1.04p pd=4.52u as=1.76p ps=8.88u w=4u l=2u
X1 a_n52_n400# a_n452_n444# a_n556_n400# w_n1130_n530# pfet_03v3 ad=1.04p pd=4.52u as=1.04p ps=4.52u w=4u l=2u
X2 a_452_n400# a_52_n444# a_n52_n400# w_n1130_n530# pfet_03v3 ad=1.04p pd=4.52u as=1.04p ps=4.52u w=4u l=2u
X3 a_956_n400# a_556_n444# a_452_n400# w_n1130_n530# pfet_03v3 ad=1.76p pd=8.88u as=1.04p ps=4.52u w=4u l=2u
C0 w_n1130_n530# a_52_n444# 0.21994f
C1 a_452_n400# a_956_n400# 0.04287f
C2 w_n1130_n530# a_452_n400# 0.18497f
C3 a_n556_n400# a_n1044_n400# 0.04287f
C4 a_n452_n444# a_n556_n400# 0.11799f
C5 w_n1130_n530# a_n52_n400# 0.18497f
C6 a_52_n444# a_452_n400# 0.11799f
C7 w_n1130_n530# a_n1044_n400# 0.12268f
C8 w_n1130_n530# a_n452_n444# 0.21994f
C9 a_52_n444# a_n52_n400# 0.11799f
C10 a_556_n444# a_956_n400# 0.11799f
C11 w_n1130_n530# a_n556_n400# 0.18497f
C12 w_n1130_n530# a_556_n444# 0.2233f
C13 a_n52_n400# a_452_n400# 0.04287f
C14 a_n956_n444# a_n1044_n400# 0.11799f
C15 a_n452_n444# a_n956_n444# 0.00519f
C16 a_n556_n400# a_n956_n444# 0.11799f
C17 a_n452_n444# a_52_n444# 0.00519f
C18 w_n1130_n530# a_956_n400# 0.12268f
C19 a_556_n444# a_52_n444# 0.00519f
C20 a_556_n444# a_452_n400# 0.11799f
C21 a_n452_n444# a_n52_n400# 0.11799f
C22 a_n556_n400# a_n52_n400# 0.04287f
C23 w_n1130_n530# a_n956_n444# 0.2233f
C24 a_956_n400# VSUBS 0.19832f
C25 a_452_n400# VSUBS 0.12191f
C26 a_n52_n400# VSUBS 0.11851f
C27 a_n556_n400# VSUBS 0.12191f
C28 a_n1044_n400# VSUBS 0.19832f
C29 w_n1130_n530# VSUBS 7.1868f
.ends

.subckt p_w0p5_l10 a_n1088_n50# a_1000_n50# w_n1174_n180# a_n1000_n94# VSUBS
X0 a_1000_n50# a_n1000_n94# a_n1088_n50# w_n1174_n180# pfet_03v3 ad=0.22p pd=1.88u as=0.22p ps=1.88u w=0.5u l=10u
C0 a_n1088_n50# a_n1000_n94# 0.01858f
C1 w_n1174_n180# a_n1000_n94# 1.0092f
C2 w_n1174_n180# a_n1088_n50# 0.02013f
C3 a_1000_n50# a_n1000_n94# 0.01858f
C4 a_1000_n50# w_n1174_n180# 0.02013f
C5 a_1000_n50# VSUBS 0.30033f
C6 a_n1088_n50# VSUBS 0.30033f
C7 w_n1174_n180# VSUBS 2.53584f
.ends

.subckt n_w2_l2_f4 a_n52_n200# a_452_n200# a_n452_n244# a_n556_n200# a_52_n244# a_956_n200#
+ a_n1044_n200# a_n956_n244# a_556_n244# VSUBS
X0 a_452_n200# a_52_n244# a_n52_n200# VSUBS nfet_03v3 ad=0.52p pd=2.52u as=0.52p ps=2.52u w=2u l=2u
X1 a_956_n200# a_556_n244# a_452_n200# VSUBS nfet_03v3 ad=0.88p pd=4.88u as=0.52p ps=2.52u w=2u l=2u
X2 a_n556_n200# a_n956_n244# a_n1044_n200# VSUBS nfet_03v3 ad=0.52p pd=2.52u as=0.88p ps=4.88u w=2u l=2u
X3 a_n52_n200# a_n452_n244# a_n556_n200# VSUBS nfet_03v3 ad=0.52p pd=2.52u as=0.52p ps=2.52u w=2u l=2u
C0 a_52_n244# a_n452_n244# 0.00519f
C1 a_452_n200# a_52_n244# 0.0587f
C2 a_n956_n244# a_n452_n244# 0.00519f
C3 a_956_n200# a_556_n244# 0.0587f
C4 a_n556_n200# a_n1044_n200# 0.02133f
C5 a_n556_n200# a_n956_n244# 0.0587f
C6 a_n52_n200# a_n452_n244# 0.0587f
C7 a_452_n200# a_n52_n200# 0.02133f
C8 a_n556_n200# a_n52_n200# 0.02133f
C9 a_n1044_n200# a_n956_n244# 0.0587f
C10 a_556_n244# a_452_n200# 0.0587f
C11 a_956_n200# a_452_n200# 0.02133f
C12 a_n52_n200# a_52_n244# 0.0587f
C13 a_556_n244# a_52_n244# 0.00519f
C14 a_n556_n200# a_n452_n244# 0.0587f
C15 a_956_n200# VSUBS 0.26162f
C16 a_452_n200# VSUBS 0.34773f
C17 a_n52_n200# VSUBS 0.34265f
C18 a_n556_n200# VSUBS 0.34773f
C19 a_n1044_n200# VSUBS 0.26162f
.ends

.subckt p_w4_l1_f4 a_252_n400# a_n556_n444# a_n644_n400# a_n252_n444# a_n356_n400#
+ a_n52_n400# a_356_n444# w_n730_n530# a_52_n444# a_556_n400# VSUBS
X0 a_n356_n400# a_n556_n444# a_n644_n400# w_n730_n530# pfet_03v3 ad=1.04p pd=4.52u as=1.76p ps=8.88u w=4u l=1u
X1 a_556_n400# a_356_n444# a_252_n400# w_n730_n530# pfet_03v3 ad=1.76p pd=8.88u as=1.04p ps=4.52u w=4u l=1u
X2 a_n52_n400# a_n252_n444# a_n356_n400# w_n730_n530# pfet_03v3 ad=1.04p pd=4.52u as=1.04p ps=4.52u w=4u l=1u
X3 a_252_n400# a_52_n444# a_n52_n400# w_n730_n530# pfet_03v3 ad=1.04p pd=4.52u as=1.04p ps=4.52u w=4u l=1u
C0 w_n730_n530# a_356_n444# 0.12548f
C1 w_n730_n530# a_n52_n400# 0.12997f
C2 a_n356_n400# a_n52_n400# 0.07756f
C3 w_n730_n530# a_52_n444# 0.12212f
C4 w_n730_n530# a_n556_n444# 0.12548f
C5 a_n356_n400# a_n556_n444# 0.08505f
C6 a_n252_n444# a_n52_n400# 0.08505f
C7 a_n356_n400# w_n730_n530# 0.12997f
C8 a_52_n444# a_n252_n444# 0.00519f
C9 a_n556_n444# a_n252_n444# 0.00519f
C10 w_n730_n530# a_n252_n444# 0.12212f
C11 a_252_n400# a_556_n400# 0.07756f
C12 a_n356_n400# a_n252_n444# 0.08505f
C13 a_252_n400# a_356_n444# 0.08505f
C14 a_252_n400# a_n52_n400# 0.07756f
C15 a_252_n400# a_52_n444# 0.08505f
C16 a_252_n400# w_n730_n530# 0.12997f
C17 a_356_n444# a_556_n400# 0.08505f
C18 a_n556_n444# a_n644_n400# 0.08505f
C19 w_n730_n530# a_n644_n400# 0.09518f
C20 a_52_n444# a_356_n444# 0.00519f
C21 a_n356_n400# a_n644_n400# 0.07756f
C22 a_52_n444# a_n52_n400# 0.08505f
C23 w_n730_n530# a_556_n400# 0.09518f
C24 a_556_n400# VSUBS 0.17216f
C25 a_252_n400# VSUBS 0.0696f
C26 a_n52_n400# VSUBS 0.06619f
C27 a_n356_n400# VSUBS 0.0696f
C28 a_n644_n400# VSUBS 0.17216f
C29 w_n730_n530# VSUBS 4.6428f
.ends

.subckt n_w4_l2_f2 a_n52_n400# a_452_n400# a_n452_n444# a_n540_n400# a_52_n444# VSUBS
X0 a_n52_n400# a_n452_n444# a_n540_n400# VSUBS nfet_03v3 ad=1.04p pd=4.52u as=1.76p ps=8.88u w=4u l=2u
X1 a_452_n400# a_52_n444# a_n52_n400# VSUBS nfet_03v3 ad=1.76p pd=8.88u as=1.04p ps=4.52u w=4u l=2u
C0 a_n452_n444# a_n540_n400# 0.11799f
C1 a_n452_n444# a_52_n444# 0.00519f
C2 a_n452_n444# a_n52_n400# 0.11799f
C3 a_452_n400# a_52_n444# 0.11799f
C4 a_452_n400# a_n52_n400# 0.04287f
C5 a_n52_n400# a_n540_n400# 0.04287f
C6 a_n52_n400# a_52_n444# 0.11799f
C7 a_452_n400# VSUBS 0.33857f
C8 a_n52_n400# VSUBS 0.35281f
C9 a_n540_n400# VSUBS 0.33857f
.ends

.subckt p_w1_l0p5 a_n138_n100# a_50_n100# a_n50_n144# w_n224_n230# VSUBS
X0 a_50_n100# a_n50_n144# a_n138_n100# w_n224_n230# pfet_03v3 ad=0.44p pd=2.88u as=0.44p ps=2.88u w=1u l=0.5u
C0 w_n224_n230# a_n138_n100# 0.0205f
C1 w_n224_n230# a_n50_n144# 0.07993f
C2 w_n224_n230# a_50_n100# 0.0205f
C3 a_n138_n100# a_n50_n144# 0.01275f
C4 a_50_n100# a_n138_n100# 0.03085f
C5 a_50_n100# a_n50_n144# 0.01275f
C6 a_50_n100# VSUBS 0.06546f
C7 a_n138_n100# VSUBS 0.06546f
C8 w_n224_n230# VSUBS 0.61824f
.ends

.subckt p_w4_l2 w_n374_n530# a_n288_n400# a_200_n400# a_n200_n444# VSUBS
X0 a_200_n400# a_n200_n444# a_n288_n400# w_n374_n530# pfet_03v3 ad=1.76p pd=8.88u as=1.76p ps=8.88u w=4u l=2u
C0 w_n374_n530# a_n288_n400# 0.12268f
C1 w_n374_n530# a_n200_n444# 0.22666f
C2 w_n374_n530# a_200_n400# 0.12268f
C3 a_n288_n400# a_n200_n444# 0.11799f
C4 a_200_n400# a_n288_n400# 0.04287f
C5 a_200_n400# a_n200_n444# 0.11799f
C6 a_200_n400# VSUBS 0.20173f
C7 a_n288_n400# VSUBS 0.20173f
C8 w_n374_n530# VSUBS 2.37864f
.ends

.subckt n_w4_l2 a_n288_n400# a_200_n400# a_n200_n444# VSUBS
X0 a_200_n400# a_n200_n444# a_n288_n400# VSUBS nfet_03v3 ad=1.76p pd=8.88u as=1.76p ps=8.88u w=4u l=2u
C0 a_n200_n444# a_200_n400# 0.11799f
C1 a_n200_n444# a_n288_n400# 0.11799f
C2 a_200_n400# a_n288_n400# 0.04287f
C3 a_200_n400# VSUBS 0.34365f
C4 a_n288_n400# VSUBS 0.34365f
.ends

.subckt p_w4_l1 a_n188_n400# a_100_n400# a_n100_n444# w_n274_n530# VSUBS
X0 a_100_n400# a_n100_n444# a_n188_n400# w_n274_n530# pfet_03v3 ad=1.76p pd=8.88u as=1.76p ps=8.88u w=4u l=1u
C0 w_n274_n530# a_n188_n400# 0.09518f
C1 w_n274_n530# a_n100_n444# 0.12884f
C2 w_n274_n530# a_100_n400# 0.09518f
C3 a_n188_n400# a_n100_n444# 0.08505f
C4 a_100_n400# a_n188_n400# 0.07756f
C5 a_100_n400# a_n100_n444# 0.08505f
C6 a_100_n400# VSUBS 0.17557f
C7 a_n188_n400# VSUBS 0.17557f
C8 w_n274_n530# VSUBS 1.74264f
.ends

.subckt r_w1_l14p19 a_n100_1419# a_n100_n1541# VSUBS
X0 a_n100_1419# a_n100_n1541# VSUBS ppolyf_u_1k r_width=1u r_length=14.19u
C0 a_n100_n1541# VSUBS 0.27003f
C1 a_n100_1419# VSUBS 0.27003f
.ends

.subckt p_w0p5_l4 a_n488_n50# a_400_n50# a_n400_n94# w_n574_n180# VSUBS
X0 a_400_n50# a_n400_n94# a_n488_n50# w_n574_n180# pfet_03v3 ad=0.22p pd=1.88u as=0.22p ps=1.88u w=0.5u l=4u
C0 w_n574_n180# a_n488_n50# 0.01856f
C1 w_n574_n180# a_n400_n94# 0.42229f
C2 w_n574_n180# a_400_n50# 0.01856f
C3 a_n488_n50# a_n400_n94# 0.01702f
C4 a_400_n50# a_n488_n50# 0.0026f
C5 a_400_n50# a_n400_n94# 0.01702f
C6 a_400_n50# VSUBS 0.14084f
C7 a_n488_n50# VSUBS 0.14084f
C8 w_n574_n180# VSUBS 1.23984f
.ends

.subckt bias_vi en vglp vgln vreset_src vth_cmp vth_ref m1_8646_1098# m1_942_738#
+ iint m1_8042_6360# ib_x2 m1_7440_2050# m1_5388_6960# m1_7102_850# m1_4894_1238#
+ a_5712_1328# a_2102_5152# m1_4546_7560# m1_502_738# m1_1276_6360# vbn_prb vdd m1_1382_738#
+ a_4976_1528# m1_8332_7080# el a_864_6450# vss ib_r1
XPP vdd vdd vbn_prb a_864_6450# vss p_w0p8_l2
XMO vdd a_864_6450# a_864_6450# vdd m1_1276_6360# a_864_6450# m1_1276_6360# a_864_6450#
+ vdd vdd vss p_w4_l2_f4
XPS vdd m1_7102_850# vdd vgln vss p_w0p5_l10
XOR vss ib_r1 vbn_prb ib_r1 vbn_prb vss vss vbn_prb vbn_prb vss n_w2_l2_f4
XKO a_4976_1528# vglp m1_1276_6360# vglp a_4976_1528# m1_1276_6360# vglp vdd vglp
+ m1_1276_6360# vss p_w4_l1_f4
XMR vdd a_864_6450# a_864_6450# vdd m1_5388_6960# a_864_6450# m1_5388_6960# a_864_6450#
+ vdd vdd vss p_w4_l2_f4
XP1 vdd a_2102_5152# a_2102_5152# vdd vss p_w2_l2
XNS vss m1_7102_850# a_5712_1328# m1_7102_850# a_5712_1328# vss n_w4_l2_f2
XPOFF vdd a_864_6450# en vdd vss p_w1_l0p5
XP2 vdd a_864_6450# a_2102_5152# vdd vss p_w2_l2
XMS2 vss en m1_8646_1098# vss n_w0p5_l1
XMS1 m1_8646_1098# m1_7102_850# a_864_6450# vss n_w0p5_l1
XNT vss m1_4894_1238# a_5712_1328# vss n_w2_l2
XMT vdd vdd m1_8332_7080# a_864_6450# vss p_w4_l2
XKR vreset_src vglp m1_5388_6960# vglp vreset_src m1_5388_6960# vglp vdd vglp m1_5388_6960#
+ vss p_w4_l1_f4
XN1 m1_4894_1238# a_864_6450# vglp vss n_w4_l2
XN2 m1_4894_1238# a_2102_5152# a_4976_1528# vss n_w4_l2
XKT m1_8332_7080# vth_ref vglp vdd vss p_w4_l1
XOX vss m1_7440_2050# vbn_prb m1_7440_2050# vbn_prb vss vss vbn_prb vbn_prb vss n_w2_l2_f4
XXR00 a_4976_1528# m1_502_738# vss r_w1_l14p19
XXR01 m1_502_738# m1_942_738# vss r_w1_l14p19
XXR03 m1_1382_738# vss vss r_w1_l14p19
XXR02 m1_942_738# m1_1382_738# vss r_w1_l14p19
XPB vdd a_5712_1328# a_864_6450# vdd vss p_w0p5_l4
XNB vss a_5712_1328# a_5712_1328# vss n_w2_l2
XMC vdd a_864_6450# a_864_6450# vdd m1_8042_6360# a_864_6450# m1_8042_6360# a_864_6450#
+ vdd vdd vss p_w4_l2_f4
XKC vth_cmp vglp m1_8042_6360# vglp vth_cmp m1_8042_6360# vglp vdd vglp m1_8042_6360#
+ vss p_w4_l1_f4
XME vdd a_864_6450# a_864_6450# vdd m1_4546_7560# a_864_6450# m1_4546_7560# a_864_6450#
+ vdd vdd vss p_w4_l2_f4
XPI vdd vdd iint a_864_6450# vss p_w0p8_l2
XSX2 m1_7440_2050# ib_r1 ib_x2 vss n_w4_l0p5
XKE el vglp m1_4546_7560# vglp el m1_4546_7560# vglp vdd vglp m1_4546_7560# vss p_w4_l1_f4
XDB vss vbn_prb vbn_prb vss n_w2_l2
C0 en a_864_6450# 0.33221f
C1 el vth_ref 0.71135f
C2 vbn_prb vdd 0.24855f
C3 a_864_6450# m1_4894_1238# 0.3222f
C4 a_4976_1528# vglp 0.38892f
C5 a_5712_1328# vgln 0.3298f
C6 iint a_864_6450# 0.13343f
C7 vglp m1_5388_6960# 0.15331f
C8 vgln vbn_prb 0.23038f
C9 a_864_6450# m1_1276_6360# 0.39666f
C10 vdd vth_ref 0.31053f
C11 m1_7102_850# ib_r1 0.03826f
C12 vth_cmp vglp 0.28484f
C13 a_2102_5152# ib_r1 0.11035f
C14 a_4976_1528# ib_x2 0.04795f
C15 a_4976_1528# el 0.00185f
C16 en ib_r1 0.13773f
C17 el m1_5388_6960# 0
C18 a_5712_1328# vbn_prb 0.18056f
C19 a_4976_1528# m1_4546_7560# 0.00278f
C20 m1_4894_1238# ib_r1 0.16682f
C21 a_4976_1528# vdd 1.4633f
C22 el vth_cmp 0.048f
C23 iint ib_r1 0.10242f
C24 vglp m1_8042_6360# 0.2232f
C25 m1_4546_7560# m1_5388_6960# 0.09335f
C26 m1_7440_2050# vglp 0.05819f
C27 vdd m1_5388_6960# 0.62183f
C28 vgln a_4976_1528# 0
C29 en m1_942_738# 0.00966f
C30 vth_cmp vdd 0.17797f
C31 vgln m1_5388_6960# 0.00536f
C32 ib_x2 m1_7440_2050# 0.08935f
C33 a_5712_1328# a_4976_1528# 0.0106f
C34 m1_7102_850# m1_8646_1098# -0.00509f
C35 m1_942_738# m1_502_738# 0.42104f
C36 m1_8042_6360# vdd 0.53891f
C37 a_864_6450# vglp 0.83998f
C38 a_4976_1528# vbn_prb 0.11005f
C39 a_5712_1328# m1_5388_6960# 0.00317f
C40 en m1_8646_1098# 0.001f
C41 vgln m1_7440_2050# 0
C42 ib_x2 a_864_6450# 0.02181f
C43 vglp m1_8332_7080# 0.0652f
C44 el a_864_6450# 0.02982f
C45 vglp vreset_src 0.54612f
C46 m1_5388_6960# vth_ref 0
C47 vth_cmp vth_ref 0.05697f
C48 m1_4546_7560# a_864_6450# 0.73f
C49 vglp ib_r1 0.44719f
C50 a_864_6450# vdd 10.38485f
C51 a_5712_1328# m1_7440_2050# 0.03242f
C52 el m1_8332_7080# 0.00199f
C53 vbn_prb m1_8042_6360# 0
C54 m1_942_738# m1_1382_738# 0.08765f
C55 el vreset_src 0.03609f
C56 vbn_prb m1_7440_2050# 0.36218f
C57 vgln a_864_6450# 0.12647f
C58 ib_x2 ib_r1 0.20298f
C59 m1_8042_6360# vth_ref 0.00285f
C60 m1_8332_7080# vdd 0.82484f
C61 m1_4546_7560# vreset_src 0.00447f
C62 vdd vreset_src 0.46224f
C63 vth_cmp m1_5388_6960# 0.00607f
C64 a_5712_1328# a_864_6450# 0.04659f
C65 vdd ib_r1 0
C66 vgln vreset_src 0
C67 vbn_prb a_864_6450# 0.59172f
C68 vgln ib_r1 0.04275f
C69 m1_8042_6360# m1_5388_6960# 0.11312f
C70 m1_942_738# vdd 0.00344f
C71 vglp m1_8646_1098# 0
C72 a_864_6450# vth_ref 0.00723f
C73 vth_cmp m1_8042_6360# 0.21651f
C74 a_5712_1328# ib_r1 0.15887f
C75 ib_x2 m1_8646_1098# 0.01147f
C76 m1_8332_7080# vth_ref 0.06042f
C77 vbn_prb ib_r1 0.81062f
C78 vth_ref vreset_src 0.1174f
C79 a_4976_1528# a_864_6450# 0.73462f
C80 a_864_6450# m1_5388_6960# 0.32262f
C81 a_864_6450# vth_cmp 0.02777f
C82 en a_2102_5152# 0.04646f
C83 m1_7102_850# en 0.14198f
C84 m1_7102_850# m1_4894_1238# 0
C85 m1_4894_1238# a_2102_5152# 0.06382f
C86 m1_5388_6960# vreset_src 0.26696f
C87 a_4976_1528# ib_r1 0.24273f
C88 vth_cmp m1_8332_7080# 0.00111f
C89 iint a_2102_5152# 0
C90 m1_7102_850# iint 0.3658f
C91 a_864_6450# m1_8042_6360# 0.5698f
C92 vth_cmp vreset_src 0.14964f
C93 en m1_4894_1238# 0
C94 m1_1276_6360# a_2102_5152# 0.00961f
C95 a_864_6450# m1_7440_2050# 0.06786f
C96 en iint 0.17194f
C97 iint m1_4894_1238# 0.00172f
C98 vbn_prb m1_8646_1098# 0
C99 a_4976_1528# m1_942_738# 0.00922f
C100 m1_8332_7080# m1_8042_6360# 0.13476f
C101 m1_8042_6360# vreset_src 0.26401f
C102 en m1_502_738# 0.01007f
C103 m1_7440_2050# ib_r1 0.00546f
C104 a_2102_5152# m1_1382_738# 0
C105 a_864_6450# m1_8332_7080# 0.09337f
C106 a_864_6450# vreset_src 0.08448f
C107 en m1_1382_738# 0.14813f
C108 m1_7102_850# vglp 0.18545f
C109 vglp a_2102_5152# 0.09855f
C110 a_864_6450# ib_r1 0.24976f
C111 m1_8332_7080# vreset_src 0.01543f
C112 en vglp 0.59159f
C113 m1_4894_1238# vglp 0.286f
C114 ib_x2 a_2102_5152# 0.01217f
C115 m1_7102_850# ib_x2 0.07339f
C116 iint vglp 0.04831f
C117 m1_502_738# m1_1382_738# 0
C118 m1_7440_2050# m1_8646_1098# 0.00687f
C119 vglp m1_1276_6360# 0.16358f
C120 en ib_x2 0.14421f
C121 m1_4546_7560# a_2102_5152# 0.0186f
C122 ib_x2 m1_4894_1238# 0.06226f
C123 vdd a_2102_5152# 1.73077f
C124 m1_7102_850# vdd 0.12129f
C125 iint ib_x2 0.04728f
C126 vgln a_2102_5152# 0.08399f
C127 m1_7102_850# vgln 0.08937f
C128 en vdd 0.32674f
C129 el m1_1276_6360# 0.00217f
C130 iint vdd 0.18374f
C131 a_864_6450# m1_8646_1098# 0.03779f
C132 vgln en 0.06792f
C133 m1_4546_7560# m1_1276_6360# 0.14038f
C134 m1_1276_6360# vdd 0.61385f
C135 m1_7102_850# a_5712_1328# 0.54324f
C136 a_5712_1328# a_2102_5152# 0.15699f
C137 vgln iint 0.12915f
C138 m1_502_738# vdd 0.00342f
C139 vbn_prb a_2102_5152# 0.11077f
C140 m1_7102_850# vbn_prb 0.11192f
C141 vglp m1_1382_738# 0.00131f
C142 a_5712_1328# en 0.05214f
C143 a_5712_1328# m1_4894_1238# 0.16211f
C144 en vbn_prb 0.26578f
C145 a_5712_1328# iint 0.29607f
C146 vbn_prb m1_4894_1238# 0.02997f
C147 ib_x2 m1_1382_738# 0
C148 iint vbn_prb 0.08998f
C149 ib_x2 vglp 0.10572f
C150 el vglp 0.41693f
C151 a_4976_1528# a_2102_5152# 0.4055f
C152 vdd m1_1382_738# 0.0035f
C153 m1_4546_7560# vglp 0.73349f
C154 a_4976_1528# en 0.05046f
C155 vglp vdd 5.25107f
C156 a_4976_1528# m1_4894_1238# 0.17878f
C157 a_4976_1528# iint 0
C158 vgln vglp 0
C159 a_4976_1528# m1_1276_6360# 0.30906f
C160 m1_4546_7560# el 0.12283f
C161 ib_x2 vdd 0
C162 el vdd 0.94055f
C163 a_4976_1528# m1_502_738# 0.04144f
C164 m1_7102_850# m1_7440_2050# 0.02863f
C165 vbn_prb m1_1382_738# 0
C166 vgln ib_x2 0.26925f
C167 m1_4546_7560# vdd 0.40586f
C168 a_5712_1328# vglp 0.16841f
C169 en m1_8042_6360# 0
C170 en m1_7440_2050# 0.05869f
C171 vbn_prb vglp 0.48983f
C172 iint m1_8042_6360# 0
C173 vgln vdd 2.2258f
C174 iint m1_7440_2050# 0
C175 a_5712_1328# ib_x2 0.10242f
C176 vglp vth_ref 0.06719f
C177 ib_x2 vbn_prb 0.06125f
C178 m1_7102_850# a_864_6450# 0.14649f
C179 a_864_6450# a_2102_5152# 0.40639f
C180 a_5712_1328# m1_4546_7560# 0
C181 a_4976_1528# m1_1382_738# 0.00776f
C182 a_5712_1328# vdd 0.56694f
C183 m1_8042_6360# vss -0.29705f
C184 vbn_prb vss 3.71278f
C185 el vss 0.65712f
C186 m1_4546_7560# vss -0.26802f
C187 ib_x2 vss 3.37258f
C188 iint vss 1.91268f
C189 vth_cmp vss 0.07828f
C190 m1_1382_738# vss 1.13003f
C191 m1_942_738# vss 0.5126f
C192 m1_502_738# vss 0.71186f
C193 m1_7440_2050# vss 0.52223f
C194 vth_ref vss 0.57598f
C195 m1_8332_7080# vss -0.04322f
C196 a_2102_5152# vss 0.19991f
C197 a_4976_1528# vss 1.61618f
C198 a_864_6450# vss -0.98223f
C199 m1_4894_1238# vss 0.33472f
C200 vglp vss 1.49743f
C201 vreset_src vss 0.10863f
C202 m1_5388_6960# vss -0.271f
C203 a_5712_1328# vss 1.81802f
C204 m1_8646_1098# vss 0.01901f
C205 en vss 2.7871f
C206 m1_7102_850# vss 0.68137f
C207 m1_1276_6360# vss -0.17835f
C208 ib_r1 vss 1.6597f
C209 vgln vss 0.40803f
C210 vdd vss 64.84496f
.ends

.subckt bias_b1 vth_ref vreset_src ib_r1 ua0 vbn_leak vbn_ref vbp_syn vbp_st vbn_prb
+ el vth_cmp vbn_ax vbp_w ua0_stim_out r0_b0 r0_b1 r0_b2 r0_b3 r0_b4 r2_b0 r2_b1 r2_b2
+ r2_b3 r2_b4 r1_b0 r1_b1 r1_b2 r1_b3 r1_b4 i2_b0 i4_b0 i2_b1 i4_b1 i2_b2 i4_b2 i2_b3
+ i4_b3 i2_b4 i4_b4 i0_b0 i1_b0 i3_b0 i0_b1 i1_b1 i3_b1 i0_b2 i1_b2 i3_b2 i0_b3 i1_b3
+ i3_b3 i0_b4 i1_b4 i3_b4 v0_c0 v0_c1 v0_c2 v0_c3 v0_c4 v0_c5 bias_en ib_x2 ua0_s0
+ ua0_s1 ua0_stim ua0_int vdd vss
XXx0 vbn_leak vdd vss rx_n4
XXx1 vbn_ref vdd vss rx_n2
XXx2 vss vdd vbp_syn rx_p24
XXx3 vbn_ax vdd vss rx_n1
XXx4 vbp_w vdd vss rx_p05
XXg Xm/in_n Xi1/g Xg/m1_6020_10200# Xg/m1_3298_2050# Xg/m1_4760_1320# Xg/m1_5022_10210#
+ Xg/m1_3530_1930# Xg/m1_4906_9490# Xg/m1_3898_9610# Xg/a_7580_5314# Xg/a_1580_5314#
+ vss Xi0/g vdd Xg/m1_6282_1450# Xg/m1_5516_1920# Xg/a_4580_5314# Xg/m1_4538_1930#
+ Xi4/g Xg/a_5188_4156# Xi2/g Xg/m1_3666_9610# Xr/vsp Xr/vsn Xr/vglp Xi3/g Xg/a_3036_4156#
+ Xr/vgln Xm/in_p bias_ladder
XXi0 i0_b0 i0_b1 i0_b3 i0_b4 vbn_leak vss Xi0/m1_988_3464# Xi0/a_1582_4392# vdd Xi0/m1_988_2804#
+ Xi0/a_528_4392# Xi0/a_2228_4392# Xi0/a_1378_4392# Xi0/a_3078_4392# Xi0/a_3928_4392#
+ Xi0/a_3282_4392# i0_b2 Xi0/m1_988_888# Xi0/g Xi0/m1_240_3480# vss Xi0/a_4132_4392#
+ Xi0/m1_1500_4312# Xi0/a_2432_4392# Xr/vgln Xi0/a_732_4392# Xr/vsp idac_p
XXi1 i1_b0 i1_b1 i1_b3 i1_b4 vbn_ref vss Xi1/m1_988_3464# Xi1/a_1582_4392# vdd Xi1/m1_988_2804#
+ Xi1/a_528_4392# Xi1/a_2228_4392# Xi1/a_1378_4392# Xi1/a_3078_4392# Xi1/a_3928_4392#
+ Xi1/a_3282_4392# i1_b2 Xi1/m1_988_888# Xi1/g Xi1/m1_240_3480# vss Xi1/a_4132_4392#
+ Xi1/m1_1500_4312# Xi1/a_2432_4392# Xr/vgln Xi1/a_732_4392# Xr/vsp idac_p
XXm ua0 ua0_s0 ua0_s1 ua0_stim ua0_int bias_en Xm/in_n Xm/in_p Xm/iint Xm/a_1744_10100#
+ vbp_st Xr/en_b ua0_stim_out Xm/a_1744_9182# vss vdd Xm/a_736_7228# Xm/a_1764_11418#
+ Xm/a_2240_11218# Xm/a_420_700# Xm/a_736_5516# bias_master
XXi2 i2_b0 i2_b1 i2_b2 i2_b3 i2_b4 vbp_syn vdd Xi2/m1_988_3304# Xi2/a_1378_4170# Xi2/a_528_4170#
+ Xi2/a_2228_4170# Xi2/a_3928_4170# Xr/vgln Xi2/a_732_4170# Xi2/a_1582_4170# Xi2/a_2432_4170#
+ Xi2/a_3282_4170# Xi2/m1_988_2644# Xi2/a_4132_4170# Xi2/m1_988_888# Xi2/m1_260_2080#
+ vdd Xi2/m1_1500_3762# Xi2/a_3078_4170# Xr/vsn Xi2/g vss idac_n
XXxst vbp_st vdd vss rx_p05
XXi3 i3_b0 i3_b1 i3_b3 i3_b4 vbn_ax vss Xi3/m1_988_3464# Xi3/a_1582_4392# vdd Xi3/m1_988_2804#
+ Xi3/a_528_4392# Xi3/a_2228_4392# Xi3/a_1378_4392# Xi3/a_3078_4392# Xi3/a_3928_4392#
+ Xi3/a_3282_4392# i3_b2 Xi3/m1_988_888# Xi3/g Xi3/m1_240_3480# vss Xi3/a_4132_4392#
+ Xi3/m1_1500_4312# Xi3/a_2432_4392# Xr/vgln Xi3/a_732_4392# Xr/vsp idac_p
XXi4 i4_b0 i4_b1 i4_b2 i4_b3 i4_b4 vbp_w vdd Xi4/m1_988_3304# Xi4/a_1378_4170# Xi4/a_528_4170#
+ Xi4/a_2228_4170# Xi4/a_3928_4170# Xr/vgln Xi4/a_732_4170# Xi4/a_1582_4170# Xi4/a_2432_4170#
+ Xi4/a_3282_4170# Xi4/m1_988_2644# Xi4/a_4132_4170# Xi4/m1_988_888# Xi4/m1_260_2080#
+ vdd Xi4/m1_1500_3762# Xi4/a_3078_4170# Xr/vsn Xi4/g vss idac_n
XXd0 r0_b0 r0_b1 r0_b2 r0_b3 r0_b4 vdd el Xd0/a_2224_3416# Xd0/a_3408_3416# Xd0/m1_822_4048#
+ Xd0/a_1632_3416# Xd0/m1_2242_4966# Xd0/m1_2742_3250# Xd0/m1_3310_2880# Xd0/m1_1262_4048#
+ Xd0/a_1040_3416# vss Xd0/a_2816_3416# Xd0/m1_617_3840# Xd0/m1_3662_4048# Xd0/m1_956_3000#
+ Xd0/m1_382_4048# vdacr_el
XXd1 r1_b0 r1_b1 r1_b2 r1_b3 r1_b4 vdd Xd1/a_680_3416# vss Xd1/a_2456_3416# Xd1/m1_462_4048#
+ Xd1/m1_860_4046# Xd1/a_1864_3416# vreset_src Xd1/a_3048_3416# Xd1/m1_2372_2520#
+ Xd1/m1_2974_2650# Xd1/m1_756_3120# Xd1/a_1272_3416# Xd1/m1_2862_4048# Xd1/m1_606_2410#
+ Xd1/m1_1780_5040# vdacr_vr
XXr Xr/vsp Xr/vgln Xr/en_b vdd Xr/m1_782_438# Xr/m1_3422_438# Xr/m1_3862_3522# Xr/m1_2542_438#
+ vss Xr/m1_1222_3522# Xr/m1_342_438# Xr/vsn Xr/m1_1662_438# Xr/vglp bias_rails
XXd2 r2_b0 r2_b1 r2_b2 r2_b3 r2_b4 vdd vth_cmp Xd2/a_680_3416# Xd2/m1_462_4048# Xd2/m1_596_2880#
+ Xd2/a_1864_3416# Xd2/m1_1342_4048# Xd2/a_3048_3416# Xd2/m1_2382_2650# Xd2/m1_1780_2760#
+ Xd2/a_2456_3416# Xd2/a_1272_3416# Xd2/m1_902_4048# Xd2/m1_756_3240# Xd2/m1_2964_2640#
+ vss vdacr_vc
XXd3 v0_c0 v0_c1 v0_c2 v0_c3 v0_c4 v0_c5 vdd Xd3/m1_2720_2760# Xd3/a_4584_3816# Xd3/m1_5422_4448#
+ Xd3/m1_382_4448# Xd3/m1_822_4448# Xd3/a_3992_3816# vth_ref Xd3/a_1624_3816# Xd3/a_3400_3816#
+ Xd3/a_2808_3816# Xd3/m1_1702_4448# vss Xd3/m1_1523_3480# Xd3/m1_3908_2760# Xd3/m1_4078_3250#
+ Xd3/m1_4102_4448# Xd3/m1_3222_4448# Xd3/a_2216_3816# Xd3/m1_4982_4448# Xd3/m1_1262_4448#
+ Xd3/m1_2408_3600# vdacr_vt
XXvi bias_en Xr/vglp Xr/vgln vreset_src vth_cmp vth_ref Xvi/m1_8646_1098# Xvi/m1_942_738#
+ Xm/iint Xvi/m1_8042_6360# ib_x2 Xvi/m1_7440_2050# Xvi/m1_5388_6960# Xvi/m1_7102_850#
+ Xvi/m1_4894_1238# Xvi/a_5712_1328# Xvi/a_2102_5152# Xvi/m1_4546_7560# Xvi/m1_502_738#
+ Xvi/m1_1276_6360# vbn_prb vdd Xvi/m1_1382_738# Xvi/a_4976_1528# Xvi/m1_8332_7080#
+ el Xvi/a_864_6450# vss ib_r1 bias_vi
C0 i1_b3 i3_b3 0.06018f
C1 vreset_src Xr/vglp 0.31712f
C2 r2_b2 vth_cmp 0.20876f
C3 Xd3/a_2216_3816# ua0_s1 0.08547f
C4 ua0_s1 Xd3/a_2808_3816# 0.05094f
C5 v0_c2 vdd 0.16645f
C6 vbp_syn i2_b1 0.0413f
C7 Xr/vgln Xvi/a_864_6450# 0.1148f
C8 r2_b4 Xd1/a_1864_3416# 0.01643f
C9 Xi4/g Xr/vgln 0.15819f
C10 Xi0/a_2432_4392# i0_b2 -0.01074f
C11 Xr/vsp bias_en 0.4869f
C12 ua0_stim_out i2_b1 0.07094f
C13 r1_b1 Xm/in_p 0.06981f
C14 i4_b1 i2_b3 0.05326f
C15 Xi3/a_2432_4392# r0_b4 0.00527f
C16 Xr/vgln Xm/in_n 0.7825f
C17 v0_c2 Xd3/m1_3222_4448# -0
C18 Xd3/a_3992_3816# ua0_s1 0.06146f
C19 Xi2/a_3928_4170# i2_b4 0.00696f
C20 i2_b4 i3_b3 0
C21 Xvi/m1_502_738# vth_cmp 0
C22 Xi4/a_4132_4170# Xr/vgln 0
C23 vdd Xi4/a_2432_4170# 0
C24 r2_b3 i2_b0 0.19491f
C25 Xm/in_n Xg/m1_4760_1320# 0.03941f
C26 Xg/m1_3298_2050# Xg/m1_3530_1930# -0
C27 Xi2/m1_988_888# Xi2/m1_260_2080# -0
C28 Xr/vsp i3_b1 0.73573f
C29 i3_b1 i0_b0 0.66336f
C30 Xd1/a_1272_3416# Xd1/m1_606_2410# -0.01053f
C31 r2_b2 Xi2/a_4132_4170# 0.03927f
C32 Xi1/a_528_4392# vbn_ref 0.0078f
C33 Xr/en_b Xm/a_420_700# -0.00121f
C34 Xd1/m1_606_2410# Xd2/a_3048_3416# 0
C35 vbn_leak vbn_prb 0.44365f
C36 r1_b4 Xi2/a_4132_4170# 0.00111f
C37 ua0_stim v0_c3 0.01968f
C38 Xi1/m1_240_3480# i0_b1 0.00665f
C39 vbn_ax r0_b1 0.04711f
C40 vdd Xvi/m1_1276_6360# -0.07882f
C41 vbp_syn ua0_stim_out 0.15044f
C42 i1_b0 i3_b4 0.01625f
C43 Xvi/m1_1276_6360# Xvi/m1_4546_7560# -0.00679f
C44 r1_b4 Xg/m1_3666_9610# 0.01631f
C45 i4_b0 Xg/m1_5022_10210# 0
C46 Xd2/m1_756_3240# vth_cmp 0.00111f
C47 Xvi/a_5712_1328# bias_en 0.20053f
C48 Xi2/g Xg/m1_5516_1920# 0.11116f
C49 Xd3/m1_2408_3600# Xd3/a_2808_3816# -0.00171f
C50 Xg/a_3036_4156# r1_b2 0.01814f
C51 r2_b1 Xvi/a_4976_1528# 0.00514f
C52 r2_b2 Xd1/m1_2862_4048# 0
C53 Xg/a_1580_5314# Xg/a_7580_5314# -0.02068f
C54 Xr/vgln Xi2/m1_260_2080# 0.02769f
C55 i3_b0 i0_b2 0
C56 Xi2/g Xr/vsn 0.66562f
C57 r1_b0 i2_b2 0
C58 vdd r1_b2 1.76818f
C59 Xi0/g ib_x2 0.4357f
C60 Xd0/a_1040_3416# r2_b0 0.05519f
C61 Xr/m1_1222_3522# Xr/vglp 0.00173f
C62 ib_r1 Xi0/g 0.01303f
C63 Xi2/g i3_b2 0.25005f
C64 r1_b2 Xi1/g 0.63541f
C65 i4_b2 vbn_ref 0.07343f
C66 i3_b2 i1_b4 0
C67 ua0_stim ua0_s0 0
C68 Xvi/m1_5388_6960# Xr/vglp 0.00146f
C69 vbn_ax Xi3/m1_988_2804# -0
C70 vdd Xi2/a_732_4170# 0.02077f
C71 r1_b1 Xi4/a_1378_4170# 0.01064f
C72 Xr/vgln Xi0/a_4132_4392# 0.00954f
C73 r2_b2 i2_b2 0.17398f
C74 Xi4/m1_988_888# vbn_prb 0.0732f
C75 Xr/vgln Xvi/m1_4894_1238# 0.12553f
C76 r1_b3 r1_b2 0.3529f
C77 r0_b2 Xd0/a_2224_3416# 0.00657f
C78 v0_c2 v0_c4 0.31917f
C79 r1_b4 i2_b2 0.03436f
C80 i4_b0 Xg/a_4580_5314# 0.0354f
C81 r2_b1 vbn_prb 0.02616f
C82 Xd0/m1_2242_4966# Xd0/m1_617_3840# -0.00246f
C83 Xi3/a_2228_4392# r0_b4 0.02328f
C84 v0_c2 Xd3/m1_2720_2760# -0.00586f
C85 Xg/a_5188_4156# Xg/m1_6020_10200# 0
C86 i4_b2 Xr/vgln 0.30864f
C87 Xd0/m1_1262_4048# Xd0/m1_617_3840# -0
C88 i3_b4 i3_b0 0.17449f
C89 i1_b2 i1_b3 0.00197f
C90 r1_b1 r0_b4 0.00606f
C91 vdd Xd1/a_2456_3416# -0.00106f
C92 Xi4/g Xvi/a_864_6450# 0.38028f
C93 r1_b0 r0_b1 0.92101f
C94 Xi4/g Xm/in_n 0.05182f
C95 Xd3/a_3400_3816# bias_en 0.07336f
C96 vbp_st ib_x2 0.05337f
C97 r1_b1 Xg/m1_4906_9490# 0
C98 r1_b1 i4_b3 0.16714f
C99 Xi1/a_528_4392# ua0_stim_out 0
C100 vbn_ref i0_b1 0.09439f
C101 vreset_src el 1.28368f
C102 Xd0/m1_2742_3250# Xd0/a_2224_3416# -0.00406f
C103 Xd3/m1_2408_3600# Xd3/m1_1702_4448# -0.01366f
C104 Xi2/a_1378_4170# r2_b2 0.00628f
C105 Xi3/m1_240_3480# r0_b4 0
C106 Xg/a_1580_5314# vbp_st 0.13574f
C107 Xr/vsn Xvi/a_4976_1528# 0.337f
C108 r1_b1 Xi3/m1_988_888# 0.14678f
C109 Xi2/m1_1500_3762# vbp_st 0.03587f
C110 i4_b2 i2_b1 0
C111 Xd2/m1_596_2880# vth_cmp 0
C112 Xvi/m1_942_738# Xvi/m1_1382_738# -0.05959f
C113 r1_b3 Xd1/a_2456_3416# 0.00206f
C114 r2_b2 r0_b1 0.17313f
C115 r2_b4 Xr/vglp 0
C116 Xi3/m1_988_3464# Xi3/m1_988_2804# -0.01585f
C117 vdd Xg/a_7580_5314# -0.07694f
C118 Xi1/a_2228_4392# Xi1/m1_988_2804# -0
C119 Xr/vgln i0_b1 0.12253f
C120 Xd0/m1_382_4048# el 0.00531f
C121 r1_b4 r0_b1 0.10219f
C122 r2_b3 i2_b4 0.03476f
C123 i4_b4 Xm/in_p 0.03295f
C124 Xd2/a_2456_3416# vbn_prb 0.00217f
C125 r2_b4 Xd0/a_1040_3416# 0.0488f
C126 vbn_ref Xr/vglp 0.00162f
C127 Xd0/a_1632_3416# vth_cmp 0.0049f
C128 Xi3/m1_240_3480# Xi3/m1_988_888# -0.01085f
C129 r1_b1 Xi3/a_3928_4392# 0
C130 Xm/a_420_700# bias_en 0.04539f
C131 Xg/a_7580_5314# Xi1/g -0.00479f
C132 Xg/a_3036_4156# Xi0/g -0
C133 Xd0/m1_2242_4966# r2_b2 0.01331f
C134 Xd3/m1_4982_4448# bias_en 0.3317f
C135 Xd0/m1_1262_4048# r2_b2 0
C136 Xi1/m1_240_3480# i3_b3 0.12711f
C137 vdd Xi0/g 0.76506f
C138 Xr/vsn vbn_prb 0.11163f
C139 v0_c2 Xd3/m1_5422_4448# 0
C140 r1_b0 Xd0/a_2816_3416# 0
C141 Xr/vgln Xr/vglp 1.10733f
C142 i4_b2 ua0_stim_out 0.24464f
C143 i4_b0 vth_cmp 0.00841f
C144 Xr/m1_1662_438# vth_ref 0.00135f
C145 r2_b0 el 0.11863f
C146 Xi2/g Xi2/m1_988_3304# -0.05388f
C147 Xi0/g Xi1/g 0.53182f
C148 Xi2/g i3_b0 0.4409f
C149 r0_b0 r1_b2 0
C150 Xvi/m1_4894_1238# Xvi/a_864_6450# -0.00119f
C151 Xi4/a_2228_4170# vth_cmp 0.06318f
C152 ua0_s1 ua0_stim_out 0.36879f
C153 i4_b2 Xi4/g 0.03809f
C154 Xvi/m1_5388_6960# el 0
C155 Xd0/a_2816_3416# r2_b2 0.05781f
C156 Xr/vglp i2_b1 0
C157 Xi1/a_732_4392# i0_b1 0.12531f
C158 Xg/a_3036_4156# vbp_st 0.05091f
C159 r2_b2 Xm/in_p 0.14032f
C160 i4_b2 Xi4/a_4132_4170# 0
C161 vbn_ax r0_b4 0.04813f
C162 vbn_leak r1_b2 0.16251f
C163 Xi3/g r1_b2 0.24893f
C164 r1_b1 Xr/vsp 0.86462f
C165 ua0_s0 Xm/a_736_5516# 0
C166 Xd3/a_1624_3816# Xd3/a_2216_3816# -0
C167 i0_b1 ua0_stim_out 0.05866f
C168 vdd vbp_st 1.8923f
C169 r1_b4 Xm/in_p 0.27024f
C170 Xg/m1_5022_10210# i2_b2 0
C171 Xd1/a_680_3416# Xd1/a_1272_3416# -0.03218f
C172 Xd3/m1_3222_4448# vbp_st 0
C173 i1_b3 i0_b2 0.03552f
C174 vbn_ax r0_b3 0.04813f
C175 Xd1/a_680_3416# Xd2/a_3048_3416# 0.01623f
C176 r2_b3 vreset_src 0.03321f
C177 Xr/vsp Xi3/m1_1500_4312# -0.00523f
C178 vbp_st Xi1/g 0.49143f
C179 v0_c5 ib_x2 0.05214f
C180 vbp_w vdd 0.42365f
C181 Xi3/m1_240_3480# Xr/vsp 0.05044f
C182 Xi0/a_528_4392# vbp_st 0
C183 Xi2/m1_988_888# i3_b3 0
C184 Xr/vglp ua0_stim_out 0.3687f
C185 Xr/vsn Xvi/a_2102_5152# 0.06443f
C186 Xd3/m1_2408_3600# ua0_stim_out 0.0516f
C187 r1_b3 vbp_st 0.57751f
C188 v0_c5 Xd3/a_4584_3816# 0.00265f
C189 i0_b3 Xi1/m1_988_3464# 0
C190 vbn_ref i3_b3 0.32665f
C191 Xd0/a_3408_3416# el 0
C192 Xg/a_5188_4156# i3_b4 0.03716f
C193 i4_b0 i2_b2 0.03407f
C194 Xd0/m1_3310_2880# vth_cmp 0.07989f
C195 Xi0/m1_988_888# Xr/vsn 0.01446f
C196 r2_b4 el 0.08774f
C197 vbp_w r1_b3 0.15166f
C198 i4_b4 i4_b3 0.24583f
C199 v0_c2 v0_c3 3.40651f
C200 i1_b3 i3_b4 0.10673f
C201 Xi2/a_3928_4170# Xr/vgln -0
C202 Xr/vglp Xvi/a_864_6450# 0.09127f
C203 vdd Xd1/a_3048_3416# 0.01092f
C204 Xi4/g Xr/vglp 0.64725f
C205 vbn_ref el 0.04193f
C206 Xr/vgln i3_b3 0.24374f
C207 r2_b1 r1_b2 0.09758f
C208 Xd2/m1_756_3240# Xd2/m1_902_4048# -0
C209 r1_b0 r0_b4 0.1153f
C210 v0_c1 ua0_int 0.02379f
C211 Xr/vglp Xm/in_n 1.70188f
C212 i4_b1 Xg/a_1580_5314# 0.24945f
C213 r1_b1 Xg/m1_3898_9610# 0.05549f
C214 vdd Xd3/m1_822_4448# 0.17452f
C215 r2_b3 r2_b0 0.05885f
C216 Xd0/a_1632_3416# r0_b1 0.02744f
C217 Xi3/a_1582_4392# r0_b4 0.01146f
C218 Xi1/a_1582_4392# Xi1/m1_1500_4312# -0
C219 Xi1/a_528_4392# i0_b1 0.00453f
C220 vth_ref ib_x2 0.20222f
C221 Xi3/a_732_4392# r0_b4 0.05793f
C222 r1_b0 r0_b3 0.58277f
C223 i3_b1 i0_b3 0.00154f
C224 Xr/vgln el 0.24405f
C225 Xi3/g Xg/a_7580_5314# 0.22465f
C226 Xi4/m1_1500_3762# vth_cmp 0
C227 Xm/a_1744_9182# Xm/a_736_5516# -0.00177f
C228 vbn_leak Xg/a_7580_5314# 0.11277f
C229 ib_r1 vth_ref 0.28869f
C230 i4_b4 Xg/m1_6282_1450# 0.00112f
C231 r2_b2 r0_b4 0.12332f
C232 Xr/vgln Xi2/a_2228_4170# 0.13143f
C233 Xvi/m1_7102_850# vth_cmp 0.00393f
C234 Xd0/m1_2242_4966# Xd0/a_1632_3416# -0.00524f
C235 r1_b4 r0_b4 0.34173f
C236 Xd3/a_3992_3816# Xd3/m1_4078_3250# -0.00102f
C237 v0_c2 ua0_s0 0.0396f
C238 Xd0/m1_1262_4048# Xd0/a_1632_3416# -0.00128f
C239 Xd1/m1_2862_4048# vth_cmp 0.08066f
C240 r2_b2 r0_b3 0.04956f
C241 vbn_leak Xi0/g 0.09284f
C242 i0_b2 Xi1/m1_988_2804# 0.10194f
C243 Xi3/g Xi0/g 0.11972f
C244 ua0_int Xm/a_2240_11218# -0.05459f
C245 r1_b4 Xg/m1_4906_9490# 0.13058f
C246 r1_b4 r0_b3 0.18466f
C247 ib_x2 Xi0/m1_1500_4312# 0.12879f
C248 Xg/m1_3298_2050# Xr/vgln 0.01762f
C249 Xd3/m1_1523_3480# ua0_stim_out 0.01616f
C250 Xr/vsn Xvi/m1_1276_6360# 0.20679f
C251 Xr/m1_1662_438# Xr/m1_342_438# -0.01417f
C252 v0_c5 vdd 0.15407f
C253 i4_b0 Xi4/a_1582_4170# 0
C254 Xi2/g Xg/a_5188_4156# -0.04638f
C255 Xi2/a_3928_4170# ua0_stim_out 0.03938f
C256 r0_b0 vbp_st 0.04927f
C257 i3_b3 ua0_stim_out 0.05124f
C258 Xg/m1_5022_10210# Xm/in_p 0.05592f
C259 vbn_ax r0_b2 0.04157f
C260 Xd2/m1_2382_2650# vbn_prb 0.06902f
C261 Xm/a_2240_11218# Xm/iint 0.0016f
C262 vreset_src Xi4/a_3282_4170# 0.00751f
C263 i4_b0 Xi3/m1_988_2804# 0.21072f
C264 Xr/vsn r1_b2 0.02323f
C265 i1_b3 i1_b4 0.01269f
C266 Xr/vsp i4_b4 0.0423f
C267 Xd2/m1_596_2880# Xd2/m1_902_4048# -0.00106f
C268 vbp_w r0_b0 0.00615f
C269 Xi2/g Xg/m1_4538_1930# 0.20191f
C270 i4_b4 i0_b0 0.49234f
C271 vbp_syn el 0.04959f
C272 i3_b2 r1_b2 0.03971f
C273 i4_b1 Xg/a_3036_4156# 0.00285f
C274 r1_b1 i2_b3 0.0534f
C275 Xi3/a_1378_4392# r0_b4 0.03105f
C276 Xi3/g vbp_st 0.10338f
C277 vbn_leak vbp_st 0.02563f
C278 i2_b2 Xi2/a_4132_4170# 0
C279 i4_b2 Xr/vglp 0.19796f
C280 r2_b3 r2_b4 0.21412f
C281 Xi4/g i3_b3 0
C282 vdd i4_b1 1.17818f
C283 Xvi/m1_8332_7080# ib_x2 0.05609f
C284 Xi3/a_528_4392# r0_b4 0.04128f
C285 Xi2/a_2228_4170# ua0_stim_out 0.00139f
C286 r2_b3 vbn_ref 0.57826f
C287 Xi3/m1_988_3464# Xr/vsp -0
C288 i4_b0 Xm/in_p 0.04513f
C289 i1_b2 Xr/vgln 0.01367f
C290 i4_b1 Xi1/g 0.03315f
C291 ib_r1 Xvi/m1_8332_7080# 0.00177f
C292 Xi0/a_3078_4392# Xr/vgln 0.00166f
C293 ua0_stim Xm/a_1764_11418# -0
C294 vbp_w Xi3/g 0.33383f
C295 vbp_w vbn_leak 0.04048f
C296 Xi3/a_528_4392# r0_b3 0
C297 Xi1/m1_240_3480# i0_b2 0.00216f
C298 el Xd1/m1_860_4046# 0.0381f
C299 Xvi/a_864_6450# el 0.37846f
C300 Xi4/g el 0.83591f
C301 vdd vth_ref 0.42091f
C302 Xr/en_b vdd 0.90703f
C303 ua0_s0 Xm/a_736_7228# -0.00171f
C304 r0_b0 Xd1/a_3048_3416# 0
C305 ua0_s1 Xd3/m1_2408_3600# 0.11376f
C306 Xi1/m1_1500_4312# Xm/in_p 0.13864f
C307 vdd Xd1/m1_756_3120# -0.0011f
C308 r2_b3 Xr/vgln 0.18757f
C309 ib_r1 Xvi/m1_8646_1098# 0
C310 Xi4/a_4132_4170# el 0
C311 r1_b0 r0_b2 1.04191f
C312 Xd3/a_1624_3816# ua0_stim_out 0
C313 v0_c1 Xd3/m1_3908_2760# 0.02835f
C314 Xi1/a_528_4392# i3_b3 0
C315 bias_en ib_x2 0.76258f
C316 v0_c1 v0_c0 0.81503f
C317 v0_c5 v0_c4 1.38453f
C318 Xi4/a_732_4170# el 0.00116f
C319 Xr/vsp Xi0/a_732_4392# 0
C320 Xr/vsp r1_b4 0.46191f
C321 Xd2/m1_1780_2760# vbn_prb 0.14742f
C322 Xg/m1_5516_1920# Xg/a_7580_5314# -0
C323 Xd0/m1_2242_4966# vth_cmp 0.06532f
C324 ib_r1 bias_en 0.12875f
C325 Xi4/a_1582_4170# vth_cmp 0.02157f
C326 Xd0/m1_1262_4048# vth_cmp 0.07739f
C327 Xg/m1_3298_2050# Xi4/g -0.00454f
C328 vdd Xi0/m1_1500_4312# 0.10579f
C329 r2_b1 vbp_st 0.0684f
C330 Xi1/m1_240_3480# i3_b4 0.02731f
C331 r2_b3 i2_b1 0.51978f
C332 Xg/m1_3298_2050# Xm/in_n 0.03357f
C333 r0_b2 r2_b2 0.18205f
C334 Xr/vsn Xg/a_7580_5314# -0
C335 Xd3/a_4584_3816# bias_en 0.08801f
C336 Xvi/m1_7102_850# Xm/iint 0.10097f
C337 r1_b1 Xi4/a_3078_4170# 0.00333f
C338 r1_b0 Xd1/a_1272_3416# 0.02256f
C339 r1_b4 r0_b2 0.08703f
C340 r1_b0 Xd2/a_3048_3416# 0
C341 i3_b1 Xg/a_1580_5314# 0.084f
C342 Xd3/m1_1262_4448# ua0_stim_out 0.0484f
C343 Xg/m1_5022_10210# Xg/m1_4906_9490# -0.00185f
C344 Xi2/g vreset_src 0.07079f
C345 i3_b2 Xg/a_7580_5314# 0.06241f
C346 ua0_stim_out Xg/m1_6020_10200# 0.15934f
C347 ib_r1 Xr/m1_342_438# 0.0013f
C348 Xd0/m1_3310_2880# Xd0/a_2816_3416# -0
C349 Xr/vsn Xi0/g 0.46379f
C350 i3_b1 i1_b1 0.0886f
C351 Xd0/a_2816_3416# vth_cmp 0.00235f
C352 Xd0/a_1632_3416# r0_b3 -0.00127f
C353 i4_b2 i3_b3 0.11971f
C354 r2_b2 Xd1/a_1272_3416# 0.04271f
C355 r2_b2 Xd0/m1_2742_3250# 0.03109f
C356 i3_b0 r1_b2 0.28704f
C357 Xi0/g i3_b2 0.56663f
C358 r2_b3 ua0_stim_out 0.03454f
C359 r2_b2 Xd2/a_3048_3416# 0.09192f
C360 Xd0/m1_956_3000# vdd 0
C361 i4_b0 r0_b4 0.54422f
C362 vbn_ref i0_b2 0.04565f
C363 vdd Xvi/m1_8332_7080# -0.10513f
C364 ua0_s1 Xd3/m1_1523_3480# 0.02542f
C365 r1_b4 Xg/m1_3898_9610# 0.01923f
C366 i4_b0 Xg/m1_4906_9490# 0
C367 i4_b2 el 0
C368 Xm/a_1744_10100# vbp_st 0
C369 vdd Xi1/m1_988_3464# -0.006f
C370 Xi4/a_528_4170# el 0
C371 vth_ref Xvi/m1_8042_6360# 0.003f
C372 i4_b3 Xg/a_4580_5314# 0.54238f
C373 Xr/vgln i0_b2 0.22202f
C374 Xi3/m1_988_888# i4_b0 0.28924f
C375 Xd3/m1_4078_3250# ua0_stim_out 0.16895f
C376 r2_b3 Xi4/g 0.0024f
C377 ua0_stim Xd3/a_2808_3816# 0.00105f
C378 Xr/vsn vbp_st 0.28954f
C379 Xi1/m1_988_3464# Xi1/g -0.05503f
C380 Xm/in_p Xg/m1_3666_9610# 0.0299f
C381 Xi4/m1_260_2080# vdd 0.03828f
C382 Xi2/m1_988_888# i3_b4 0
C383 Xd3/a_3992_3816# ua0_stim 0
C384 i3_b3 i0_b1 0.05721f
C385 i4_b4 i2_b3 0
C386 vbn_ref i3_b4 0.13742f
C387 Xr/vgln Xi4/a_3282_4170# 0
C388 vreset_src Xvi/a_4976_1528# 0.23165f
C389 Xm/a_1764_11418# Xm/a_736_5516# -0.00629f
C390 r1_b1 Xi3/a_4132_4392# 0
C391 vdd bias_en 3.05824f
C392 Xi3/g i4_b1 1.4252f
C393 Xd2/m1_1780_2760# Xd2/m1_1342_4048# -0
C394 ua0_s0 vbp_st 0.21885f
C395 i4_b1 vbn_leak 0.05579f
C396 i3_b2 vbp_st 0.03492f
C397 r2_b3 Xi4/a_732_4170# 0.02145f
C398 i4_b0 Xi3/a_3928_4392# 0
C399 Xd3/m1_1523_3480# Xd3/m1_2408_3600# 0
C400 i3_b1 Xg/a_3036_4156# 0.08325f
C401 Xd3/m1_3222_4448# bias_en 0.17376f
C402 i2_b0 r1_b2 0.06211f
C403 vdd i3_b1 0.12735f
C404 r1_b0 i2_b3 0.00124f
C405 Xg/a_4580_5314# Xg/m1_6282_1450# -0
C406 Xr/vglp i3_b3 0.04129f
C407 Xr/vgln i3_b4 0.18753f
C408 Xvi/m1_942_738# vth_cmp 0
C409 Xi3/m1_240_3480# Xi3/a_4132_4392# -0
C410 Xi4/a_1378_4170# vth_cmp 0.07577f
C411 Xr/vsp Xg/m1_5022_10210# 0.00897f
C412 vdd Xr/m1_342_438# 0.08519f
C413 i3_b1 Xi1/g 0.04641f
C414 Xm/in_p i2_b2 0.03122f
C415 Xd0/m1_3310_2880# r0_b4 -0.0055f
C416 Xi2/a_732_4170# i2_b0 0.00113f
C417 Xi0/m1_240_3480# Xm/iint 0
C418 Xi3/a_3282_4392# r0_b4 0.04383f
C419 Xd3/a_1624_3816# ua0_s1 0.10626f
C420 Xg/a_7580_5314# i3_b0 0.03491f
C421 Xi1/a_2228_4392# i0_b1 0
C422 vreset_src vbn_prb 0.09039f
C423 Xr/vglp el 0.26272f
C424 Xr/m1_782_438# vreset_src 0.00507f
C425 Xi1/a_1582_4392# Xm/in_p 0.00171f
C426 Xvi/m1_7440_2050# ib_x2 0
C427 ua0_stim_out i0_b2 0.10184f
C428 r2_b2 i2_b3 0.19733f
C429 r1_b4 i2_b3 0.08447f
C430 vdd Xd0/a_2224_3416# 0.0234f
C431 i4_b2 Xg/m1_6020_10200# 0
C432 Xi0/g i3_b0 0.15975f
C433 Xvi/m1_8332_7080# Xvi/m1_8042_6360# -0.02794f
C434 i4_b3 vth_cmp 0.70202f
C435 r2_b1 i4_b1 0.07481f
C436 Xi4/a_3078_4170# i4_b4 0.00476f
C437 Xd0/m1_382_4048# vbn_prb 0.04375f
C438 Xd0/a_1632_3416# r0_b2 -0.0015f
C439 Xr/vsp i4_b0 1.12748f
C440 Xd3/m1_822_4448# ua0_s0 0.0744f
C441 Xi2/m1_988_2644# Xi2/m1_1500_3762# -0
C442 Xi2/g Xi2/m1_988_888# -0.11186f
C443 Xr/vsp Xg/a_4580_5314# -0.00477f
C444 v0_c5 v0_c3 0.03641f
C445 r2_b3 i4_b2 0.06752f
C446 Xd0/m1_617_3840# Xd0/m1_3662_4048# -0
C447 Xd0/a_2816_3416# r0_b1 0.04188f
C448 Xm/in_p Xm/iint 0.22497f
C449 Xi1/a_732_4392# i3_b4 0.10319f
C450 r2_b3 Xi4/a_528_4170# 0.00457f
C451 v0_c4 bias_en 0.04704f
C452 Xr/vsp Xi1/m1_1500_4312# -0.03286f
C453 Xm/a_1744_9182# vbp_st -0.0021f
C454 Xd3/a_1624_3816# Xd3/m1_2408_3600# -0.00351f
C455 ua0_stim_out i3_b4 0.25349f
C456 Xd3/m1_2720_2760# bias_en 0.13483f
C457 i1_b2 i0_b1 0
C458 r2_b0 vbn_prb 0.11307f
C459 Xd0/a_1632_3416# Xd0/m1_2742_3250# -0.00169f
C460 bias_en Xvi/m1_8042_6360# 0.00448f
C461 vth_cmp Xg/m1_6282_1450# 0
C462 Xi2/g Xr/vgln 1.33298f
C463 vbp_st Xi2/m1_988_3304# 0.08303f
C464 vreset_src Xd1/m1_1780_5040# 0.02881f
C465 Xr/vglp Xr/m1_3862_3522# 0
C466 Xi2/a_3078_4170# Xi2/g -0.01358f
C467 vbp_st i3_b0 0.89404f
C468 Xg/a_5188_4156# r1_b2 0.00838f
C469 Xr/vgln i1_b4 0.06342f
C470 v0_c0 ua0_int 0.06538f
C471 Xi2/g Xg/m1_4760_1320# 0.02238f
C472 r1_b1 Xg/a_1580_5314# 0.21758f
C473 Xvi/a_2102_5152# vreset_src 0.05235f
C474 v0_c5 ua0_s0 0.04091f
C475 Xi3/a_3078_4392# r0_b4 0.01809f
C476 Xi1/m1_1500_4312# Xi1/a_3078_4392# -0
C477 r0_b4 i2_b2 0.089f
C478 Xd3/m1_2408_3600# Xd3/m1_1262_4448# -0
C479 Xi1/a_1378_4392# Xm/in_p 0.00177f
C480 Xr/vglp Xg/m1_6020_10200# -0.02274f
C481 Xi0/m1_988_888# vreset_src 0.3752f
C482 ua0_s1 Xd3/m1_4078_3250# 0.08613f
C483 Xr/m1_2542_438# Xm/iint 0.00686f
C484 Xm/in_p Xi1/m1_988_888# 0.0209f
C485 i2_b4 r1_b2 0.04438f
C486 ua0 ua0_int 0.01065f
C487 r2_b2 Xd0/m1_3662_4048# 0.00132f
C488 Xr/vsn i4_b1 0.70464f
C489 r0_b3 i2_b2 0.19837f
C490 r2_b3 Xr/vglp 0.0016f
C491 vbn_leak bias_en 0
C492 Xi0/a_1378_4392# Xr/vgln 0.03559f
C493 Xd3/a_3400_3816# v0_c1 0.05713f
C494 Xr/m1_3422_438# Xm/in_n 0.05918f
C495 vdd Xi2/m1_988_2644# -0.03872f
C496 i4_b1 i3_b2 0.39921f
C497 Xd1/a_680_3416# vdd -0.01061f
C498 Xi0/m1_988_3464# Xi0/m1_240_3480# -0
C499 Xvi/m1_1382_738# ib_x2 0.29977f
C500 r2_b0 Xd1/m1_1780_5040# 0.08034f
C501 Xr/en_b Xr/vsn -0.00114f
C502 Xr/vsn vth_ref 0.34431f
C503 Xd3/m1_5422_4448# bias_en 0.35555f
C504 Xi1/a_528_4392# i3_b4 0.06477f
C505 i3_b1 vbn_leak 0.29941f
C506 Xi3/g i3_b1 0.19035f
C507 Xi2/m1_260_2080# i3_b4 0
C508 i2_b0 vbp_st 0
C509 Xi1/a_2228_4392# i3_b3 0.00165f
C510 Xi3/a_3078_4392# Xi3/a_3928_4392# -0
C511 Xd3/a_1624_3816# Xd3/m1_1523_3480# -0
C512 Xi2/g ua0_stim_out 0
C513 Xr/vgln Xvi/a_4976_1528# 0.16798f
C514 ua0_stim ua0_stim_out -0.08222f
C515 r0_b0 Xd0/a_2224_3416# 0
C516 r0_b4 r0_b1 0.05384f
C517 vth_ref ua0_s0 0.02438f
C518 Xr/en_b ua0_s0 0.04164f
C519 vreset_src Xi4/a_2432_4170# 0.00669f
C520 Xg/a_7580_5314# Xg/a_5188_4156# -0.01319f
C521 r1_b3 Xi2/m1_988_2644# 0.05749f
C522 Xr/vsp Xg/m1_3666_9610# 0.00729f
C523 vbn_ref vbn_prb 0.25521f
C524 i4_b2 Xi4/a_3282_4170# 0
C525 r0_b1 r0_b3 0.11394f
C526 Xm/in_p Xd3/m1_3908_2760# 0.00303f
C527 Xvi/a_5712_1328# vth_cmp 0.04517f
C528 Xr/vsn Xi0/m1_1500_4312# 0.01929f
C529 v0_c0 Xm/in_p 0
C530 Xi4/m1_260_2080# r2_b1 0.1196f
C531 Xd0/m1_3310_2880# Xd0/m1_2742_3250# -0
C532 Xi2/g Xi4/g 0.4594f
C533 r1_b1 vdd 1.46569f
C534 Xvi/m1_1276_6360# vreset_src 0
C535 Xi2/g Xm/in_n 0.09335f
C536 Xd3/m1_1523_3480# Xd3/m1_1262_4448# -0
C537 Xd1/a_1272_3416# vth_cmp 0
C538 Xr/vgln vbn_prb 0.18455f
C539 Xd0/m1_2742_3250# vth_cmp 0.08476f
C540 i4_b2 i3_b4 0.03769f
C541 v0_c2 Xd3/a_2808_3816# 0.16617f
C542 Xi0/g Xg/a_5188_4156# -0.06314f
C543 i0_b4 Xi1/m1_988_888# 0.25686f
C544 i0_b1 i0_b2 0.00208f
C545 Xd2/a_3048_3416# vth_cmp 0.02265f
C546 v0_c2 Xd3/a_2216_3816# -0.03183f
C547 r1_b1 Xi1/g 0.17299f
C548 i4_b0 i2_b3 0.03981f
C549 vreset_src r1_b2 0
C550 Xi3/m1_1500_4312# vdd -0.0035f
C551 v0_c2 Xd3/a_3992_3816# 0.05699f
C552 i1_b2 i3_b3 0.03462f
C553 Xi3/m1_240_3480# vdd -0.0978f
C554 Xm/in_p i0_b4 0.04184f
C555 r2_b1 i3_b1 0.05371f
C556 Xvi/a_5712_1328# Xvi/m1_7102_850# -0.00169f
C557 r1_b1 r1_b3 0.23217f
C558 Xr/vsp i2_b2 0.02865f
C559 vdd Xd2/a_1864_3416# -0
C560 Xd2/m1_2964_2640# Xd1/m1_462_4048# 0.03886f
C561 Xi3/m1_988_888# Xi3/m1_988_2804# -0
C562 v0_c0 Xd3/m1_3908_2760# 0.46195f
C563 i2_b4 Xi0/g 0.098f
C564 r2_b4 Xd1/m1_1780_5040# 0.08852f
C565 r2_b3 i3_b3 0.02942f
C566 Xi2/g Xi2/m1_260_2080# -0.0032f
C567 i0_b1 i3_b4 0.18218f
C568 Xd0/a_2816_3416# r0_b3 0
C569 i4_b4 Xg/a_1580_5314# 0.03697f
C570 bias_en v0_c3 0.03815f
C571 Xm/in_p Xg/m1_4906_9490# 0.07415f
C572 Xm/in_p i4_b3 0.03468f
C573 Xg/a_5188_4156# vbp_st 0.03315f
C574 i4_b1 i3_b0 0.03124f
C575 r2_b3 el 0.21864f
C576 Xi4/g Xvi/a_4976_1528# 0.05123f
C577 r2_b0 r1_b2 0.00184f
C578 Xvi/a_864_6450# Xvi/a_4976_1528# -0
C579 i1_b2 Xi1/a_2228_4392# 0
C580 v0_c0 i0_b4 0.00156f
C581 Xi4/m1_260_2080# Xr/vsn 0.00755f
C582 vbp_syn vbn_prb 0.17604f
C583 Xr/vsp Xm/iint 0.39638f
C584 Xd3/a_1624_3816# Xd3/m1_1262_4448# -0.0179f
C585 Xr/vglp i3_b4 0.03544f
C586 Xr/vgln Xvi/a_2102_5152# 0.00703f
C587 Xr/vsn bias_en 1.05532f
C588 Xd2/a_680_3416# vbn_prb 0.2151f
C589 i2_b4 vbp_st 0
C590 i4_b2 Xi2/g 0.49118f
C591 Xd3/m1_4102_4448# bias_en 0
C592 Xi0/m1_988_2804# Xi0/g -0.0705f
C593 Xr/vsn i3_b1 0.40798f
C594 bias_en ua0_s0 0.36839f
C595 Xd1/m1_462_4048# r2_b2 0
C596 vbp_st Xm/a_1764_11418# 0.00393f
C597 vbn_ax vdd 0.30244f
C598 Xi4/g vbn_prb 0.56217f
C599 Xvi/a_864_6450# vbn_prb -0.03565f
C600 vbn_prb Xd1/m1_860_4046# 0.03983f
C601 r0_b2 r0_b1 0.6204f
C602 Xr/vsp Xi0/m1_240_3480# 0.00663f
C603 vbn_leak Xi2/m1_988_2644# 0.00842f
C604 Xvi/m1_502_738# ib_x2 0
C605 Xi1/a_3282_4392# Xm/in_p 0.00181f
C606 Xr/m1_782_438# Xm/in_n 0.00821f
C607 Xr/vsn Xr/m1_342_438# -0.00302f
C608 i3_b1 i3_b2 0.42903f
C609 r2_b2 Xi2/m1_1500_3762# 0.06553f
C610 r1_b4 Xg/a_1580_5314# 0.00237f
C611 r2_b0 Xd1/a_2456_3416# 0.05569f
C612 Xr/vsp Xi3/m1_988_2804# 0.16755f
C613 vreset_src Xi0/g 0.62587f
C614 r1_b4 Xi2/m1_1500_3762# 0.00544f
C615 Xvi/a_5712_1328# Xm/iint 0.215f
C616 ua0_s1 ua0_stim 0.18382f
C617 i2_b3 Xi2/a_4132_4170# 0.00145f
C618 Xd0/m1_2242_4966# r0_b2 -0.00276f
C619 v0_c2 Xr/vgln 0.02721f
C620 vdd Xd0/m1_617_3840# 0
C621 i3_b3 i0_b2 0.06367f
C622 vbn_ax r1_b3 0.07425f
C623 i0_b0 Xi1/m1_988_888# 0
C624 Xr/vsp Xi1/m1_988_888# 0.11352f
C625 vdd i4_b4 0.95249f
C626 r1_b1 Xi3/g 0.36403f
C627 Xi1/m1_1500_4312# i0_b3 0.0046f
C628 Xm/in_p i0_b0 0.0366f
C629 r2_b4 r1_b2 0
C630 r0_b4 r0_b3 0.31585f
C631 r1_b1 vbn_leak 0.65852f
C632 Xr/vsp Xm/in_p 0.68839f
C633 i4_b4 Xi1/g 0.03804f
C634 Xi2/g Xr/vglp 0.5213f
C635 vbp_st Xi1/m1_988_2804# 0.00221f
C636 vbn_ref r1_b2 0.03976f
C637 Xi3/m1_988_3464# vdd -0.00254f
C638 Xd0/m1_2242_4966# Xd0/m1_2742_3250# 0
C639 i4_b4 Xi0/a_528_4392# 0
C640 Xd3/a_3400_3816# ua0_int 0.00275f
C641 Xi3/g Xi3/m1_1500_4312# -0.01921f
C642 Xd0/m1_1262_4048# Xd0/m1_2742_3250# -0.00169f
C643 Xi3/a_4132_4392# i4_b0 0.00191f
C644 i1_b0 i3_b1 0.04952f
C645 Xr/vgln Xvi/m1_1276_6360# 0.0021f
C646 Xi3/m1_240_3480# Xi3/g -0.00145f
C647 r0_b2 Xd0/a_2816_3416# 0.00441f
C648 r1_b0 vdd 1.21361f
C649 Xi4/a_3078_4170# vth_cmp 0.10389f
C650 Xd3/m1_382_4448# vbp_st 0.00405f
C651 i3_b3 i3_b4 0.89593f
C652 el Xi4/a_3282_4170# 0.00116f
C653 Xvi/a_2102_5152# Xvi/a_864_6450# -0
C654 Xi4/g Xvi/a_2102_5152# 0.05319f
C655 Xi3/a_1582_4392# vdd -0.00367f
C656 i2_b3 i2_b2 0.924f
C657 vbp_w vreset_src 0.10406f
C658 Xm/a_1744_9182# bias_en 0.00138f
C659 Xd0/m1_3310_2880# Xd0/m1_3662_4048# -0
C660 Xr/vgln r1_b2 0.1287f
C661 Xi3/a_3928_4392# r0_b4 0.02143f
C662 Xi1/a_3282_4392# i0_b4 0.00207f
C663 Xi1/a_2228_4392# i0_b2 0.10249f
C664 Xvi/m1_4894_1238# vbn_prb -0.00465f
C665 i4_b1 Xg/m1_3530_1930# 0.04504f
C666 Xi1/a_3078_4392# Xm/in_p 0.002f
C667 vth_cmp Xd0/m1_3662_4048# 0.06223f
C668 r1_b4 Xg/a_3036_4156# 0
C669 vdd r2_b2 0.8422f
C670 r2_b4 Xd1/a_2456_3416# 0.06255f
C671 r1_b0 r1_b3 0.15797f
C672 Xr/vsp Xi0/m1_988_3464# -0.00414f
C673 Xi0/m1_988_888# Xm/in_n 0.50906f
C674 Xm/a_420_700# ua0_int 0.10384f
C675 vdd Xi0/a_732_4392# 0.00705f
C676 r1_b4 vdd 1.40443f
C677 r1_b1 r2_b1 0.032f
C678 Xi4/a_3928_4170# i4_b4 0.00466f
C679 vbp_w Xd0/m1_382_4048# 0
C680 i4_b1 Xg/a_5188_4156# 0.21572f
C681 i2_b1 r1_b2 0.03818f
C682 Xm/in_p Xg/m1_3898_9610# 0.02502f
C683 r1_b4 Xi1/g 0.24703f
C684 i3_b1 i3_b0 0.22815f
C685 r2_b0 vbp_st 0.04944f
C686 Xi2/a_1582_4170# r2_b2 0.00522f
C687 vbn_ax r0_b0 0.03705f
C688 r1_b3 r2_b2 0.74489f
C689 Xm/a_420_700# Xm/iint 0.03405f
C690 Xr/vsp i0_b4 0.46719f
C691 Xi1/a_2228_4392# i3_b4 0
C692 Xr/vglp Xvi/a_4976_1528# -0.01108f
C693 i4_b1 Xg/m1_4538_1930# 0.00319f
C694 Xi1/m1_240_3480# vbp_st 0.00167f
C695 r1_b4 r1_b3 0.78073f
C696 i4_b1 i2_b4 0.03885f
C697 Xd3/m1_382_4448# Xd3/m1_822_4448# -0.12739f
C698 i1_b2 i0_b2 0.28047f
C699 vbp_w r2_b0 1.05951f
C700 Xd2/m1_756_3240# vdd -0.00239f
C701 Xr/vsn Xi2/m1_988_2644# -0.04414f
C702 r2_b2 Xd2/a_1272_3416# 0
C703 Xr/vsp r0_b4 0.00213f
C704 v0_c1 ib_x2 0.70504f
C705 ua0_s1 Xm/a_736_5516# 0.71432f
C706 ua0_stim_out r1_b2 0.12741f
C707 Xi2/g i3_b3 0.2277f
C708 vbn_ax vbn_leak 0.23815f
C709 Xr/vsp Xg/m1_4906_9490# 0.01115f
C710 Xr/vsp i4_b3 0.15234f
C711 Xi2/a_528_4170# vbp_st 0.00201f
C712 i4_b3 i0_b0 0
C713 Xi1/a_3078_4392# i0_b4 0
C714 i3_b3 i1_b4 0.14684f
C715 Xr/vglp vbn_prb 0.12043f
C716 Xi4/g Xvi/m1_1276_6360# 0
C717 Xvi/m1_1276_6360# Xvi/a_864_6450# -0.01938f
C718 Xr/vgln Xg/a_7580_5314# -0.00742f
C719 r0_b2 r0_b4 0.05121f
C720 vbn_ref Xi0/g 0.00481f
C721 Xr/m1_782_438# Xr/vglp 0
C722 Xr/vsp Xi3/m1_988_888# 0.28381f
C723 ib_x2 Xg/a_4580_5314# 0
C724 v0_c1 Xd3/a_4584_3816# 0.05573f
C725 Xi2/a_732_4170# ua0_stim_out 0
C726 r2_b0 Xd1/a_3048_3416# 0.0664f
C727 Xi2/g el 0
C728 Xr/en_b Xm/a_1764_11418# -0
C729 i4_b0 Xg/a_1580_5314# 0.12176f
C730 i1_b2 i3_b4 0.06051f
C731 Xm/a_736_7228# ua0_stim_out -0.0045f
C732 Xg/a_1580_5314# Xg/a_4580_5314# -0
C733 r0_b2 r0_b3 0.13481f
C734 Xi0/a_3928_4392# bias_en 0
C735 r1_b1 Xr/vsn 0.02361f
C736 Xd3/m1_1702_4448# vbp_st 0.00238f
C737 Xd2/m1_756_3240# Xd2/a_1272_3416# -0
C738 r1_b0 r0_b0 0.80819f
C739 Xr/vgln Xi0/g 0.07086f
C740 Xi3/g i4_b4 0.31037f
C741 i4_b4 vbn_leak 0.06838f
C742 Xi3/a_2228_4392# i3_b2 0.00102f
C743 Xr/vsp Xi3/a_3928_4392# 0
C744 Xd3/a_3400_3816# Xd3/m1_3908_2760# -0.0293f
C745 Xi3/a_528_4392# r1_b3 0
C746 Xvi/a_5712_1328# i4_b3 0.00264f
C747 r1_b1 i3_b2 0.4397f
C748 Xd3/a_3400_3816# v0_c0 0.25544f
C749 Xm/in_p i2_b3 0.18293f
C750 r2_b4 vbp_st 0.04129f
C751 r2_b3 i3_b4 0.03121f
C752 Xi2/m1_988_888# vbp_st 0.06827f
C753 Xi1/a_1582_4392# i0_b3 0
C754 Xi3/m1_988_3464# Xi3/g -0.00733f
C755 Xd1/a_1864_3416# r1_b2 0
C756 vbp_w Xd0/a_3408_3416# 0.05604f
C757 vbn_ref vbp_st 0.05068f
C758 r1_b0 vbn_leak 0.04262f
C759 Xi4/m1_988_2644# vth_cmp 0
C760 i4_b1 vreset_src 0
C761 r2_b2 r0_b0 0.18611f
C762 Xg/m1_5022_10210# Xg/a_3036_4156# -0
C763 Xi0/g i2_b1 0
C764 vbp_w r2_b4 0.28526f
C765 r1_b4 r0_b0 0.20115f
C766 Xi3/a_4132_4392# Xi3/a_3078_4392# -0
C767 Xg/m1_5022_10210# vdd -0.03042f
C768 r2_b2 Xi2/a_2432_4170# 0.00703f
C769 vbp_w vbn_ref 0.86442f
C770 i4_b2 Xi4/a_2432_4170# 0
C771 Xr/vgln vbp_st 0.10082f
C772 Xg/m1_5022_10210# Xi1/g -0.00155f
C773 Xg/a_7580_5314# ua0_stim_out 0.00665f
C774 Xvi/a_2102_5152# Xr/vglp -0.02074f
C775 vth_ref vreset_src 0.27713f
C776 Xd0/a_1632_3416# vdd 0.04175f
C777 Xi2/a_3078_4170# vbp_st 0.02132f
C778 Xr/vsn Xvi/m1_1382_738# 0
C779 r2_b2 vbn_leak 0.08353f
C780 Xvi/a_4976_1528# el 0.07731f
C781 Xd0/m1_2242_4966# Xd0/m1_3662_4048# -0
C782 Xr/en_b Xd3/m1_382_4448# 0.05203f
C783 v0_c2 ua0_s1 0.06651f
C784 v0_c0 Xd3/m1_4982_4448# 0.1118f
C785 Xi3/g r1_b4 0.00339f
C786 Xd1/m1_756_3120# vreset_src 0.02577f
C787 r2_b1 i4_b4 0.04389f
C788 vth_cmp ib_x2 0.00952f
C789 r1_b4 vbn_leak 0.16149f
C790 Xr/vsp i0_b0 0.15388f
C791 v0_c1 vdd 0.21341f
C792 vbp_w Xr/vgln 0
C793 Xi0/m1_988_2804# Xi0/m1_1500_4312# -0.0094f
C794 Xi0/m1_988_888# Xr/vglp 0.31451f
C795 vbn_leak Xi0/a_732_4392# 0.00434f
C796 i4_b0 Xg/a_3036_4156# 0.10387f
C797 Xi0/g ua0_stim_out 0.10015f
C798 Xd1/m1_462_4048# vth_cmp 0.0506f
C799 r2_b4 Xd1/a_3048_3416# 0.05476f
C800 v0_c1 Xd3/m1_3222_4448# 0.03158f
C801 Xg/a_3036_4156# Xg/a_4580_5314# -0
C802 i4_b0 vdd 1.41828f
C803 Xr/m1_1662_438# Xm/iint 0.0134f
C804 Xd2/m1_596_2880# Xd2/a_1272_3416# -0.00185f
C805 i3_b1 Xg/a_5188_4156# 0.05662f
C806 vdd Xg/a_4580_5314# -0.01919f
C807 ua0 Xm/a_420_700# 0.01029f
C808 i4_b2 r1_b2 0
C809 Xi1/a_4132_4392# Xm/in_p 0.00167f
C810 r1_b0 r2_b1 0.04138f
C811 i4_b0 Xi1/g 0.12482f
C812 vdd Xi1/m1_1500_4312# -0.01552f
C813 r2_b3 Xi2/g 0.03857f
C814 el vbn_prb 0.77906f
C815 Xi3/a_528_4392# r0_b0 0
C816 vbn_ax Xr/vsn 0.01246f
C817 r0_b4 i2_b3 0.04307f
C818 Xvi/m1_7102_850# ib_x2 0.08383f
C819 Xi0/g Xm/in_n 0.26169f
C820 Xi1/m1_1500_4312# Xi1/g -0.04134f
C821 i3_b4 i0_b2 0.03986f
C822 vdd Xm/a_2240_11218# 0.2753f
C823 i3_b1 i2_b4 0
C824 ib_r1 Xvi/m1_7102_850# 0.01485f
C825 i0_b3 Xi1/m1_988_888# 0.2111f
C826 vbp_syn vbp_st 0.06896f
C827 vbn_ax i3_b2 0.0074f
C828 r2_b0 Xd1/m1_756_3120# 0.22578f
C829 ua0_stim_out vbp_st 0.15372f
C830 r1_b1 i3_b0 0.03373f
C831 Xr/m1_1222_3522# vth_ref 0.00376f
C832 r2_b2 r2_b1 0.52499f
C833 i2_b3 i4_b3 0.0359f
C834 r1_b4 r2_b1 0.10667f
C835 i2_b3 r0_b3 0.03433f
C836 Xg/m1_5516_1920# i4_b4 0.03935f
C837 Xm/in_p i0_b3 0.04318f
C838 Xr/vsp Xg/m1_3898_9610# 0.00206f
C839 r2_b1 Xvi/m1_502_738# 0.01769f
C840 vbp_w vbp_syn 0.30224f
C841 vbp_w ua0_stim_out 0.03503f
C842 Xvi/m1_8332_7080# vreset_src 0.02127f
C843 vth_ref Xvi/m1_5388_6960# 0.00718f
C844 Xr/vsn i4_b4 1.00409f
C845 Xi1/m1_988_3464# Xi1/m1_988_2804# -0.01387f
C846 Xd1/m1_606_2410# vreset_src 0.1076f
C847 ua0_s1 Xm/a_736_7228# 0.30859f
C848 r0_b2 Xd0/m1_2742_3250# -0.00376f
C849 v0_c1 v0_c4 0.32899f
C850 i4_b4 i3_b2 0.6832f
C851 v0_c1 Xd3/m1_2720_2760# 0
C852 Xd0/m1_3310_2880# vdd -0.00289f
C853 vbp_st Xm/in_n 0.23962f
C854 Xr/vglp r1_b2 0.48145f
C855 Xi0/m1_988_2804# bias_en 0.41001f
C856 Xi3/a_3282_4392# vdd -0.06192f
C857 Xi4/m1_988_3304# vth_cmp 0
C858 Xi1/a_4132_4392# i0_b4 0.04826f
C859 Xi4/m1_260_2080# vreset_src 0.05615f
C860 el Xd1/m1_1780_5040# 0.0397f
C861 vdd vth_cmp 1.43912f
C862 vth_cmp Xvi/m1_4546_7560# 0
C863 r2_b0 Xd0/m1_822_4048# 0.00138f
C864 i4_b2 Xg/a_7580_5314# 0.10716f
C865 Xi1/a_3928_4392# Xm/in_p 0.00246f
C866 r1_b1 i2_b0 0.05746f
C867 Xd2/a_2456_3416# r2_b2 0.02183f
C868 Xvi/a_2102_5152# el 0.0491f
C869 Xr/en_b Xd3/m1_1702_4448# 0
C870 Xd3/m1_1702_4448# vth_ref -0.00226f
C871 vbn_ref i4_b1 0.0407f
C872 Xd0/a_1632_3416# r0_b0 0.00314f
C873 bias_en vreset_src 0.08297f
C874 Xd3/m1_382_4448# bias_en 0
C875 Xd3/m1_822_4448# ua0_stim_out 0.04462f
C876 vdd Xi2/a_4132_4170# 0.00227f
C877 Xd0/m1_956_3000# r2_b0 0.07591f
C878 r2_b2 Xr/vsn 0.00126f
C879 i4_b2 Xi0/g 0.28142f
C880 i1_b4 i0_b2 0
C881 Xd2/m1_1342_4048# el 0
C882 Xi4/a_3078_4170# i4_b3 0.06521f
C883 Xm/iint ib_x2 0.14415f
C884 Xi2/m1_260_2080# vbp_st 0.16572f
C885 r2_b4 Xd1/m1_756_3120# 0.07154f
C886 r2_b0 Xd1/m1_606_2410# 0.1205f
C887 r1_b4 Xr/vsn 0.37026f
C888 vdd Xvi/m1_7102_850# -0.02494f
C889 ib_r1 Xm/iint 0.3641f
C890 i4_b1 Xr/vgln 0.40245f
C891 Xi0/a_2228_4392# Xi1/m1_988_888# 0
C892 i0_b4 i0_b3 0.02358f
C893 i1_b0 i4_b4 0
C894 Xr/vsn Xvi/m1_502_738# 0.03344f
C895 vreset_src Xr/m1_342_438# 0.02628f
C896 i4_b1 Xg/m1_4760_1320# 0.00393f
C897 Xi1/m1_240_3480# Xi1/m1_988_3464# -0
C898 Xr/vsp i2_b3 0.11212f
C899 i2_b3 i0_b0 0
C900 r1_b3 Xi2/a_4132_4170# 0.02679f
C901 Xi0/m1_240_3480# ib_x2 0.09487f
C902 vbn_ax i3_b0 0.1802f
C903 i4_b0 vbn_leak 0.04752f
C904 Xr/vgln vth_ref 0.60304f
C905 Xd3/a_2216_3816# bias_en 0.17573f
C906 bias_en Xd3/a_2808_3816# 0.20702f
C907 Xi3/g i4_b0 0.91782f
C908 Xi3/g Xg/a_4580_5314# 0.09806f
C909 i4_b1 i2_b1 0.03168f
C910 Xi2/g i3_b4 0.13212f
C911 vbn_leak Xg/a_4580_5314# 0.10073f
C912 Xd3/a_3992_3816# bias_en 0.0688f
C913 r1_b3 Xg/m1_3666_9610# 0.00158f
C914 Xi4/a_3928_4170# vth_cmp 0.07579f
C915 i3_b4 i1_b4 0.22102f
C916 Xi4/a_2432_4170# el 0.00113f
C917 Xi3/a_3078_4392# vdd -0.00353f
C918 i4_b2 vbp_st 0.03356f
C919 Xr/vglp Xg/a_7580_5314# 0.06366f
C920 Xr/m1_1222_3522# bias_en 0
C921 vdd i2_b2 0.48771f
C922 Xi1/a_3928_4392# i0_b4 0.00939f
C923 ib_x2 Xi1/m1_988_888# 0.02607f
C924 r2_b4 Xd0/m1_822_4048# 0
C925 i3_b3 r1_b2 0.0414f
C926 i4_b4 i3_b0 0.03467f
C927 Xi3/a_4132_4392# r0_b4 0.01427f
C928 vdd Xi1/a_1582_4392# 0
C929 i2_b2 Xi1/g 0.00789f
C930 vbp_w i4_b2 0
C931 Xr/vgln Xi0/m1_1500_4312# 0.00214f
C932 Xr/vglp Xi0/g 0.33341f
C933 Xm/in_p ib_x2 0.14561f
C934 Xvi/m1_8042_6360# vth_cmp 0.06767f
C935 ua0_s1 vbp_st 0.16676f
C936 i4_b1 ua0_stim_out 0.05226f
C937 r1_b3 i2_b2 0.06013f
C938 Xd0/m1_956_3000# r2_b4 0.01885f
C939 vdd ua0_int 1.08185f
C940 vdd Xi2/a_1378_4170# 0.00484f
C941 r2_b4 Xd1/m1_606_2410# 0.02288f
C942 i0_b1 vbp_st 0.06736f
C943 vdd Xi0/a_1582_4392# 0.01199f
C944 Xi1/a_2432_4392# Xi1/m1_1500_4312# -0
C945 i4_b0 r2_b1 0.04019f
C946 r2_b0 Xd0/a_2224_3416# 0.06576f
C947 Xm/in_p i1_b1 0
C948 Xi1/a_3282_4392# i0_b3 0.04978f
C949 Xd2/m1_2382_2650# Xd2/m1_2964_2640# -0.00725f
C950 vdd r0_b1 0.89488f
C951 vdd Xm/iint 1.56502f
C952 Xr/en_b ua0_stim_out 0.23196f
C953 r1_b1 i2_b4 0.05698f
C954 Xi4/g i4_b1 0.12172f
C955 i4_b1 Xm/in_n 0.11452f
C956 Xd0/m1_3310_2880# vbn_leak 0.00256f
C957 r2_b2 Xi2/m1_988_3304# 0.20993f
C958 v0_c0 ib_x2 0.50955f
C959 Xr/vglp vbp_st 0.03338f
C960 Xi0/m1_988_3464# ib_x2 0.08028f
C961 vbn_leak vth_cmp 0.24287f
C962 r1_b4 Xi2/m1_988_3304# 0
C963 Xi4/a_1582_4170# vdd 0
C964 Xd0/m1_2242_4966# vdd -0.00284f
C965 r1_b4 i3_b0 0.0357f
C966 v0_c1 v0_c3 0.18433f
C967 Xi4/g vth_ref 0.01319f
C968 vdd Xi0/m1_240_3480# 0.21633f
C969 r1_b3 r0_b1 0
C970 Xvi/m1_8646_1098# Xr/vgln 0
C971 vdd Xi3/m1_988_2804# -0.02267f
C972 Xr/en_b Xm/in_n 0.03696f
C973 vth_ref Xm/in_n 0.32034f
C974 v0_c0 Xd3/a_4584_3816# 0
C975 Xr/vsp i0_b3 0.33001f
C976 Xi1/a_3078_4392# Xi1/a_4132_4392# -0
C977 Xvi/m1_942_738# ib_x2 0
C978 Xd1/a_680_3416# vreset_src 0.11648f
C979 Xi2/m1_988_888# i3_b1 0.00399f
C980 vbp_w Xd0/a_1040_3416# 0.05237f
C981 i3_b3 Xg/a_7580_5314# 0.04108f
C982 vdd Xi1/a_1378_4392# 0
C983 i0_b4 ib_x2 0.01531f
C984 vbn_ref i3_b1 0.04353f
C985 r1_b0 i2_b0 0.24609f
C986 Xr/vgln bias_en 0.67807f
C987 vdd Xi1/m1_988_888# 0.14245f
C988 Xd0/a_2816_3416# vdd 0.04264f
C989 Xi0/g i3_b3 0.1297f
C990 v0_c2 Xd3/m1_4078_3250# 0.00266f
C991 v0_c4 ua0_int 0.02581f
C992 Xm/in_p Xg/a_3036_4156# 0
C993 i4_b0 Xr/vsn 0.02318f
C994 Xi1/g Xi1/m1_988_888# -0.01822f
C995 Xg/m1_6020_10200# r1_b2 0.00928f
C996 v0_c1 ua0_s0 0.13862f
C997 Xd2/m1_2382_2650# r2_b2 0
C998 Xd0/m1_2742_3250# Xd0/m1_3662_4048# -0.01444f
C999 Xi3/a_4132_4392# Xr/vsp 0
C1000 vdd Xm/in_p 1.44409f
C1001 i3_b1 Xr/vgln 0.22738f
C1002 Xi4/m1_988_888# vth_cmp 0
C1003 Xr/vsn Xg/a_4580_5314# 0.0222f
C1004 r2_b4 Xd0/a_2224_3416# 0.10308f
C1005 Xm/in_p Xd3/m1_3222_4448# 0.02708f
C1006 r2_b2 i2_b0 0.07675f
C1007 Xi1/a_3078_4392# i0_b3 0.06845f
C1008 Xd2/m1_1780_2760# Xd2/m1_2964_2640# -0.00105f
C1009 Xd0/a_1040_3416# Xd1/a_3048_3416# 0.02257f
C1010 i4_b3 ib_x2 0.03f
C1011 Xm/in_p Xi1/g 0.79822f
C1012 r2_b1 vth_cmp 0.04082f
C1013 r1_b1 vreset_src 0
C1014 Xi3/a_1378_4392# i3_b0 0
C1015 i4_b0 i3_b2 0.03101f
C1016 r1_b4 i2_b0 0.15319f
C1017 r2_b3 r1_b2 0.271f
C1018 Xi3/a_528_4392# i3_b0 0.00504f
C1019 i3_b2 Xg/a_4580_5314# 0.16202f
C1020 v0_c5 ua0_s1 0.05368f
C1021 Xi2/a_2432_4170# i2_b2 0.0021f
C1022 ua0_stim_out Xi1/m1_988_3464# 0.01662f
C1023 Xd1/a_680_3416# r2_b0 0.19371f
C1024 i4_b4 Xg/m1_3530_1930# 0.12643f
C1025 i4_b2 i4_b1 0.82172f
C1026 r1_b3 Xm/in_p 0.44926f
C1027 Xvi/m1_8042_6360# Xm/iint 0
C1028 Xi2/a_3928_4170# vbp_st 0
C1029 Xvi/m1_8332_7080# Xvi/a_864_6450# -0
C1030 vdd Xd3/m1_3908_2760# 0.08519f
C1031 Xi4/m1_1500_3762# r2_b1 0
C1032 i4_b4 Xg/a_5188_4156# 0.13882f
C1033 i3_b3 vbp_st 0.27928f
C1034 Xi1/a_3078_4392# Xi1/a_3928_4392# -0.00158f
C1035 Xi0/m1_988_3464# vdd 0.21734f
C1036 Xd3/m1_3222_4448# Xd3/m1_3908_2760# -0
C1037 v0_c0 vdd 0.56713f
C1038 r0_b0 r0_b1 0.91922f
C1039 bias_en ua0_stim_out 1.22454f
C1040 Xr/vsp Xi0/a_2228_4392# 0.00415f
C1041 v0_c0 Xd3/m1_3222_4448# 0.29271f
C1042 i3_b1 ua0_stim_out 0.0563f
C1043 i4_b4 Xg/m1_4538_1930# 0.04242f
C1044 el vbp_st 0.34256f
C1045 r1_b1 r2_b0 0.00606f
C1046 i4_b4 i2_b4 0.02932f
C1047 vreset_src Xvi/m1_1382_738# 0.00114f
C1048 Xi2/a_2228_4170# vbp_st 0
C1049 vdd i0_b4 0.91023f
C1050 ua0_s1 Xr/en_b 0.23501f
C1051 r0_b1 vbn_leak 0.0476f
C1052 vbp_w el 0.12255f
C1053 Xi4/g bias_en 0.23149f
C1054 bias_en Xvi/a_864_6450# 0.20589f
C1055 Xr/vsn vth_cmp 0.14388f
C1056 i0_b4 Xi1/g 0.13675f
C1057 ua0_stim Xm/a_736_5516# 0
C1058 bias_en Xm/in_n 0.05491f
C1059 r2_b1 i2_b2 0.05056f
C1060 vdd r0_b4 0.60143f
C1061 Xi3/a_2432_4392# Xr/vgln 0.00427f
C1062 Xi4/g i3_b1 0.00465f
C1063 Xg/m1_4906_9490# Xg/a_3036_4156# -0
C1064 i4_b1 Xr/vglp 0.11574f
C1065 Xr/vsp Xi0/a_3282_4392# 0
C1066 Xr/vsp ib_x2 0.41627f
C1067 Xi0/g Xg/m1_6020_10200# -0.00274f
C1068 Xd2/a_1864_3416# r2_b0 0.09298f
C1069 r0_b4 Xi1/g 0
C1070 vdd Xg/m1_4906_9490# -0.01217f
C1071 Xd1/a_680_3416# r2_b4 0.11836f
C1072 ib_r1 Xr/vsp 0.0338f
C1073 vbn_leak Xi0/m1_240_3480# -0.00128f
C1074 Xi2/m1_988_888# Xi2/m1_988_2644# -0.00976f
C1075 r1_b4 Xg/a_5188_4156# 0
C1076 vdd r0_b3 0.37399f
C1077 vdd i4_b3 1.56941f
C1078 Xr/vsp Xg/a_1580_5314# 0.02661f
C1079 i4_b0 i3_b0 0.56231f
C1080 i4_b3 Xvi/m1_4546_7560# 0.01411f
C1081 Xi3/g Xi3/m1_988_2804# -0.11681f
C1082 Xr/m1_342_438# Xm/in_n 0.24969f
C1083 Xd0/a_2816_3416# r0_b0 0.00369f
C1084 Xg/m1_4906_9490# Xi1/g 0.02195f
C1085 Xi3/m1_988_888# vdd -0.04175f
C1086 vth_ref Xr/vglp 1.07914f
C1087 i4_b3 Xi1/g 0.03299f
C1088 r1_b3 r0_b4 0.09991f
C1089 Xr/en_b Xr/vglp 0.00619f
C1090 Xd3/m1_2408_3600# vth_ref -0.00352f
C1091 i3_b0 Xg/a_4580_5314# 0.1213f
C1092 Xvi/a_4976_1528# vbn_prb -0
C1093 Xd2/m1_756_3240# Xd2/m1_1780_2760# -0
C1094 Xr/en_b Xd3/m1_2408_3600# 0
C1095 v0_c0 v0_c4 0
C1096 r2_b2 i2_b4 0.06964f
C1097 Xi2/a_1582_4170# r0_b3 0
C1098 r1_b3 Xg/m1_4906_9490# 0
C1099 v0_c0 Xd3/m1_2720_2760# 0.05008f
C1100 Xr/vgln Xi2/m1_988_2644# 0.18387f
C1101 r1_b4 i2_b4 0.10723f
C1102 Xi1/a_528_4392# i3_b1 0
C1103 r2_b1 r0_b1 0
C1104 Xd2/m1_2964_2640# vreset_src 0.00196f
C1105 Xvi/a_5712_1328# ib_x2 0.04515f
C1106 r1_b3 r0_b3 0.19934f
C1107 Xi3/a_3928_4392# vdd -0.00147f
C1108 Xi2/a_3078_4170# Xi2/m1_988_2644# -0.00787f
C1109 Xd3/m1_1262_4448# vbp_st 0.0026f
C1110 Xi3/g Xm/in_p 0.1029f
C1111 ib_r1 Xvi/a_5712_1328# 0.03497f
C1112 vdd Xg/m1_6282_1450# -0.00451f
C1113 r1_b1 r2_b4 0.08616f
C1114 r1_b1 Xi2/m1_988_888# 0
C1115 i3_b4 r1_b2 0.1875f
C1116 i4_b4 vreset_src 0
C1117 r1_b1 vbn_ref 0.04024f
C1118 Xi3/a_3078_4392# Xr/vsn 0
C1119 vdd Xi1/a_3282_4392# 0.03554f
C1120 bias_en Xvi/m1_4894_1238# 0.04922f
C1121 ua0_int v0_c3 0.03011f
C1122 r2_b0 Xd1/m1_2974_2650# 0.05495f
C1123 r2_b3 vbp_st 0.04673f
C1124 i4_b0 i2_b0 0.01754f
C1125 vbn_ax r2_b0 0.27025f
C1126 Xi4/a_3928_4170# i4_b3 0.01619f
C1127 r1_b0 vreset_src 0.02708f
C1128 r1_b1 Xr/vgln 0.72859f
C1129 v0_c2 ua0_stim 0.08414f
C1130 i0_b1 Xi1/m1_988_3464# 0.10068f
C1131 vreset_src Xd1/m1_2372_2520# 0
C1132 r2_b3 vbp_w 0.17208f
C1133 i4_b2 i3_b1 0.21282f
C1134 Xi1/a_2432_4392# Xm/in_p 0
C1135 Xi1/a_4132_4392# i0_b3 0.00251f
C1136 i4_b1 i3_b3 0.03971f
C1137 Xr/vsp Xg/a_3036_4156# 0
C1138 Xd2/m1_2964_2640# r2_b0 0.00902f
C1139 Xvi/a_2102_5152# Xvi/a_4976_1528# -0.00178f
C1140 Xvi/m1_8332_7080# Xr/vglp 0.00105f
C1141 r2_b0 Xd0/m1_617_3840# 0.08887f
C1142 ua0_s1 bias_en 0.37501f
C1143 vbp_syn Xi2/m1_988_2644# -0
C1144 vdd i0_b0 0.03967f
C1145 Xr/vsp vdd 3.00248f
C1146 Xr/en_b Xd3/m1_1523_3480# 0.00212f
C1147 ua0_s0 ua0_int 0.00399f
C1148 Xi3/m1_240_3480# Xr/vgln 0.04428f
C1149 v0_c0 Xd3/m1_5422_4448# 0.09934f
C1150 r2_b1 Xm/in_p 0.10947f
C1151 r2_b2 vreset_src 0.1303f
C1152 Xvi/m1_8042_6360# i4_b3 0.0799f
C1153 Xr/vsn Xm/iint 0.00378f
C1154 Xr/vsp Xi1/g 0.68567f
C1155 r1_b1 i2_b1 0.04546f
C1156 i4_b1 el 0
C1157 r0_b0 r0_b4 0.05796f
C1158 i0_b0 Xi1/g 0.06168f
C1159 Xvi/m1_8646_1098# Xr/vglp 0
C1160 Xvi/m1_7440_2050# Xvi/a_864_6450# -0.00268f
C1161 Xvi/m1_502_738# vreset_src 0
C1162 r0_b2 vdd 0.38869f
C1163 Xr/vsp Xi0/a_528_4392# 0.00119f
C1164 i3_b1 i0_b1 0.03652f
C1165 vbn_prb Xd1/m1_1780_5040# 0.0517f
C1166 r0_b0 r0_b3 0.26466f
C1167 Xi2/g r1_b2 0.02255f
C1168 ua0_s0 Xm/iint 0.06141f
C1169 Xg/m1_5022_10210# Xg/a_5188_4156# -0
C1170 Xr/vsp r1_b3 0.27085f
C1171 r2_b2 Xd0/m1_382_4048# 0
C1172 Xg/a_7580_5314# i3_b4 0.04052f
C1173 r1_b0 r2_b0 1.13972f
C1174 vth_ref el 0.1496f
C1175 vdd Xi1/a_3078_4392# 0.00379f
C1176 r0_b4 vbn_leak 0.03834f
C1177 Xr/vgln Xvi/m1_1382_738# 0.04488f
C1178 Xi3/g r0_b4 0
C1179 Xr/vsn Xi0/m1_240_3480# 0.08745f
C1180 bias_en Xr/vglp 0.7945f
C1181 Xd1/m1_756_3120# el 0
C1182 r2_b0 Xd1/m1_2372_2520# 0.06588f
C1183 Xd3/m1_2408_3600# bias_en 0.01009f
C1184 Xi2/a_2432_4170# r0_b3 0
C1185 r2_b4 Xd1/m1_2974_2650# 0.06771f
C1186 Xg/m1_3298_2050# i4_b1 0.09162f
C1187 r2_b2 Xi2/a_3282_4170# 0.06758f
C1188 Xi3/g Xg/m1_4906_9490# -0
C1189 Xd2/m1_2382_2650# vth_cmp 0.00762f
C1190 r0_b2 r1_b3 0.00444f
C1191 r1_b1 ua0_stim_out 0.12837f
C1192 Xi0/g i3_b4 0.20386f
C1193 vbn_leak r0_b3 0.04863f
C1194 vdd Xd2/a_3048_3416# -0.01039f
C1195 vdd Xd0/m1_2742_3250# -0.00454f
C1196 vbn_ax Xi2/m1_988_888# 0.01262f
C1197 vbn_leak i4_b3 0.03811f
C1198 vbn_ax r2_b4 0.04408f
C1199 Xi3/g i4_b3 0.02229f
C1200 Xd2/m1_1342_4048# vbn_prb 0.0714f
C1201 i3_b1 Xr/vglp 0.14375f
C1202 r2_b2 r2_b0 0.33243f
C1203 vbn_ax vbn_ref 0.04007f
C1204 vbp_st i0_b2 0.09477f
C1205 ua0_stim Xm/a_736_7228# -0
C1206 Xi3/g Xi3/m1_988_888# -0.01546f
C1207 i4_b0 Xg/a_5188_4156# 0.0851f
C1208 Xd3/a_4584_3816# Xd3/m1_4982_4448# -0.0031f
C1209 r1_b4 r2_b0 0
C1210 Xr/vglp Xr/m1_342_438# 0.00271f
C1211 r1_b0 Xi2/a_528_4170# 0
C1212 Xi1/a_1378_4392# i3_b2 0
C1213 Xi1/a_3928_4392# i0_b3 0.01045f
C1214 Xg/a_5188_4156# Xg/a_4580_5314# -0.00321f
C1215 r2_b4 Xd0/m1_617_3840# 0.11964f
C1216 Xd3/a_1624_3816# Xr/en_b 0.00567f
C1217 Xi2/m1_260_2080# Xi2/m1_988_2644# -0.01022f
C1218 Xi4/a_3078_4170# Xi4/m1_988_2644# -0.00348f
C1219 Xvi/m1_1276_6360# Xvi/a_4976_1528# -0.00784f
C1220 vbn_ax Xr/vgln 0.01941f
C1221 r1_b1 Xi4/a_4132_4170# 0.00187f
C1222 Xd3/m1_4102_4448# Xm/in_p 0.00899f
C1223 Xm/a_1744_9182# ua0_int -0
C1224 v0_c3 Xd3/m1_3908_2760# -0.00256f
C1225 Xm/in_p i3_b2 0.02956f
C1226 Xd0/m1_822_4048# el 0.00758f
C1227 Xm/in_p ua0_s0 0.18403f
C1228 Xd3/a_3400_3816# vdd 0
C1229 r1_b3 Xg/m1_3898_9610# 0
C1230 i4_b0 i2_b4 0.05162f
C1231 vbn_ref i4_b4 0.03872f
C1232 v0_c0 v0_c3 0.10193f
C1233 Xi2/a_528_4170# r2_b2 0.00801f
C1234 i4_b1 Xg/m1_6020_10200# 0
C1235 r2_b1 r0_b4 0.37346f
C1236 r1_b1 Xi4/a_732_4170# 0.00951f
C1237 Xr/en_b Xr/m1_3862_3522# -0.00238f
C1238 i3_b4 vbp_st 0.69248f
C1239 Xd3/a_3400_3816# Xd3/m1_3222_4448# -0.00334f
C1240 Xd2/m1_756_3240# r2_b0 0.0112f
C1241 r1_b0 Xd0/a_3408_3416# 0.00861f
C1242 Xi2/g Xg/a_7580_5314# -0.02405f
C1243 r2_b1 r0_b3 0
C1244 r2_b1 i4_b3 0.04722f
C1245 Xvi/m1_8332_7080# el 0.15241f
C1246 r2_b3 i4_b1 0.34267f
C1247 r1_b0 r2_b4 1.24563f
C1248 Xr/en_b Xd3/m1_1262_4448# 0.00193f
C1249 i4_b4 Xr/vgln 1.29554f
C1250 Xd1/m1_606_2410# el 0
C1251 r2_b4 Xd1/m1_2372_2520# 0.07577f
C1252 Xd3/m1_1523_3480# bias_en 0.00181f
C1253 r1_b0 vbn_ref 0.10329f
C1254 Xi0/m1_988_3464# Xr/vsn 0.0191f
C1255 Xd2/m1_1780_2760# vth_cmp 0.00837f
C1256 i4_b4 Xg/m1_4760_1320# 0.0334f
C1257 Xi2/g Xi0/g 0.01651f
C1258 Xd3/m1_4102_4448# Xd3/m1_3908_2760# -0.04443f
C1259 Xr/m1_2542_438# Xr/vsn 0
C1260 r2_b2 Xd0/a_3408_3416# 0.08029f
C1261 Xi0/a_2432_4392# Xi1/m1_988_888# 0
C1262 v0_c0 Xd3/m1_4102_4448# 0.10277f
C1263 ua0_s0 Xd3/m1_3908_2760# 0.06327f
C1264 Xi4/g Xvi/m1_1382_738# 0.13593f
C1265 vdd Xm/a_420_700# -0.00705f
C1266 i2_b0 i2_b2 1.28243f
C1267 r2_b4 r2_b2 1.5769f
C1268 r0_b2 r0_b0 1.83191f
C1269 v0_c0 ua0_s0 0.08032f
C1270 Xi3/g Xr/vsp 0.55289f
C1271 vbn_ax vbp_syn 0.04697f
C1272 Xi4/m1_260_2080# el 0.21425f
C1273 vbn_leak i0_b0 0.20943f
C1274 Xr/vsp vbn_leak 0.05586f
C1275 Xi2/m1_988_888# r2_b2 0
C1276 vdd Xd3/m1_4982_4448# 0.06187f
C1277 vdd i2_b3 0.95644f
C1278 Xr/vsn Xvi/m1_942_738# 0.00519f
C1279 r1_b4 r2_b4 0
C1280 i3_b1 i3_b3 1.29894f
C1281 r1_b0 Xr/vgln 0.1152f
C1282 vbn_ax ua0_stim_out 0.01517f
C1283 vbn_ref r2_b2 0.05041f
C1284 r1_b4 Xi2/m1_988_888# 0.1907f
C1285 bias_en el 0.31895f
C1286 r1_b4 vbn_ref 0.05047f
C1287 i0_b3 ib_x2 0
C1288 i0_b3 Xi0/a_3282_4392# -0
C1289 i2_b3 Xi1/g 0
C1290 r0_b2 vbn_leak 0.05911f
C1291 r1_b1 i4_b2 0.80021f
C1292 ua0 ua0_s0 0.07119f
C1293 Xr/vsn r0_b4 0.09162f
C1294 i4_b0 vreset_src 0
C1295 r1_b1 Xi4/a_528_4170# 0.00805f
C1296 Xd3/a_3400_3816# v0_c4 0.00156f
C1297 r2_b2 Xr/vgln 0.2018f
C1298 Xi2/g vbp_st 0.43894f
C1299 r1_b3 i2_b3 0.1857f
C1300 r1_b0 i2_b1 0.05882f
C1301 Xi2/a_3078_4170# r2_b2 0.14834f
C1302 Xvi/m1_7440_2050# Xr/vglp 0.05932f
C1303 Xr/vgln Xi0/a_732_4392# 0.05824f
C1304 r1_b4 Xr/vgln 0.08728f
C1305 Xd3/a_3400_3816# Xd3/m1_2720_2760# -0.00191f
C1306 Xi1/m1_1500_4312# Xi1/m1_988_2804# -0.01873f
C1307 i4_b4 ua0_stim_out 0.04148f
C1308 Xd2/m1_596_2880# r2_b0 -0.0016f
C1309 r0_b4 i3_b2 0.11637f
C1310 Xr/vsn i4_b3 0.25582f
C1311 r1_b4 Xi2/a_3078_4170# 0.00539f
C1312 r0_b1 i2_b0 0.01347f
C1313 Xr/vgln Xvi/m1_502_738# 0.01033f
C1314 Xi4/a_2228_4170# vreset_src 0.03865f
C1315 Xvi/m1_1276_6360# Xvi/a_2102_5152# -0
C1316 ib_r1 Xr/m1_1662_438# 0.00267f
C1317 Xm/a_736_7228# Xm/a_736_5516# -0.04239f
C1318 Xm/in_p i3_b0 0.03714f
C1319 Xd3/a_1624_3816# bias_en 0.00251f
C1320 i2_b4 Xi2/a_4132_4170# 0
C1321 Xd0/a_1632_3416# r2_b0 0.05199f
C1322 Xr/vsp r2_b1 0.17562f
C1323 i3_b2 i4_b3 0.12558f
C1324 r2_b2 i2_b1 0.0434f
C1325 v0_c1 Xd3/a_2216_3816# 0.16803f
C1326 v0_c1 Xd3/a_2808_3816# 0.04816f
C1327 r1_b4 i2_b1 0.11196f
C1328 r1_b0 vbp_syn 0.20782f
C1329 r1_b0 ua0_stim_out 0.16309f
C1330 Xi4/a_3078_4170# vdd 0
C1331 i4_b4 Xvi/a_864_6450# 0.0908f
C1332 Xi4/g i4_b4 0.0539f
C1333 v0_c1 Xd3/a_3992_3816# 0.05368f
C1334 vdd Xi1/a_4132_4392# 0.00642f
C1335 i4_b4 Xm/in_n 0.26923f
C1336 Xi4/a_4132_4170# i4_b4 0
C1337 Xr/vsn Xg/m1_6282_1450# 0.04804f
C1338 vbn_ax Xi2/m1_260_2080# 0
C1339 r2_b2 vbp_syn 0.07403f
C1340 r1_b1 Xr/vglp 0.55846f
C1341 r2_b2 ua0_stim_out 0.71682f
C1342 r2_b3 Xi4/m1_260_2080# 0.02615f
C1343 Xi0/a_2228_4392# Xi0/a_3282_4392# -0
C1344 i4_b1 i3_b4 0.04007f
C1345 r1_b4 ua0_stim_out 0.80611f
C1346 i1_b2 i3_b1 0.01543f
C1347 Xi1/a_528_4392# i4_b4 0
C1348 Xm/in_p i2_b0 0
C1349 i2_b4 i2_b2 0.01722f
C1350 vreset_src vth_cmp 2.06631f
C1351 Xi0/a_3928_4392# Xi1/m1_988_888# 0
C1352 vdd i0_b3 0.94366f
C1353 r2_b2 Xd1/m1_860_4046# 0
C1354 i0_b3 Xi1/g 0.38884f
C1355 r2_b3 i3_b1 0.03451f
C1356 r1_b0 Xd1/a_1864_3416# 0.05067f
C1357 Xr/vsp Xr/vsn 0.31996f
C1358 Xi4/g Xvi/m1_502_738# 0.01915f
C1359 Xd0/m1_382_4048# vth_cmp 0.07401f
C1360 Xd0/a_1632_3416# r2_b4 0.11124f
C1361 vbn_prb vbp_st 0.19628f
C1362 r0_b4 i3_b0 0.07763f
C1363 bias_en Xd3/m1_4078_3250# 0.09702f
C1364 Xi4/m1_1500_3762# vreset_src 0.01543f
C1365 ib_x2 Xi0/a_3282_4392# 0.00275f
C1366 Xi3/a_4132_4392# vdd -0
C1367 Xr/vsp i3_b2 0.16386f
C1368 Xi3/g i2_b3 0
C1369 i3_b2 i0_b0 0.06569f
C1370 Xd2/a_680_3416# Xd2/m1_756_3240# -0.00131f
C1371 Xvi/m1_7440_2050# el 0
C1372 Xvi/m1_7102_850# vreset_src 0.02834f
C1373 v0_c5 ua0_stim 0.40574f
C1374 vdd Xi1/a_3928_4392# 0.05982f
C1375 ib_r1 ib_x2 0.09416f
C1376 Xd1/a_1864_3416# r2_b2 0.01866f
C1377 ua0_int Xm/a_1764_11418# -0
C1378 Xd0/m1_3310_2880# r2_b0 0.05247f
C1379 r0_b3 i3_b0 0.00887f
C1380 Xd3/m1_4982_4448# Xd3/m1_5422_4448# -0.14727f
C1381 vbp_w vbn_prb 0.05373f
C1382 i4_b2 i4_b4 0.04563f
C1383 i4_b3 i3_b0 0.53926f
C1384 Xd1/a_680_3416# el 0
C1385 i4_b0 Xi2/m1_988_888# 0
C1386 vbp_st Xm/a_736_5516# -0.00675f
C1387 r2_b0 vth_cmp 0.25677f
C1388 i4_b0 vbn_ref 0.06701f
C1389 r2_b2 Xi2/m1_260_2080# 0.05435f
C1390 Xi0/m1_988_888# Xi0/g -0.06568f
C1391 Xm/iint Xm/a_1764_11418# 0.00536f
C1392 r1_b4 Xi2/m1_260_2080# 0.11737f
C1393 Xi1/m1_988_3464# i0_b2 0.09338f
C1394 v0_c1 Xr/vgln 0.00156f
C1395 Xi2/g i4_b1 0.26602f
C1396 Xd0/m1_382_4048# Xd1/m1_2862_4048# 0.00158f
C1397 r1_b1 i3_b3 0.02641f
C1398 Xi1/m1_1500_4312# vbn_ref -0
C1399 Xvi/m1_5388_6960# vth_cmp 0.01842f
C1400 i4_b0 Xr/vgln 0.06205f
C1401 Xr/vsp i1_b0 0.00131f
C1402 Xi1/a_1582_4392# Xi1/m1_988_2804# -0
C1403 i1_b0 i0_b0 0.0194f
C1404 r0_b4 i2_b0 0.07879f
C1405 Xr/vgln Xg/a_4580_5314# 0.13252f
C1406 Xr/vsp Xi0/a_2432_4392# 0
C1407 vdd Xi0/a_2228_4392# 0.01474f
C1408 Xd3/a_3400_3816# v0_c3 0.05542f
C1409 Xm/in_p Xg/a_5188_4156# 0
C1410 Xi2/g vth_ref 0
C1411 Xi0/a_3928_4392# i0_b4 0
C1412 r1_b1 el 0
C1413 i1_b3 Xm/in_p 0
C1414 r2_b1 i2_b3 0.0355f
C1415 Xr/en_b ua0_stim 0.35473f
C1416 Xi0/a_2228_4392# Xi1/g 0
C1417 r2_b0 Xd1/m1_2862_4048# 0.00474f
C1418 i2_b0 r0_b3 0.6503f
C1419 Xi0/m1_988_2804# Xm/iint 0
C1420 i3_b4 Xi1/m1_988_3464# 0
C1421 i4_b0 i2_b1 0.05632f
C1422 i3_b1 i0_b2 0.01554f
C1423 Xg/m1_5022_10210# ua0_stim_out 0.02811f
C1424 r2_b3 Xi3/a_2432_4392# 0.00357f
C1425 i4_b4 Xr/vglp 0.27259f
C1426 i2_b2 Xi2/a_3282_4170# 0
C1427 Xm/in_p i2_b4 0.26574f
C1428 Xd2/a_680_3416# Xd2/m1_596_2880# -0.01161f
C1429 Xd0/m1_3310_2880# Xd0/a_3408_3416# -0.00114f
C1430 Xd0/m1_3310_2880# r2_b4 0.00182f
C1431 vbn_leak Xd0/m1_3662_4048# 0
C1432 Xd2/a_1864_3416# el 0
C1433 vreset_src Xm/iint 0.53255f
C1434 Xd0/a_3408_3416# vth_cmp 0.00784f
C1435 Xd3/m1_382_4448# Xm/iint 0
C1436 vdd Xi0/a_3282_4392# 0.03579f
C1437 Xd3/a_3400_3816# ua0_s0 0
C1438 Xg/a_7580_5314# r1_b2 0.05708f
C1439 vdd ib_x2 1.19355f
C1440 r2_b4 vth_cmp 0.06071f
C1441 Xr/vsp i3_b0 0.50528f
C1442 Xd3/m1_4982_4448# v0_c3 0
C1443 i0_b0 i3_b0 0.03823f
C1444 ib_r1 vdd 0.13795f
C1445 Xg/a_1580_5314# Xg/a_3036_4156# -0.01366f
C1446 vdd Xg/a_1580_5314# -0.13759f
C1447 r1_b0 Xr/vglp 0
C1448 vbn_ref vth_cmp 0.05223f
C1449 ib_x2 Xi1/g 0.00301f
C1450 vdd Xi2/m1_1500_3762# -0.0154f
C1451 i4_b0 ua0_stim_out 0.09937f
C1452 i3_b1 i3_b4 0.14897f
C1453 Xi0/g r1_b2 0.0137f
C1454 vdd Xd3/a_4584_3816# 0.01359f
C1455 Xvi/m1_1382_738# el 0.04399f
C1456 Xi4/a_1582_4170# vreset_src 0.0042f
C1457 r1_b0 Xd0/a_1040_3416# 0.00705f
C1458 vreset_src Xi0/m1_240_3480# 0
C1459 Xi0/a_528_4392# ib_x2 0
C1460 Xd3/a_2808_3816# ua0_int 0
C1461 Xd3/a_2216_3816# ua0_int 0.00195f
C1462 ua0_stim_out Xg/a_4580_5314# 0.00422f
C1463 Xg/a_1580_5314# Xi1/g -0.0849f
C1464 vdd i1_b1 -0.00283f
C1465 Xi3/a_3282_4392# Xr/vgln 0.14419f
C1466 Xd3/a_3992_3816# ua0_int 0.00154f
C1467 Xi4/a_3078_4170# r2_b1 0.00789f
C1468 Xi1/m1_1500_4312# ua0_stim_out 0.00419f
C1469 i1_b3 i0_b4 0
C1470 Xr/vgln vth_cmp 0.33512f
C1471 r2_b2 Xr/vglp 0.05778f
C1472 Xi1/m1_988_2804# Xi1/m1_988_888# 0
C1473 Xm/a_420_700# ua0_s0 0.02214f
C1474 r1_b4 Xr/vglp 0.38432f
C1475 Xd0/a_1040_3416# r2_b2 0.0494f
C1476 r1_b3 Xi2/m1_1500_3762# 0.03276f
C1477 Xd3/m1_4982_4448# ua0_s0 0.04472f
C1478 r2_b4 Xd1/m1_2862_4048# 0
C1479 r2_b0 r0_b1 0.5042f
C1480 Xi4/g Xg/a_4580_5314# -0
C1481 ua0_stim_out Xm/a_2240_11218# 0
C1482 r1_b4 Xd0/a_1040_3416# 0
C1483 Xm/in_n Xg/a_4580_5314# 0.00119f
C1484 Xr/vgln Xi2/a_4132_4170# 0
C1485 Xm/in_p Xi1/m1_988_2804# 0.0769f
C1486 Xi1/a_2432_4392# i0_b3 0.0099f
C1487 el Xd1/m1_2974_2650# 0.00289f
C1488 Xg/m1_4906_9490# Xg/a_5188_4156# -0
C1489 Xr/vsp i2_b0 0.00962f
C1490 r2_b3 Xi3/a_2228_4392# 0.00281f
C1491 Xg/a_5188_4156# i4_b3 0.14191f
C1492 vbp_st r1_b2 0.18838f
C1493 r2_b3 r1_b1 0.28534f
C1494 Xd3/m1_382_4448# Xm/in_p 0.05038f
C1495 vbn_ax el 0.01672f
C1496 i4_b0 Xi4/a_732_4170# 0.00146f
C1497 Xr/m1_782_438# vth_ref 0
C1498 Xvi/m1_7102_850# Xr/vgln -0.00936f
C1499 Xd1/m1_756_3120# vbn_prb 0.00638f
C1500 Xd0/m1_2242_4966# r2_b0 0.09999f
C1501 r0_b4 i2_b4 0.03559f
C1502 i4_b4 i3_b3 0.15022f
C1503 Xd0/m1_1262_4048# r2_b0 0.00152f
C1504 v0_c4 ib_x2 0.14754f
C1505 r2_b4 i2_b2 0.00102f
C1506 Xr/vsp Xi0/a_3928_4392# 0
C1507 vbp_w r1_b2 0.06534f
C1508 r2_b3 Xi3/m1_1500_4312# 0.1349f
C1509 Xg/m1_4906_9490# i2_b4 0
C1510 vbn_ref i2_b2 0.2779f
C1511 Xd2/m1_2964_2640# el 0.18225f
C1512 bias_en ua0_stim 1.57207f
C1513 i2_b4 i4_b3 0.1848f
C1514 r2_b3 Xi3/m1_240_3480# 0.03076f
C1515 el Xd0/m1_617_3840# 0.00624f
C1516 Xi0/m1_988_2804# Xi0/m1_988_3464# -0.00993f
C1517 Xi2/a_732_4170# vbp_st 0.00256f
C1518 vdd Xg/a_3036_4156# -0.02682f
C1519 vdd Xi4/m1_988_3304# 0
C1520 Xi2/g i3_b1 0.33098f
C1521 vbp_syn vth_cmp 0.04681f
C1522 v0_c4 Xd3/a_4584_3816# 0.05854f
C1523 vdd Xvi/m1_4546_7560# -0.00452f
C1524 Xvi/m1_8042_6360# ib_x2 0.05943f
C1525 Xi0/g Xg/a_7580_5314# -0
C1526 Xg/a_3036_4156# Xi1/g -0.01424f
C1527 Xi4/a_3078_4170# Xr/vsn -0
C1528 vdd Xd3/m1_3222_4448# 0.04471f
C1529 Xi3/a_3078_4392# Xr/vgln 0.01315f
C1530 vdd Xi1/g 0.86423f
C1531 Xd0/a_2816_3416# r2_b0 0.04434f
C1532 Xi1/m1_240_3480# Xi1/m1_988_888# -0.01062f
C1533 Xr/vgln i2_b2 0.00778f
C1534 r0_b1 Xd0/a_3408_3416# 0.04971f
C1535 vdd Xi0/a_528_4392# 0.00802f
C1536 ua0_stim_out Xi2/a_4132_4170# 0.04962f
C1537 Xd0/m1_822_4048# vbn_prb 0.04631f
C1538 Xi2/a_1582_4170# vdd 0.05373f
C1539 r1_b0 el 0.00106f
C1540 vbp_w Xd1/a_2456_3416# 0.00111f
C1541 Xi2/a_3928_4170# r2_b2 0.0357f
C1542 Xi1/m1_240_3480# Xm/in_p 0.08429f
C1543 i0_b4 Xi1/m1_988_2804# 0.00251f
C1544 r1_b3 vdd 1.17913f
C1545 Xvi/m1_942_738# vreset_src 0.00116f
C1546 Xd1/m1_860_4046# vth_cmp 0.04214f
C1547 Xvi/a_864_6450# vth_cmp 0.23817f
C1548 Xi4/g vth_cmp 0.06596f
C1549 Xg/m1_3298_2050# i4_b4 0.03612f
C1550 r2_b4 r0_b1 1.36183f
C1551 Xi0/a_528_4392# Xi1/g 0
C1552 v0_c2 v0_c5 0.0654f
C1553 el Xd1/m1_2372_2520# 0.00456f
C1554 i4_b0 i4_b2 0.75352f
C1555 r1_b4 Xi2/a_3928_4170# 0.00134f
C1556 Xg/m1_3666_9610# ua0_stim_out 0.00657f
C1557 vbn_ref r0_b1 0.42063f
C1558 Xi4/a_1378_4170# vreset_src 0.03055f
C1559 Xd1/m1_756_3120# Xd1/m1_1780_5040# -0
C1560 i4_b2 Xg/a_4580_5314# 0.13586f
C1561 Xi4/a_4132_4170# vth_cmp 0.02767f
C1562 i2_b2 i2_b1 0.45167f
C1563 r1_b3 Xi1/g 0
C1564 Xd0/m1_956_3000# vbn_prb 0.00661f
C1565 vbn_leak ib_x2 0.0135f
C1566 Xi2/a_1378_4170# Xr/vgln 0
C1567 bias_en Xvi/a_4976_1528# 0.06588f
C1568 Xi0/m1_988_888# vth_ref 0.03466f
C1569 Xi0/a_1582_4392# Xr/vgln 0.02083f
C1570 Xd3/a_2808_3816# Xd3/m1_3908_2760# -0.00473f
C1571 v0_c1 ua0_s1 0.23459f
C1572 Xg/a_7580_5314# vbp_st 0.03166f
C1573 i2_b3 i3_b0 0.00656f
C1574 r2_b2 el 0.35334f
C1575 Xi4/a_732_4170# vth_cmp 0.02054f
C1576 Xd1/m1_606_2410# vbn_prb 0
C1577 Xd0/m1_2242_4966# r2_b4 0.06193f
C1578 Xr/vsp Xg/a_5188_4156# 0
C1579 Xd0/m1_1262_4048# r2_b4 0
C1580 v0_c0 Xd3/a_2808_3816# 0.23936f
C1581 v0_c0 Xd3/a_2216_3816# 0.09032f
C1582 Xi3/g Xg/a_1580_5314# 0.04188f
C1583 i0_b3 i3_b2 0.01798f
C1584 Xr/vgln Xm/iint 0.23101f
C1585 Xg/a_1580_5314# vbn_leak 0.18774f
C1586 r0_b1 Xr/vgln 0
C1587 Xi4/m1_988_888# Xi4/m1_988_2644# -0.00263f
C1588 Xd3/a_3992_3816# v0_c0 0
C1589 r2_b2 Xi2/a_2228_4170# 0.00717f
C1590 Xg/m1_5022_10210# Xr/vglp -0.03062f
C1591 Xvi/m1_502_738# el 0.06528f
C1592 Xvi/m1_7102_850# Xvi/a_864_6450# -0.00572f
C1593 r2_b3 vbn_ax 0.06103f
C1594 Xi0/g vbp_st 0.08786f
C1595 r2_b1 Xi4/m1_988_2644# 0.18649f
C1596 vreset_src i4_b3 0.22997f
C1597 i2_b2 vbp_syn -0.01216f
C1598 v0_c4 vdd 0.46196f
C1599 r1_b1 Xi4/a_3282_4170# 0
C1600 Xm/in_p Xd3/m1_1702_4448# 0.21094f
C1601 i2_b2 ua0_stim_out 0.05905f
C1602 Xr/vsp i2_b4 0.55358f
C1603 i2_b4 i0_b0 0
C1604 Xd0/a_2816_3416# Xd0/a_3408_3416# -0.00229f
C1605 vdd Xd3/m1_2720_2760# 0.05539f
C1606 Xi1/a_1582_4392# Xi1/a_732_4392# -0
C1607 bias_en vbn_prb 0.25952f
C1608 Xr/vgln Xi0/m1_240_3480# 0.00306f
C1609 Xd3/m1_2720_2760# Xd3/m1_3222_4448# -0.06056f
C1610 Xi1/a_1582_4392# ua0_stim_out 0
C1611 Xi1/m1_1500_4312# i0_b1 0.02123f
C1612 r0_b1 i2_b1 0.00112f
C1613 ua0_s1 Xm/a_2240_11218# 0.06327f
C1614 r2_b4 Xd0/a_2816_3416# 0.0278f
C1615 v0_c1 Xd3/m1_2408_3600# 0
C1616 vdd Xvi/m1_8042_6360# -0.03956f
C1617 Xr/vgln Xi3/m1_988_2804# 0.00244f
C1618 r1_b1 i3_b4 0.0629f
C1619 Xd2/m1_462_4048# vbn_prb 0.02745f
C1620 Xd2/m1_756_3240# el 0.0084f
C1621 Xi1/m1_240_3480# i0_b4 0.09307f
C1622 i1_b3 Xi1/a_3078_4392# 0
C1623 i4_b0 Xr/vglp 0.52082f
C1624 ua0_stim_out ua0_int 0.01283f
C1625 r2_b0 r0_b4 0.08029f
C1626 Xr/vglp Xg/a_4580_5314# 0.0516f
C1627 vbn_ref Xm/in_p 0.01402f
C1628 r0_b3 Xi2/a_3282_4170# 0
C1629 i2_b0 i2_b3 0.30875f
C1630 bias_en Xm/a_736_5516# 0
C1631 Xr/m1_782_438# Xr/m1_342_438# -0
C1632 i4_b1 r1_b2 0
C1633 vdd r0_b0 0.19209f
C1634 Xr/vgln Xi1/m1_988_888# 0.00744f
C1635 Xi2/a_1378_4170# ua0_stim_out 0.00278f
C1636 i4_b2 vth_cmp 0.00722f
C1637 r2_b0 r0_b3 0.2089f
C1638 r0_b1 vbp_syn 0.32748f
C1639 r2_b3 Xi3/m1_988_3464# 0.04379f
C1640 ua0_stim_out Xm/iint 0.11983f
C1641 r0_b1 ua0_stim_out 0.19263f
C1642 Xm/in_p Xr/vgln 0.04955f
C1643 Xi4/a_528_4170# vth_cmp 0.04636f
C1644 r2_b3 r1_b0 0.07526f
C1645 Xi2/g Xi2/m1_988_2644# -0.15805f
C1646 vbp_w vbp_st 0.15293f
C1647 vdd Xi2/a_2432_4170# 0.00147f
C1648 Xg/a_3036_4156# vbn_leak 0.04079f
C1649 Xi3/g Xg/a_3036_4156# 0.04938f
C1650 Xr/vsp Xi0/m1_988_2804# -0.01357f
C1651 Xi3/g vdd 1.35979f
C1652 Xr/vsn Xi4/m1_988_2644# -0.01378f
C1653 r1_b4 Xg/m1_6020_10200# 0.02233f
C1654 vdd vbn_leak 1.7803f
C1655 v0_c3 ib_x2 0.04377f
C1656 r1_b3 r0_b0 0.09024f
C1657 Xvi/m1_5388_6960# i4_b3 0.13441f
C1658 Xr/vsp Xi1/m1_988_2804# -0.04662f
C1659 Xvi/a_864_6450# Xm/iint 0.09156f
C1660 vbn_leak Xi1/g 0.05235f
C1661 vdd Xd3/m1_5422_4448# 0.16799f
C1662 Xi3/g Xi1/g 0.04364f
C1663 bias_en Xvi/a_2102_5152# 0.04789f
C1664 r2_b3 r2_b2 0.33082f
C1665 Xr/vsp vreset_src 0.59738f
C1666 Xi2/a_528_4170# r0_b3 0.00198f
C1667 Xi1/a_1378_4392# Xi1/a_732_4392# -0.00261f
C1668 Xm/iint Xm/in_n 1.09298f
C1669 r2_b3 r1_b4 0.05713f
C1670 vbn_leak Xi0/a_528_4392# 0.00636f
C1671 Xd3/a_4584_3816# v0_c3 0.06862f
C1672 Xr/en_b Xm/a_736_7228# -0.00166f
C1673 Xi0/m1_988_888# bias_en 0.02549f
C1674 Xi3/a_2228_4392# Xi2/g 0
C1675 r1_b3 vbn_leak 0.04883f
C1676 Xi3/g r1_b3 0
C1677 v0_c0 Xr/vgln 0.07504f
C1678 Xd2/m1_596_2880# el 0.00272f
C1679 Xi0/m1_988_3464# Xr/vgln 0.0016f
C1680 r1_b1 Xi2/g 0.02471f
C1681 Xr/vsn ib_x2 1.68831f
C1682 Xg/m1_5516_1920# Xg/a_1580_5314# -0.00174f
C1683 r0_b4 Xd0/a_3408_3416# -0
C1684 Xd3/m1_822_4448# vbp_st 0.00257f
C1685 ua0_stim_out Xi1/m1_988_888# 0.02356f
C1686 vbn_ref i0_b4 0.00174f
C1687 Xi1/a_732_4392# Xm/in_p 0.00369f
C1688 vdd Xi1/a_2432_4392# 0
C1689 vbp_w Xd1/a_3048_3416# 0.00694f
C1690 Xr/vglp vth_cmp 0.60538f
C1691 Xi0/m1_240_3480# Xm/in_n 0.0021f
C1692 r2_b4 r0_b4 0.07004f
C1693 Xr/vsn Xg/a_1580_5314# -0.03304f
C1694 Xi2/m1_988_888# r0_b4 0.01511f
C1695 i4_b2 i2_b2 0.04766f
C1696 ua0_s0 ib_x2 0.0271f
C1697 Xr/vgln Xvi/m1_942_738# 0.01432f
C1698 Xr/vsn Xi2/m1_1500_3762# -0
C1699 i4_b1 Xg/a_7580_5314# 0.09461f
C1700 Xm/in_p ua0_stim_out 1.87605f
C1701 vbn_ref r0_b4 0.21081f
C1702 i4_b0 i3_b3 0.02615f
C1703 Xvi/a_5712_1328# vreset_src 0.08824f
C1704 Xd0/a_1040_3416# vth_cmp 0.00428f
C1705 r2_b1 Xi4/m1_988_3304# 0
C1706 i3_b3 Xg/a_4580_5314# 0.09363f
C1707 r2_b4 r0_b3 0.15969f
C1708 vdd r2_b1 1.1304f
C1709 i0_b4 Xr/vgln 0.31821f
C1710 Xg/a_1580_5314# i3_b2 0.09689f
C1711 v0_c2 bias_en 0.29433f
C1712 Xd3/a_4584_3816# ua0_s0 0.00299f
C1713 vbn_ref r0_b3 0.30196f
C1714 vbn_ref i4_b3 0.05575f
C1715 Xd1/a_1272_3416# vreset_src 0.00292f
C1716 vreset_src Xd2/a_3048_3416# 0.01244f
C1717 r2_b1 Xi1/g 0
C1718 i4_b1 Xi0/g 0.40524f
C1719 i4_b0 el 0
C1720 r0_b4 Xr/vgln 0.16206f
C1721 i3_b2 i1_b1 0.04942f
C1722 Xi2/a_3078_4170# r0_b4 0
C1723 Xr/vsp Xi1/m1_240_3480# -0.04666f
C1724 Xg/m1_3666_9610# Xr/vglp -0.02365f
C1725 Xvi/m1_7102_850# Xr/vglp 0.19289f
C1726 Xm/in_p Xm/in_n 0.01033f
C1727 i2_b4 i2_b3 0.27305f
C1728 Xi4/a_2228_4170# el 0.00145f
C1729 r1_b3 r2_b1 0.14591f
C1730 i4_b4 i3_b4 0.03234f
C1731 Xvi/m1_4894_1238# Xm/iint 0.00157f
C1732 r0_b2 r2_b0 0.36149f
C1733 Xr/vgln i4_b3 0.72076f
C1734 ua0_stim_out Xd3/m1_3908_2760# 0.07862f
C1735 Xr/vgln r0_b3 0.02734f
C1736 vth_ref Xi0/g 0.12383f
C1737 v0_c0 ua0_stim_out 0.40263f
C1738 Xi3/m1_988_888# Xr/vgln 0.19181f
C1739 Xi0/a_2432_4392# Xi0/a_3282_4392# -0
C1740 vdd v0_c3 0.56942f
C1741 r0_b4 i2_b1 0.03143f
C1742 Xd3/a_1624_3816# v0_c1 -0.05039f
C1743 Xi1/a_1582_4392# i0_b1 0.00715f
C1744 r2_b1 Xd2/a_1272_3416# 0.00352f
C1745 ua0_s1 ua0_int 0.68155f
C1746 Xd3/m1_3222_4448# v0_c3 0
C1747 vdd Xm/a_1744_10100# 0
C1748 Xi1/m1_1500_4312# Xi1/a_2228_4392# -0
C1749 r0_b0 vbn_leak 0.03824f
C1750 Xg/m1_5516_1920# vdd -0.00141f
C1751 i4_b1 vbp_st 0.03536f
C1752 r0_b3 i2_b1 0.49133f
C1753 Xg/m1_5022_10210# Xg/m1_6020_10200# -0.0182f
C1754 Xi1/a_528_4392# Xm/in_p 0.00176f
C1755 Xr/vglp i2_b2 0.05935f
C1756 r2_b0 Xd1/a_1272_3416# 0.05183f
C1757 r2_b0 Xd0/m1_2742_3250# 0.05593f
C1758 Xi3/a_3928_4392# Xr/vgln 0.03756f
C1759 Xr/vsn Xg/a_3036_4156# -0
C1760 i0_b4 ua0_stim_out 0.03705f
C1761 i1_b0 i1_b1 -0.00569f
C1762 r2_b0 Xd2/a_3048_3416# 0.05736f
C1763 Xi4/a_3928_4170# r2_b1 0
C1764 Xi0/g Xi0/m1_1500_4312# -0.00638f
C1765 i3_b1 r1_b2 0.13724f
C1766 Xr/vgln Xg/m1_6282_1450# 0.02169f
C1767 Xi3/a_3282_4392# i3_b3 0
C1768 Xi0/a_1582_4392# i0_b1 -0
C1769 vdd Xr/vsn 1.71875f
C1770 Xr/vsn Xvi/m1_4546_7560# 0.01876f
C1771 vbn_ax Xi2/g 0.05487f
C1772 vbp_w i4_b1 0.20931f
C1773 Xr/m1_2542_438# Xm/in_n 0.06487f
C1774 Xg/a_3036_4156# i3_b2 0.0382f
C1775 vdd Xd3/m1_4102_4448# 0.02338f
C1776 r0_b4 ua0_stim_out 0.03541f
C1777 bias_en Xm/a_736_7228# 0.00351f
C1778 vth_ref vbp_st 0.3206f
C1779 Xi1/a_3282_4392# Xr/vgln 0.00593f
C1780 Xi4/g Xvi/m1_942_738# 0.2127f
C1781 Xr/en_b vbp_st 0.18966f
C1782 Xi3/g vbn_leak 0.16808f
C1783 vdd i3_b2 0.7393f
C1784 vdd ua0_s0 0.52368f
C1785 Xr/vsp Xi2/m1_988_888# 0
C1786 Xd0/m1_3310_2880# el 0.06671f
C1787 Xr/vsn Xi0/a_528_4392# 0
C1788 Xd3/m1_3222_4448# ua0_s0 0.31162f
C1789 r0_b3 vbp_syn 0.08025f
C1790 Xg/m1_4906_9490# ua0_stim_out 0.02986f
C1791 ua0_stim_out i4_b3 0.05263f
C1792 r0_b3 ua0_stim_out 0.30402f
C1793 i4_b0 Xg/m1_6020_10200# 0.03924f
C1794 Xr/vsp vbn_ref 0.0371f
C1795 vbn_ref i0_b0 0.04002f
C1796 Xvi/a_4976_1528# Xvi/m1_1382_738# -0.00442f
C1797 r1_b3 Xr/vsn 0.10163f
C1798 Xd3/a_3400_3816# Xd3/a_2808_3816# -0.08321f
C1799 el vth_cmp 1.15336f
C1800 i3_b2 Xi1/g 0.09967f
C1801 r0_b2 Xd0/a_3408_3416# 0.00966f
C1802 Xg/a_1580_5314# i3_b0 0.14541f
C1803 i4_b2 Xm/in_p 0.09604f
C1804 Xi2/g i4_b4 0.32818f
C1805 Xd2/a_1864_3416# vbn_prb 0.00882f
C1806 Xr/vglp Xm/iint 0.14129f
C1807 r0_b2 r2_b4 0.1059f
C1808 i1_b1 i3_b0 0
C1809 i1_b3 i0_b3 0.39402f
C1810 r2_b3 i4_b0 0.75842f
C1811 v0_c4 v0_c3 0.21008f
C1812 r0_b2 vbn_ref 0.03825f
C1813 Xd0/a_1040_3416# r0_b1 0.01941f
C1814 Xr/vgln i0_b0 0.01981f
C1815 Xr/vsp Xr/vgln 0.40326f
C1816 Xi4/g i4_b3 0.17548f
C1817 Xvi/a_864_6450# i4_b3 0.48178f
C1818 Xi1/a_1378_4392# i0_b1 0.05136f
C1819 Xi4/m1_1500_3762# el 0.05942f
C1820 v0_c1 Xd3/m1_4078_3250# 0.0237f
C1821 i4_b3 Xm/in_n 0.04653f
C1822 i0_b1 Xi1/m1_988_888# 0.18035f
C1823 Xvi/m1_1382_738# vbn_prb 0.00775f
C1824 Xi4/a_4132_4170# i4_b3 0.01768f
C1825 Xr/vglp Xi0/m1_240_3480# 0.01462f
C1826 Xd0/a_3408_3416# Xd0/m1_2742_3250# -0
C1827 r1_b0 Xi2/g 0
C1828 i1_b0 vdd 0.00202f
C1829 Xvi/m1_7102_850# el 0.04635f
C1830 Xi0/a_2432_4392# vdd 0.03801f
C1831 i2_b3 Xi2/a_3282_4170# 0.002f
C1832 r2_b4 Xd1/a_1272_3416# 0.15903f
C1833 r2_b4 Xd0/m1_2742_3250# 0.02509f
C1834 Xi3/g r2_b1 0.17388f
C1835 r2_b1 vbn_leak 0.03603f
C1836 r2_b4 Xd2/a_3048_3416# 0.06004f
C1837 Xd1/m1_2862_4048# el 0.0023f
C1838 Xr/en_b Xd3/m1_822_4448# 0.00517f
C1839 Xm/in_p i0_b1 0.07898f
C1840 Xi3/a_3078_4392# i3_b3 0.00149f
C1841 i3_b1 Xg/a_7580_5314# 0.131f
C1842 bias_en Xi0/g 0.5924f
C1843 Xvi/a_5712_1328# Xr/vgln 0.04015f
C1844 vbp_w Xd0/m1_822_4048# 0
C1845 r0_b4 Xi2/m1_260_2080# 0.04757f
C1846 Xi1/a_3078_4392# Xr/vgln 0.00734f
C1847 Xi3/a_2432_4392# r1_b2 0.0223f
C1848 Xi2/g r2_b2 0.06837f
C1849 v0_c4 ua0_s0 0.06649f
C1850 i0_b4 Xi0/a_4132_4392# 0.00106f
C1851 vdd Xm/a_1744_9182# -0.00706f
C1852 Xm/in_n Xg/m1_6282_1450# 0.02055f
C1853 Xi0/a_3928_4392# ib_x2 0.0032f
C1854 r1_b4 Xi2/g 0.65399f
C1855 i3_b1 Xi0/g 0.2196f
C1856 Xi1/a_1582_4392# i3_b3 0
C1857 Xi4/a_3078_4170# vreset_src 0.11673f
C1858 vbn_prb Xd1/m1_2974_2650# 0.01123f
C1859 Xd3/m1_2720_2760# ua0_s0 0.09618f
C1860 r0_b3 Xi2/m1_260_2080# 0.01044f
C1861 i4_b4 Xvi/a_4976_1528# 0.14363f
C1862 ua0_s1 Xd3/m1_3908_2760# 0.07658f
C1863 Xr/vsp Xi1/a_732_4392# 0
C1864 Xm/in_p Xr/vglp 0.59679f
C1865 vbn_ax vbn_prb 0
C1866 Xd0/m1_956_3000# vbp_w 0.05534f
C1867 Xd3/m1_2408_3600# Xm/in_p 0.05051f
C1868 Xg/a_3036_4156# i3_b0 0.04713f
C1869 v0_c0 ua0_s1 0.33467f
C1870 vdd Xi2/m1_988_3304# -0.02092f
C1871 ua0_stim_out i0_b0 0.04484f
C1872 Xr/vsp ua0_stim_out 0.54366f
C1873 vdd i3_b0 1.93678f
C1874 r2_b1 Xi4/m1_988_888# 0.32677f
C1875 r2_b3 Xi3/a_3282_4392# 0.00451f
C1876 Xd3/m1_5422_4448# v0_c3 0.00232f
C1877 Xd2/m1_2964_2640# vbn_prb 0.05631f
C1878 bias_en vbp_st 0.15019f
C1879 i3_b0 Xi1/g 0.0773f
C1880 r0_b2 vbp_syn 0.03951f
C1881 r2_b3 vth_cmp 0.05281f
C1882 vbn_prb Xd0/m1_617_3840# 0.12939f
C1883 Xi3/g Xg/m1_5516_1920# 0.00136f
C1884 i0_b3 Xi1/m1_988_2804# 0.29383f
C1885 r0_b2 ua0_stim_out 0.04459f
C1886 ua0_s1 ua0 0.02432f
C1887 r1_b1 Xi4/a_2432_4170# 0.01472f
C1888 r1_b3 Xi2/m1_988_3304# 0.21468f
C1889 i3_b1 vbp_st 0.07756f
C1890 i4_b2 i4_b3 0.01632f
C1891 r1_b3 i3_b0 0.00116f
C1892 Xr/vsp Xi4/g 0
C1893 Xi3/g Xr/vsn 0.725f
C1894 Xr/vsn vbn_leak 0.28771f
C1895 Xr/vsp Xm/in_n 0.08814f
C1896 Xi1/m1_1500_4312# i0_b2 0.07077f
C1897 Xi3/m1_988_888# i4_b2 0.01559f
C1898 el Xm/iint 0.1108f
C1899 v0_c0 Xd3/m1_2408_3600# 0.02153f
C1900 vbn_leak i3_b2 0.64878f
C1901 Xi3/g i3_b2 0.17595f
C1902 r2_b3 Xi4/m1_1500_3762# 0
C1903 Xd1/m1_1780_5040# Xd1/m1_2974_2650# -0.0014f
C1904 r2_b4 i2_b3 0
C1905 Xr/m1_1662_438# vreset_src 0
C1906 Xi3/a_2228_4392# r1_b2 0.02501f
C1907 Xd3/m1_5422_4448# ua0_s0 0.05172f
C1908 vbn_ref i2_b3 0.81257f
C1909 r2_b0 Xd0/m1_3662_4048# 0
C1910 vdd i2_b0 0.39796f
C1911 Xi1/a_1378_4392# i3_b3 0
C1912 vbn_prb Xd1/m1_2372_2520# 0.03301f
C1913 Xg/a_1580_5314# Xg/a_5188_4156# -0
C1914 Xd0/m1_2242_4966# el 0.0063f
C1915 i4_b0 i3_b4 0.0482f
C1916 Xg/m1_3898_9610# ua0_stim_out 0.01303f
C1917 r1_b1 r1_b2 0.61421f
C1918 Xi4/a_1582_4170# el 0
C1919 Xvi/a_5712_1328# Xi4/g 0
C1920 Xd0/m1_1262_4048# el 0.01557f
C1921 Xr/en_b vth_ref 0.10437f
C1922 i3_b4 Xg/a_4580_5314# 0.07251f
C1923 i3_b3 Xi1/m1_988_888# 0
C1924 Xr/vsp Xi1/a_528_4392# 0.00454f
C1925 i2_b0 Xi1/g 0.0043f
C1926 Xd3/m1_1523_3480# Xm/in_p 0.00242f
C1927 Xi1/a_528_4392# i0_b0 0
C1928 Xi3/m1_1500_4312# r1_b2 0.01055f
C1929 Xi0/a_3928_4392# vdd 0.00669f
C1930 Xi1/m1_1500_4312# i3_b4 0
C1931 r2_b2 vbn_prb 0.00472f
C1932 Xr/vsn Xi4/m1_988_888# 0.04419f
C1933 Xr/vgln i2_b3 0.05981f
C1934 Xi3/m1_240_3480# r1_b2 0.15412f
C1935 Xg/a_1580_5314# Xg/m1_4538_1930# -0.00316f
C1936 Xm/in_p i3_b3 0.054f
C1937 Xi2/a_1582_4170# i2_b0 0
C1938 Xi2/a_3078_4170# i2_b3 0.00466f
C1939 r1_b3 i2_b0 0.10467f
C1940 r2_b3 Xi3/a_3078_4392# 0.00388f
C1941 vbp_w Xd0/a_2224_3416# 0.06026f
C1942 r2_b3 i2_b2 0.03821f
C1943 r2_b1 Xr/vsn 0.62257f
C1944 Xi0/a_3928_4392# Xi1/g 0
C1945 Xi1/m1_240_3480# i0_b3 0.01835f
C1946 Xg/m1_4906_9490# Xr/vglp -0.03894f
C1947 Xvi/m1_502_738# vbn_prb 0.00122f
C1948 Xr/vglp i4_b3 0.71626f
C1949 Xd3/a_3400_3816# ua0_stim_out 0
C1950 r0_b2 Xi2/m1_260_2080# 0
C1951 Xr/vsp Xi0/a_4132_4392# 0.00256f
C1952 r2_b1 i3_b2 0.03332f
C1953 i2_b3 i2_b1 0.00124f
C1954 r1_b0 Xd1/m1_1780_5040# 0
C1955 Xr/vsp i4_b2 0.30802f
C1956 v0_c0 Xd3/m1_1523_3480# 0
C1957 Xd2/m1_756_3240# vbn_prb 0.19019f
C1958 vreset_src Xi4/m1_988_2644# 0.02513f
C1959 Xi4/a_3282_4170# vth_cmp 0.03623f
C1960 Xd1/m1_1780_5040# Xd1/m1_2372_2520# -0
C1961 vdd Xg/m1_3530_1930# -0.00275f
C1962 v0_c5 bias_en 0.04852f
C1963 v0_c1 ua0_stim 0.06245f
C1964 Xi1/a_2228_4392# Xm/in_p 0
C1965 Xr/vglp Xg/m1_6282_1450# 0.09073f
C1966 Xi0/m1_988_2804# ib_x2 0.07743f
C1967 Xm/a_420_700# ua0_stim_out -0.0055f
C1968 i4_b0 Xi2/g 0.02313f
C1969 r1_b1 Xg/a_7580_5314# 0.02231f
C1970 Xg/a_3036_4156# Xg/a_5188_4156# -0
C1971 ua0_s0 v0_c3 0.04173f
C1972 r2_b2 Xd1/m1_1780_5040# 0.10511f
C1973 Xvi/m1_8332_7080# vth_ref 0.00722f
C1974 Xi2/g Xg/a_4580_5314# -0.0037f
C1975 vbn_leak i3_b0 0.6504f
C1976 Xd3/m1_4982_4448# ua0_stim_out 0.10865f
C1977 i2_b3 ua0_stim_out 0.18588f
C1978 Xi3/g i3_b0 0.17274f
C1979 Xi4/a_3078_4170# Xr/vgln 0.00206f
C1980 vdd Xg/a_5188_4156# -0.04554f
C1981 Xg/m1_5516_1920# Xr/vsn 0.03956f
C1982 Xi1/a_4132_4392# Xr/vgln 0.00371f
C1983 i0_b4 i3_b3 0.04782f
C1984 Xr/vsp i0_b1 0.36196f
C1985 i1_b3 vdd 0.00256f
C1986 Xd1/m1_606_2410# Xd1/m1_756_3120# -0.00397f
C1987 vreset_src ib_x2 0.48798f
C1988 i0_b1 i0_b0 0
C1989 Xg/a_5188_4156# Xi1/g -0.00458f
C1990 vbn_ax r1_b2 0.12619f
C1991 r2_b3 Xi4/a_1582_4170# 0.00232f
C1992 Xd1/m1_462_4048# vreset_src 0.22106f
C1993 ib_r1 vreset_src 0.08867f
C1994 vdd Xg/m1_4538_1930# -0.0055f
C1995 Xi2/m1_988_2644# vbp_st 0.14056f
C1996 vbn_ref i0_b3 0.03953f
C1997 Xvi/m1_942_738# el 0.06207f
C1998 r0_b4 i3_b3 0.08277f
C1999 Xi0/a_3078_4392# Xi1/m1_988_888# 0
C2000 Xr/vsn i3_b2 0.22373f
C2001 vdd i2_b4 1.57466f
C2002 ua0_stim Xm/a_2240_11218# 0
C2003 r2_b3 Xi3/m1_988_2804# 0.15968f
C2004 i3_b1 i4_b1 0.07532f
C2005 Xi4/a_1378_4170# el 0
C2006 i4_b4 Xvi/m1_1276_6360# 0.10645f
C2007 Xm/in_p Xd3/m1_1262_4448# 0.04688f
C2008 Xr/en_b bias_en 0.34361f
C2009 bias_en vth_ref 0.16633f
C2010 Xd3/m1_4102_4448# ua0_s0 0.0484f
C2011 Xr/vsp Xr/vglp 0.9298f
C2012 i2_b0 Xi2/a_2432_4170# 0
C2013 Xm/in_p Xg/m1_6020_10200# 0.04862f
C2014 i2_b4 Xi1/g 0.10043f
C2015 vdd Xm/a_1764_11418# 0
C2016 i3_b3 i4_b3 0.05361f
C2017 Xr/vgln i0_b3 0.21981f
C2018 Xd3/a_1624_3816# v0_c0 0.14516f
C2019 Xi1/a_1582_4392# i0_b2 0
C2020 Xd2/m1_596_2880# vbn_prb 0.20858f
C2021 r2_b1 i3_b0 0.04799f
C2022 r1_b3 i2_b4 0.13657f
C2023 r1_b1 vbp_st 0.21448f
C2024 el i4_b3 0.0316f
C2025 vth_ref Xr/m1_342_438# 0.03623f
C2026 Xr/en_b Xr/m1_342_438# -0.00967f
C2027 Xi3/m1_988_3464# r1_b2 0.01523f
C2028 bias_en Xi0/m1_1500_4312# 0.01142f
C2029 Xvi/a_5712_1328# Xr/vglp -0
C2030 r1_b0 r1_b2 0.05816f
C2031 Xi2/g vth_cmp 0
C2032 Xi3/a_4132_4392# Xr/vgln 0.03469f
C2033 Xi3/a_3928_4392# i3_b3 0
C2034 r1_b1 vbp_w 0.05452f
C2035 Xm/in_p Xd3/m1_4078_3250# 0.00649f
C2036 Xi1/a_3928_4392# Xr/vgln 0.00794f
C2037 Xi3/a_1582_4392# r1_b2 0.01962f
C2038 Xi0/m1_988_2804# vdd -0.00172f
C2039 Xi1/a_1582_4392# i3_b4 0.00252f
C2040 Xd3/a_3400_3816# ua0_s1 0.06669f
C2041 i1_b0 i3_b2 0.06674f
C2042 Xi4/a_3078_4170# Xi4/g -0.00118f
C2043 Xi3/a_732_4392# r1_b2 0.02795f
C2044 r1_b0 Xi2/a_732_4170# 0.00205f
C2045 vdd Xi1/m1_988_2804# 0.08005f
C2046 r2_b2 r1_b2 0.00675f
C2047 Xi3/m1_240_3480# vbp_w 0.00678f
C2048 Xg/m1_3898_9610# Xr/vglp -0.00158f
C2049 vreset_src Xi4/m1_988_3304# 0.04186f
C2050 vdd vreset_src 1.30426f
C2051 vdd Xd3/m1_382_4448# 0.35687f
C2052 i0_b3 ua0_stim_out 0.04808f
C2053 r1_b4 r1_b2 0.31697f
C2054 r2_b1 i2_b0 0.12722f
C2055 Xi1/m1_988_2804# Xi1/g -0.1254f
C2056 i4_b2 i2_b3 0.16391f
C2057 bias_en Xvi/m1_8332_7080# 0.09068f
C2058 r1_b0 Xd1/a_2456_3416# 0.06242f
C2059 Xi3/g Xg/m1_3530_1930# 0.00292f
C2060 Xr/vsn Xi2/m1_988_3304# -0.00857f
C2061 Xr/vsn i3_b0 0.30024f
C2062 Xd3/m1_4078_3250# Xd3/m1_3908_2760# -0.00162f
C2063 Xi2/a_732_4170# r2_b2 0.00647f
C2064 Xi1/a_1378_4392# i0_b2 0
C2065 i4_b4 Xg/a_7580_5314# 0.13004f
C2066 Xr/vgln Xi0/a_2228_4392# 0.04939f
C2067 Xr/vsp i3_b3 0.47498f
C2068 v0_c0 Xd3/m1_4078_3250# 0.10009f
C2069 i3_b3 i0_b0 0.20049f
C2070 ua0_s1 Xm/a_420_700# 0.17818f
C2071 r2_b3 Xi4/a_1378_4170# 0
C2072 i0_b2 Xi1/m1_988_888# 0.21851f
C2073 Xvi/m1_8646_1098# bias_en 0
C2074 i3_b2 i3_b0 0.75527f
C2075 Xi3/g Xg/a_5188_4156# 0.15872f
C2076 ua0_s1 Xd3/m1_4982_4448# 0
C2077 vdd Xi2/a_3282_4170# 0.00191f
C2078 Xg/m1_4906_9490# Xg/m1_6020_10200# -0
C2079 Xvi/a_4976_1528# vth_cmp 0.21077f
C2080 vbn_leak Xg/a_5188_4156# 0.07396f
C2081 r2_b2 Xd1/a_2456_3416# 0.05362f
C2082 Xr/m1_3422_438# Xm/iint 0.00141f
C2083 Xi3/a_3078_4392# Xi2/g 0
C2084 i4_b4 Xi0/g 0.18317f
C2085 Xm/in_p i0_b2 0.04807f
C2086 Xi1/a_3928_4392# ua0_stim_out 0
C2087 r2_b3 r0_b4 0.65206f
C2088 r1_b4 Xd1/a_2456_3416# 0.00175f
C2089 Xd3/a_2216_3816# vdd 0.01065f
C2090 vdd Xd3/a_2808_3816# 0.00882f
C2091 Xd3/m1_3222_4448# Xd3/a_2808_3816# -0.05301f
C2092 Xd3/a_2216_3816# Xd3/m1_3222_4448# -0.00366f
C2093 vdd r2_b0 0.67837f
C2094 Xd3/a_3992_3816# vdd 0.0153f
C2095 Xi3/g Xg/m1_4538_1930# 0
C2096 vbn_ax vbp_st 0.06857f
C2097 Xi1/a_1378_4392# i3_b4 0.03297f
C2098 r2_b3 r0_b3 0.01453f
C2099 Xr/m1_1662_438# Xm/in_n 0.09281f
C2100 Xi3/a_1378_4392# r1_b2 0.02665f
C2101 vbp_w Xd1/m1_2974_2650# 0.00253f
C2102 Xi3/a_528_4392# r1_b2 0.03433f
C2103 Xd0/m1_3310_2880# vbn_prb 0.05007f
C2104 vdd Xi1/m1_240_3480# 0.04595f
C2105 Xi3/g i2_b4 0.09231f
C2106 Xi1/a_3078_4392# i3_b3 0
C2107 Xi4/a_3928_4170# vreset_src 0.05295f
C2108 Xr/vgln ib_x2 0.52024f
C2109 Xr/vgln Xi0/a_3282_4392# 0.00128f
C2110 r1_b3 Xi2/a_3282_4170# 0.01518f
C2111 r2_b3 Xi3/m1_988_888# 0.15415f
C2112 vbn_ref i1_b1 -0.0045f
C2113 ib_r1 Xr/vgln 0.73201f
C2114 vbn_prb vth_cmp 0.55957f
C2115 vbn_ax vbp_w 0.83952f
C2116 Xi1/m1_240_3480# Xi1/g 0.18735f
C2117 vdd Xvi/m1_5388_6960# -0.02524f
C2118 Xg/a_1580_5314# Xr/vgln -0.01234f
C2119 ua0_stim ua0_int 0.87734f
C2120 Xr/vglp i2_b3 0.09627f
C2121 Xvi/m1_5388_6960# Xvi/m1_4546_7560# -0
C2122 r1_b3 r2_b0 0
C2123 Xr/vgln Xi2/m1_1500_3762# 0.08098f
C2124 r1_b4 Xg/a_7580_5314# 0
C2125 Xm/in_p i3_b4 0.50536f
C2126 Xvi/a_5712_1328# el 0.04568f
C2127 Xi2/a_528_4170# vdd 0.01573f
C2128 i1_b0 i3_b0 0.127f
C2129 i4_b4 vbp_st 0.03651f
C2130 Xd1/a_680_3416# Xd1/m1_756_3120# -0.00392f
C2131 Xg/a_1580_5314# Xg/m1_4760_1320# -0
C2132 r2_b3 Xi3/a_3928_4392# 0.00137f
C2133 Xr/vgln i1_b1 -0.01601f
C2134 Xi3/a_2228_4392# i4_b1 0
C2135 v0_c2 v0_c1 0.74468f
C2136 Xd2/a_1272_3416# r2_b0 0.04822f
C2137 r1_b1 i4_b1 0.13825f
C2138 vreset_src Xvi/m1_8042_6360# 0.15576f
C2139 vbp_w Xd0/m1_617_3840# 0.1175f
C2140 el Xd0/m1_2742_3250# 0.09892f
C2141 Xi0/a_3928_4392# Xr/vsn 0
C2142 el Xd2/a_3048_3416# 0.19733f
C2143 r1_b4 Xi0/g 0
C2144 vdd Xd3/m1_1702_4448# 0.01546f
C2145 r1_b0 vbp_st 0.05538f
C2146 Xi3/m1_1500_4312# i4_b1 0.02511f
C2147 Xi2/a_528_4170# r1_b3 0
C2148 Xd1/m1_2862_4048# vbn_prb 0.05826f
C2149 Xd3/m1_3222_4448# Xd3/m1_1702_4448# -0.01015f
C2150 Xg/m1_5022_10210# r1_b2 0.16991f
C2151 Xi4/g Xi4/m1_988_2644# -0.05048f
C2152 Xi3/m1_240_3480# i4_b1 0.04824f
C2153 Xi0/m1_988_2804# vbn_leak -0
C2154 vdd Xd0/a_3408_3416# 0.05434f
C2155 Xr/vsp Xi0/a_3078_4392# 0
C2156 r2_b1 i2_b4 0.03652f
C2157 v0_c0 i3_b4 0.02392f
C2158 Xd3/a_3992_3816# v0_c4 0.02364f
C2159 Xr/vsp Xg/m1_6020_10200# -0.01393f
C2160 r1_b1 Xd1/m1_756_3120# -0
C2161 r2_b4 vdd 1.58961f
C2162 Xd3/a_2216_3816# Xd3/m1_2720_2760# -0
C2163 Xd3/m1_2720_2760# Xd3/a_2808_3816# -0.01906f
C2164 Xi2/m1_988_888# vdd 0.00158f
C2165 ua0_stim_out ib_x2 0.12856f
C2166 r1_b0 vbp_w 0.02656f
C2167 Xd1/m1_1780_5040# vth_cmp 0.06185f
C2168 r2_b2 vbp_st 0.41854f
C2169 vdd vbn_ref 1.53019f
C2170 Xvi/a_2102_5152# vth_cmp 0.13109f
C2171 r2_b3 Xr/vsp 0.35428f
C2172 Xg/a_1580_5314# ua0_stim_out 0
C2173 Xr/vsn Xg/m1_3530_1930# 0.05956f
C2174 r1_b4 vbp_st 0.3162f
C2175 Xi1/a_732_4392# i1_b1 -0.04775f
C2176 i0_b4 i3_b4 0.05099f
C2177 vbn_ref Xi1/g 0.08486f
C2178 Xi4/g ib_x2 0.07901f
C2179 r2_b4 r1_b3 0.01138f
C2180 Xvi/a_864_6450# ib_x2 0.59721f
C2181 vbp_w r2_b2 0.27794f
C2182 i4_b0 r1_b2 0.14501f
C2183 r1_b2 Xg/a_4580_5314# 0
C2184 Xi2/m1_988_888# r1_b3 0.03994f
C2185 Xm/in_p i1_b4 0
C2186 Xi2/a_3928_4170# i2_b3 0
C2187 vdd Xr/vgln 3.29076f
C2188 Xd2/m1_1342_4048# vth_cmp 0.00144f
C2189 Xd1/a_680_3416# Xd1/m1_606_2410# -0.01481f
C2190 Xd1/m1_462_4048# Xd1/m1_860_4046# -0.03882f
C2191 ib_r1 Xvi/a_864_6450# -0.0129f
C2192 vbp_w r1_b4 0.04072f
C2193 ib_x2 Xm/in_n 0.23771f
C2194 Xr/vsn Xg/a_5188_4156# -0.05926f
C2195 Xi2/a_3078_4170# vdd 0.00547f
C2196 r1_b3 vbn_ref 0.03846f
C2197 i4_b3 Xi4/a_3282_4170# 0.01673f
C2198 r1_b0 Xd1/a_3048_3416# 0.05511f
C2199 r2_b0 r0_b0 0.20117f
C2200 Xi3/a_2432_4392# i3_b1 0.00121f
C2201 r0_b4 i3_b4 0.20072f
C2202 Xi4/g Xg/a_1580_5314# -0.04393f
C2203 ib_r1 Xm/in_n 0.00397f
C2204 vdd Xg/m1_4760_1320# 0.00125f
C2205 Xr/vgln Xi1/g 0.00767f
C2206 Xg/m1_5516_1920# Xg/m1_4538_1930# -0.04083f
C2207 i3_b2 Xg/a_5188_4156# 0.06437f
C2208 Xr/vgln Xi0/a_528_4392# 0.05948f
C2209 bias_en Xvi/m1_7440_2050# 0.06275f
C2210 Xr/vsn Xg/m1_4538_1930# 0.0335f
C2211 i4_b3 i3_b4 0.03486f
C2212 Xi2/a_1582_4170# Xr/vgln -0.00351f
C2213 i1_b3 i3_b2 0.03844f
C2214 Xi0/a_1378_4392# Xi1/m1_988_888# 0
C2215 r1_b3 Xr/vgln 0.02981f
C2216 vdd i2_b1 0.69296f
C2217 Xi4/m1_988_888# vreset_src 0.04934f
C2218 vbn_prb Xm/iint -0.00538f
C2219 r2_b2 Xd1/a_3048_3416# 0.0555f
C2220 r2_b0 vbn_leak 0.12374f
C2221 Xi2/a_3078_4170# r1_b3 0.13332f
C2222 Xi1/a_3282_4392# i0_b2 0
C2223 vbn_ax i4_b1 0
C2224 Xr/m1_782_438# Xm/iint 0.00667f
C2225 r2_b3 Xd2/a_3048_3416# 0
C2226 r2_b1 vreset_src 0.02979f
C2227 r1_b4 Xd1/a_3048_3416# 0.00749f
C2228 ua0_int Xm/a_736_5516# 0.05618f
C2229 i2_b4 i3_b2 0.11736f
C2230 Xi4/a_2432_4170# vth_cmp 0.02891f
C2231 Xr/m1_1662_438# Xr/vglp 0
C2232 v0_c0 ua0_stim 0.13802f
C2233 Xi2/a_1582_4170# i2_b1 -0
C2234 vdd Xi1/a_732_4392# -0.00557f
C2235 r1_b3 i2_b1 0.27612f
C2236 Xd0/m1_2242_4966# vbn_prb 0.02081f
C2237 Xi3/a_3928_4392# i3_b4 0.00162f
C2238 Xg/a_3036_4156# ua0_stim_out 0.01385f
C2239 Xd0/m1_1262_4048# vbn_prb 0.06214f
C2240 Xi1/a_528_4392# i1_b1 -0
C2241 vdd vbp_syn 0.36708f
C2242 Xvi/m1_1276_6360# vth_cmp 0
C2243 vdd ua0_stim_out 1.76254f
C2244 Xi0/a_4132_4392# ib_x2 0.00295f
C2245 Xi3/a_3282_4392# r1_b2 0.02178f
C2246 i4_b4 i4_b1 0.03161f
C2247 Xd3/m1_3222_4448# ua0_stim_out 0.07033f
C2248 Xr/vsp i0_b2 0.1782f
C2249 i0_b4 i1_b4 0.18721f
C2250 Xd2/a_680_3416# vdd -0.06141f
C2251 Xvi/m1_4894_1238# ib_x2 -0
C2252 r0_b0 Xd0/a_3408_3416# 0
C2253 i4_b0 Xg/a_7580_5314# 0.07424f
C2254 ua0_stim_out Xi1/g 0.54417f
C2255 ua0 ua0_stim 0.40244f
C2256 vth_cmp r1_b2 0
C2257 ib_r1 Xvi/m1_4894_1238# 0.01126f
C2258 r2_b4 r0_b0 0.06688f
C2259 Xi3/a_2228_4392# i3_b1 0.0084f
C2260 Xi4/g Xg/a_3036_4156# -0
C2261 Xi2/g r0_b4 0.05204f
C2262 Xi0/m1_988_2804# Xr/vsn 0.06349f
C2263 r1_b3 vbp_syn 0.01414f
C2264 Xi2/a_1582_4170# ua0_stim_out 0.0015f
C2265 vbn_ref r0_b0 0.20021f
C2266 i1_b0 i2_b4 0.00266f
C2267 r2_b1 r2_b0 0.22078f
C2268 vdd Xvi/a_864_6450# -0.12758f
C2269 Xi3/m1_988_3464# i4_b1 0.02318f
C2270 vdd Xi4/g 0.78604f
C2271 r1_b1 i3_b1 0.03582f
C2272 r1_b3 ua0_stim_out 0.10851f
C2273 i4_b0 Xi0/g 0.30198f
C2274 Xi4/a_3078_4170# el 0.06616f
C2275 Xvi/a_864_6450# Xvi/m1_4546_7560# -0.00526f
C2276 Xi4/g Xvi/m1_4546_7560# 0.06857f
C2277 vdd Xm/in_n 0.55383f
C2278 i4_b2 Xg/a_1580_5314# 0.13522f
C2279 Xi2/g r0_b3 0
C2280 Xi0/g Xg/a_4580_5314# 0.0977f
C2281 vbn_leak Xd0/a_3408_3416# 0.00214f
C2282 Xi2/g i4_b3 0.59285f
C2283 Xr/vsn vreset_src 0.07489f
C2284 r2_b4 vbn_leak 0.0339f
C2285 Xr/vsp i3_b4 0.21273f
C2286 Xi1/a_3078_4392# i0_b2 0.00597f
C2287 i0_b3 i3_b3 0.03431f
C2288 i3_b4 i0_b0 0.03291f
C2289 vdd Xi4/a_732_4170# 0
C2290 el Xd0/m1_3662_4048# 0.13663f
C2291 Xi2/m1_988_888# vbn_leak 0.14483f
C2292 Xg/m1_3666_9610# r1_b2 0.00127f
C2293 Xd2/m1_902_4048# vbn_prb 0.1818f
C2294 Xi0/m1_988_888# Xm/iint 0.46648f
C2295 Xg/a_5188_4156# i3_b0 0.03633f
C2296 Xi3/g vbn_ref 0.00513f
C2297 Xd2/a_680_3416# Xd2/a_1272_3416# -0.00301f
C2298 vbn_ref vbn_leak 0.66474f
C2299 Xd1/a_1864_3416# vdd -0
C2300 Xd3/a_2808_3816# v0_c3 0.04187f
C2301 r1_b0 Xd1/m1_756_3120# 0
C2302 Xd3/m1_382_4448# ua0_s0 0.05588f
C2303 ua0_s1 Xd3/a_4584_3816# 0.06789f
C2304 r2_b3 i2_b3 0.04397f
C2305 Xi3/a_3928_4392# Xi2/g 0
C2306 v0_c2 ua0_int 0.04393f
C2307 Xd3/a_3992_3816# v0_c3 0.05557f
C2308 Xr/vgln Xi2/a_2432_4170# 0.00328f
C2309 bias_en Xvi/m1_1382_738# 0.04896f
C2310 Xd1/m1_756_3120# Xd1/m1_2372_2520# -0.00159f
C2311 vbp_w Xd0/a_1632_3416# 0.04645f
C2312 vdd Xi2/m1_260_2080# 0.02266f
C2313 Xi2/g Xg/m1_6282_1450# 0.00607f
C2314 Xi3/g Xr/vgln 0.37297f
C2315 i4_b0 vbp_st 0.29955f
C2316 Xd2/a_2456_3416# r2_b0 0.07862f
C2317 vbn_leak Xr/vgln 0.2025f
C2318 Xd2/m1_1780_2760# Xd2/m1_2382_2650# -0.00675f
C2319 vbp_st Xg/a_4580_5314# 0.10052f
C2320 i2_b4 i3_b0 0.10126f
C2321 Xi1/a_528_4392# Xi1/g 0
C2322 Xi3/a_3078_4392# r1_b2 0.06105f
C2323 Xi3/g Xg/m1_4760_1320# 0
C2324 Xd3/m1_2720_2760# ua0_stim_out 0.06839f
C2325 i0_b1 i1_b1 0.27622f
C2326 Xi1/a_3078_4392# i3_b4 0
C2327 i2_b2 r1_b2 0.05934f
C2328 r2_b2 Xd1/m1_756_3120# 0.03364f
C2329 Xd1/a_1864_3416# r1_b3 0.00116f
C2330 Xr/vglp ib_x2 0.47853f
C2331 Xi1/a_3928_4392# i3_b3 0
C2332 vbp_w i4_b0 0.08148f
C2333 ib_r1 Xr/vglp 0.02254f
C2334 Xd0/m1_956_3000# Xd0/m1_617_3840# -0
C2335 vdd Xi0/a_4132_4392# 0.0023f
C2336 Xg/a_1580_5314# Xr/vglp 0.23725f
C2337 Xi1/a_2228_4392# i0_b3 0.00659f
C2338 Xvi/m1_942_738# vbn_prb 0
C2339 Xvi/a_4976_1528# i4_b3 0.04318f
C2340 Xd3/a_3992_3816# Xd3/m1_4102_4448# -0.0027f
C2341 r1_b3 Xi2/m1_260_2080# 0.1786f
C2342 r2_b4 r2_b1 0.05013f
C2343 r0_b0 vbp_syn 0.0383f
C2344 i4_b2 Xg/a_3036_4156# 0.2047f
C2345 Xd3/a_3992_3816# ua0_s0 0
C2346 vbn_ref r2_b1 0.03658f
C2347 i4_b2 vdd 1.03304f
C2348 r0_b0 ua0_stim_out 0.05292f
C2349 Xi1/a_2432_4392# Xr/vgln 0.00252f
C2350 Xi4/a_528_4170# vdd 0
C2351 Xi1/m1_240_3480# i3_b2 0
C2352 Xvi/a_864_6450# Xvi/m1_8042_6360# -0.00627f
C2353 Xr/vsp Xi2/g 0.02453f
C2354 Xi4/m1_988_888# Xr/vgln 0
C2355 vbn_ax i3_b1 0.01161f
C2356 i4_b2 Xi1/g 0.23731f
C2357 Xi2/a_2432_4170# ua0_stim_out 0.00484f
C2358 r2_b1 Xr/vgln 0.37535f
C2359 i2_b4 i2_b0 0
C2360 r2_b2 Xd0/m1_822_4048# 0
C2361 vbn_leak vbp_syn 0.09359f
C2362 Xi3/g ua0_stim_out 0.15544f
C2363 ua0_s1 vdd 0.91303f
C2364 Xm/a_736_7228# ua0_int 0.12594f
C2365 ua0_s1 Xd3/m1_3222_4448# 0.04899f
C2366 i1_b2 i0_b3 0.01674f
C2367 Xi0/a_3078_4392# i0_b3 -0.00394f
C2368 Xd3/m1_5422_4448# ua0_stim_out 0.00285f
C2369 vdd i0_b1 0.30735f
C2370 Xd2/a_2456_3416# r2_b4 0
C2371 Xd0/m1_956_3000# r2_b2 0.00415f
C2372 i4_b4 i3_b1 0.52937f
C2373 vbp_st vth_cmp 0.2725f
C2374 r1_b1 Xd1/a_680_3416# -0.02973f
C2375 r2_b1 i2_b1 0.0671f
C2376 el Xi4/m1_988_2644# 0.05335f
C2377 r2_b2 Xd1/m1_606_2410# 0.03036f
C2378 Xm/a_736_7228# Xm/iint 0.00157f
C2379 Xd0/m1_3310_2880# vbp_w 0.09197f
C2380 Xi3/g Xi4/g 0.22137f
C2381 i0_b1 Xi1/g 0.72983f
C2382 Xr/vsp Xi0/a_1378_4392# 0
C2383 Xd3/m1_1702_4448# ua0_s0 0.05505f
C2384 Xi3/m1_988_2804# r1_b2 0.00383f
C2385 Xi3/g Xm/in_n 0.05189f
C2386 Xg/a_3036_4156# Xr/vglp 0.1637f
C2387 v0_c1 v0_c5 0.57556f
C2388 Xr/vgln v0_c3 0.00567f
C2389 vbp_w vth_cmp 0.08852f
C2390 Xi2/m1_988_888# Xr/vsn 0.00151f
C2391 Xi1/a_2432_4392# ua0_stim_out 0
C2392 vdd Xr/vglp 1.86414f
C2393 vdd Xd3/m1_2408_3600# 0.07011f
C2394 Xi4/m1_260_2080# r2_b2 0
C2395 Xr/vglp Xvi/m1_4546_7560# -0.00353f
C2396 Xi0/g i2_b2 0
C2397 Xd0/a_1040_3416# vdd 0.08526f
C2398 Xd0/m1_617_3840# Xd0/a_2224_3416# -0
C2399 Xg/a_1580_5314# i3_b3 0.07077f
C2400 Xi2/m1_988_888# i3_b2 0.19319f
C2401 Xd3/m1_2408_3600# Xd3/m1_3222_4448# -0.01306f
C2402 Xg/m1_5516_1920# Xr/vgln 0.00713f
C2403 v0_c2 Xd3/m1_3908_2760# 0
C2404 Xr/vglp Xi1/g 0.6269f
C2405 Xi3/a_1582_4392# i3_b1 -0.00361f
C2406 v0_c2 v0_c0 1.12984f
C2407 vbn_ref i3_b2 0.03923f
C2408 r2_b1 ua0_stim_out 0.04928f
C2409 el ib_x2 0.85274f
C2410 Xm/in_p r1_b2 0.06058f
C2411 Xd1/m1_462_4048# el 0.10658f
C2412 r2_b3 Xi3/a_4132_4392# 0.00596f
C2413 Xr/vsn Xr/vgln 1.6738f
C2414 i3_b3 i1_b1 0.05548f
C2415 ib_r1 el 0.00749f
C2416 Xi2/a_3078_4170# Xr/vsn -0.00591f
C2417 Xd2/a_680_3416# r2_b1 -0.01535f
C2418 bias_en Xvi/m1_502_738# 0.16392f
C2419 Xvi/a_2102_5152# i4_b3 0.10468f
C2420 Xd1/a_3048_3416# vth_cmp 0.00207f
C2421 r1_b3 Xr/vglp 0.25959f
C2422 Xr/vsn Xg/m1_4760_1320# 0.03027f
C2423 vbn_leak Xi2/m1_260_2080# 0.01489f
C2424 ua0_s1 v0_c4 0.05114f
C2425 Xi4/g Xi4/m1_988_888# 0.21038f
C2426 r1_b4 i3_b1 0
C2427 i4_b0 i4_b1 0.4626f
C2428 Xr/vgln i3_b2 0.32649f
C2429 ua0_s1 Xd3/m1_2720_2760# 0.10133f
C2430 Xd3/a_3400_3816# ua0_stim 0.00167f
C2431 r1_b1 Xi3/m1_240_3480# 0
C2432 r1_b0 Xd0/a_2224_3416# 0
C2433 r2_b1 Xi4/g 0.6331f
C2434 i4_b1 Xg/a_4580_5314# 0.12366f
C2435 Xi0/g Xm/iint 0.64043f
C2436 i1_b0 vbn_ref 0.06742f
C2437 r2_b2 Xd0/a_2224_3416# 0.04876f
C2438 Xi3/g i4_b2 0.96139f
C2439 Xd2/m1_2382_2650# r2_b0 0.00988f
C2440 r1_b4 Xd0/a_2224_3416# 0
C2441 i4_b2 vbn_leak 0.05183f
C2442 ua0_int vbp_st -0.05871f
C2443 Xi0/g Xi0/m1_240_3480# 0.00966f
C2444 vdd Xd3/m1_1523_3480# 0.10903f
C2445 i0_b3 i0_b2 0.10842f
C2446 Xm/a_420_700# ua0_stim 0.12312f
C2447 Xg/a_3036_4156# i3_b3 0.05041f
C2448 Xd3/m1_2408_3600# Xd3/m1_2720_2760# -0
C2449 Xd3/m1_1523_3480# Xd3/m1_3222_4448# -0.00441f
C2450 Xi2/a_1378_4170# vbp_st 0
C2451 Xi2/a_3928_4170# vdd -0
C2452 Xi0/a_2432_4392# Xr/vgln 0.04502f
C2453 vdd i3_b3 0.23675f
C2454 Xr/en_b Xm/a_2240_11218# -0.00125f
C2455 Xi3/a_1378_4392# i3_b1 0
C2456 Xr/vglp Xvi/m1_8042_6360# 0.09226f
C2457 vbn_prb Xd0/m1_2742_3250# 0.07536f
C2458 Xi0/a_3078_4392# ib_x2 0.0029f
C2459 Xi0/a_3078_4392# Xi0/a_3282_4392# -0
C2460 Xd3/m1_4102_4448# ua0_stim_out 0.08417f
C2461 Xm/in_p Xg/a_7580_5314# 0.00124f
C2462 r0_b1 vbp_st 0.04165f
C2463 i3_b2 ua0_stim_out 0.1177f
C2464 vbp_st Xm/iint 0.19511f
C2465 ua0_s0 ua0_stim_out 0.10522f
C2466 Xg/m1_5516_1920# Xi4/g -0.00897f
C2467 i3_b3 Xi1/g 0.3359f
C2468 r0_b4 r1_b2 0.20578f
C2469 Xi2/m1_988_888# i3_b0 0.26964f
C2470 el Xi4/m1_988_3304# 0.21778f
C2471 Xvi/m1_1276_6360# i4_b3 0.02123f
C2472 Xg/m1_5516_1920# Xm/in_n 0.04617f
C2473 vdd el 1.44301f
C2474 ua0_s1 Xd3/m1_5422_4448# 0
C2475 Xr/vsn Xvi/a_864_6450# 0.28618f
C2476 Xi4/g Xr/vsn 0.40726f
C2477 Xi2/a_3928_4170# r1_b3 0.12417f
C2478 vbn_ref i3_b0 0.2657f
C2479 i0_b3 i3_b4 0.03206f
C2480 vbp_w r0_b1 0.00136f
C2481 r1_b1 vbn_ax 0
C2482 Xg/m1_4906_9490# r1_b2 0.14587f
C2483 Xm/in_p Xi0/g 0.07588f
C2484 i1_b2 i1_b1 0.00195f
C2485 i4_b1 vth_cmp 0.00786f
C2486 Xr/vsn Xm/in_n 1.2631f
C2487 vdd Xi2/a_2228_4170# 0
C2488 Xd0/a_1040_3416# r0_b0 -0.00111f
C2489 Xr/vsp Xi0/m1_988_888# 0.21477f
C2490 i4_b2 r2_b1 0.15321f
C2491 Xi3/m1_988_888# r1_b2 0.00142f
C2492 Xr/vgln Xi2/m1_988_3304# 0
C2493 ua0_s0 Xm/in_n 0.1448f
C2494 vdd Xi1/a_2228_4392# 0
C2495 Xr/vgln i3_b0 0.1342f
C2496 Xd1/a_680_3416# r1_b0 0.01614f
C2497 Xd0/m1_2242_4966# vbp_w 0.09672f
C2498 vbn_leak Xr/vglp 0.04799f
C2499 Xi3/g Xr/vglp 0.3216f
C2500 Xg/m1_3298_2050# vdd 0.00165f
C2501 vth_ref vth_cmp 0.07334f
C2502 vbp_w Xd0/m1_1262_4048# 0
C2503 Xd2/m1_462_4048# Xd2/m1_596_2880# -0.00116f
C2504 Xi2/a_732_4170# r0_b3 0
C2505 Xd2/m1_1780_2760# r2_b0 0.0092f
C2506 Xd1/m1_756_3120# vth_cmp 0.04589f
C2507 Xi3/a_4132_4392# i3_b4 0
C2508 r1_b3 Xi2/a_2228_4170# 0
C2509 vbp_st Xi1/m1_988_888# 0.34224f
C2510 Xi1/a_2432_4392# i0_b1 0.00123f
C2511 r1_b1 i4_b4 0.0996f
C2512 Xi3/a_3928_4392# r1_b2 0.07926f
C2513 Xd3/a_1624_3816# vdd 0.07648f
C2514 Xi1/a_3928_4392# i3_b4 0
C2515 Xr/vsn Xi2/m1_260_2080# -0.00123f
C2516 Xd3/a_4584_3816# Xd3/m1_4078_3250# -0
C2517 r2_b4 i2_b0 0.0816f
C2518 Xi1/a_4132_4392# i1_b4 0
C2519 Xd1/a_680_3416# r2_b2 0.07617f
C2520 Xi0/m1_988_3464# Xi0/g -0.01909f
C2521 Xi0/a_2228_4392# i0_b2 -0.00418f
C2522 Xm/in_p vbp_st 0.36679f
C2523 r2_b2 Xi2/m1_988_2644# 0.04021f
C2524 Xi1/m1_1500_4312# Xi1/m1_988_3464# -0
C2525 v0_c1 bias_en 0.78285f
C2526 vbn_ref i2_b0 0.38763f
C2527 Xi1/a_528_4392# i3_b2 0
C2528 vdd Xr/m1_3862_3522# 0.01139f
C2529 r1_b4 Xi2/m1_988_2644# 0.3406f
C2530 i3_b2 Xi2/m1_260_2080# 0
C2531 Xi4/a_3928_4170# el 0.00151f
C2532 vbp_w Xd0/a_2816_3416# 0.03573f
C2533 r1_b1 r1_b0 0.10435f
C2534 Xr/vsn Xi0/a_4132_4392# 0
C2535 vdd Xd3/m1_1262_4448# 0.05523f
C2536 v0_c5 ua0_int 0.11709f
C2537 Xr/vgln i2_b0 0
C2538 i1_b2 vdd 0
C2539 i4_b0 i3_b1 0.03391f
C2540 vdd Xi0/a_3078_4392# 0.06143f
C2541 vdd Xg/m1_6020_10200# -0.0197f
C2542 i4_b1 i2_b2 0.14105f
C2543 Xi3/m1_988_3464# Xi3/m1_240_3480# -0
C2544 i3_b1 Xg/a_4580_5314# 0.06012f
C2545 i0_b3 i1_b4 0.0396f
C2546 Xd0/m1_822_4048# vth_cmp 0.04132f
C2547 ua0_s1 v0_c3 0.0395f
C2548 ua0_stim_out i3_b0 0.07311f
C2549 r2_b1 Xr/vglp 0
C2550 i4_b2 Xr/vsn 0.33872f
C2551 i0_b2 Xi0/a_3282_4392# -0
C2552 Xg/a_7580_5314# i4_b3 0.0013f
C2553 Xi0/a_3078_4392# Xi1/g 0
C2554 Xd3/m1_3908_2760# vbp_st 0
C2555 Xg/m1_6020_10200# Xi1/g 0.01986f
C2556 Xm/a_420_700# Xm/a_736_5516# -0.00332f
C2557 r1_b1 r2_b2 0.00635f
C2558 Xd0/a_1632_3416# Xd0/a_2224_3416# -0.01529f
C2559 el Xvi/m1_8042_6360# 0.16438f
C2560 bias_en Xm/a_2240_11218# 0.00302f
C2561 ua0_s1 Xm/a_1744_10100# 0.00319f
C2562 Xi0/a_3928_4392# Xr/vgln 0.01423f
C2563 Xr/vsp r1_b2 0.94009f
C2564 r2_b3 vdd 1.98502f
C2565 r1_b1 r1_b4 0.04876f
C2566 i4_b2 i3_b2 0.07032f
C2567 Xvi/m1_8332_7080# vth_cmp 0
C2568 Xd0/m1_956_3000# vth_cmp 0.1014f
C2569 Xi0/g i4_b3 0.41443f
C2570 i2_b0 i2_b1 0.59107f
C2571 r2_b3 Xi1/g 0
C2572 Xd1/m1_606_2410# vth_cmp 0.00523f
C2573 Xi3/a_4132_4392# Xi2/g 0
C2574 Xd3/m1_822_4448# Xm/in_p 0.0439f
C2575 r0_b2 r1_b2 0
C2576 vbn_leak i3_b3 0.70268f
C2577 Xi3/g i3_b3 0.15958f
C2578 i1_b1 i0_b2 0
C2579 Xi3/m1_240_3480# r1_b4 0
C2580 i0_b4 vbp_st 0.10137f
C2581 ua0_s1 Xd3/m1_4102_4448# 0
C2582 vdd Xd3/m1_4078_3250# 0.13131f
C2583 Xi1/a_3928_4392# i1_b4 0
C2584 r2_b2 Xd2/a_1864_3416# 0.01071f
C2585 r2_b3 r1_b3 0.04548f
C2586 ua0_s1 ua0_s0 0.09022f
C2587 Xr/en_b ua0_int 0.02446f
C2588 Xi4/m1_260_2080# vth_cmp 0.00176f
C2589 vbn_leak el 0.30554f
C2590 r0_b4 vbp_st 0.12147f
C2591 i2_b0 vbp_syn 0.0758f
C2592 Xg/a_1580_5314# i3_b4 0.20371f
C2593 Xd3/a_3400_3816# v0_c2 0.02351f
C2594 i2_b0 ua0_stim_out 0.05331f
C2595 i3_b2 i0_b1 0.0507f
C2596 bias_en vth_cmp 0.00237f
C2597 Xr/vgln Xg/m1_3530_1930# 0.03243f
C2598 Xg/m1_5516_1920# Xr/vglp 0.00748f
C2599 vth_ref Xm/iint 0.63321f
C2600 Xr/en_b Xm/iint 0
C2601 r0_b3 vbp_st 0.11418f
C2602 Xi4/a_1582_4170# i4_b1 0
C2603 Xr/vsn Xr/vglp 1.06399f
C2604 Xi1/a_528_4392# i3_b0 0.00146f
C2605 r1_b0 Xd1/m1_2974_2650# 0.00211f
C2606 vbp_w r0_b4 0
C2607 i4_b3 vbp_st 0.10916f
C2608 Xi1/a_2432_4392# i3_b3 0
C2609 i3_b4 i1_b1 0.15267f
C2610 vbn_prb Xd0/m1_3662_4048# 0.0485f
C2611 Xi2/m1_260_2080# i3_b0 0.00368f
C2612 Xg/m1_3898_9610# r1_b2 0.00198f
C2613 r2_b0 vreset_src 0.20172f
C2614 Xd1/m1_2372_2520# Xd1/m1_2974_2650# -0
C2615 i4_b1 Xi3/m1_988_2804# 0.27293f
C2616 Xi1/m1_240_3480# Xi1/m1_988_2804# -0.03032f
C2617 vbn_ax r1_b0 0.0414f
C2618 Xr/vgln Xg/a_5188_4156# 0.05622f
C2619 vbn_ref i2_b4 0.26861f
C2620 vbp_w i4_b3 0
C2621 vbp_w r0_b3 0
C2622 Xi3/g Xg/m1_3298_2050# 0.00363f
C2623 Xr/vglp i3_b2 0.03738f
C2624 Xd3/m1_2408_3600# ua0_s0 0.06734f
C2625 Xr/vsp Xg/a_7580_5314# -0.00424f
C2626 i1_b3 Xr/vgln 0.02303f
C2627 r2_b1 i3_b3 0.03645f
C2628 vbp_w Xi3/m1_988_888# 0.03342f
C2629 Xi3/a_732_4392# vbn_ax 0
C2630 Xvi/m1_7102_850# bias_en 0
C2631 r2_b2 Xd1/m1_2974_2650# 0.09412f
C2632 r2_b0 Xd0/m1_382_4048# 0.00309f
C2633 Xg/m1_4538_1930# Xr/vgln -0.01066f
C2634 vdd i0_b2 0.30174f
C2635 r1_b4 Xd1/m1_2974_2650# 0
C2636 Xvi/m1_5388_6960# vreset_src 0.00799f
C2637 i1_b0 i0_b1 0.02464f
C2638 Xi4/m1_988_888# el 0.04964f
C2639 vbn_ax r2_b2 0.18469f
C2640 i2_b4 Xr/vgln 0.14918f
C2641 Xi0/g i0_b0 0
C2642 i4_b1 Xm/in_p 0.0394f
C2643 Xi2/a_3078_4170# i2_b4 0.01447f
C2644 Xr/vsp Xi0/g 0.63841f
C2645 r2_b1 el 0.15144f
C2646 vth_cmp Xd0/a_2224_3416# 0.00439f
C2647 vbn_ax r1_b4 0.19521f
C2648 i0_b2 Xi1/g 0.40998f
C2649 Xd3/a_2216_3816# Xd3/a_2808_3816# -0.01924f
C2650 i4_b2 i3_b0 0.28835f
C2651 v0_c0 v0_c5 0.00608f
C2652 vdd Xi4/a_3282_4170# 0
C2653 Xi2/g ib_x2 0.17425f
C2654 ua0_s1 Xm/a_1744_9182# 0.14848f
C2655 Xd2/m1_2964_2640# r2_b2 0
C2656 r2_b2 Xd0/m1_617_3840# 0.01936f
C2657 Xr/en_b Xm/in_p 0.07641f
C2658 Xg/a_3036_4156# i3_b4 0.0355f
C2659 Xm/in_p vth_ref 0.14136f
C2660 r1_b1 Xg/m1_5022_10210# 0
C2661 Xi2/g Xg/a_1580_5314# 0.10776f
C2662 Xi3/g Xg/m1_6020_10200# -0.00111f
C2663 Xi2/g Xi2/m1_1500_3762# -0.01005f
C2664 vdd i3_b4 1.183f
C2665 Xvi/m1_8332_7080# Xm/iint 0.18194f
C2666 Xi3/a_3078_4392# i3_b1 0
C2667 Xg/a_5188_4156# ua0_stim_out 0.02732f
C2668 Xd3/a_4584_3816# ua0_stim 0.00954f
C2669 r1_b0 Xd1/m1_2372_2520# 0.00113f
C2670 r2_b3 Xi3/g 0.53313f
C2671 i3_b4 Xi1/g 0.44781f
C2672 i0_b1 i3_b0 0.10001f
C2673 r2_b3 vbn_leak 0.03056f
C2674 i2_b3 r1_b2 0.03269f
C2675 r2_b4 vreset_src 0.03856f
C2676 Xi4/g Xg/m1_3530_1930# -0.00949f
C2677 Xr/vsp vbp_st 0.73738f
C2678 vbn_ref Xi1/m1_988_2804# -0.00386f
C2679 Xg/m1_3530_1930# Xm/in_n 0.06467f
C2680 Xr/vsn i3_b3 0.47307f
C2681 i0_b0 vbp_st 0.07588f
C2682 Xvi/m1_8646_1098# Xm/iint 0.01143f
C2683 Xd2/a_2456_3416# el 0.00932f
C2684 Xd0/m1_956_3000# Xd0/m1_2242_4966# -0
C2685 Xd3/m1_1523_3480# ua0_s0 0.01139f
C2686 bias_en ua0_int 0.30267f
C2687 r1_b0 r2_b2 0.29534f
C2688 Xd0/m1_956_3000# Xd0/m1_1262_4048# -0.0021f
C2689 Xi3/a_732_4392# Xi3/a_1582_4392# -0
C2690 r1_b1 i4_b0 0.69882f
C2691 r2_b2 Xd1/m1_2372_2520# 0.0452f
C2692 r1_b0 r1_b4 0.55045f
C2693 vbp_w Xr/vsp 0.21558f
C2694 Xi3/a_528_4392# vbn_ax 0
C2695 i2_b4 ua0_stim_out 0.21032f
C2696 r0_b2 vbp_st 0.06574f
C2697 Xm/a_420_700# Xm/a_736_7228# -0.02379f
C2698 r2_b4 Xd0/m1_382_4048# 0
C2699 i3_b3 i3_b2 0.60207f
C2700 r1_b1 Xi4/a_2228_4170# 0.00769f
C2701 Xr/vsn el 0.14861f
C2702 bias_en Xm/iint 0.99555f
C2703 Xr/vglp i3_b0 0.03137f
C2704 Xr/vgln vreset_src 0.68342f
C2705 i4_b0 Xi3/m1_1500_4312# 0.08438f
C2706 Xvi/a_4976_1528# ib_x2 0.05235f
C2707 Xi3/m1_240_3480# i4_b0 0.063f
C2708 Xi3/a_732_4392# r1_b4 0
C2709 ua0_stim_out Xm/a_1764_11418# -0.01073f
C2710 Xi4/g Xg/m1_4538_1930# -0.00845f
C2711 ib_r1 Xvi/a_4976_1528# 0.01066f
C2712 vbp_w r0_b2 0
C2713 Xg/m1_4538_1930# Xm/in_n 0.02458f
C2714 r2_b0 Xd0/a_3408_3416# 0.06532f
C2715 r1_b4 r2_b2 0.0066f
C2716 r2_b4 r2_b0 1.11534f
C2717 Xd1/a_680_3416# vth_cmp 0.01186f
C2718 Xr/m1_342_438# Xm/iint 0.06374f
C2719 Xi0/m1_988_3464# Xi0/m1_1500_4312# -0
C2720 bias_en Xi0/m1_240_3480# 0.11666f
C2721 Xi2/g Xg/a_3036_4156# 0.21966f
C2722 r2_b3 r2_b1 0.36856f
C2723 i4_b1 i4_b3 0
C2724 Xg/m1_3298_2050# Xr/vsn 0.06327f
C2725 vbn_ref r2_b0 0.41829f
C2726 Xi2/g vdd 0.54943f
C2727 Xr/vgln Xi2/a_3282_4170# 0.00158f
C2728 Xm/in_p Xi1/m1_988_3464# 0.1408f
C2729 vdd ua0_stim 1.33779f
C2730 vdd i1_b4 0.01219f
C2731 vbn_prb ib_x2 0.19124f
C2732 Xi3/m1_988_888# i4_b1 0.29286f
C2733 Xi1/a_2228_4392# i3_b2 0
C2734 i1_b0 i3_b3 0.06027f
C2735 vbp_w Xd0/m1_2742_3250# 0.06706f
C2736 vbn_ref Xi1/m1_240_3480# -0.00158f
C2737 Xd1/m1_462_4048# vbn_prb 0.08468f
C2738 ib_r1 vbn_prb -0.01954f
C2739 Xr/m1_782_438# ib_r1 0
C2740 vth_ref i4_b3 0.10758f
C2741 r0_b1 Xd0/a_2224_3416# 0.03773f
C2742 Xr/vglp i2_b0 0.00162f
C2743 Xi1/a_1378_4392# i3_b1 0
C2744 ua0_stim_out Xi1/m1_988_2804# 0.19078f
C2745 Xi3/a_732_4392# Xi3/a_1378_4392# -0
C2746 Xi3/a_3928_4392# i4_b1 0
C2747 Xi2/g r1_b3 0.3747f
C2748 Xm/in_p bias_en 0.03132f
C2749 r1_b1 vth_cmp 0.12316f
C2750 Xd3/m1_382_4448# ua0_stim_out 0.04683f
C2751 Xi0/g i2_b3 0
C2752 Xd0/m1_2242_4966# Xd0/a_2224_3416# -0.00129f
C2753 Xi3/a_1378_4392# r1_b4 0
C2754 i4_b2 Xg/a_5188_4156# 0.05826f
C2755 i3_b1 Xm/in_p 0.03878f
C2756 Xr/vgln Xvi/m1_5388_6960# -0
C2757 vdd Xi0/a_1378_4392# 0.01163f
C2758 r2_b0 i2_b1 0.09009f
C2759 r2_b3 Xd2/a_2456_3416# 0.00117f
C2760 vbn_ax i4_b0 0.00418f
C2761 Xi3/a_528_4392# r1_b4 0.00297f
C2762 Xi0/m1_988_2804# Xm/in_n 0
C2763 Xd0/a_1632_3416# Xd0/m1_617_3840# -0.00185f
C2764 i3_b3 i3_b0 0.1214f
C2765 Xd3/m1_1262_4448# ua0_s0 0.05385f
C2766 i1_b2 i3_b2 0.12451f
C2767 vreset_src Xd1/m1_860_4046# 0.33768f
C2768 Xi4/g vreset_src 0.19848f
C2769 vreset_src Xvi/a_864_6450# 0.21341f
C2770 r2_b4 Xd0/a_3408_3416# 0.05515f
C2771 Xi0/a_1378_4392# Xi1/g 0
C2772 Xd3/m1_4078_3250# v0_c3 0.00104f
C2773 vbn_leak i3_b4 0.53316f
C2774 Xi3/g i3_b4 0.5752f
C2775 Xi1/a_2432_4392# i0_b2 0.02324f
C2776 r2_b3 Xr/vsn 0.02887f
C2777 vdd Xvi/a_4976_1528# -0.08281f
C2778 vreset_src Xm/in_n 0.21634f
C2779 r1_b1 Xg/m1_3666_9610# 0.173f
C2780 i4_b2 i2_b4 0.03675f
C2781 Xi4/a_4132_4170# vreset_src 0.0057f
C2782 Xvi/a_4976_1528# Xvi/m1_4546_7560# -0
C2783 Xd3/m1_382_4448# Xm/in_n 0.00399f
C2784 bias_en Xd3/m1_3908_2760# 0.11032f
C2785 ua0_stim_out Xi2/a_3282_4170# 0.04905f
C2786 r2_b4 vbn_ref 0.5081f
C2787 Xvi/a_2102_5152# ib_x2 0.04407f
C2788 Xi0/m1_988_3464# bias_en 0.00131f
C2789 Xm/a_420_700# vbp_st 0.00778f
C2790 Xd3/a_2808_3816# ua0_stim_out 0
C2791 Xd3/a_2216_3816# ua0_stim_out 0
C2792 v0_c0 bias_en 0.48376f
C2793 r2_b0 vbp_syn 0.05571f
C2794 r2_b3 i3_b2 0.02732f
C2795 Xi3/a_4132_4392# r1_b2 0.0361f
C2796 v0_c4 ua0_stim 0.48692f
C2797 Xr/vsp i4_b1 0.87073f
C2798 r2_b0 ua0_stim_out 0.16884f
C2799 vreset_src Xi4/a_732_4170# 0.00681f
C2800 i2_b3 vbp_st 0
C2801 ib_r1 Xvi/a_2102_5152# 0.00395f
C2802 r1_b0 Xd0/a_1632_3416# 0.00173f
C2803 i4_b4 Xg/a_4580_5314# 0.08373f
C2804 Xvi/m1_1382_738# vth_cmp 0
C2805 Xd1/a_1864_3416# vreset_src 0
C2806 Xi0/m1_988_888# ib_x2 0.02301f
C2807 Xd2/a_680_3416# r2_b0 0.15586f
C2808 Xvi/m1_8332_7080# i4_b3 0
C2809 Xi1/m1_240_3480# ua0_stim_out 0.08527f
C2810 bias_en Xvi/m1_942_738# 0.04298f
C2811 ib_r1 Xi0/m1_988_888# 0.00614f
C2812 Xi2/m1_988_888# Xr/vgln 0.31352f
C2813 Xd3/m1_4102_4448# Xd3/m1_4078_3250# -0.0031f
C2814 r2_b4 Xr/vgln 0
C2815 Xvi/m1_7440_2050# Xm/iint 0.00117f
C2816 vdd vbn_prb 0.40203f
C2817 ua0 bias_en 0.14471f
C2818 Xr/vsp vth_ref 0.07818f
C2819 Xr/vsp Xr/en_b 0.12247f
C2820 Xd3/m1_4078_3250# ua0_s0 0.05517f
C2821 r1_b4 Xg/m1_5022_10210# 0.03014f
C2822 r1_b1 i2_b2 0.15371f
C2823 vbn_ref Xr/vgln 0.00837f
C2824 ua0_s1 Xm/a_1764_11418# 0.06528f
C2825 Xr/vglp Xg/a_5188_4156# 0.16697f
C2826 r2_b0 Xi4/g 0
C2827 r2_b0 Xd1/m1_860_4046# 0.00341f
C2828 Xd0/a_1632_3416# r2_b2 0.05248f
C2829 Xd0/a_1632_3416# r1_b4 0
C2830 Xi2/a_528_4170# ua0_stim_out 0
C2831 r2_b1 i3_b4 0.03702f
C2832 Xd1/m1_2974_2650# vth_cmp 0.06373f
C2833 v0_c2 ib_x2 0.05761f
C2834 Xd2/m1_2382_2650# el 0.02836f
C2835 r2_b4 i2_b1 1.07399f
C2836 Xg/m1_4538_1930# Xr/vglp 0
C2837 r0_b4 i3_b1 0.1147f
C2838 vbn_ax vth_cmp 0.20928f
C2839 Xi2/a_3078_4170# Xr/vgln -0.00144f
C2840 vbn_ref i2_b1 0.18948f
C2841 Xd2/m1_596_2880# Xd2/m1_756_3240# -0.01505f
C2842 Xi4/g Xvi/m1_5388_6960# 0.11797f
C2843 Xvi/m1_5388_6960# Xvi/a_864_6450# -0.00785f
C2844 Xr/vsp Xi0/m1_1500_4312# -0
C2845 i2_b4 Xr/vglp 0.14031f
C2846 Xr/vgln Xg/m1_4760_1320# 0.0179f
C2847 Xi3/g Xi2/g 0.3364f
C2848 Xi2/g vbn_leak 0.36833f
C2849 v0_c2 Xd3/a_4584_3816# 0.0446f
C2850 i4_b0 r1_b4 0.10984f
C2851 Xd1/a_1864_3416# r2_b0 0.0295f
C2852 Xd3/m1_1702_4448# ua0_stim_out 0.04763f
C2853 Xd2/a_1272_3416# vbn_prb 0.06299f
C2854 i4_b2 vreset_src 0
C2855 i3_b1 i4_b3 0.12576f
C2856 i1_b2 i3_b0 0
C2857 Xd2/m1_2964_2640# vth_cmp 0.28916f
C2858 Xi4/a_528_4170# vreset_src 0.04927f
C2859 Xd0/m1_617_3840# vth_cmp 0.16531f
C2860 r2_b4 vbp_syn 0.29563f
C2861 Xr/vgln i2_b1 0.00226f
C2862 r2_b4 ua0_stim_out 0.04708f
C2863 Xi1/a_732_4392# vbn_ref 0.00383f
C2864 i4_b4 vth_cmp 0.00705f
C2865 Xd1/a_1272_3416# Xd1/m1_756_3120# -0.0039f
C2866 i3_b2 i0_b2 0.04277f
C2867 vbn_ref vbp_syn 0.67119f
C2868 vdd Xvi/a_2102_5152# -0.02089f
C2869 vbn_ref ua0_stim_out 0.05848f
C2870 Xvi/a_2102_5152# Xvi/m1_4546_7560# -0
C2871 r2_b3 i3_b0 0.03295f
C2872 r1_b1 Xi4/a_1582_4170# 0.01263f
C2873 i0_b1 Xi1/m1_988_2804# 0.08213f
C2874 Xi3/a_3928_4392# i3_b1 0
C2875 Xi0/m1_988_888# vdd -0.05981f
C2876 r0_b3 Xd0/a_2224_3416# -0.00126f
C2877 vbp_w Xd0/m1_3662_4048# 0
C2878 Xg/a_1580_5314# r1_b2 0.17114f
C2879 r2_b4 Xi4/g 0
C2880 Xr/vsn i3_b4 0.24266f
C2881 i0_b3 vbp_st 0.20894f
C2882 Xr/vgln vbp_syn -0.00381f
C2883 r1_b0 vth_cmp 0.03159f
C2884 Xi0/m1_988_2804# Xr/vglp 0.10643f
C2885 Xr/vsp Xi1/m1_988_3464# -0.01023f
C2886 Xr/vgln ua0_stim_out 0.6822f
C2887 Xi2/a_3078_4170# ua0_stim_out 0.05399f
C2888 Xi2/g r2_b1 0.03726f
C2889 Xd2/m1_1780_2760# el 0.00435f
C2890 Xd1/m1_2372_2520# vth_cmp 0.08188f
C2891 i3_b3 Xg/a_5188_4156# 0.0541f
C2892 Xd1/m1_2862_4048# Xd0/m1_617_3840# 0
C2893 Xi3/m1_1500_4312# Xi3/m1_988_2804# -0.01126f
C2894 Xd0/m1_3310_2880# r2_b2 0.09213f
C2895 i3_b2 i3_b4 1.57324f
C2896 Xvi/m1_8042_6360# vss -0.34565f
C2897 vbn_prb vss 3.81161f
C2898 el vss 8.84627f
C2899 Xvi/m1_4546_7560# vss -0.33808f
C2900 ib_x2 vss 3.45008f
C2901 Xm/iint vss 2.37882f
C2902 vth_cmp vss 3.08408f
C2903 Xvi/m1_1382_738# vss -0.27404f
C2904 Xvi/m1_942_738# vss -0.3116f
C2905 Xvi/m1_502_738# vss -0.25508f
C2906 Xvi/m1_7440_2050# vss -0.41505f
C2907 vth_ref vss 2.26982f
C2908 Xvi/m1_8332_7080# vss -0.29828f
C2909 Xvi/a_2102_5152# vss -0.49849f
C2910 Xvi/a_4976_1528# vss -0.86093f
C2911 Xvi/a_864_6450# vss -2.93411f
C2912 Xvi/m1_4894_1238# vss -0.72177f
C2913 Xr/vglp vss -3.06502f
C2914 vreset_src vss 2.24404f
C2915 Xvi/m1_5388_6960# vss -0.33877f
C2916 Xvi/a_5712_1328# vss -1.71577f
C2917 Xvi/m1_8646_1098# vss -0.08118f
C2918 bias_en vss 1.42957f
C2919 Xvi/m1_7102_850# vss -0.72644f
C2920 Xvi/m1_1276_6360# vss -0.32612f
C2921 ib_r1 vss 1.7145f
C2922 vdd vss -0.29829p
C2923 Xd3/m1_4078_3250# vss -0.84776f
C2924 Xd3/m1_3908_2760# vss -0.87519f
C2925 Xd3/m1_1262_4448# vss -0.25636f
C2926 Xd3/m1_1702_4448# vss -0.25059f
C2927 Xd3/m1_3222_4448# vss -0.87748f
C2928 Xd3/m1_2720_2760# vss -0.86007f
C2929 Xd3/m1_822_4448# vss -0.2951f
C2930 Xd3/m1_2408_3600# vss -0.93316f
C2931 Xd3/m1_1523_3480# vss -0.75302f
C2932 Xd3/m1_382_4448# vss -0.25077f
C2933 Xd3/m1_5422_4448# vss -0.30525f
C2934 Xd3/m1_4982_4448# vss -0.3066f
C2935 Xd3/a_1624_3816# vss -0.35425f
C2936 v0_c0 vss 1.14483f
C2937 Xd3/a_2216_3816# vss -0.43322f
C2938 v0_c1 vss 1.88618f
C2939 v0_c2 vss 0.5688f
C2940 Xd3/a_2808_3816# vss -0.41711f
C2941 Xd3/a_3400_3816# vss -0.36429f
C2942 v0_c3 vss 1.54003f
C2943 Xd3/a_3992_3816# vss -0.48076f
C2944 v0_c4 vss 1.67408f
C2945 Xd3/a_4584_3816# vss -0.29025f
C2946 v0_c5 vss 1.57057f
C2947 Xd3/m1_4102_4448# vss -0.27056f
C2948 Xd2/m1_2964_2640# vss -0.68229f
C2949 Xd2/m1_1342_4048# vss -0.29877f
C2950 Xd2/m1_2382_2650# vss -0.75795f
C2951 Xd2/m1_1780_2760# vss -0.80256f
C2952 Xd2/m1_902_4048# vss -0.31033f
C2953 Xd2/m1_756_3240# vss -0.92726f
C2954 Xd2/m1_596_2880# vss -0.70483f
C2955 Xd2/m1_462_4048# vss -0.29908f
C2956 Xd2/a_680_3416# vss -0.26954f
C2957 r2_b0 vss -0.12009f
C2958 Xd2/a_1272_3416# vss -0.34859f
C2959 r2_b1 vss 2.66169f
C2960 Xd2/a_1864_3416# vss -0.41101f
C2961 r2_b2 vss 1.24011f
C2962 r2_b4 vss -0.19308f
C2963 Xd2/a_2456_3416# vss -0.38315f
C2964 r2_b3 vss 0.8988f
C2965 Xd2/a_3048_3416# vss -0.28393f
C2966 Xr/m1_3862_3522# vss -0.25117f
C2967 Xr/m1_3422_438# vss -0.2362f
C2968 Xr/m1_2542_438# vss -0.2362f
C2969 Xr/m1_1662_438# vss -0.23318f
C2970 Xr/m1_1222_3522# vss -0.25114f
C2971 Xr/m1_782_438# vss -0.22695f
C2972 Xr/m1_342_438# vss -0.30791f
C2973 Xd1/m1_2974_2650# vss -0.76409f
C2974 Xd1/m1_2372_2520# vss -0.79058f
C2975 Xd1/m1_1780_5040# vss -0.72013f
C2976 Xd1/m1_860_4046# vss -0.26332f
C2977 Xd1/m1_756_3120# vss -0.78273f
C2978 Xd1/m1_606_2410# vss -0.69216f
C2979 Xd1/m1_462_4048# vss -0.28816f
C2980 Xd1/a_680_3416# vss -0.30575f
C2981 r1_b0 vss 0.44111f
C2982 Xd1/a_1272_3416# vss -0.3471f
C2983 r1_b1 vss 0.95097f
C2984 Xd1/a_1864_3416# vss -0.40098f
C2985 r1_b2 vss 1.75431f
C2986 r1_b4 vss 1.15992f
C2987 Xd1/a_2456_3416# vss -0.33916f
C2988 r1_b3 vss 0.68888f
C2989 Xd1/a_3048_3416# vss -0.2615f
C2990 Xd1/m1_2862_4048# vss -0.27599f
C2991 Xd0/m1_3310_2880# vss -0.73948f
C2992 Xd0/m1_1262_4048# vss -0.25434f
C2993 Xd0/m1_2242_4966# vss -0.70024f
C2994 Xd0/m1_2742_3250# vss -0.71539f
C2995 Xd0/m1_822_4048# vss -0.24452f
C2996 Xd0/m1_617_3840# vss -0.84196f
C2997 Xd0/m1_956_3000# vss -0.63797f
C2998 Xd0/m1_382_4048# vss -0.29098f
C2999 Xd0/a_1040_3416# vss -0.16606f
C3000 r0_b0 vss 1.69144f
C3001 Xd0/a_1632_3416# vss -0.32709f
C3002 r0_b1 vss -0.01341f
C3003 Xd0/a_2224_3416# vss -0.29316f
C3004 r0_b2 vss 1.06981f
C3005 Xd0/a_2816_3416# vss -0.27356f
C3006 r0_b3 vss 0.50329f
C3007 Xd0/a_3408_3416# vss -0.19246f
C3008 r0_b4 vss 1.37449f
C3009 Xd0/m1_3662_4048# vss -0.28f
C3010 Xi4/m1_988_888# vss -1.28609f
C3011 Xr/vsn vss -9.09972f
C3012 Xi4/g vss -12.11345f
C3013 Xi4/a_3928_4170# vss -0.18615f
C3014 Xi4/a_3078_4170# vss -0.2499f
C3015 Xi4/m1_1500_3762# vss -0.11584f
C3016 Xi4/a_1378_4170# vss -0.18612f
C3017 Xi4/a_2228_4170# vss -0.18393f
C3018 Xi4/m1_260_2080# vss -0.12523f
C3019 vbp_w vss 1.20458f
C3020 Xi4/a_528_4170# vss -0.18542f
C3021 Xi4/m1_988_3304# vss -0.27347f
C3022 Xi4/a_4132_4170# vss -0.26644f
C3023 i4_b4 vss 0.92964f
C3024 Xi4/a_2432_4170# vss -0.27132f
C3025 i4_b2 vss 0.96605f
C3026 Xi4/a_3282_4170# vss -0.272f
C3027 i4_b3 vss 0.82911f
C3028 Xi4/a_1582_4170# vss -0.27171f
C3029 i4_b1 vss 0.87914f
C3030 Xi4/a_732_4170# vss -0.27253f
C3031 i4_b0 vss 0.92742f
C3032 Xi4/m1_988_2644# vss -0.71211f
C3033 Xi3/m1_988_888# vss -0.04266f
C3034 Xr/vsp vss -16.7907f
C3035 Xi3/g vss -4.6885f
C3036 Xi3/a_4132_4392# vss -0.11324f
C3037 Xi3/a_3928_4392# vss -0.1857f
C3038 Xi3/a_3282_4392# vss -0.08488f
C3039 Xi3/a_3078_4392# vss -0.15047f
C3040 Xi3/m1_1500_4312# vss -0.03019f
C3041 Xi3/a_1582_4392# vss -0.10167f
C3042 Xi3/a_1378_4392# vss -0.19073f
C3043 Xi3/a_2432_4392# vss -0.09803f
C3044 Xi3/a_2228_4392# vss -0.1789f
C3045 Xi3/m1_240_3480# vss 0.04366f
C3046 vbn_ax vss 1.23614f
C3047 Xi3/a_732_4392# vss -0.11833f
C3048 Xi3/a_528_4392# vss -0.20254f
C3049 Xi3/m1_988_3464# vss -0.04524f
C3050 i3_b4 vss 0.80832f
C3051 i3_b3 vss 1.01035f
C3052 i3_b2 vss 0.50914f
C3053 i3_b1 vss -0.78933f
C3054 i3_b0 vss 0.8849f
C3055 Xi3/m1_988_2804# vss -0.06823f
C3056 vbp_st vss 1.78268f
C3057 Xi2/m1_988_888# vss -1.40105f
C3058 Xi2/g vss -13.90971f
C3059 Xi2/a_3928_4170# vss -0.18615f
C3060 Xi2/a_3078_4170# vss -0.24984f
C3061 Xi2/m1_1500_3762# vss -0.11584f
C3062 Xi2/a_1378_4170# vss -0.18612f
C3063 Xi2/a_2228_4170# vss -0.18393f
C3064 Xi2/m1_260_2080# vss -0.17908f
C3065 vbp_syn vss 0.05696f
C3066 Xi2/a_528_4170# vss -0.18553f
C3067 Xi2/m1_988_3304# vss -0.27347f
C3068 Xi2/a_4132_4170# vss -0.26671f
C3069 i2_b4 vss 0.37061f
C3070 Xi2/a_2432_4170# vss -0.27158f
C3071 i2_b2 vss 0.4776f
C3072 Xi2/a_3282_4170# vss -0.27218f
C3073 i2_b3 vss 0.39602f
C3074 Xi2/a_1582_4170# vss -0.27185f
C3075 i2_b1 vss 0.41351f
C3076 Xi2/a_732_4170# vss -0.27263f
C3077 i2_b0 vss 0.26097f
C3078 Xi2/m1_988_2644# vss -0.71384f
C3079 Xm/a_2240_11218# vss -0.64739f
C3080 ua0_int vss 1.80977f
C3081 Xm/a_736_7228# vss -7.07127f
C3082 Xr/en_b vss -0.01972f
C3083 ua0_stim_out vss 0.48086f
C3084 ua0_stim vss 0.29588f
C3085 Xm/a_1764_11418# vss -0.4716f
C3086 Xm/a_736_5516# vss -6.75098f
C3087 Xm/a_1744_9182# vss -0.51518f
C3088 Xm/a_420_700# vss -1.48284f
C3089 ua0_s0 vss 2.03265f
C3090 ua0_s1 vss 1.75899f
C3091 ua0 vss 0.50417f
C3092 Xm/a_1744_10100# vss -0.56044f
C3093 Xi1/m1_988_888# vss -0.00943f
C3094 Xi1/g vss -5.18591f
C3095 Xi1/a_4132_4392# vss -0.1202f
C3096 Xi1/a_3928_4392# vss -0.20347f
C3097 Xi1/a_3282_4392# vss -0.12232f
C3098 Xi1/a_3078_4392# vss -0.20561f
C3099 Xi1/m1_1500_4312# vss 0.04544f
C3100 Xi1/a_1582_4392# vss -0.06144f
C3101 Xi1/a_1378_4392# vss -0.1844f
C3102 Xi1/a_2432_4392# vss -0.12098f
C3103 Xi1/a_2228_4392# vss -0.21645f
C3104 Xi1/m1_240_3480# vss -0.13091f
C3105 vbn_ref vss -0.78058f
C3106 Xi1/a_732_4392# vss -0.12406f
C3107 Xi1/a_528_4392# vss -0.2075f
C3108 Xi1/m1_988_3464# vss 0.08877f
C3109 i1_b4 vss 0.24556f
C3110 i1_b3 vss 0.19642f
C3111 i1_b2 vss 0.15434f
C3112 i1_b1 vss 0.12401f
C3113 i1_b0 vss 0.28231f
C3114 Xi1/m1_988_2804# vss 0.04846f
C3115 Xi0/m1_988_888# vss -0.06628f
C3116 Xi0/g vss -3.89851f
C3117 Xi0/a_4132_4392# vss -0.09773f
C3118 Xi0/a_3928_4392# vss -0.17744f
C3119 Xi0/a_3282_4392# vss -0.06704f
C3120 Xi0/a_3078_4392# vss -0.15895f
C3121 Xi0/m1_1500_4312# vss -0.03019f
C3122 Xi0/a_1582_4392# vss -0.10587f
C3123 Xi0/a_1378_4392# vss -0.19126f
C3124 Xi0/a_2432_4392# vss -0.08113f
C3125 Xi0/a_2228_4392# vss -0.1566f
C3126 Xi0/m1_240_3480# vss -0.12959f
C3127 vbn_leak vss -0.47134f
C3128 Xi0/a_732_4392# vss -0.12407f
C3129 Xi0/a_528_4392# vss -0.20714f
C3130 Xi0/m1_988_3464# vss -0.0453f
C3131 i0_b4 vss 0.51688f
C3132 i0_b3 vss 0.32445f
C3133 i0_b2 vss 1.02055f
C3134 i0_b1 vss 0.75492f
C3135 i0_b0 vss 0.62906f
C3136 Xi0/m1_988_2804# vss -0.07532f
C3137 Xg/a_1580_5314# vss -0.49162f
C3138 Xg/m1_4906_9490# vss -0.1012f
C3139 Xg/m1_3898_9610# vss -0.0928f
C3140 Xg/m1_3666_9610# vss -0.09893f
C3141 Xm/in_p vss 0.44955f
C3142 Xg/m1_4538_1930# vss -0.22372f
C3143 Xg/m1_3530_1930# vss -0.41831f
C3144 Xr/vgln vss -8.37447f
C3145 Xg/a_5188_4156# vss -0.9083f
C3146 Xg/a_7580_5314# vss -0.09017f
C3147 Xg/a_3036_4156# vss -0.89863f
C3148 Xg/a_4580_5314# vss -0.1629f
C3149 Xg/m1_6282_1450# vss -0.11955f
C3150 Xg/m1_5516_1920# vss -0.25072f
C3151 Xg/m1_4760_1320# vss -0.18804f
C3152 Xg/m1_3298_2050# vss -0.25812f
C3153 Xm/in_n vss 0.57834f
C3154 Xg/m1_6020_10200# vss -0.14796f
C3155 Xg/m1_5022_10210# vss -0.09562f
.ends
