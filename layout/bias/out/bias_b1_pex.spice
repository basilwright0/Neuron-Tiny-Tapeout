* NGSPICE file created from bias_b1.ext - technology: gf180mcuD

.subckt n_w2_l4_f4 a_n52_n200# a_852_n200# a_n852_n244# a_n956_n200# a_52_n244# a_n1756_n244#
+ a_1756_n200# a_n1844_n200# a_956_n244# VSUBS
X0 a_852_n200# a_52_n244# a_n52_n200# VSUBS nfet_03v3 ad=0.52p pd=2.52u as=0.52p ps=2.52u w=2u l=4u
X1 a_1756_n200# a_956_n244# a_852_n200# VSUBS nfet_03v3 ad=0.88p pd=4.88u as=0.52p ps=2.52u w=2u l=4u
X2 a_n956_n200# a_n1756_n244# a_n1844_n200# VSUBS nfet_03v3 ad=0.52p pd=2.52u as=0.88p ps=4.88u w=2u l=4u
X3 a_n52_n200# a_n852_n244# a_n956_n200# VSUBS nfet_03v3 ad=0.52p pd=2.52u as=0.52p ps=2.52u w=2u l=4u
C0 a_52_n244# a_852_n200# 0.07019f
C1 a_852_n200# a_n52_n200# 0.01073f
C2 a_n852_n244# a_n1756_n244# 0.00519f
C3 a_852_n200# a_1756_n200# 0.01073f
C4 a_52_n244# a_956_n244# 0.00519f
C5 a_n1844_n200# a_n1756_n244# 0.07019f
C6 a_n852_n244# a_n956_n200# 0.07019f
C7 a_956_n244# a_852_n200# 0.07019f
C8 a_n852_n244# a_52_n244# 0.00519f
C9 a_n956_n200# a_n1756_n244# 0.07019f
C10 a_n852_n244# a_n52_n200# 0.07019f
C11 a_956_n244# a_1756_n200# 0.07019f
C12 a_n1844_n200# a_n956_n200# 0.01073f
C13 a_n956_n200# a_n52_n200# 0.01073f
C14 a_52_n244# a_n52_n200# 0.07019f
C15 a_1756_n200# VSUBS 0.41176f
C16 a_852_n200# VSUBS 0.648f
C17 a_n52_n200# VSUBS 0.64292f
C18 a_n956_n200# VSUBS 0.648f
C19 a_n1844_n200# VSUBS 0.41176f
.ends

.subckt rx_n4 line vdd vss
XD vss line line line line line vss vss line vss n_w2_l4_f4
C0 vdd vss 0.06604f
C1 line vss 2.16208f
.ends

.subckt n_w2_l4_f2 a_n52_n200# a_852_n200# a_n852_n244# a_n940_n200# a_52_n244# VSUBS
X0 a_852_n200# a_52_n244# a_n52_n200# VSUBS nfet_03v3 ad=0.88p pd=4.88u as=0.52p ps=2.52u w=2u l=4u
X1 a_n52_n200# a_n852_n244# a_n940_n200# VSUBS nfet_03v3 ad=0.52p pd=2.52u as=0.88p ps=4.88u w=2u l=4u
C0 a_n940_n200# a_n52_n200# 0.01073f
C1 a_n852_n244# a_n52_n200# 0.07019f
C2 a_n852_n244# a_52_n244# 0.00519f
C3 a_n940_n200# a_n852_n244# 0.07019f
C4 a_852_n200# a_n52_n200# 0.01073f
C5 a_852_n200# a_52_n244# 0.07019f
C6 a_n52_n200# a_52_n244# 0.07019f
C7 a_852_n200# VSUBS 0.41176f
C8 a_n52_n200# VSUBS 0.65308f
C9 a_n940_n200# VSUBS 0.41176f
.ends

.subckt rx_n2 line vdd vss
XD line vss line vss line vss n_w2_l4_f2
C0 vdd line 0.00181f
C1 vdd vss 0.06098f
C2 line vss 1.08247f
.ends

.subckt p_w2_l4 a_400_n200# a_n400_n244# w_n574_n330# a_n488_n200# VSUBS
X0 a_400_n200# a_n400_n244# a_n488_n200# w_n574_n330# pfet_03v3 ad=0.88p pd=4.88u as=0.88p ps=4.88u w=2u l=4u
C0 a_n400_n244# w_n574_n330# 0.42229f
C1 a_n400_n244# a_n488_n200# 0.07019f
C2 a_n400_n244# a_400_n200# 0.07019f
C3 w_n574_n330# a_n488_n200# 0.07409f
C4 w_n574_n330# a_400_n200# 0.07409f
C5 a_n488_n200# a_400_n200# 0.01073f
C6 a_400_n200# VSUBS 0.18936f
C7 a_n488_n200# VSUBS 0.18936f
C8 w_n574_n330# VSUBS 2.27304f
.ends

.subckt rx_p24 vss vdd line
XD line line vdd vdd vss p_w2_l4
C0 line vdd 0.78494f
C1 line vss -0.06364f
C2 vdd vss 5.17939f
.ends

.subckt n_w2_l4 a_400_n200# a_n400_n244# a_n488_n200# VSUBS
X0 a_400_n200# a_n400_n244# a_n488_n200# VSUBS nfet_03v3 ad=0.88p pd=4.88u as=0.88p ps=4.88u w=2u l=4u
C0 a_400_n200# a_n400_n244# 0.07019f
C1 a_400_n200# a_n488_n200# 0.01073f
C2 a_n488_n200# a_n400_n244# 0.07019f
C3 a_400_n200# VSUBS 0.41684f
C4 a_n488_n200# VSUBS 0.41684f
.ends

.subckt rx_n1 line vdd vss
XD line line vss vss n_w2_l4
C0 vdd line 0.00323f
C1 vdd vss 0.05846f
C2 line vss 0.60968f
.ends

.subckt p_w1_l4 a_n488_n100# a_400_n100# a_n400_n144# w_n574_n230# VSUBS
X0 a_400_n100# a_n400_n144# a_n488_n100# w_n574_n230# pfet_03v3 ad=0.44p pd=2.88u as=0.44p ps=2.88u w=1u l=4u
C0 w_n574_n230# a_400_n100# 0.03707f
C1 a_400_n100# a_n488_n100# 0.00531f
C2 w_n574_n230# a_n488_n100# 0.03707f
C3 a_n400_n144# a_400_n100# 0.03474f
C4 w_n574_n230# a_n400_n144# 0.42229f
C5 a_n400_n144# a_n488_n100# 0.03474f
C6 a_400_n100# VSUBS 0.15701f
C7 a_n488_n100# VSUBS 0.15701f
C8 w_n574_n230# VSUBS 1.58424f
.ends

.subckt rx_p05 line vdd vss
XD vdd line line vdd vss p_w1_l4
C0 vdd line 0.81576f
C1 line vss 0.00304f
C2 vdd vss 5.0752f
.ends

.subckt p_w4_l2_f5 a_n304_n400# a_704_n400# a_n704_n444# a_n808_n400# a_304_n444#
+ a_n1208_n444# a_n1296_n400# a_1208_n400# w_n1382_n530# a_200_n400# a_808_n444# a_n200_n444#
+ VSUBS
X0 a_1208_n400# a_808_n444# a_704_n400# w_n1382_n530# pfet_03v3 ad=1.76p pd=8.88u as=1.04p ps=4.52u w=4u l=2u
X1 a_704_n400# a_304_n444# a_200_n400# w_n1382_n530# pfet_03v3 ad=1.04p pd=4.52u as=1.04p ps=4.52u w=4u l=2u
X2 a_n808_n400# a_n1208_n444# a_n1296_n400# w_n1382_n530# pfet_03v3 ad=1.04p pd=4.52u as=1.76p ps=8.88u w=4u l=2u
X3 a_n304_n400# a_n704_n444# a_n808_n400# w_n1382_n530# pfet_03v3 ad=1.04p pd=4.52u as=1.04p ps=4.52u w=4u l=2u
X4 a_200_n400# a_n200_n444# a_n304_n400# w_n1382_n530# pfet_03v3 ad=1.04p pd=4.52u as=1.04p ps=4.52u w=4u l=2u
C0 a_n808_n400# a_n704_n444# 0.11799f
C1 a_1208_n400# a_704_n400# 0.04287f
C2 a_n304_n400# w_n1382_n530# 0.18497f
C3 a_n1208_n444# a_n704_n444# 0.00519f
C4 a_808_n444# a_1208_n400# 0.11799f
C5 a_200_n400# a_704_n400# 0.04287f
C6 a_n704_n444# w_n1382_n530# 0.21994f
C7 a_n200_n444# a_304_n444# 0.00519f
C8 a_n808_n400# a_n1208_n444# 0.11799f
C9 a_n808_n400# w_n1382_n530# 0.18497f
C10 a_n200_n444# a_n304_n400# 0.11799f
C11 a_n808_n400# a_n1296_n400# 0.04287f
C12 a_n1208_n444# w_n1382_n530# 0.2233f
C13 a_808_n444# a_704_n400# 0.11799f
C14 a_200_n400# a_304_n444# 0.11799f
C15 a_n200_n444# a_n704_n444# 0.00519f
C16 a_n1208_n444# a_n1296_n400# 0.11799f
C17 a_n1296_n400# w_n1382_n530# 0.12268f
C18 a_704_n400# a_304_n444# 0.11799f
C19 a_200_n400# a_n304_n400# 0.04287f
C20 a_808_n444# a_304_n444# 0.00519f
C21 a_n200_n444# w_n1382_n530# 0.21994f
C22 a_1208_n400# w_n1382_n530# 0.12268f
C23 a_200_n400# w_n1382_n530# 0.18497f
C24 a_704_n400# w_n1382_n530# 0.18497f
C25 a_808_n444# w_n1382_n530# 0.2233f
C26 a_n200_n444# a_200_n400# 0.11799f
C27 a_n304_n400# a_n704_n444# 0.11799f
C28 a_n808_n400# a_n304_n400# 0.04287f
C29 a_304_n444# w_n1382_n530# 0.21994f
C30 a_1208_n400# VSUBS 0.19832f
C31 a_704_n400# VSUBS 0.12191f
C32 a_200_n400# VSUBS 0.11851f
C33 a_n304_n400# VSUBS 0.11851f
C34 a_n808_n400# VSUBS 0.12191f
C35 a_n1296_n400# VSUBS 0.19832f
C36 w_n1382_n530# VSUBS 8.78952f
.ends

.subckt p_w2_l1 a_100_n200# a_n100_n244# w_n274_n330# a_n188_n200# VSUBS
X0 a_100_n200# a_n100_n244# a_n188_n200# w_n274_n330# pfet_03v3 ad=0.88p pd=4.88u as=0.88p ps=4.88u w=2u l=1u
C0 w_n274_n330# a_n188_n200# 0.04851f
C1 a_n100_n244# w_n274_n330# 0.12884f
C2 a_100_n200# a_n188_n200# 0.03858f
C3 a_100_n200# a_n100_n244# 0.04231f
C4 a_100_n200# w_n274_n330# 0.04851f
C5 a_n100_n244# a_n188_n200# 0.04231f
C6 a_100_n200# VSUBS 0.11088f
C7 a_n188_n200# VSUBS 0.11088f
C8 w_n274_n330# VSUBS 1.08504f
.ends

.subckt n_w4_l2_f6 a_n956_n444# a_1060_n444# a_556_n444# a_n52_n400# a_n1548_n400#
+ a_n1060_n400# a_452_n400# a_n452_n444# a_n556_n400# a_n1460_n444# a_1460_n400# a_52_n444#
+ a_956_n400# VSUBS
X0 a_n556_n400# a_n956_n444# a_n1060_n400# VSUBS nfet_03v3 ad=1.04p pd=4.52u as=1.04p ps=4.52u w=4u l=2u
X1 a_n52_n400# a_n452_n444# a_n556_n400# VSUBS nfet_03v3 ad=1.04p pd=4.52u as=1.04p ps=4.52u w=4u l=2u
X2 a_452_n400# a_52_n444# a_n52_n400# VSUBS nfet_03v3 ad=1.04p pd=4.52u as=1.04p ps=4.52u w=4u l=2u
X3 a_n1060_n400# a_n1460_n444# a_n1548_n400# VSUBS nfet_03v3 ad=1.04p pd=4.52u as=1.76p ps=8.88u w=4u l=2u
X4 a_956_n400# a_556_n444# a_452_n400# VSUBS nfet_03v3 ad=1.04p pd=4.52u as=1.04p ps=4.52u w=4u l=2u
X5 a_1460_n400# a_1060_n444# a_956_n400# VSUBS nfet_03v3 ad=1.76p pd=8.88u as=1.04p ps=4.52u w=4u l=2u
C0 a_n52_n400# a_452_n400# 0.04287f
C1 a_1060_n444# a_556_n444# 0.00519f
C2 a_452_n400# a_956_n400# 0.04287f
C3 a_52_n444# a_556_n444# 0.00519f
C4 a_n956_n444# a_n1060_n400# 0.11799f
C5 a_n956_n444# a_n1460_n444# 0.00519f
C6 a_n1460_n444# a_n1060_n400# 0.11799f
C7 a_1060_n444# a_956_n400# 0.11799f
C8 a_n52_n400# a_52_n444# 0.11799f
C9 a_52_n444# a_n452_n444# 0.00519f
C10 a_1460_n400# a_956_n400# 0.04287f
C11 a_n1548_n400# a_n1060_n400# 0.04287f
C12 a_n1548_n400# a_n1460_n444# 0.11799f
C13 a_556_n444# a_956_n400# 0.11799f
C14 a_52_n444# a_452_n400# 0.11799f
C15 a_n52_n400# a_n556_n400# 0.04287f
C16 a_n556_n400# a_n452_n444# 0.11799f
C17 a_556_n444# a_452_n400# 0.11799f
C18 a_n52_n400# a_n452_n444# 0.11799f
C19 a_n956_n444# a_n556_n400# 0.11799f
C20 a_1060_n444# a_1460_n400# 0.11799f
C21 a_n956_n444# a_n452_n444# 0.00519f
C22 a_n556_n400# a_n1060_n400# 0.04287f
C23 a_1460_n400# VSUBS 0.33857f
C24 a_956_n400# VSUBS 0.34773f
C25 a_452_n400# VSUBS 0.34265f
C26 a_n52_n400# VSUBS 0.34265f
C27 a_n556_n400# VSUBS 0.34265f
C28 a_n1060_n400# VSUBS 0.34773f
C29 a_n1548_n400# VSUBS 0.33857f
.ends

.subckt n_w2_l2_f2 a_n52_n200# a_452_n200# a_n452_n244# a_n540_n200# a_52_n244# VSUBS
X0 a_452_n200# a_52_n244# a_n52_n200# VSUBS nfet_03v3 ad=0.88p pd=4.88u as=0.52p ps=2.52u w=2u l=2u
X1 a_n52_n200# a_n452_n244# a_n540_n200# VSUBS nfet_03v3 ad=0.52p pd=2.52u as=0.88p ps=4.88u w=2u l=2u
C0 a_n540_n200# a_n52_n200# 0.02133f
C1 a_n540_n200# a_n452_n244# 0.0587f
C2 a_n52_n200# a_452_n200# 0.02133f
C3 a_n52_n200# a_n452_n244# 0.0587f
C4 a_52_n244# a_452_n200# 0.0587f
C5 a_n52_n200# a_52_n244# 0.0587f
C6 a_52_n244# a_n452_n244# 0.00519f
C7 a_452_n200# VSUBS 0.26162f
C8 a_n52_n200# VSUBS 0.35281f
C9 a_n540_n200# VSUBS 0.26162f
.ends

.subckt n_w2_l1 a_100_n200# a_n100_n244# a_n188_n200# VSUBS
X0 a_100_n200# a_n100_n244# a_n188_n200# VSUBS nfet_03v3 ad=0.88p pd=4.88u as=0.88p ps=4.88u w=2u l=1u
C0 a_100_n200# a_n100_n244# 0.04231f
C1 a_100_n200# a_n188_n200# 0.03858f
C2 a_n188_n200# a_n100_n244# 0.04231f
C3 a_100_n200# VSUBS 0.19164f
C4 a_n188_n200# VSUBS 0.19164f
.ends

.subckt p_w2_l2_f8 a_n52_n200# a_n1060_n200# a_452_n200# a_1564_n244# a_n452_n244#
+ w_n2138_n330# a_n556_n200# a_n1460_n244# a_1460_n200# a_52_n244# a_n1564_n200# a_956_n200#
+ a_n2052_n200# a_n956_n244# a_1060_n244# a_n1964_n244# a_556_n244# a_1964_n200# VSUBS
X0 a_1964_n200# a_1564_n244# a_1460_n200# w_n2138_n330# pfet_03v3 ad=0.88p pd=4.88u as=0.52p ps=2.52u w=2u l=2u
X1 a_452_n200# a_52_n244# a_n52_n200# w_n2138_n330# pfet_03v3 ad=0.52p pd=2.52u as=0.52p ps=2.52u w=2u l=2u
X2 a_956_n200# a_556_n244# a_452_n200# w_n2138_n330# pfet_03v3 ad=0.52p pd=2.52u as=0.52p ps=2.52u w=2u l=2u
X3 a_1460_n200# a_1060_n244# a_956_n200# w_n2138_n330# pfet_03v3 ad=0.52p pd=2.52u as=0.52p ps=2.52u w=2u l=2u
X4 a_n1564_n200# a_n1964_n244# a_n2052_n200# w_n2138_n330# pfet_03v3 ad=0.52p pd=2.52u as=0.88p ps=4.88u w=2u l=2u
X5 a_n1060_n200# a_n1460_n244# a_n1564_n200# w_n2138_n330# pfet_03v3 ad=0.52p pd=2.52u as=0.52p ps=2.52u w=2u l=2u
X6 a_n556_n200# a_n956_n244# a_n1060_n200# w_n2138_n330# pfet_03v3 ad=0.52p pd=2.52u as=0.52p ps=2.52u w=2u l=2u
X7 a_n52_n200# a_n452_n244# a_n556_n200# w_n2138_n330# pfet_03v3 ad=0.52p pd=2.52u as=0.52p ps=2.52u w=2u l=2u
C0 a_n1460_n244# a_n956_n244# 0.00519f
C1 a_n956_n244# a_n1060_n200# 0.0587f
C2 a_n1564_n200# a_n1964_n244# 0.0587f
C3 a_n1460_n244# w_n2138_n330# 0.21994f
C4 a_n1060_n200# w_n2138_n330# 0.09155f
C5 w_n2138_n330# a_n52_n200# 0.09155f
C6 a_n1460_n244# a_n1564_n200# 0.0587f
C7 a_n1564_n200# a_n1060_n200# 0.02133f
C8 a_n956_n244# a_n452_n244# 0.00519f
C9 a_n452_n244# w_n2138_n330# 0.21994f
C10 a_452_n200# a_956_n200# 0.02133f
C11 a_1060_n244# a_956_n200# 0.0587f
C12 w_n2138_n330# a_452_n200# 0.09155f
C13 a_1060_n244# w_n2138_n330# 0.21994f
C14 a_1060_n244# a_1460_n200# 0.0587f
C15 w_n2138_n330# a_956_n200# 0.09155f
C16 a_n956_n244# w_n2138_n330# 0.21994f
C17 a_956_n200# a_1460_n200# 0.02133f
C18 w_n2138_n330# a_1460_n200# 0.09155f
C19 a_n1564_n200# w_n2138_n330# 0.09155f
C20 a_52_n244# a_n52_n200# 0.0587f
C21 a_556_n244# a_452_n200# 0.0587f
C22 w_n2138_n330# a_1964_n200# 0.0618f
C23 a_556_n244# a_1060_n244# 0.00519f
C24 a_52_n244# a_n452_n244# 0.00519f
C25 a_n556_n200# a_n1060_n200# 0.02133f
C26 a_n2052_n200# a_n1964_n244# 0.0587f
C27 a_1460_n200# a_1964_n200# 0.02133f
C28 a_52_n244# a_452_n200# 0.0587f
C29 a_556_n244# a_956_n200# 0.0587f
C30 a_n556_n200# a_n52_n200# 0.02133f
C31 a_1564_n244# a_1060_n244# 0.00519f
C32 a_556_n244# w_n2138_n330# 0.21994f
C33 a_n556_n200# a_n452_n244# 0.0587f
C34 a_52_n244# w_n2138_n330# 0.21994f
C35 a_1564_n244# w_n2138_n330# 0.2233f
C36 a_n1460_n244# a_n1964_n244# 0.00519f
C37 a_1564_n244# a_1460_n200# 0.0587f
C38 a_n556_n200# a_n956_n244# 0.0587f
C39 a_n556_n200# w_n2138_n330# 0.09155f
C40 a_n1460_n244# a_n1060_n200# 0.0587f
C41 a_1564_n244# a_1964_n200# 0.0587f
C42 a_n2052_n200# w_n2138_n330# 0.0618f
C43 a_556_n244# a_52_n244# 0.00519f
C44 a_n452_n244# a_n52_n200# 0.0587f
C45 a_n2052_n200# a_n1564_n200# 0.02133f
C46 a_n1964_n244# w_n2138_n330# 0.2233f
C47 a_n52_n200# a_452_n200# 0.02133f
C48 a_1964_n200# VSUBS 0.13364f
C49 a_1460_n200# VSUBS 0.12191f
C50 a_956_n200# VSUBS 0.11851f
C51 a_452_n200# VSUBS 0.11851f
C52 a_n52_n200# VSUBS 0.11851f
C53 a_n556_n200# VSUBS 0.11851f
C54 a_n1060_n200# VSUBS 0.11851f
C55 a_n1564_n200# VSUBS 0.12191f
C56 a_n2052_n200# VSUBS 0.13364f
C57 w_n2138_n330# VSUBS 8.46648f
.ends

.subckt n_w2_l2_f8 a_n52_n200# a_n1060_n200# a_452_n200# a_1564_n244# a_n452_n244#
+ a_n556_n200# a_n1460_n244# a_1460_n200# a_52_n244# a_n1564_n200# a_956_n200# a_n2052_n200#
+ a_n956_n244# a_1060_n244# a_n1964_n244# a_556_n244# a_1964_n200# VSUBS
X0 a_1964_n200# a_1564_n244# a_1460_n200# VSUBS nfet_03v3 ad=0.88p pd=4.88u as=0.52p ps=2.52u w=2u l=2u
X1 a_452_n200# a_52_n244# a_n52_n200# VSUBS nfet_03v3 ad=0.52p pd=2.52u as=0.52p ps=2.52u w=2u l=2u
X2 a_956_n200# a_556_n244# a_452_n200# VSUBS nfet_03v3 ad=0.52p pd=2.52u as=0.52p ps=2.52u w=2u l=2u
X3 a_1460_n200# a_1060_n244# a_956_n200# VSUBS nfet_03v3 ad=0.52p pd=2.52u as=0.52p ps=2.52u w=2u l=2u
X4 a_n1564_n200# a_n1964_n244# a_n2052_n200# VSUBS nfet_03v3 ad=0.52p pd=2.52u as=0.88p ps=4.88u w=2u l=2u
X5 a_n1060_n200# a_n1460_n244# a_n1564_n200# VSUBS nfet_03v3 ad=0.52p pd=2.52u as=0.52p ps=2.52u w=2u l=2u
X6 a_n556_n200# a_n956_n244# a_n1060_n200# VSUBS nfet_03v3 ad=0.52p pd=2.52u as=0.52p ps=2.52u w=2u l=2u
X7 a_n52_n200# a_n452_n244# a_n556_n200# VSUBS nfet_03v3 ad=0.52p pd=2.52u as=0.52p ps=2.52u w=2u l=2u
C0 a_452_n200# a_556_n244# 0.0587f
C1 a_n1060_n200# a_n956_n244# 0.0587f
C2 a_n2052_n200# a_n1564_n200# 0.02133f
C3 a_n1564_n200# a_n1460_n244# 0.0587f
C4 a_n1564_n200# a_n1060_n200# 0.02133f
C5 a_452_n200# a_n52_n200# 0.02133f
C6 a_n956_n244# a_n452_n244# 0.00519f
C7 a_1564_n244# a_1964_n200# 0.0587f
C8 a_956_n200# a_1060_n244# 0.0587f
C9 a_1460_n200# a_1964_n200# 0.02133f
C10 a_n452_n244# a_52_n244# 0.00519f
C11 a_956_n200# a_556_n244# 0.0587f
C12 a_n556_n200# a_n1060_n200# 0.02133f
C13 a_n2052_n200# a_n1964_n244# 0.0587f
C14 a_52_n244# a_556_n244# 0.00519f
C15 a_n556_n200# a_n956_n244# 0.0587f
C16 a_1060_n244# a_556_n244# 0.00519f
C17 a_n52_n200# a_n452_n244# 0.0587f
C18 a_n1964_n244# a_n1460_n244# 0.00519f
C19 a_1460_n200# a_956_n200# 0.02133f
C20 a_1564_n244# a_1060_n244# 0.00519f
C21 a_n556_n200# a_n452_n244# 0.0587f
C22 a_n52_n200# a_52_n244# 0.0587f
C23 a_n1964_n244# a_n1564_n200# 0.0587f
C24 a_1460_n200# a_1060_n244# 0.0587f
C25 a_452_n200# a_956_n200# 0.02133f
C26 a_1564_n244# a_1460_n200# 0.0587f
C27 a_452_n200# a_52_n244# 0.0587f
C28 a_n52_n200# a_n556_n200# 0.02133f
C29 a_n1060_n200# a_n1460_n244# 0.0587f
C30 a_n1460_n244# a_n956_n244# 0.00519f
C31 a_1964_n200# VSUBS 0.26162f
C32 a_1460_n200# VSUBS 0.34773f
C33 a_956_n200# VSUBS 0.34265f
C34 a_452_n200# VSUBS 0.34265f
C35 a_n52_n200# VSUBS 0.34265f
C36 a_n556_n200# VSUBS 0.34265f
C37 a_n1060_n200# VSUBS 0.34265f
C38 a_n1564_n200# VSUBS 0.34773f
C39 a_n2052_n200# VSUBS 0.26162f
.ends

.subckt p_w2_l2 a_n288_n200# a_200_n200# a_n200_n244# w_n374_n330# VSUBS
X0 a_200_n200# a_n200_n244# a_n288_n200# w_n374_n330# pfet_03v3 ad=0.88p pd=4.88u as=0.88p ps=4.88u w=2u l=2u
C0 a_n200_n244# w_n374_n330# 0.22666f
C1 a_n200_n244# a_200_n200# 0.0587f
C2 w_n374_n330# a_n288_n200# 0.0618f
C3 a_200_n200# a_n288_n200# 0.02133f
C4 a_n200_n244# a_n288_n200# 0.0587f
C5 w_n374_n330# a_200_n200# 0.0618f
C6 a_200_n200# VSUBS 0.13704f
C7 a_n288_n200# VSUBS 0.13704f
C8 w_n374_n330# VSUBS 1.48104f
.ends

.subckt n_w2_l2 a_n288_n200# a_200_n200# a_n200_n244# VSUBS
X0 a_200_n200# a_n200_n244# a_n288_n200# VSUBS nfet_03v3 ad=0.88p pd=4.88u as=0.88p ps=4.88u w=2u l=2u
C0 a_n288_n200# a_n200_n244# 0.0587f
C1 a_n200_n244# a_200_n200# 0.0587f
C2 a_n288_n200# a_200_n200# 0.02133f
C3 a_200_n200# VSUBS 0.2667f
C4 a_n288_n200# VSUBS 0.2667f
.ends

.subckt p_w2_l2_f2 a_n52_n200# a_452_n200# a_n452_n244# a_n540_n200# w_n626_n330#
+ a_52_n244# VSUBS
X0 a_452_n200# a_52_n244# a_n52_n200# w_n626_n330# pfet_03v3 ad=0.88p pd=4.88u as=0.52p ps=2.52u w=2u l=2u
X1 a_n52_n200# a_n452_n244# a_n540_n200# w_n626_n330# pfet_03v3 ad=0.52p pd=2.52u as=0.88p ps=4.88u w=2u l=2u
C0 a_n452_n244# w_n626_n330# 0.2233f
C1 a_52_n244# a_452_n200# 0.0587f
C2 a_n452_n244# a_n540_n200# 0.0587f
C3 w_n626_n330# a_n52_n200# 0.09155f
C4 a_n540_n200# a_n52_n200# 0.02133f
C5 w_n626_n330# a_52_n244# 0.2233f
C6 a_n452_n244# a_n52_n200# 0.0587f
C7 w_n626_n330# a_452_n200# 0.0618f
C8 a_n452_n244# a_52_n244# 0.00519f
C9 a_52_n244# a_n52_n200# 0.0587f
C10 w_n626_n330# a_n540_n200# 0.0618f
C11 a_n52_n200# a_452_n200# 0.02133f
C12 a_452_n200# VSUBS 0.13364f
C13 a_n52_n200# VSUBS 0.12532f
C14 a_n540_n200# VSUBS 0.13364f
C15 w_n626_n330# VSUBS 2.47896f
.ends

.subckt bias_ladder in_n vgp3 m1_4760_1320# m1_6020_10200# m1_3298_2050# m1_5022_10210#
+ m1_3530_1930# m1_3898_9610# a_7580_5314# vss vgp5 m1_4906_9490# vdd m1_6282_1450#
+ a_1580_5314# m1_5516_1920# a_4580_5314# m1_4538_1930# vgn5 vgn3 a_5188_4156# m1_3666_9610#
+ vsp vsn vglp vgp6 a_3036_4156# vgln in_p
XnpSE m1_3898_9610# m1_4906_9490# vglp m1_3666_9610# vglp vglp in_p m1_6020_10200#
+ vdd m1_5022_10210# vglp vglp vss p_w4_l2_f5
XFP3 vgp3 a_1580_5314# vgp3 vss vss p_w2_l1
XnnSE vgln vgln vgln m1_4760_1320# in_n m1_3298_2050# m1_4538_1930# vgln m1_3530_1930#
+ vgln m1_6282_1450# vgln m1_5516_1920# vss n_w4_l2_f6
XnnSH6T m1_6282_1450# vdd vgln a_7580_5314# vgln vss n_w2_l2_f2
XFP5 vgp5 a_4580_5314# vgp5 vss vss p_w2_l1
XFN3 vgn3 a_3036_4156# vdd vss n_w2_l1
XDP3 vsp vsp a_1580_5314# vgp3 vgp3 vdd a_1580_5314# vgp3 a_1580_5314# vgp3 a_1580_5314#
+ vsp vsp vgp3 vgp3 vgp3 vgp3 vsp vss p_w2_l2_f8
XFP6 vgp6 a_7580_5314# vgp6 vss vss p_w2_l1
XFN5 vgn5 a_5188_4156# vdd vss n_w2_l1
XDP5 vsp vsp a_4580_5314# vgp5 vgp5 vdd a_4580_5314# vgp5 a_4580_5314# vgp5 a_4580_5314#
+ vsp vsp vgp5 vgp5 vgp5 vgp5 vsp vss p_w2_l2_f8
XDN3 vsn vsn a_3036_4156# vgn3 vgn3 a_3036_4156# vgn3 a_3036_4156# vgn3 a_3036_4156#
+ vsn vsn vgn3 vgn3 vgn3 vgn3 vsn vss n_w2_l2_f8
XDP6 vsp vsp a_7580_5314# vgp6 vgp6 vdd a_7580_5314# vgp6 a_7580_5314# vgp6 a_7580_5314#
+ vsp vsp vgp6 vgp6 vgp6 vgp6 vsp vss p_w2_l2_f8
XBP3 vsp vgp3 vgp6 vdd vss p_w2_l2
XDN5 vsn vsn a_5188_4156# vgn5 vgn5 a_5188_4156# vgn5 a_5188_4156# vgn5 a_5188_4156#
+ vsn vsn vgn5 vgn5 vgn5 vgn5 vsn vss n_w2_l2_f8
XBP5 vsp vgp5 vgp6 vdd vss p_w2_l2
XBN3 vgn3 vsn vgn5 vss n_w2_l2
XnnSH01 vdd m1_3298_2050# vgln in_n vgln vss n_w2_l2_f2
XBP6 vsp vgp6 vgp6 vdd vss p_w2_l2
XnnSH24 vdd m1_4538_1930# vgln m1_3530_1930# vgln vss n_w2_l2_f2
XBN5 vgn5 vsn vgn5 vss n_w2_l2
XnpSH3 m1_5022_10210# a_3036_4156# vglp vdd vss p_w2_l2
XnpSH5T m1_6020_10200# vss vglp a_5188_4156# vdd vglp vss p_w2_l2_f2
XnpSH01 vss m1_3666_9610# vglp in_p vdd vglp vss p_w2_l2_f2
XnpSH24 vss m1_4906_9490# vglp m1_3898_9610# vdd vglp vss p_w2_l2_f2
XnnSH3 m1_4760_1320# a_1580_5314# vgln vss n_w2_l2
XnnSH5 m1_5516_1920# a_4580_5314# vgln vss n_w2_l2
C0 a_5188_4156# vgp3 0.00485f
C1 a_5188_4156# a_7580_5314# 0.41188f
C2 m1_3898_9610# vsp 0.00217f
C3 vgp5 vsn 0.17915f
C4 a_1580_5314# m1_5516_1920# 0.05179f
C5 m1_5516_1920# vgn3 0.00897f
C6 m1_3898_9610# vgp3 0.04635f
C7 vgn5 vgp6 0.00421f
C8 a_4580_5314# a_3036_4156# 0.1705f
C9 m1_5516_1920# m1_6282_1450# 0.00546f
C10 vgp5 a_3036_4156# 0.72992f
C11 vgn5 vdd 0.10294f
C12 a_3036_4156# m1_5022_10210# 0
C13 vdd vgp6 5.47456f
C14 m1_4538_1930# a_4580_5314# 0.00211f
C15 a_1580_5314# vsp 0.66577f
C16 a_1580_5314# vgp3 1.41665f
C17 a_1580_5314# a_7580_5314# 0.02594f
C18 vgp3 vgn3 0.00714f
C19 vgn5 vgln 0.02641f
C20 a_5188_4156# a_4580_5314# 0.4945f
C21 m1_3666_9610# in_p 0.0161f
C22 vdd m1_3298_2050# 0.05664f
C23 m1_6020_10200# a_3036_4156# 0.00106f
C24 m1_4906_9490# m1_5022_10210# 0.22756f
C25 a_5188_4156# vgp5 0.18257f
C26 in_n m1_3298_2050# 0.02053f
C27 m1_6282_1450# a_7580_5314# 0.00102f
C28 a_5188_4156# m1_5022_10210# 0
C29 a_4580_5314# m1_4760_1320# 0
C30 m1_3666_9610# vglp 0.38355f
C31 in_n vdd 0.07179f
C32 vgln m1_3298_2050# 0.28259f
C33 m1_5516_1920# a_7580_5314# 0
C34 m1_3898_9610# m1_5022_10210# 0
C35 vglp a_3036_4156# 0.03135f
C36 m1_4906_9490# m1_6020_10200# 0.00282f
C37 vgln vdd 2.28298f
C38 m1_6020_10200# a_5188_4156# 0.00728f
C39 vgln in_n 0.47579f
C40 vsn vgn5 1.27598f
C41 vsn vgp6 0.03394f
C42 a_1580_5314# a_4580_5314# 0.06015f
C43 m1_4906_9490# vglp 0.38823f
C44 a_4580_5314# vgn3 0
C45 a_1580_5314# vgp5 0.16694f
C46 vgp5 vgn3 0
C47 vglp a_5188_4156# 0.03121f
C48 vgp3 vsp 1.5721f
C49 a_7580_5314# vsp 0.4942f
C50 vsn m1_3298_2050# 0.01482f
C51 m1_3666_9610# vgp6 0.00881f
C52 vgp3 a_7580_5314# 0.20875f
C53 m1_3898_9610# vglp 0.4412f
C54 a_3036_4156# vgn5 0.11976f
C55 m1_6282_1450# a_4580_5314# 0.21332f
C56 a_3036_4156# vgp6 0.42099f
C57 vsn vdd 0.58029f
C58 m1_5516_1920# a_4580_5314# -0.00812f
C59 vsn in_n 0.17665f
C60 m1_4538_1930# vgn5 0.00106f
C61 vsn vgln 0.48987f
C62 m1_3666_9610# vdd 0.05802f
C63 m1_4906_9490# vgp6 0.01016f
C64 m1_3298_2050# m1_3530_1930# 0.33404f
C65 a_3036_4156# vdd 1.03471f
C66 a_5188_4156# vgn5 1.16612f
C67 a_5188_4156# vgp6 0.14378f
C68 a_1580_5314# vglp 0
C69 vdd m1_3530_1930# 0.05235f
C70 m1_3898_9610# vgp6 0.01466f
C71 a_4580_5314# vsp 0.80414f
C72 a_3036_4156# vgln 0.00497f
C73 in_n m1_3530_1930# 0.00742f
C74 m1_4538_1930# vdd 0.27134f
C75 a_4580_5314# a_7580_5314# 0.29998f
C76 m1_4906_9490# vdd 0.08697f
C77 vgp5 vsp 0.78845f
C78 vgln m1_3530_1930# 0.4385f
C79 vgp3 vgp5 0.00867f
C80 vgp5 a_7580_5314# 0.32553f
C81 a_5188_4156# vdd 0.39619f
C82 m1_5022_10210# vsp 0.00393f
C83 m1_4538_1930# vgln 0.37308f
C84 vgp3 m1_5022_10210# 0.00919f
C85 m1_3898_9610# vdd 0.15129f
C86 m1_3298_2050# m1_4760_1320# -0
C87 a_1580_5314# vgn5 0.21481f
C88 vdd m1_4760_1320# 0.02112f
C89 a_5188_4156# vgln 0.06289f
C90 vgn3 vgn5 0.06099f
C91 a_1580_5314# vgp6 0.24833f
C92 m1_6020_10200# vsp 0.02019f
C93 in_p vsp 0.13384f
C94 a_3036_4156# vsn 0.14439f
C95 in_p vgp3 0.0017f
C96 vsn m1_3530_1930# 0.01898f
C97 vgln m1_4760_1320# 0.22369f
C98 vgn3 m1_3298_2050# 0.00878f
C99 m1_6282_1450# vgn5 0
C100 vglp vsp 0.34417f
C101 a_1580_5314# vdd 1.62506f
C102 vglp a_7580_5314# 0
C103 vglp vgp3 0.48996f
C104 vgn3 vdd 0.17852f
C105 m1_5516_1920# vgn5 0.00187f
C106 vgp5 a_4580_5314# 1.87678f
C107 vgn3 in_n 0.00344f
C108 a_5188_4156# vsn 0.39706f
C109 a_1580_5314# vgln 0.07765f
C110 vgn3 vgln 0.47992f
C111 m1_6282_1450# vdd 0.04143f
C112 m1_4906_9490# a_3036_4156# 0.00404f
C113 vsn m1_4760_1320# 0
C114 m1_5516_1920# vdd 0.03975f
C115 a_5188_4156# a_3036_4156# 0.27107f
C116 vgp6 vsp 1.5758f
C117 m1_3666_9610# m1_3898_9610# 0.08953f
C118 m1_6282_1450# vgln 0.19109f
C119 m1_6020_10200# vgp5 0.01029f
C120 vgn5 a_7580_5314# 0.26387f
C121 vgp3 vgp6 0.38706f
C122 vgp6 a_7580_5314# 1.8657f
C123 m1_3898_9610# a_3036_4156# 0
C124 m1_5516_1920# vgln 0.29348f
C125 m1_6020_10200# m1_5022_10210# 0.0182f
C126 vglp a_4580_5314# 0
C127 a_1580_5314# vsn 0.16559f
C128 vgn3 vsn 1.08253f
C129 m1_4906_9490# a_5188_4156# 0
C130 vglp vgp5 0.1447f
C131 m1_3530_1930# m1_4760_1320# 0
C132 vdd vsp 3.61245f
C133 m1_3898_9610# m1_4906_9490# 0.00256f
C134 vglp m1_5022_10210# 0.22247f
C135 vdd a_7580_5314# 0.83515f
C136 vgp3 vdd 3.78758f
C137 m1_4538_1930# m1_4760_1320# 0.16397f
C138 a_1580_5314# a_3036_4156# 0.14234f
C139 vgn3 a_3036_4156# 0.80773f
C140 vgln a_7580_5314# 0.10386f
C141 vglp m1_6020_10200# 0.27284f
C142 vglp in_p 0.7203f
C143 vgn3 m1_3530_1930# 0.04819f
C144 a_4580_5314# vgn5 0.10109f
C145 a_4580_5314# vgp6 0.58598f
C146 a_1580_5314# m1_4538_1930# 0.00316f
C147 m1_4538_1930# vgn3 0.08119f
C148 vgp5 vgn5 0.0996f
C149 vgp5 vgp6 0.35193f
C150 m1_5022_10210# vgp6 0.00778f
C151 a_1580_5314# a_5188_4156# 0.12061f
C152 m1_4538_1930# m1_6282_1450# 0
C153 a_4580_5314# vdd 1.73154f
C154 vsn a_7580_5314# 0.31213f
C155 a_1580_5314# m1_4760_1320# -0.02087f
C156 m1_4538_1930# m1_5516_1920# 0.04505f
C157 vgp5 vdd 3.48321f
C158 vgn3 m1_4760_1320# 0.12142f
C159 m1_6020_10200# vgp6 0.04538f
C160 in_p vgp6 0
C161 a_5188_4156# m1_6282_1450# 0.00163f
C162 vdd m1_5022_10210# 0.0596f
C163 a_4580_5314# vgln 0.49007f
C164 m1_3666_9610# vsp 0.00336f
C165 a_5188_4156# m1_5516_1920# 0
C166 m1_3666_9610# vgp3 0
C167 a_3036_4156# vsp 0.0883f
C168 vglp vgp6 0.49335f
C169 vgp3 a_3036_4156# 0.03477f
C170 a_3036_4156# a_7580_5314# 0.0745f
C171 m1_6282_1450# m1_4760_1320# 0
C172 m1_6020_10200# vdd 0.18314f
C173 a_1580_5314# vgn3 0.04478f
C174 in_p vdd 1.4091f
C175 m1_4906_9490# vsp 0.00394f
C176 m1_4906_9490# vgp3 0.0279f
C177 vglp vdd 5.16392f
C178 a_5188_4156# vsp 0.36532f
C179 a_4580_5314# vsn 0.36645f
C180 a_1580_5314# vss 1.70876f
C181 m1_4906_9490# vss -0.04028f
C182 m1_3898_9610# vss 0.09303f
C183 m1_3666_9610# vss -0.03204f
C184 in_p vss -0
C185 vglp vss -0.37909f
C186 m1_4538_1930# vss 0.07674f
C187 m1_3530_1930# vss 0.05197f
C188 m1_3298_2050# vss 0.04402f
C189 vdd vss 86.64923f
C190 in_n vss 1.35999f
C191 vgln vss 3.3753f
C192 vgn5 vss 4.03953f
C193 a_5188_4156# vss 1.44532f
C194 vsp vss -0.14973f
C195 a_7580_5314# vss 1.40837f
C196 vsn vss 4.2523f
C197 a_3036_4156# vss 1.80989f
C198 vgn3 vss 3.02208f
C199 vgp6 vss 2.43502f
C200 a_4580_5314# vss 3.24613f
C201 vgp5 vss 1.91603f
C202 m1_6282_1450# vss 0.17092f
C203 m1_5516_1920# vss -0.01345f
C204 m1_4760_1320# vss -0.06206f
C205 vgp3 vss 2.7134f
C206 m1_6020_10200# vss -0.16436f
C207 m1_5022_10210# vss -0.09509f
.ends

.subckt p_w1_l0p28_f2 a_n196_n100# a_n52_n100# w_n282_n230# a_108_n100# a_52_n144#
+ a_n108_n144# VSUBS
X0 a_n52_n100# a_n108_n144# a_n196_n100# w_n282_n230# pfet_03v3 ad=0.26p pd=1.52u as=0.44p ps=2.88u w=1u l=0.28u
X1 a_108_n100# a_52_n144# a_n52_n100# w_n282_n230# pfet_03v3 ad=0.44p pd=2.88u as=0.26p ps=1.52u w=1u l=0.28u
C0 w_n282_n230# a_108_n100# 0.01808f
C1 w_n282_n230# a_n108_n144# 0.05505f
C2 w_n282_n230# a_n196_n100# 0.01808f
C3 w_n282_n230# a_52_n144# 0.05505f
C4 a_n52_n100# w_n282_n230# 0.01828f
C5 a_52_n144# a_108_n100# 0.00769f
C6 a_n108_n144# a_n196_n100# 0.00769f
C7 a_n108_n144# a_52_n144# 0.00519f
C8 a_n52_n100# a_108_n100# 0.04256f
C9 a_n52_n100# a_n108_n144# 0.00769f
C10 a_n52_n100# a_n196_n100# 0.04256f
C11 a_n52_n100# a_52_n144# 0.00769f
C12 a_108_n100# VSUBS 0.0563f
C13 a_n52_n100# VSUBS 0.03533f
C14 a_n196_n100# VSUBS 0.0563f
C15 w_n282_n230# VSUBS 0.77832f
.ends

.subckt n_w0p5_l0p28_f2 a_n52_n50# a_n196_n50# a_52_n94# a_108_n50# a_n108_n94# VSUBS
X0 a_108_n50# a_52_n94# a_n52_n50# VSUBS nfet_03v3 ad=0.22p pd=1.88u as=0.13p ps=1.02u w=0.5u l=0.28u
X1 a_n52_n50# a_n108_n94# a_n196_n50# VSUBS nfet_03v3 ad=0.13p pd=1.02u as=0.22p ps=1.88u w=0.5u l=0.28u
C0 a_n108_n94# a_52_n94# 0.00519f
C1 a_n108_n94# a_n52_n50# 0.00377f
C2 a_n108_n94# a_n196_n50# 0.00377f
C3 a_52_n94# a_n52_n50# 0.00377f
C4 a_108_n50# a_52_n94# 0.00377f
C5 a_n196_n50# a_n52_n50# 0.02085f
C6 a_108_n50# a_n52_n50# 0.02085f
C7 a_108_n50# VSUBS 0.07479f
C8 a_n52_n50# VSUBS 0.09458f
C9 a_n196_n50# VSUBS 0.07479f
.ends

.subckt p_w2_l2_f7 a_n704_n244# a_n808_n200# a_304_n244# a_n1712_n244# a_1712_n200#
+ a_n1800_n200# a_n1208_n244# a_1208_n200# a_200_n200# a_1312_n244# a_808_n244# a_n200_n244#
+ a_n304_n200# w_n1886_n330# a_n1312_n200# a_704_n200# VSUBS
X0 a_n1312_n200# a_n1712_n244# a_n1800_n200# w_n1886_n330# pfet_03v3 ad=0.52p pd=2.52u as=0.88p ps=4.88u w=2u l=2u
X1 a_n304_n200# a_n704_n244# a_n808_n200# w_n1886_n330# pfet_03v3 ad=0.52p pd=2.52u as=0.52p ps=2.52u w=2u l=2u
X2 a_200_n200# a_n200_n244# a_n304_n200# w_n1886_n330# pfet_03v3 ad=0.52p pd=2.52u as=0.52p ps=2.52u w=2u l=2u
X3 a_1712_n200# a_1312_n244# a_1208_n200# w_n1886_n330# pfet_03v3 ad=0.88p pd=4.88u as=0.52p ps=2.52u w=2u l=2u
X4 a_1208_n200# a_808_n244# a_704_n200# w_n1886_n330# pfet_03v3 ad=0.52p pd=2.52u as=0.52p ps=2.52u w=2u l=2u
X5 a_n808_n200# a_n1208_n244# a_n1312_n200# w_n1886_n330# pfet_03v3 ad=0.52p pd=2.52u as=0.52p ps=2.52u w=2u l=2u
X6 a_704_n200# a_304_n244# a_200_n200# w_n1886_n330# pfet_03v3 ad=0.52p pd=2.52u as=0.52p ps=2.52u w=2u l=2u
C0 a_704_n200# a_1208_n200# 0.02133f
C1 a_1312_n244# a_1208_n200# 0.0587f
C2 w_n1886_n330# a_704_n200# 0.09155f
C3 w_n1886_n330# a_1312_n244# 0.2233f
C4 a_n1800_n200# a_n1312_n200# 0.02133f
C5 w_n1886_n330# a_304_n244# 0.21994f
C6 w_n1886_n330# a_n1712_n244# 0.2233f
C7 a_n808_n200# a_n704_n244# 0.0587f
C8 a_1312_n244# a_1712_n200# 0.0587f
C9 a_n808_n200# a_n1208_n244# 0.0587f
C10 w_n1886_n330# a_n704_n244# 0.21994f
C11 w_n1886_n330# a_n1208_n244# 0.21994f
C12 a_n200_n244# w_n1886_n330# 0.21994f
C13 a_n808_n200# a_n1312_n200# 0.02133f
C14 a_200_n200# a_n304_n200# 0.02133f
C15 w_n1886_n330# a_n1312_n200# 0.09155f
C16 w_n1886_n330# a_n1800_n200# 0.0618f
C17 a_704_n200# a_808_n244# 0.0587f
C18 a_808_n244# a_1312_n244# 0.00519f
C19 a_704_n200# a_200_n200# 0.02133f
C20 a_808_n244# a_304_n244# 0.00519f
C21 w_n1886_n330# a_1208_n200# 0.09155f
C22 a_200_n200# a_304_n244# 0.0587f
C23 w_n1886_n330# a_n808_n200# 0.09155f
C24 a_n304_n200# a_n704_n244# 0.0587f
C25 a_1208_n200# a_1712_n200# 0.02133f
C26 a_n200_n244# a_n304_n200# 0.0587f
C27 w_n1886_n330# a_1712_n200# 0.0618f
C28 a_n200_n244# a_200_n200# 0.0587f
C29 a_704_n200# a_304_n244# 0.0587f
C30 a_n1712_n244# a_n1208_n244# 0.00519f
C31 a_808_n244# a_1208_n200# 0.0587f
C32 a_n200_n244# a_304_n244# 0.00519f
C33 a_n808_n200# a_n304_n200# 0.02133f
C34 a_n1208_n244# a_n704_n244# 0.00519f
C35 w_n1886_n330# a_808_n244# 0.21994f
C36 w_n1886_n330# a_n304_n200# 0.09155f
C37 a_n200_n244# a_n704_n244# 0.00519f
C38 a_n1712_n244# a_n1312_n200# 0.0587f
C39 w_n1886_n330# a_200_n200# 0.09155f
C40 a_n1712_n244# a_n1800_n200# 0.0587f
C41 a_n1312_n200# a_n1208_n244# 0.0587f
C42 a_1712_n200# VSUBS 0.13364f
C43 a_1208_n200# VSUBS 0.12191f
C44 a_704_n200# VSUBS 0.11851f
C45 a_200_n200# VSUBS 0.11851f
C46 a_n304_n200# VSUBS 0.11851f
C47 a_n808_n200# VSUBS 0.11851f
C48 a_n1312_n200# VSUBS 0.12191f
C49 a_n1800_n200# VSUBS 0.13364f
C50 w_n1886_n330# VSUBS 7.46856f
.ends

.subckt p_w0p5_l0p5_f2 a_n52_n50# w_n326_n180# a_52_n94# a_152_n50# a_n240_n50# a_n152_n94#
+ VSUBS
X0 a_152_n50# a_52_n94# a_n52_n50# w_n326_n180# pfet_03v3 ad=0.22p pd=1.88u as=0.13p ps=1.02u w=0.5u l=0.5u
X1 a_n52_n50# a_n152_n94# a_n240_n50# w_n326_n180# pfet_03v3 ad=0.13p pd=1.02u as=0.22p ps=1.88u w=0.5u l=0.5u
C0 a_n52_n50# a_152_n50# 0.01511f
C1 a_n52_n50# a_52_n94# 0.00625f
C2 a_n152_n94# a_52_n94# 0.00519f
C3 a_n52_n50# a_n152_n94# 0.00625f
C4 a_n52_n50# a_n240_n50# 0.01511f
C5 a_n240_n50# a_n152_n94# 0.00625f
C6 w_n326_n180# a_152_n50# 0.01152f
C7 w_n326_n180# a_52_n94# 0.07657f
C8 w_n326_n180# a_n52_n50# 0.01225f
C9 w_n326_n180# a_n152_n94# 0.07657f
C10 w_n326_n180# a_n240_n50# 0.01152f
C11 a_52_n94# a_152_n50# 0.00625f
C12 a_152_n50# VSUBS 0.04588f
C13 a_n52_n50# VSUBS 0.04684f
C14 a_n240_n50# VSUBS 0.04588f
C15 w_n326_n180# VSUBS 0.70416f
.ends

.subckt idac_p b0 b1 b2 b3 b4 out vss m1_988_3644# vdd m1_988_2984# a_528_4572# a_1378_4572#
+ a_3078_4572# a_3928_4572# g m1_988_1168# a_2228_4572# dump m1_650_4492# vsp a_1582_4572#
+ a_4132_4572# a_2432_4572# m1_1460_4102# a_732_4572# vcas a_3282_4572#
XU4b vsp vsp m1_988_1168# g g vdd m1_988_1168# g m1_988_1168# g m1_988_1168# vsp vsp
+ g g g g vsp vss p_w2_l2_f8
XU3 vsp vsp m1_988_2984# g g vdd m1_988_2984# g m1_988_2984# g m1_988_2984# vsp vsp
+ g g g g vsp vss p_w2_l2_f8
XIP0 a_528_4572# vdd vdd a_732_4572# a_528_4572# b0 vss p_w1_l0p28_f2
XIP1 a_1378_4572# vdd vdd a_1582_4572# a_1378_4572# b1 vss p_w1_l0p28_f2
XIN0 vcas a_528_4572# a_528_4572# a_732_4572# b0 vss n_w0p5_l0p28_f2
XIP2 a_2228_4572# vdd vdd a_2432_4572# a_2228_4572# b2 vss p_w1_l0p28_f2
XIN1 vcas a_1378_4572# a_1378_4572# a_1582_4572# b1 vss n_w0p5_l0p28_f2
XIP3 a_3078_4572# vdd vdd a_3282_4572# a_3078_4572# b3 vss p_w1_l0p28_f2
XIN3 vcas a_3078_4572# a_3078_4572# a_3282_4572# b3 vss n_w0p5_l0p28_f2
XIN2 vcas a_2228_4572# a_2228_4572# a_2432_4572# b2 vss n_w0p5_l0p28_f2
XIP4 a_3928_4572# vdd vdd a_4132_4572# a_3928_4572# b4 vss p_w1_l0p28_f2
XIN4 vcas a_3928_4572# a_3928_4572# a_4132_4572# b4 vss n_w0p5_l0p28_f2
XU210 g vsp g g m1_650_4492# vsp g vsp vsp g g g m1_988_3644# vdd m1_988_3644# m1_1460_4102#
+ vss p_w2_l2_f7
XSW0 m1_650_4492# vdd a_732_4572# dump out a_528_4572# vss p_w0p5_l0p5_f2
XSW2 m1_988_3644# vdd a_2432_4572# dump out a_2228_4572# vss p_w0p5_l0p5_f2
XSW1 m1_1460_4102# vdd a_1582_4572# dump out a_1378_4572# vss p_w0p5_l0p5_f2
XSW3 m1_988_2984# vdd a_3282_4572# dump out a_3078_4572# vss p_w0p5_l0p5_f2
XSW4 m1_988_1168# vdd a_4132_4572# dump out a_3928_4572# vss p_w0p5_l0p5_f2
XU4a vsp vsp m1_988_1168# g g vdd m1_988_1168# g m1_988_1168# g m1_988_1168# vsp vsp
+ g g g g vsp vss p_w2_l2_f8
C0 a_3928_4572# g 0
C1 a_732_4572# vcas 0.04204f
C2 vsp dump 0
C3 m1_1460_4102# dump 0.14116f
C4 out g 0.09093f
C5 m1_988_2984# g 1.08988f
C6 vdd a_4132_4572# 0.34563f
C7 dump m1_988_1168# 0.14336f
C8 a_3078_4572# a_2228_4572# 0.01385f
C9 a_4132_4572# a_3928_4572# 0.13001f
C10 a_1378_4572# g 0.00659f
C11 vcas a_1582_4572# 0.05158f
C12 out a_4132_4572# 0
C13 a_3078_4572# dump 0.09418f
C14 a_3078_4572# b3 0.13359f
C15 a_528_4572# g 0.00514f
C16 vdd vcas 0.54087f
C17 b1 g 0
C18 a_3078_4572# a_3282_4572# 0.33407f
C19 vcas a_3928_4572# 0.16267f
C20 out vcas 0.09048f
C21 b0 g 0
C22 m1_1460_4102# g 0.50847f
C23 vsp g 4.06891f
C24 b2 m1_988_3644# 0.00149f
C25 dump b4 0
C26 g m1_988_1168# 2.25905f
C27 b3 b4 0.00638f
C28 a_1378_4572# vcas 0.1047f
C29 a_3282_4572# b4 0.00266f
C30 vsp a_4132_4572# 0
C31 a_4132_4572# m1_988_1168# 0.0253f
C32 a_528_4572# vcas 0.06041f
C33 b1 vcas 0.26352f
C34 a_3078_4572# g 0.00748f
C35 m1_650_4492# a_732_4572# 0.01944f
C36 vdd a_2432_4572# 0.37857f
C37 b0 vcas 0.04594f
C38 a_2432_4572# a_3928_4572# 0
C39 a_3078_4572# a_4132_4572# 0.25655f
C40 m1_650_4492# a_1582_4572# 0
C41 out a_2432_4572# 0.07529f
C42 a_2432_4572# m1_988_2984# 0
C43 vdd m1_650_4492# 1.01833f
C44 m1_988_3644# a_2228_4572# 0.03738f
C45 m1_650_4492# a_3928_4572# 0.001f
C46 a_3078_4572# vcas 0.58185f
C47 b2 a_2228_4572# 0.06497f
C48 out m1_650_4492# 0.09864f
C49 a_4132_4572# b4 0.15044f
C50 m1_650_4492# m1_988_2984# 0.40258f
C51 m1_988_3644# dump 0.16715f
C52 m1_988_3644# a_3282_4572# 0
C53 a_1378_4572# m1_650_4492# 0
C54 b2 dump 0.02903f
C55 b2 b3 0.15952f
C56 b2 a_3282_4572# 0
C57 a_2432_4572# m1_1460_4102# 0.00133f
C58 vcas b4 0.03901f
C59 a_528_4572# m1_650_4492# 0.02127f
C60 b0 m1_650_4492# 0.00204f
C61 a_3078_4572# a_2432_4572# 0.03391f
C62 m1_650_4492# vsp 0.25939f
C63 m1_650_4492# m1_1460_4102# 0.00149f
C64 m1_650_4492# m1_988_1168# 0.39889f
C65 m1_988_3644# g 0.39331f
C66 b2 g 0
C67 dump a_2228_4572# 0.14613f
C68 b3 a_2228_4572# 0.00203f
C69 a_3078_4572# m1_650_4492# 0.01008f
C70 a_2432_4572# b4 0
C71 a_2228_4572# a_3282_4572# 0
C72 b3 dump 0
C73 dump a_3282_4572# 0.0467f
C74 b3 a_3282_4572# 0.00365f
C75 m1_650_4492# b4 0
C76 b2 vcas 0.24768f
C77 a_2228_4572# g 0.00234f
C78 a_732_4572# a_1582_4572# 0.002f
C79 dump g 0.2083f
C80 b3 g 0
C81 vdd a_732_4572# 0.36344f
C82 a_3282_4572# g 0.00246f
C83 a_2432_4572# m1_988_3644# 0.00185f
C84 a_4132_4572# dump 0.05544f
C85 b3 a_4132_4572# 0
C86 out a_732_4572# 0.18479f
C87 a_2432_4572# b2 0.16627f
C88 vdd a_1582_4572# 0.37736f
C89 a_4132_4572# a_3282_4572# 0.0018f
C90 vcas a_2228_4572# 0.3011f
C91 a_1378_4572# a_732_4572# 0.0125f
C92 out a_1582_4572# 0.09368f
C93 m1_650_4492# m1_988_3644# 0.06805f
C94 vcas dump 0.17396f
C95 b3 vcas 0.14476f
C96 vdd a_3928_4572# 0.55267f
C97 a_528_4572# a_732_4572# 0.17763f
C98 a_1378_4572# a_1582_4572# 0.14513f
C99 vcas a_3282_4572# 0.03139f
C100 out vdd 1.37197f
C101 a_732_4572# b1 0
C102 vdd m1_988_2984# 0.25832f
C103 out a_3928_4572# 0.00526f
C104 m1_988_2984# a_3928_4572# 0
C105 a_528_4572# a_1582_4572# 0.00112f
C106 a_1378_4572# vdd 0.52764f
C107 b0 a_732_4572# 0.00646f
C108 out m1_988_2984# 0.09522f
C109 b1 a_1582_4572# 0.32231f
C110 a_4132_4572# g 0
C111 a_1378_4572# out 0.31303f
C112 a_528_4572# vdd 0.60074f
C113 b0 a_1582_4572# 0
C114 a_2432_4572# a_2228_4572# 0.11855f
C115 vdd b1 0.23981f
C116 m1_1460_4102# a_1582_4572# 0.01157f
C117 a_528_4572# out 0.05579f
C118 a_2432_4572# dump 0.0666f
C119 a_2432_4572# b3 0.00219f
C120 b0 vdd 0.33876f
C121 out b1 0.27469f
C122 vdd vsp 2.37304f
C123 vdd m1_1460_4102# 0.31124f
C124 a_2432_4572# a_3282_4572# 0
C125 vdd m1_988_1168# 0.86013f
C126 a_528_4572# a_1378_4572# 0.00565f
C127 m1_650_4492# a_2228_4572# 0
C128 a_1378_4572# b1 0.10949f
C129 b0 out 0.01451f
C130 vsp a_3928_4572# 0
C131 a_4132_4572# vcas 0.08601f
C132 out vsp 0.00962f
C133 out m1_1460_4102# 0.05383f
C134 a_3928_4572# m1_988_1168# 0.02302f
C135 vsp m1_988_2984# 0.2942f
C136 m1_988_2984# m1_1460_4102# 0.05766f
C137 out m1_988_1168# 0.03455f
C138 m1_988_2984# m1_988_1168# 0.4309f
C139 m1_650_4492# dump 0.05484f
C140 b0 a_1378_4572# 0
C141 a_528_4572# b1 0.00166f
C142 a_3078_4572# vdd 0.94665f
C143 a_1378_4572# m1_1460_4102# 0.03861f
C144 a_3078_4572# a_3928_4572# 0.20614f
C145 a_528_4572# b0 0.25598f
C146 a_3078_4572# out 0.14081f
C147 b0 b1 0.00881f
C148 a_528_4572# vsp 0
C149 a_3078_4572# m1_988_2984# 0.01439f
C150 b1 m1_1460_4102# 0
C151 a_2432_4572# g 0.00216f
C152 vdd b4 0.58144f
C153 b0 vsp 0
C154 vsp m1_1460_4102# 0.04575f
C155 a_3928_4572# b4 0.15141f
C156 vsp m1_988_1168# 0.61316f
C157 m1_650_4492# g 1.86486f
C158 a_2432_4572# vcas 0.11606f
C159 m1_650_4492# a_4132_4572# 0
C160 a_3078_4572# vsp 0.00385f
C161 a_3078_4572# m1_1460_4102# 0
C162 a_3078_4572# m1_988_1168# 0.04118f
C163 a_732_4572# m1_988_3644# 0
C164 m1_988_3644# a_1582_4572# 0.00521f
C165 vsp b4 0
C166 b2 a_1582_4572# 0
C167 b4 m1_988_1168# 0
C168 vdd m1_988_3644# 0.15596f
C169 vdd b2 0.40027f
C170 out m1_988_3644# 0.09583f
C171 m1_988_2984# m1_988_3644# 0.03286f
C172 a_3078_4572# b4 0.13901f
C173 out b2 0.01202f
C174 a_1378_4572# m1_988_3644# 0.00163f
C175 a_1378_4572# b2 0.00157f
C176 m1_988_3644# b1 0
C177 a_732_4572# dump 0.06755f
C178 b2 b1 0.00252f
C179 a_2228_4572# a_1582_4572# 0.0132f
C180 vsp m1_988_3644# 0.07096f
C181 m1_988_3644# m1_1460_4102# 0.14466f
C182 dump a_1582_4572# 0.18244f
C183 vdd a_2228_4572# 0.55826f
C184 b2 m1_1460_4102# 0
C185 out a_2228_4572# 0.1275f
C186 vdd dump 0.99313f
C187 vdd b3 0.30654f
C188 a_3078_4572# m1_988_3644# 0
C189 vdd a_3282_4572# 0.58819f
C190 b3 a_3928_4572# 0
C191 a_3928_4572# dump 0.01456f
C192 out dump 0.48021f
C193 out b3 0.00306f
C194 a_1378_4572# a_2228_4572# 0.0022f
C195 m1_988_2984# dump 0.09035f
C196 m1_988_2984# b3 0.00137f
C197 a_3078_4572# b2 0.00501f
C198 a_3928_4572# a_3282_4572# 0.14401f
C199 a_732_4572# g 0.00218f
C200 out a_3282_4572# 0.05302f
C201 m1_988_2984# a_3282_4572# 0.02053f
C202 a_1378_4572# dump 0.06699f
C203 b1 a_2228_4572# 0
C204 a_1582_4572# g 0.0023f
C205 a_528_4572# dump 0
C206 b2 b4 0
C207 b1 dump 0.24305f
C208 m1_1460_4102# a_2228_4572# 0
C209 vdd g 9.02222f
C210 m1_988_1168# vss 0.1501f
C211 vsp vss 0.05972f
C212 g vss -2.69355f
C213 vdd vss 31.94884f
C214 a_4132_4572# vss 0.0154f
C215 a_3928_4572# vss 0.05244f
C216 a_3282_4572# vss 0.04518f
C217 a_3078_4572# vss 0.45712f
C218 a_1582_4572# vss -0.05476f
C219 a_1378_4572# vss 0.05508f
C220 a_2432_4572# vss -0.05086f
C221 a_2228_4572# vss 0.02015f
C222 dump vss 0.03637f
C223 out vss 0.27373f
C224 a_732_4572# vss -0.03275f
C225 a_528_4572# vss 0.12165f
C226 m1_650_4492# vss 0.07291f
C227 m1_1460_4102# vss -0.02161f
C228 m1_988_3644# vss -0.03566f
C229 b4 vss 0.76939f
C230 b3 vss 0.2234f
C231 b2 vss 0.46373f
C232 vcas vss 1.24466f
C233 b1 vss 0.25118f
C234 b0 vss 0.51454f
C235 m1_988_2984# vss -0.00584f
.ends

.subckt r_w4_l3p97 a_n400_n519# a_n400_397# VSUBS
X0 a_n400_397# a_n400_n519# VSUBS ppolyf_u_1k r_width=4u r_length=3.97u
C0 a_n400_397# a_n400_n519# 0.02123f
C1 a_n400_n519# VSUBS 0.80683f
C2 a_n400_397# VSUBS 0.80683f
.ends

.subckt n_w8_l0p5 a_50_n800# a_n50_n844# a_n138_n800# VSUBS
X0 a_50_n800# a_n50_n844# a_n138_n800# VSUBS nfet_03v3 ad=3.52p pd=16.88u as=3.52p ps=16.88u w=8u l=0.5u
C0 a_n138_n800# a_50_n800# 0.25117f
C1 a_n138_n800# a_n50_n844# 0.10385f
C2 a_n50_n844# a_50_n800# 0.10385f
C3 a_50_n800# VSUBS 0.38495f
C4 a_n138_n800# VSUBS 0.38495f
.ends

.subckt n_w4_l0p5 a_n138_n400# a_50_n400# a_n50_n444# VSUBS
X0 a_50_n400# a_n50_n444# a_n138_n400# VSUBS nfet_03v3 ad=1.76p pd=8.88u as=1.76p ps=8.88u w=4u l=0.5u
C0 a_n138_n400# a_50_n400# 0.12527f
C1 a_n138_n400# a_n50_n444# 0.05179f
C2 a_n50_n444# a_50_n400# 0.05179f
C3 a_50_n400# VSUBS 0.23105f
C4 a_n138_n400# VSUBS 0.23105f
.ends

.subckt n_w0p5_l0p28 a_n28_n94# a_n116_n50# a_28_n50# VSUBS
X0 a_28_n50# a_n28_n94# a_n116_n50# VSUBS nfet_03v3 ad=0.22p pd=1.88u as=0.22p ps=1.88u w=0.5u l=0.28u
C0 a_n116_n50# a_28_n50# 0.02085f
C1 a_n116_n50# a_n28_n94# 0.00377f
C2 a_n28_n94# a_28_n50# 0.00377f
C3 a_28_n50# VSUBS 0.07987f
C4 a_n116_n50# VSUBS 0.07987f
.ends

.subckt p_w1_l0p28 w_n202_n230# a_28_n100# a_n28_n144# a_n116_n100# VSUBS
X0 a_28_n100# a_n28_n144# a_n116_n100# w_n202_n230# pfet_03v3 ad=0.44p pd=2.88u as=0.44p ps=2.88u w=1u l=0.28u
C0 a_n28_n144# a_n116_n100# 0.00769f
C1 a_n28_n144# w_n202_n230# 0.05841f
C2 a_n116_n100# a_28_n100# 0.04256f
C3 w_n202_n230# a_28_n100# 0.01808f
C4 a_n28_n144# a_28_n100# 0.00769f
C5 w_n202_n230# a_n116_n100# 0.01808f
C6 a_28_n100# VSUBS 0.0597f
C7 a_n116_n100# VSUBS 0.0597f
C8 w_n202_n230# VSUBS 0.55752f
.ends

.subckt p_w2_l2_f4 a_n52_n200# a_452_n200# a_n452_n244# a_n556_n200# a_52_n244# a_956_n200#
+ a_n1044_n200# w_n1130_n330# a_n956_n244# a_556_n244# VSUBS
X0 a_452_n200# a_52_n244# a_n52_n200# w_n1130_n330# pfet_03v3 ad=0.52p pd=2.52u as=0.52p ps=2.52u w=2u l=2u
X1 a_956_n200# a_556_n244# a_452_n200# w_n1130_n330# pfet_03v3 ad=0.88p pd=4.88u as=0.52p ps=2.52u w=2u l=2u
X2 a_n556_n200# a_n956_n244# a_n1044_n200# w_n1130_n330# pfet_03v3 ad=0.52p pd=2.52u as=0.88p ps=4.88u w=2u l=2u
X3 a_n52_n200# a_n452_n244# a_n556_n200# w_n1130_n330# pfet_03v3 ad=0.52p pd=2.52u as=0.52p ps=2.52u w=2u l=2u
C0 a_556_n244# a_956_n200# 0.0587f
C1 a_n52_n200# a_52_n244# 0.0587f
C2 a_n956_n244# a_n452_n244# 0.00519f
C3 a_556_n244# a_52_n244# 0.00519f
C4 a_n52_n200# a_n452_n244# 0.0587f
C5 a_452_n200# w_n1130_n330# 0.09155f
C6 w_n1130_n330# a_n556_n200# 0.09155f
C7 a_n556_n200# a_n1044_n200# 0.02133f
C8 w_n1130_n330# a_n1044_n200# 0.0618f
C9 a_n956_n244# a_n556_n200# 0.0587f
C10 a_n956_n244# w_n1130_n330# 0.2233f
C11 a_n956_n244# a_n1044_n200# 0.0587f
C12 a_n452_n244# a_52_n244# 0.00519f
C13 a_n52_n200# a_452_n200# 0.02133f
C14 a_n52_n200# a_n556_n200# 0.02133f
C15 a_452_n200# a_556_n244# 0.0587f
C16 a_n52_n200# w_n1130_n330# 0.09155f
C17 w_n1130_n330# a_556_n244# 0.2233f
C18 a_452_n200# a_956_n200# 0.02133f
C19 w_n1130_n330# a_956_n200# 0.0618f
C20 a_452_n200# a_52_n244# 0.0587f
C21 w_n1130_n330# a_52_n244# 0.21994f
C22 a_n556_n200# a_n452_n244# 0.0587f
C23 w_n1130_n330# a_n452_n244# 0.21994f
C24 a_956_n200# VSUBS 0.13364f
C25 a_452_n200# VSUBS 0.12191f
C26 a_n52_n200# VSUBS 0.11851f
C27 a_n556_n200# VSUBS 0.12191f
C28 a_n1044_n200# VSUBS 0.13364f
C29 w_n1130_n330# VSUBS 4.4748f
.ends

.subckt p_w2_l0p5 a_50_n200# a_n50_n244# w_n224_n330# a_n138_n200# VSUBS
X0 a_50_n200# a_n50_n244# a_n138_n200# w_n224_n330# pfet_03v3 ad=0.88p pd=4.88u as=0.88p ps=4.88u w=2u l=0.5u
C0 a_n50_n244# a_n138_n200# 0.02577f
C1 a_50_n200# w_n224_n330# 0.03848f
C2 w_n224_n330# a_n138_n200# 0.03848f
C3 w_n224_n330# a_n50_n244# 0.07993f
C4 a_50_n200# a_n138_n200# 0.06232f
C5 a_50_n200# a_n50_n244# 0.02577f
C6 a_50_n200# VSUBS 0.0978f
C7 a_n138_n200# VSUBS 0.0978f
C8 w_n224_n330# VSUBS 0.88704f
.ends

.subckt n_w2_l0p5 a_50_n200# a_n50_n244# a_n138_n200# VSUBS
X0 a_50_n200# a_n50_n244# a_n138_n200# VSUBS nfet_03v3 ad=0.88p pd=4.88u as=0.88p ps=4.88u w=2u l=0.5u
C0 a_n138_n200# a_50_n200# 0.06232f
C1 a_n50_n244# a_50_n200# 0.02577f
C2 a_n50_n244# a_n138_n200# 0.02577f
C3 a_50_n200# VSUBS 0.1541f
C4 a_n138_n200# VSUBS 0.1541f
.ends

.subckt p_w4_l0p5 a_n138_n400# a_50_n400# a_n50_n444# w_n224_n530# VSUBS
X0 a_50_n400# a_n50_n444# a_n138_n400# w_n224_n530# pfet_03v3 ad=1.76p pd=8.88u as=1.76p ps=8.88u w=4u l=0.5u
C0 a_n50_n444# a_n138_n400# 0.05179f
C1 a_50_n400# w_n224_n530# 0.07442f
C2 w_n224_n530# a_n138_n400# 0.07442f
C3 w_n224_n530# a_n50_n444# 0.07993f
C4 a_50_n400# a_n138_n400# 0.12527f
C5 a_50_n400# a_n50_n444# 0.05179f
C6 a_50_n400# VSUBS 0.16249f
C7 a_n138_n400# VSUBS 0.16249f
C8 w_n224_n530# VSUBS 1.42464f
.ends

.subckt bias_master pad s0 s1 stim intref en in_n in_p iint a_1744_10100# en_b vbp_st
+ ua0_stim a_1744_9182# vss vdd a_1764_11418# a_2240_11218# a_420_700# a_736_7228#
+ a_736_5516#
XOP vss a_1744_10100# a_736_7228# vss n_w2_l2
XRS pad a_420_700# vss r_w4_l3p97
XS1 a_736_5516# s1 a_420_700# vss n_w8_l0p5
XS0 a_420_700# a_736_7228# s0 vss n_w4_l0p5
XOS vss vbp_st a_736_7228# vss n_w2_l2
XIENn en vss en_b vss n_w0p5_l0p28
XIENp vdd en_b en vdd vss p_w1_l0p28
XQX a_1744_9182# vdd a_1744_9182# vdd a_1744_9182# a_736_7228# a_736_7228# vdd a_1744_9182#
+ a_1744_9182# vss p_w2_l2_f4
XDXa vss vss a_736_5516# a_736_5516# a_736_5516# a_736_5516# a_736_5516# a_736_5516#
+ a_736_5516# a_736_5516# vss vss a_736_5516# a_736_5516# a_736_5516# a_736_5516#
+ vss vss n_w2_l2_f8
XOX vss a_1744_9182# a_736_5516# vss n_w2_l2
XDXb vss vss a_736_5516# a_736_5516# a_736_5516# a_736_5516# a_736_5516# a_736_5516#
+ a_736_5516# a_736_5516# vss vss a_736_5516# a_736_5516# a_736_5516# a_736_5516#
+ vss vss n_w2_l2_f8
XISTn stim vss a_1764_11418# vss n_w0p5_l0p28
XISTp vdd a_1764_11418# stim vdd vss p_w1_l0p28
XSWI a_736_7228# a_2240_11218# vdd iint vss p_w2_l0p5
XPD vdd a_1744_10100# a_1744_10100# in_p a_1744_10100# vdd vdd vdd a_1744_10100# a_1744_10100#
+ vss p_w2_l2_f4
XSTN ua0_stim stim a_420_700# vss n_w2_l0p5
XSTP a_420_700# ua0_stim a_1764_11418# vdd vss p_w4_l0p5
XPDN a_736_7228# vss en_b vss n_w4_l0p5
XDa vss vss a_736_7228# a_736_7228# a_736_7228# a_736_7228# a_736_7228# a_736_7228#
+ a_736_7228# a_736_7228# vss vss a_736_7228# a_736_7228# a_736_7228# a_736_7228#
+ vss vss n_w2_l2_f8
XDb vss vss a_736_7228# a_736_7228# a_736_7228# a_736_7228# a_736_7228# a_736_7228#
+ a_736_7228# a_736_7228# vss vss a_736_7228# a_736_7228# a_736_7228# a_736_7228#
+ vss vss n_w2_l2_f8
XIIRn intref vss a_2240_11218# vss n_w0p5_l0p28
XIIRp vdd a_2240_11218# intref vdd vss p_w1_l0p28
XON vss in_n a_736_7228# vss n_w2_l2
D0 vss a_420_700# diode_nd2ps_03v3 pj=22u area=10p
D1 a_420_700# vdd diode_pd2nw_03v3 pj=22u area=10p
C0 stim in_n 0
C1 a_420_700# ua0_stim 0.27553f
C2 a_736_5516# a_1764_11418# 0.29581f
C3 a_420_700# vdd 1.39245f
C4 stim a_1764_11418# 0.89967f
C5 a_2240_11218# a_736_5516# 0.20875f
C6 en a_420_700# 1.35379f
C7 vbp_st ua0_stim 0.28759f
C8 a_2240_11218# stim 0.02672f
C9 a_736_5516# intref 0.42454f
C10 vbp_st vdd 1.24211f
C11 stim intref 0.10135f
C12 a_420_700# s1 0.34537f
C13 en vbp_st 0.4389f
C14 a_420_700# a_736_7228# 0.60616f
C15 vbp_st a_736_7228# 0.19283f
C16 en_b ua0_stim 0.11556f
C17 en_b vdd 1.53555f
C18 en en_b 0.16284f
C19 a_420_700# pad 0.54069f
C20 en_b s1 0.04984f
C21 en_b a_736_7228# 0.01852f
C22 iint a_1744_10100# 0.0038f
C23 a_1744_9182# a_1744_10100# 0.21634f
C24 en_b pad 0.00118f
C25 a_1744_10100# in_p 0.1228f
C26 a_736_5516# ua0_stim 0.76166f
C27 stim ua0_stim 0.17275f
C28 vdd a_736_5516# 0.03946f
C29 en a_736_5516# 0.1206f
C30 vdd stim 0.43645f
C31 a_1744_10100# in_n 0
C32 en stim 0.16867f
C33 s1 a_736_5516# 0.04485f
C34 a_1744_10100# a_1764_11418# 0.20361f
C35 a_736_5516# a_736_7228# 0.94834f
C36 stim s1 0.05023f
C37 stim a_736_7228# 0.67831f
C38 a_2240_11218# a_1744_10100# 0.00646f
C39 a_1744_10100# intref 0.00123f
C40 stim pad 0.03728f
C41 iint in_p 0
C42 a_1744_9182# in_p 0.0074f
C43 a_1744_9182# in_n 0.05554f
C44 a_420_700# vbp_st 0.00221f
C45 iint a_1764_11418# 0.04831f
C46 a_1744_9182# a_1764_11418# 0.08433f
C47 in_n in_p 0.00893f
C48 a_2240_11218# iint 0.04705f
C49 a_2240_11218# a_1744_9182# 0.04423f
C50 s0 intref 0
C51 a_1744_9182# intref 0.06003f
C52 a_1764_11418# in_p 0.10845f
C53 a_420_700# en_b 0.00238f
C54 a_2240_11218# in_p 0
C55 in_n a_1764_11418# 0
C56 a_1744_10100# ua0_stim 0.0495f
C57 en_b vbp_st 0.22396f
C58 vdd a_1744_10100# 2.14231f
C59 en a_1744_10100# 0
C60 a_2240_11218# a_1764_11418# 0.0155f
C61 a_1744_10100# a_736_7228# 0.21495f
C62 intref a_1764_11418# 0.13911f
C63 a_2240_11218# intref 0.51277f
C64 a_420_700# a_736_5516# 0.22588f
C65 a_420_700# stim 0.39449f
C66 vbp_st a_736_5516# 0.01681f
C67 s0 ua0_stim 0
C68 iint ua0_stim 0.22215f
C69 a_1744_9182# ua0_stim 0
C70 vbp_st stim 0.03538f
C71 iint vdd 0.20167f
C72 vdd a_1744_9182# 1.89441f
C73 en s0 0.08622f
C74 en iint 0.04364f
C75 en a_1744_9182# 0
C76 in_p ua0_stim 0.13299f
C77 s1 s0 0.37932f
C78 en_b a_736_5516# 0.10641f
C79 vdd in_p 0.3992f
C80 s0 a_736_7228# 0.08339f
C81 iint a_736_7228# 0.07137f
C82 a_1744_9182# a_736_7228# 0.40049f
C83 en_b stim 0.09516f
C84 en in_p 0.1023f
C85 in_n ua0_stim 0.13986f
C86 vdd in_n 0.93129f
C87 en in_n 0.22085f
C88 in_p a_736_7228# 0.13123f
C89 a_1764_11418# ua0_stim 0.39761f
C90 vdd a_1764_11418# 0.9203f
C91 pad s0 0.04859f
C92 a_2240_11218# ua0_stim 0.01891f
C93 en a_1764_11418# 0.00964f
C94 in_n a_736_7228# 0.22106f
C95 a_2240_11218# vdd 1.56334f
C96 intref ua0_stim 0.38842f
C97 en a_2240_11218# 0.0689f
C98 vdd intref 1.1637f
C99 a_1764_11418# a_736_7228# 0.58069f
C100 en intref 0.18747f
C101 a_2240_11218# a_736_7228# 0.1092f
C102 s1 intref 0.00169f
C103 intref a_736_7228# 1.05564f
C104 stim a_736_5516# 0.46322f
C105 a_420_700# a_1744_10100# 0
C106 pad intref 0.04537f
C107 vbp_st a_1744_10100# 0.06941f
C108 en_b a_1744_10100# 0
C109 vdd ua0_stim 0.7438f
C110 en ua0_stim 0.04932f
C111 en vdd 1.40435f
C112 s1 ua0_stim 0
C113 a_736_7228# ua0_stim 0.65944f
C114 a_420_700# s0 0.23128f
C115 a_420_700# a_1744_9182# 0
C116 vdd s1 0
C117 vdd a_736_7228# 1.34623f
C118 en s1 0.05296f
C119 en a_736_7228# 0.06595f
C120 vbp_st iint 0.03426f
C121 vbp_st a_1744_9182# 0.27778f
C122 a_420_700# in_p 0.14384f
C123 s1 a_736_7228# 0.26174f
C124 vdd pad 0.30131f
C125 a_420_700# in_n 0.06513f
C126 vbp_st in_p 0.01109f
C127 en pad 0.07917f
C128 en_b s0 0
C129 en_b iint 0.00566f
C130 stim a_1744_10100# 0.5686f
C131 a_420_700# a_1764_11418# 0.01871f
C132 vbp_st in_n 0
C133 s1 pad 0.04303f
C134 pad a_736_7228# 0.00246f
C135 a_420_700# a_2240_11218# 0
C136 vbp_st a_1764_11418# 0.24107f
C137 a_420_700# intref 0.08048f
C138 vbp_st a_2240_11218# 0.09119f
C139 vbp_st intref 0.10375f
C140 en_b a_1764_11418# 0.04298f
C141 en_b a_2240_11218# 0.55285f
C142 a_736_5516# s0 0.00164f
C143 a_1744_9182# a_736_5516# 0.06682f
C144 en_b intref 0.13348f
C145 stim s0 0
C146 iint stim 0
C147 stim a_1744_9182# 0.09507f
C148 stim in_p 0
C149 in_n vss 0.4171f
C150 a_2240_11218# vss 1.12079f
C151 intref vss 1.56078f
C152 a_736_7228# vss 7.21627f
C153 en_b vss 2.84339f
C154 ua0_stim vss 1.3904f
C155 stim vss 1.68124f
C156 in_p vss 0.10852f
C157 iint vss -0.02046f
C158 a_1764_11418# vss 0.23987f
C159 a_1744_9182# vss -0.31499f
C160 a_736_5516# vss 5.14983f
C161 vdd vss 48.57603f
C162 en vss 2.99933f
C163 vbp_st vss 0.13312f
C164 a_420_700# vss 2.09001f
C165 s0 vss 0.69974f
C166 s1 vss 0.67954f
C167 pad vss 1.41208f
C168 a_1744_10100# vss -0.2385f
.ends

.subckt n_w2_l2_f7 a_n704_n244# a_n808_n200# a_304_n244# a_n1712_n244# a_1712_n200#
+ a_n1800_n200# a_n1208_n244# a_1208_n200# a_200_n200# a_1312_n244# a_808_n244# a_n200_n244#
+ a_n304_n200# a_n1312_n200# a_704_n200# VSUBS
X0 a_n304_n200# a_n704_n244# a_n808_n200# VSUBS nfet_03v3 ad=0.52p pd=2.52u as=0.52p ps=2.52u w=2u l=2u
X1 a_200_n200# a_n200_n244# a_n304_n200# VSUBS nfet_03v3 ad=0.52p pd=2.52u as=0.52p ps=2.52u w=2u l=2u
X2 a_1712_n200# a_1312_n244# a_1208_n200# VSUBS nfet_03v3 ad=0.88p pd=4.88u as=0.52p ps=2.52u w=2u l=2u
X3 a_1208_n200# a_808_n244# a_704_n200# VSUBS nfet_03v3 ad=0.52p pd=2.52u as=0.52p ps=2.52u w=2u l=2u
X4 a_704_n200# a_304_n244# a_200_n200# VSUBS nfet_03v3 ad=0.52p pd=2.52u as=0.52p ps=2.52u w=2u l=2u
X5 a_n1312_n200# a_n1712_n244# a_n1800_n200# VSUBS nfet_03v3 ad=0.52p pd=2.52u as=0.88p ps=4.88u w=2u l=2u
X6 a_n808_n200# a_n1208_n244# a_n1312_n200# VSUBS nfet_03v3 ad=0.52p pd=2.52u as=0.52p ps=2.52u w=2u l=2u
C0 a_n304_n200# a_n808_n200# 0.02133f
C1 a_n200_n244# a_304_n244# 0.00519f
C2 a_704_n200# a_304_n244# 0.0587f
C3 a_n704_n244# a_n200_n244# 0.00519f
C4 a_n304_n200# a_200_n200# 0.02133f
C5 a_1208_n200# a_704_n200# 0.02133f
C6 a_n1208_n244# a_n704_n244# 0.00519f
C7 a_n1208_n244# a_n1712_n244# 0.00519f
C8 a_n704_n244# a_n808_n200# 0.0587f
C9 a_n1800_n200# a_n1712_n244# 0.0587f
C10 a_n1208_n244# a_n808_n200# 0.0587f
C11 a_1712_n200# a_1312_n244# 0.0587f
C12 a_1208_n200# a_1712_n200# 0.02133f
C13 a_200_n200# a_n200_n244# 0.0587f
C14 a_1208_n200# a_1312_n244# 0.0587f
C15 a_808_n244# a_304_n244# 0.00519f
C16 a_808_n244# a_704_n200# 0.0587f
C17 a_n304_n200# a_n200_n244# 0.0587f
C18 a_200_n200# a_304_n244# 0.0587f
C19 a_200_n200# a_704_n200# 0.02133f
C20 a_n1712_n244# a_n1312_n200# 0.0587f
C21 a_n1208_n244# a_n1312_n200# 0.0587f
C22 a_n1312_n200# a_n808_n200# 0.02133f
C23 a_808_n244# a_1312_n244# 0.00519f
C24 a_1208_n200# a_808_n244# 0.0587f
C25 a_n1800_n200# a_n1312_n200# 0.02133f
C26 a_n704_n244# a_n304_n200# 0.0587f
C27 a_1712_n200# VSUBS 0.26162f
C28 a_1208_n200# VSUBS 0.34773f
C29 a_704_n200# VSUBS 0.34265f
C30 a_200_n200# VSUBS 0.34265f
C31 a_n304_n200# VSUBS 0.34265f
C32 a_n808_n200# VSUBS 0.34265f
C33 a_n1312_n200# VSUBS 0.34773f
C34 a_n1800_n200# VSUBS 0.26162f
.ends

.subckt n_w0p5_l0p5_f2 a_n52_n50# a_52_n94# a_152_n50# a_n240_n50# a_n152_n94# VSUBS
X0 a_152_n50# a_52_n94# a_n52_n50# VSUBS nfet_03v3 ad=0.22p pd=1.88u as=0.13p ps=1.02u w=0.5u l=0.5u
X1 a_n52_n50# a_n152_n94# a_n240_n50# VSUBS nfet_03v3 ad=0.13p pd=1.02u as=0.22p ps=1.88u w=0.5u l=0.5u
C0 a_n240_n50# a_n152_n94# 0.00625f
C1 a_n240_n50# a_n52_n50# 0.01511f
C2 a_n52_n50# a_n152_n94# 0.00625f
C3 a_52_n94# a_n152_n94# 0.00519f
C4 a_52_n94# a_n52_n50# 0.00625f
C5 a_n52_n50# a_152_n50# 0.01511f
C6 a_52_n94# a_152_n50# 0.00625f
C7 a_152_n50# VSUBS 0.09131f
C8 a_n52_n50# VSUBS 0.12761f
C9 a_n240_n50# VSUBS 0.09131f
.ends

.subckt idac_n b0 b1 b2 b3 b4 out vcas vdd vss m1_988_3644# a_528_4510# a_3928_4510#
+ a_3078_4510# m1_988_2984# a_732_4510# a_1582_4510# a_3282_4510# a_4132_4510# a_2432_4510#
+ m1_988_1168# dump m1_640_4420# a_1378_4510# a_2228_4510# m1_1500_4102# vsn g
XU4b vsn vsn m1_988_1168# g g m1_988_1168# g m1_988_1168# g m1_988_1168# vsn vsn g
+ g g g vsn vss n_w2_l2_f8
XU3 vsn vsn m1_988_2984# g g m1_988_2984# g m1_988_2984# g m1_988_2984# vsn vsn g
+ g g g vsn vss n_w2_l2_f8
XIP0 a_732_4510# vcas vcas a_528_4510# a_732_4510# b0 vss p_w1_l0p28_f2
XIP1 a_1582_4510# vcas vcas a_1378_4510# a_1582_4510# b1 vss p_w1_l0p28_f2
XIP2 a_2432_4510# vcas vcas a_2228_4510# a_2432_4510# b2 vss p_w1_l0p28_f2
XIN0 vss a_732_4510# a_732_4510# a_528_4510# b0 vss n_w0p5_l0p28_f2
XIP3 a_3282_4510# vcas vcas a_3078_4510# a_3282_4510# b3 vss p_w1_l0p28_f2
XIN1 vss a_1582_4510# a_1582_4510# a_1378_4510# b1 vss n_w0p5_l0p28_f2
XIP4 a_4132_4510# vcas vcas a_3928_4510# a_4132_4510# b4 vss p_w1_l0p28_f2
XIN3 vss a_3282_4510# a_3282_4510# a_3078_4510# b3 vss n_w0p5_l0p28_f2
XIN2 vss a_2432_4510# a_2432_4510# a_2228_4510# b2 vss n_w0p5_l0p28_f2
XIN4 vss a_4132_4510# a_4132_4510# a_3928_4510# b4 vss n_w0p5_l0p28_f2
XU210 g vsn g g m1_640_4420# vsn g vsn vsn g g g m1_988_3644# m1_988_3644# m1_1500_4102#
+ vss n_w2_l2_f7
XSW0 m1_640_4420# a_732_4510# dump out a_528_4510# vss n_w0p5_l0p5_f2
XSW2 m1_988_3644# a_2432_4510# dump out a_2228_4510# vss n_w0p5_l0p5_f2
XSW1 m1_1500_4102# a_1582_4510# dump out a_1378_4510# vss n_w0p5_l0p5_f2
XSW3 m1_988_2984# a_3282_4510# dump out a_3078_4510# vss n_w0p5_l0p5_f2
XSW4 m1_988_1168# a_4132_4510# dump out a_3928_4510# vss n_w0p5_l0p5_f2
XU4a vsn vsn m1_988_1168# g g m1_988_1168# g m1_988_1168# g m1_988_1168# vsn vsn g
+ g g g vsn vss n_w2_l2_f8
C0 g b2 0
C1 out m1_1500_4102# 0.23687f
C2 m1_1500_4102# b1 0
C3 a_3282_4510# a_2432_4510# 0.0139f
C4 dump m1_640_4420# 0.0671f
C5 g a_3928_4510# 0.00134f
C6 a_1378_4510# m1_1500_4102# 0
C7 m1_988_3644# m1_988_2984# 0.02717f
C8 a_3282_4510# dump 0.0375f
C9 a_3282_4510# vcas 0.25118f
C10 m1_988_3644# a_2432_4510# 0.00358f
C11 b2 a_2228_4510# 0.1862f
C12 a_3078_4510# m1_1500_4102# 0.00565f
C13 m1_988_1168# m1_640_4420# 0.40443f
C14 m1_988_3644# dump 0.18463f
C15 a_3282_4510# b3 0.16136f
C16 a_1582_4510# m1_1500_4102# 0.01438f
C17 out m1_640_4420# 0.11936f
C18 b0 dump 0.02448f
C19 a_3282_4510# out 0.01963f
C20 a_3282_4510# b1 0
C21 b4 dump 0.19408f
C22 dump m1_988_2984# 0.008f
C23 b0 vcas 0.35488f
C24 b4 vcas 0.57541f
C25 m1_988_2984# vcas 0
C26 g m1_1500_4102# 0.48065f
C27 dump a_2432_4510# 0.05327f
C28 a_1378_4510# a_3282_4510# 0
C29 vdd b4 0.0055f
C30 vcas a_2432_4510# 0.28651f
C31 a_732_4510# m1_640_4420# 0.00799f
C32 a_3928_4510# vsn 0
C33 m1_988_3644# out 0.36927f
C34 m1_988_1168# b4 0
C35 m1_988_1168# m1_988_2984# 0.36873f
C36 b4 b3 0.02332f
C37 b3 m1_988_2984# 0
C38 dump vcas 0.48072f
C39 out b0 0.18193f
C40 b0 b1 0.00416f
C41 a_3282_4510# a_3078_4510# 0.23138f
C42 m1_640_4420# a_4132_4510# 0.00424f
C43 out m1_988_2984# 0.11859f
C44 a_1378_4510# m1_988_3644# 0
C45 b3 a_2432_4510# 0.00174f
C46 vdd dump 0.02751f
C47 a_3282_4510# a_4132_4510# 0.00734f
C48 m1_1500_4102# a_2228_4510# 0
C49 a_3282_4510# a_1582_4510# 0
C50 vdd vcas 0.00553f
C51 out a_2432_4510# 0.01737f
C52 m1_640_4420# a_528_4510# -0
C53 a_1378_4510# b0 0
C54 a_2432_4510# b1 0
C55 m1_988_1168# dump 0.09736f
C56 b3 dump 0.1188f
C57 a_732_4510# b0 0.2633f
C58 g m1_640_4420# 1.80971f
C59 b3 vcas 0.62689f
C60 a_3282_4510# g 0.00457f
C61 out dump 0.63429f
C62 dump b1 0.20373f
C63 a_1378_4510# a_2432_4510# 0.0516f
C64 m1_1500_4102# vsn 0.02779f
C65 out vcas 0.32837f
C66 vcas b1 0.36568f
C67 vdd b3 0.00856f
C68 b4 a_3078_4510# 0.00502f
C69 a_3078_4510# m1_988_2984# 0.01645f
C70 a_1378_4510# dump 0.09756f
C71 a_1582_4510# b0 0
C72 b4 a_4132_4510# 0.14f
C73 a_732_4510# dump 0.09978f
C74 a_1378_4510# vcas 0.14056f
C75 m1_988_3644# g 0.65607f
C76 a_3078_4510# a_2432_4510# 0.08149f
C77 b0 a_528_4510# 0.07632f
C78 m1_988_1168# out 0.03637f
C79 a_732_4510# vcas 0.26628f
C80 out b3 0.00579f
C81 a_1582_4510# a_2432_4510# 0.00399f
C82 g b0 0
C83 a_3282_4510# a_2228_4510# 0.05966f
C84 b2 m1_1500_4102# 0
C85 a_3078_4510# dump 0.00123f
C86 out b1 0
C87 g m1_988_2984# 1.04697f
C88 dump a_4132_4510# 0.16313f
C89 a_3078_4510# vcas 0.19953f
C90 a_1582_4510# dump 0.15501f
C91 vcas a_4132_4510# 0.30332f
C92 g a_2432_4510# 0.00282f
C93 a_1582_4510# vcas 0.32387f
C94 vdd a_3078_4510# 0
C95 m1_640_4420# vsn 0.21018f
C96 a_1378_4510# out 0.07248f
C97 dump a_528_4510# 0.05747f
C98 a_1378_4510# b1 0.09632f
C99 m1_988_3644# a_2228_4510# 0.01831f
C100 a_732_4510# out 0.22696f
C101 vcas a_528_4510# 0.12659f
C102 a_732_4510# b1 0.00175f
C103 g dump 0.06247f
C104 b3 a_3078_4510# 0.21645f
C105 g vcas 0.00165f
C106 m1_988_1168# a_4132_4510# 0.00827f
C107 b3 a_4132_4510# 0.07656f
C108 b4 a_2228_4510# 0
C109 out a_3078_4510# 0.05011f
C110 a_732_4510# a_1378_4510# 0.00704f
C111 out a_4132_4510# 0
C112 m1_988_3644# vsn 0.10763f
C113 a_2432_4510# a_2228_4510# 0.21918f
C114 a_1582_4510# out 0.03274f
C115 a_1582_4510# b1 0.20863f
C116 a_3282_4510# b2 0.00507f
C117 m1_988_1168# g 2.38663f
C118 out a_528_4510# 0.1447f
C119 g b3 0
C120 a_528_4510# b1 0.00107f
C121 m1_988_2984# vsn 0.2568f
C122 dump a_2228_4510# 0.20003f
C123 g out 0.47621f
C124 a_1378_4510# a_1582_4510# 0.16506f
C125 g b1 0
C126 vcas a_2228_4510# 0.88181f
C127 a_3928_4510# m1_640_4420# 0.00207f
C128 a_732_4510# a_1582_4510# 0.01858f
C129 a_2432_4510# vsn 0
C130 a_3282_4510# a_3928_4510# 0.01295f
C131 m1_988_3644# b2 0.00245f
C132 a_732_4510# a_528_4510# 0.20157f
C133 a_1378_4510# g 0.00386f
C134 a_3078_4510# a_4132_4510# 0.02801f
C135 dump vsn 0.00243f
C136 a_1582_4510# a_3078_4510# 0
C137 a_732_4510# g 0.00302f
C138 b3 a_2228_4510# 0.0693f
C139 out a_2228_4510# 0.05944f
C140 b1 a_2228_4510# 0.03121f
C141 g a_3078_4510# 0.00277f
C142 a_1582_4510# a_528_4510# 0.15414f
C143 b2 a_2432_4510# 0.26648f
C144 g a_4132_4510# 0.00179f
C145 b4 a_3928_4510# 0.19804f
C146 g a_1582_4510# 0.00302f
C147 a_3928_4510# m1_988_2984# 0
C148 m1_988_1168# vsn 0.64878f
C149 m1_640_4420# m1_1500_4102# 0
C150 a_1378_4510# a_2228_4510# 0.08075f
C151 dump b2 0.03736f
C152 g a_528_4510# 0.00314f
C153 out vsn 0.08074f
C154 b2 vcas 0.43587f
C155 a_3928_4510# dump 0.24085f
C156 a_3078_4510# a_2228_4510# 0.08352f
C157 a_3928_4510# vcas 0.14312f
C158 a_4132_4510# a_2228_4510# 0
C159 m1_988_3644# m1_1500_4102# 0.1f
C160 a_1582_4510# a_2228_4510# 0.04378f
C161 b3 b2 0.00131f
C162 out b2 0
C163 b2 b1 0.00754f
C164 m1_988_2984# m1_1500_4102# 0.12093f
C165 g a_2228_4510# 0.00298f
C166 m1_988_1168# a_3928_4510# 0.05714f
C167 a_4132_4510# vsn 0.00246f
C168 m1_1500_4102# a_2432_4510# 0.00549f
C169 a_1378_4510# b2 0.00372f
C170 out a_3928_4510# 0.00333f
C171 a_528_4510# vsn 0.00272f
C172 dump m1_1500_4102# 0.19754f
C173 g vsn 4.13912f
C174 vcas m1_1500_4102# 0
C175 a_3078_4510# b2 0
C176 m1_988_3644# m1_640_4420# 0.06234f
C177 a_1582_4510# b2 0.00194f
C178 b0 m1_640_4420# 0
C179 b4 m1_640_4420# 0
C180 m1_988_2984# m1_640_4420# 0.42567f
C181 a_3078_4510# a_3928_4510# 0
C182 b4 a_3282_4510# 0.00157f
C183 a_3282_4510# m1_988_2984# 0.00685f
C184 a_3928_4510# a_4132_4510# 0.22322f
C185 vdd vss 0.0208f
C186 m1_988_1168# vss 1.13391f
C187 vsn vss 2.23819f
C188 g vss 6.33801f
C189 a_3928_4510# vss 0.32602f
C190 a_3078_4510# vss 0.46553f
C191 a_1378_4510# vss 0.31495f
C192 a_2432_4510# vss 0.49752f
C193 a_2228_4510# vss 0.53126f
C194 dump vss 2.48651f
C195 out vss 1.55846f
C196 a_528_4510# vss 0.42948f
C197 m1_640_4420# vss 1.05766f
C198 m1_1500_4102# vss 0.27508f
C199 m1_988_3644# vss 0.10411f
C200 a_4132_4510# vss 0.73601f
C201 b4 vss 0.34915f
C202 b2 vss 0.16641f
C203 a_3282_4510# vss 0.50614f
C204 b3 vss 0.39209f
C205 a_1582_4510# vss 0.63021f
C206 b1 vss 0.16751f
C207 a_732_4510# vss 0.61485f
C208 b0 vss 0.21914f
C209 vcas vss 10.53474f
C210 m1_988_2984# vss 0.29737f
.ends

.subckt r_w1_l7p765 a_n100_n899# a_n100_777# VSUBS
X0 a_n100_777# a_n100_n899# VSUBS ppolyf_u_1k r_width=1u r_length=7.77u
C0 a_n100_n899# VSUBS 0.27003f
C1 a_n100_777# VSUBS 0.27003f
.ends

.subckt r_w2_l1p97 a_n200_n319# a_n200_197# VSUBS
X0 a_n200_197# a_n200_n319# VSUBS ppolyf_u_1k r_width=2u r_length=1.97u
C0 a_n200_n319# a_n200_197# 0.02096f
C1 a_n200_n319# VSUBS 0.42971f
C2 a_n200_197# VSUBS 0.42971f
.ends

.subckt r_w1_l1p94 a_n100_n316# a_n100_194# VSUBS
X0 a_n100_194# a_n100_n316# VSUBS ppolyf_u_1k r_width=1u r_length=1.94u
C0 a_n100_n316# a_n100_194# 0.01052f
C1 a_n100_n316# VSUBS 0.2541f
C2 a_n100_194# VSUBS 0.2541f
.ends

.subckt r_w1_l3p88 a_n100_n510# a_n100_388# VSUBS
X0 a_n100_388# a_n100_n510# VSUBS ppolyf_u_1k r_width=1u r_length=3.88u
C0 a_n100_n510# a_n100_388# 0.00535f
C1 a_n100_n510# VSUBS 0.26053f
C2 a_n100_388# VSUBS 0.26053f
.ends

.subckt n_w0p5_l1 a_100_n50# a_n100_n94# a_n188_n50# VSUBS
X0 a_100_n50# a_n100_n94# a_n188_n50# VSUBS nfet_03v3 ad=0.22p pd=1.88u as=0.22p ps=1.88u w=0.5u l=1u
C0 a_100_n50# a_n100_n94# 0.01026f
C1 a_n188_n50# a_n100_n94# 0.01026f
C2 a_100_n50# a_n188_n50# 0.00935f
C3 a_100_n50# VSUBS 0.13392f
C4 a_n188_n50# VSUBS 0.13392f
.ends

.subckt p_w1_l1 a_n188_n100# a_100_n100# a_n100_n144# w_n274_n230# VSUBS
X0 a_100_n100# a_n100_n144# a_n188_n100# w_n274_n230# pfet_03v3 ad=0.44p pd=2.88u as=0.44p ps=2.88u w=1u l=1u
C0 a_n188_n100# a_100_n100# 0.0191f
C1 a_n188_n100# w_n274_n230# 0.02517f
C2 a_n100_n144# a_100_n100# 0.02094f
C3 a_n100_n144# w_n274_n230# 0.12884f
C4 a_n188_n100# a_n100_n144# 0.02094f
C5 w_n274_n230# a_100_n100# 0.02517f
C6 a_100_n100# VSUBS 0.07854f
C7 a_n188_n100# VSUBS 0.07854f
C8 w_n274_n230# VSUBS 0.75624f
.ends

.subckt r_w1_l11p645 a_n100_1165# a_n100_n1287# VSUBS
X0 a_n100_1165# a_n100_n1287# VSUBS ppolyf_u_1k r_width=1u r_length=11.65u
C0 a_n100_n1287# VSUBS 0.27003f
C1 a_n100_1165# VSUBS 0.27003f
.ends

.subckt n_w4_l0p28_f2 a_n52_n400# a_52_n444# a_108_n400# a_n108_n444# a_n196_n400#
+ VSUBS
X0 a_108_n400# a_52_n444# a_n52_n400# VSUBS nfet_03v3 ad=1.76p pd=8.88u as=1.04p ps=4.52u w=4u l=0.28u
X1 a_n52_n400# a_n108_n444# a_n196_n400# VSUBS nfet_03v3 ad=1.04p pd=4.52u as=1.76p ps=8.88u w=4u l=0.28u
C0 a_52_n444# a_108_n400# 0.03125f
C1 a_n196_n400# a_n52_n400# 0.17284f
C2 a_n196_n400# a_n108_n444# 0.03125f
C3 a_52_n444# a_n52_n400# 0.03125f
C4 a_52_n444# a_n108_n444# 0.00519f
C5 a_n52_n400# a_108_n400# 0.17284f
C6 a_n108_n444# a_n52_n400# 0.03125f
C7 a_108_n400# VSUBS 0.20946f
C8 a_n52_n400# VSUBS 0.09458f
C9 a_n196_n400# VSUBS 0.20946f
.ends

.subckt vdacr_el b0 b1 b2 b3 b4 vdd m1_4222_4048# a_2392_3416# a_3576_3416# m1_942_4048#
+ a_1800_3416# m1_2262_4048# m1_3342_4048# m1_4094_3010# m1_1382_4048# a_2984_3416#
+ out a_4168_3416# m1_2760_3412# m1_1822_4048# vss m1_502_4048#
XXRS4_0 m1_4222_4048# m1_4094_3010# vss r_w1_l7p765
XXRS4_1 vss m1_4222_4048# vss r_w1_l7p765
XXRS0 m1_2262_4048# m1_1822_4048# vss r_w2_l1p97
XXRS1 m1_2760_3412# m1_2262_4048# vss r_w1_l1p94
XXRS3 m1_4094_3010# m1_3342_4048# vss r_w1_l7p765
XXRS2 m1_3342_4048# m1_2760_3412# vss r_w1_l3p88
XIB4n a_4168_3416# b4 vss vss n_w0p5_l1
XIB3n a_3576_3416# b3 vss vss n_w0p5_l1
XIB4p vdd a_4168_3416# b4 vdd vss p_w1_l1
XIB2n a_2984_3416# b2 vss vss n_w0p5_l1
XIB3p vdd a_3576_3416# b3 vdd vss p_w1_l1
XIB2p vdd a_2984_3416# b2 vdd vss p_w1_l1
XIB1n a_2392_3416# b1 vss vss n_w0p5_l1
XIB0n a_1800_3416# b0 vss vss n_w0p5_l1
XIB1p vdd a_2392_3416# b1 vdd vss p_w1_l1
XIB0p vdd a_1800_3416# b0 vdd vss p_w1_l1
XXRB0 out m1_502_4048# vss r_w1_l11p645
XSW0 m1_2262_4048# a_1800_3416# m1_1822_4048# a_1800_3416# m1_1822_4048# vss n_w4_l0p28_f2
XXRB1 m1_502_4048# m1_942_4048# vss r_w1_l11p645
XSW2 m1_3342_4048# a_2984_3416# m1_2760_3412# a_2984_3416# m1_2760_3412# vss n_w4_l0p28_f2
XSW1 m1_2760_3412# a_2392_3416# m1_2262_4048# a_2392_3416# m1_2262_4048# vss n_w4_l0p28_f2
XXRB3 m1_1382_4048# m1_1822_4048# vss r_w1_l11p645
XXRB2 m1_942_4048# m1_1382_4048# vss r_w1_l11p645
XSW3 m1_4094_3010# a_3576_3416# m1_3342_4048# a_3576_3416# m1_3342_4048# vss n_w4_l0p28_f2
XSW4 vss a_4168_3416# m1_4094_3010# a_4168_3416# m1_4094_3010# vss n_w4_l0p28_f2
C0 b2 b4 0
C1 m1_4222_4048# m1_3342_4048# 0.06437f
C2 m1_4094_3010# vdd 0.00117f
C3 m1_4094_3010# m1_2262_4048# 0.00343f
C4 a_4168_3416# b4 0.08723f
C5 b4 a_2984_3416# 0
C6 m1_4222_4048# m1_2262_4048# 0
C7 m1_4094_3010# m1_4222_4048# 0.32763f
C8 b2 a_3576_3416# 0
C9 b2 b3 0.0858f
C10 a_4168_3416# a_3576_3416# 0.05563f
C11 a_4168_3416# b3 0.00279f
C12 a_1800_3416# b1 0.02378f
C13 out m1_942_4048# 0.06958f
C14 a_3576_3416# a_2984_3416# 0.03485f
C15 b3 a_2984_3416# 0.11129f
C16 a_4168_3416# m1_2760_3412# 0
C17 b2 m1_3342_4048# 0.0068f
C18 a_4168_3416# m1_3342_4048# 0
C19 a_2984_3416# m1_2760_3412# 0.28127f
C20 out m1_1382_4048# 0.02493f
C21 b2 vdd 0.54911f
C22 m1_1822_4048# b1 0.00833f
C23 b2 a_2392_3416# 0.01373f
C24 a_2984_3416# m1_3342_4048# 0.13071f
C25 b0 b1 0.02048f
C26 a_4168_3416# vdd 0.27917f
C27 a_4168_3416# m1_2262_4048# 0
C28 m1_1822_4048# a_1800_3416# 0.09997f
C29 b3 b1 0
C30 b0 a_1800_3416# 0.2037f
C31 a_3576_3416# b4 0.06652f
C32 a_1800_3416# m1_1382_4048# 0.01706f
C33 b3 b4 0.03476f
C34 a_2984_3416# vdd 0.11011f
C35 a_2392_3416# a_2984_3416# 0.04802f
C36 m1_4094_3010# a_4168_3416# 0.11823f
C37 a_2984_3416# m1_2262_4048# 0.03635f
C38 m1_1822_4048# m1_942_4048# 0
C39 m1_4094_3010# a_2984_3416# 0.00843f
C40 m1_942_4048# m1_1382_4048# 0.11001f
C41 a_1800_3416# m1_2760_3412# 0
C42 a_4168_3416# m1_4222_4048# 0.00345f
C43 m1_1822_4048# m1_1382_4048# 0.11431f
C44 vdd b1 0.60011f
C45 a_2392_3416# b1 0.26752f
C46 b1 m1_2262_4048# 0.01445f
C47 b4 vdd 0.72875f
C48 a_3576_3416# b3 0.12657f
C49 m1_1822_4048# m1_2760_3412# 0
C50 a_1800_3416# vdd 0.17226f
C51 a_1800_3416# a_2392_3416# 0.01991f
C52 a_1800_3416# m1_2262_4048# 0.04031f
C53 m1_1382_4048# m1_2760_3412# 0.00312f
C54 m1_4094_3010# b4 0
C55 m1_1822_4048# m1_3342_4048# 0
C56 a_3576_3416# m1_2760_3412# 0.00689f
C57 out m1_502_4048# 0.06293f
C58 a_3576_3416# m1_3342_4048# 0.19263f
C59 b3 m1_3342_4048# 0.0067f
C60 m1_1822_4048# vdd 0.00239f
C61 m1_1822_4048# a_2392_3416# 0.06921f
C62 b0 vdd 0.49782f
C63 m1_1822_4048# m1_2262_4048# 0.2724f
C64 b0 a_2392_3416# 0
C65 m1_3342_4048# m1_2760_3412# 0.31317f
C66 m1_1382_4048# m1_2262_4048# 0
C67 a_3576_3416# vdd 0.16485f
C68 b3 vdd 0.75321f
C69 b3 a_2392_3416# 0
C70 a_3576_3416# m1_2262_4048# 0
C71 b2 a_2984_3416# 0.25515f
C72 m1_4094_3010# a_3576_3416# 0.20164f
C73 m1_4094_3010# b3 0.06497f
C74 vdd m1_2760_3412# 0.00478f
C75 a_2392_3416# m1_2760_3412# 0.1015f
C76 m1_2262_4048# m1_2760_3412# 0.4402f
C77 a_4168_3416# a_2984_3416# 0
C78 m1_502_4048# m1_942_4048# 0.29397f
C79 vdd m1_3342_4048# 0.00477f
C80 a_2392_3416# m1_3342_4048# -0
C81 m1_4094_3010# m1_2760_3412# 0.00462f
C82 m1_2262_4048# m1_3342_4048# 0
C83 a_3576_3416# m1_4222_4048# 0
C84 m1_1822_4048# m1_502_4048# 0
C85 m1_4094_3010# m1_3342_4048# 0.26112f
C86 a_2392_3416# vdd 0.19015f
C87 m1_4222_4048# m1_2760_3412# 0
C88 b2 b1 0.03015f
C89 vdd m1_2262_4048# 0.01298f
C90 a_2392_3416# m1_2262_4048# 0.32464f
C91 m1_4094_3010# vss 1.24421f
C92 m1_1382_4048# vss 0.63563f
C93 m1_2760_3412# vss 0.51839f
C94 m1_3342_4048# vss 0.51288f
C95 m1_942_4048# vss 0.35136f
C96 m1_2262_4048# vss 0.29456f
C97 m1_1822_4048# vss 0.33864f
C98 m1_502_4048# vss 0.6194f
C99 out vss 0.79041f
C100 vdd vss 15.08764f
C101 a_1800_3416# vss 0.84103f
C102 b0 vss 0.53222f
C103 a_2392_3416# vss 0.56569f
C104 b1 vss 0.44836f
C105 a_2984_3416# vss 0.44317f
C106 b2 vss 0.55514f
C107 b4 vss 0.62555f
C108 a_3576_3416# vss 0.65055f
C109 b3 vss 0.54803f
C110 a_4168_3416# vss 1.35234f
C111 m1_4222_4048# vss 0.2956f
.ends

.subckt r_w1_l13p91 a_n100_n1513# a_n100_1391# VSUBS
X0 a_n100_1391# a_n100_n1513# VSUBS ppolyf_u_1k r_width=1u r_length=13.91u
C0 a_n100_n1513# VSUBS 0.27003f
C1 a_n100_1391# VSUBS 0.27003f
.ends

.subckt vdacr_vr b0 b1 b2 b3 b4 vdd a_2392_3416# a_3576_3416# m1_942_4048# m1_502_4048#
+ a_1800_3416# out m1_2318_2410# m1_3492_2640# m1_3662_2290# vss a_2984_3416# a_4168_3416#
+ m1_2910_2650# m1_3782_4048# m1_1716_2640#
XXRS4_0 m1_3782_4048# m1_3662_2290# vss r_w1_l7p765
XXRS4_1 vss m1_3782_4048# vss r_w1_l7p765
XXRS0 m1_2318_2410# m1_1716_2640# vss r_w2_l1p97
XXRS1 m1_2910_2650# m1_2318_2410# vss r_w1_l1p94
XXRS3 m1_3662_2290# m1_3492_2640# vss r_w1_l7p765
XXRS2 m1_3492_2640# m1_2910_2650# vss r_w1_l3p88
XIB4n a_4168_3416# b4 vss vss n_w0p5_l1
XIB3n a_3576_3416# b3 vss vss n_w0p5_l1
XIB4p vdd a_4168_3416# b4 vdd vss p_w1_l1
XIB2n a_2984_3416# b2 vss vss n_w0p5_l1
XIB3p vdd a_3576_3416# b3 vdd vss p_w1_l1
XIB2p vdd a_2984_3416# b2 vdd vss p_w1_l1
XIB1n a_2392_3416# b1 vss vss n_w0p5_l1
XIB0n a_1800_3416# b0 vss vss n_w0p5_l1
XIB1p vdd a_2392_3416# b1 vdd vss p_w1_l1
XIB0p vdd a_1800_3416# b0 vdd vss p_w1_l1
XXRB0 m1_502_4048# out vss r_w1_l13p91
XSW0 m1_2318_2410# a_1800_3416# m1_1716_2640# a_1800_3416# m1_1716_2640# vss n_w4_l0p28_f2
XXRB1 m1_942_4048# m1_502_4048# vss r_w1_l13p91
XSW2 m1_3492_2640# a_2984_3416# m1_2910_2650# a_2984_3416# m1_2910_2650# vss n_w4_l0p28_f2
XSW1 m1_2910_2650# a_2392_3416# m1_2318_2410# a_2392_3416# m1_2318_2410# vss n_w4_l0p28_f2
XXRB2 m1_1716_2640# m1_942_4048# vss r_w1_l13p91
XSW3 m1_3662_2290# a_3576_3416# m1_3492_2640# a_3576_3416# m1_3492_2640# vss n_w4_l0p28_f2
XSW4 vss a_4168_3416# m1_3662_2290# a_4168_3416# m1_3662_2290# vss n_w4_l0p28_f2
C0 a_4168_3416# m1_3662_2290# 0.09446f
C1 vdd b1 0.64727f
C2 a_2392_3416# m1_2910_2650# 0.10575f
C3 b2 a_1800_3416# 0
C4 m1_2318_2410# b1 0.01095f
C5 a_3576_3416# b3 0.23396f
C6 m1_2910_2650# m1_3492_2640# 0.4255f
C7 b4 a_2984_3416# 0
C8 a_2392_3416# m1_3492_2640# 0
C9 b4 vdd 0.7855f
C10 a_4168_3416# a_2984_3416# 0.00142f
C11 b2 a_3576_3416# 0
C12 m1_3662_2290# b3 0.03077f
C13 vdd a_4168_3416# 0.2173f
C14 a_1800_3416# b0 0.19236f
C15 a_2392_3416# b1 0.06781f
C16 m1_2318_2410# m1_942_4048# 0
C17 b3 a_2984_3416# 0.04137f
C18 vdd m1_1716_2640# 0.00575f
C19 vdd b3 0.49099f
C20 m1_2318_2410# m1_1716_2640# 0.65049f
C21 b2 a_2984_3416# 0.1241f
C22 a_4168_3416# m1_2910_2650# 0
C23 b2 vdd 0.70269f
C24 a_4168_3416# m1_3492_2640# 0.00141f
C25 m1_2318_2410# m1_502_4048# 0
C26 m1_1716_2640# m1_2910_2650# 0.04159f
C27 a_2392_3416# m1_1716_2640# 0.04631f
C28 vdd b0 0.56802f
C29 b2 m1_2910_2650# 0.04099f
C30 m1_1716_2640# m1_3492_2640# 0
C31 b2 a_2392_3416# 0.09705f
C32 m1_3782_4048# a_3576_3416# 0.0078f
C33 b2 m1_3492_2640# 0.00107f
C34 m1_942_4048# out 0.03171f
C35 b4 a_4168_3416# 0.14638f
C36 m1_1716_2640# b1 0.02654f
C37 m1_3662_2290# m1_3782_4048# 0.3267f
C38 m1_3662_2290# a_3576_3416# 0.30182f
C39 b2 b1 0.02658f
C40 a_1800_3416# vdd 0.17745f
C41 b4 b3 0.03565f
C42 m1_942_4048# m1_1716_2640# 0.0409f
C43 a_1800_3416# m1_2318_2410# 0.10972f
C44 a_4168_3416# b3 0.00455f
C45 a_3576_3416# a_2984_3416# 0.01854f
C46 vdd a_3576_3416# 0.23034f
C47 m1_2318_2410# m1_3782_4048# 0
C48 out m1_502_4048# 0.0905f
C49 b0 b1 0.03005f
C50 m1_3662_2290# a_2984_3416# 0.02389f
C51 m1_942_4048# m1_502_4048# 0.22901f
C52 vdd m1_3662_2290# 0
C53 a_1800_3416# m1_2910_2650# 0.00203f
C54 a_1800_3416# a_2392_3416# 0.03101f
C55 m1_2318_2410# m1_3662_2290# 0
C56 m1_2910_2650# m1_3782_4048# 0
C57 b2 b3 0.03632f
C58 m1_502_4048# m1_1716_2640# 0
C59 m1_2910_2650# a_3576_3416# 0.00192f
C60 vdd a_2984_3416# 0.30382f
C61 m1_2318_2410# a_2984_3416# 0.02082f
C62 m1_3782_4048# m1_3492_2640# 0.01069f
C63 m1_2910_2650# m1_3662_2290# 0.01509f
C64 a_2392_3416# m1_3662_2290# 0
C65 a_1800_3416# b1 0.06437f
C66 m1_2318_2410# vdd 0.0012f
C67 m1_3492_2640# a_3576_3416# 0.14935f
C68 m1_3662_2290# m1_3492_2640# 0.29405f
C69 m1_2910_2650# a_2984_3416# 0.33905f
C70 a_2392_3416# a_2984_3416# 0.06043f
C71 vdd m1_2910_2650# 0.0023f
C72 a_1800_3416# m1_942_4048# 0
C73 a_2392_3416# vdd 0.27248f
C74 m1_2318_2410# m1_2910_2650# 0.21981f
C75 m1_2318_2410# a_2392_3416# 0.24082f
C76 m1_3492_2640# a_2984_3416# 0.19145f
C77 b4 a_3576_3416# 0.03753f
C78 a_4168_3416# m1_3782_4048# 0.00195f
C79 vdd m1_3492_2640# 0.00698f
C80 a_4168_3416# a_3576_3416# 0.09216f
C81 a_1800_3416# m1_1716_2640# 0.06997f
C82 m1_2318_2410# m1_3492_2640# 0
C83 b1 a_2984_3416# 0
C84 m1_3662_2290# vss 1.32246f
C85 m1_2910_2650# vss 0.57102f
C86 m1_3492_2640# vss 0.58918f
C87 m1_942_4048# vss 0.68475f
C88 m1_2318_2410# vss 0.33445f
C89 m1_1716_2640# vss 0.27476f
C90 m1_502_4048# vss 0.74307f
C91 out vss 0.95167f
C92 vdd vss 15.01984f
C93 a_1800_3416# vss 0.95743f
C94 b0 vss 0.57434f
C95 a_2392_3416# vss 0.55472f
C96 b1 vss 0.60104f
C97 a_2984_3416# vss 0.73623f
C98 b2 vss 0.77591f
C99 b4 vss 0.4195f
C100 a_3576_3416# vss 0.68085f
C101 b3 vss 0.47349f
C102 a_4168_3416# vss 1.18373f
C103 m1_3782_4048# vss 0.43439f
.ends

.subckt r_w1_l14p555 a_n100_1456# a_n100_n1578# VSUBS
X0 a_n100_1456# a_n100_n1578# VSUBS ppolyf_u_1k r_width=1u r_length=14.56u
C0 a_n100_n1578# VSUBS 0.27003f
C1 a_n100_1456# VSUBS 0.27003f
.ends

.subckt p_w10_l10 w_n1174_n1130# a_n1000_n1044# a_1000_n1000# a_n1088_n1000# VSUBS
X0 a_1000_n1000# a_n1000_n1044# a_n1088_n1000# w_n1174_n1130# pfet_03v3 ad=4.4p pd=20.88u as=4.4p ps=20.88u w=10u l=10u
C0 a_n1088_n1000# w_n1174_n1130# 0.41194f
C1 a_n1088_n1000# a_n1000_n1044# 0.38624f
C2 w_n1174_n1130# a_1000_n1000# 0.41194f
C3 a_n1000_n1044# a_1000_n1000# 0.38624f
C4 w_n1174_n1130# a_n1000_n1044# 1.0092f
C5 a_1000_n1000# VSUBS 0.65771f
C6 a_n1088_n1000# VSUBS 0.65771f
C7 w_n1174_n1130# VSUBS 15.9194f
.ends

.subckt bias_rails vgln en_b m1_3422_438# vsp m1_782_438# m1_3862_3522# m1_2542_438#
+ vss vdd m1_1222_3522# m1_342_438# vsn m1_1662_438# vglp
XR0 vsp m1_342_438# vss r_w1_l14p555
XR1 vsp m1_782_438# vss r_w1_l14p555
XR2 m1_1222_3522# m1_782_438# vss r_w1_l14p555
XR3 m1_1222_3522# m1_1662_438# vss r_w1_l14p555
XR4 vgln m1_1662_438# vss r_w1_l14p555
XHDR vdd m1_342_438# en_b vdd vss p_w4_l0p5
XR5 vgln m1_2542_438# vss r_w1_l14p555
XR6 vglp m1_2542_438# vss r_w1_l14p555
XR7 vglp m1_3422_438# vss r_w1_l14p555
XR9 m1_3862_3522# vsn vss r_w1_l14p555
XR8 m1_3862_3522# m1_3422_438# vss r_w1_l14p555
XR10 vss vsn vss r_w1_l14p555
XC2 vsp vdd vsp vsp vss p_w10_l10
XC1 vss vsn vss vss vss p_w10_l10
C0 vgln vsp 0.29255f
C1 m1_782_438# m1_1662_438# 0.00961f
C2 m1_342_438# vglp 0.04118f
C3 m1_342_438# m1_1662_438# 0
C4 vsn m1_3862_3522# 0.0092f
C5 m1_342_438# en_b 0.02924f
C6 vsp m1_3862_3522# 0.02981f
C7 m1_342_438# m1_1222_3522# 0
C8 vsn m1_342_438# 0.21777f
C9 m1_342_438# vsp 0.1737f
C10 vglp vdd 0.20542f
C11 en_b vdd 0.30814f
C12 vsn vdd 0.01756f
C13 en_b vglp 0.09243f
C14 vsn vglp 0.55135f
C15 vsp vdd 1.4201f
C16 vsp vglp 0.20078f
C17 vsn en_b 0
C18 vsn m1_1222_3522# 0.01495f
C19 vgln m1_342_438# 0.12699f
C20 vsp en_b 0
C21 vsp m1_1222_3522# 0.10193f
C22 vsn vsp 0.89734f
C23 vsn m1_3422_438# 0.03048f
C24 m1_342_438# m1_782_438# 0.01545f
C25 m1_2542_438# m1_1662_438# 0.00961f
C26 vsn m1_2542_438# 0.00151f
C27 vgln vdd 0.21356f
C28 vgln vglp 0.04051f
C29 m1_2542_438# m1_3422_438# 0.00961f
C30 m1_3862_3522# vdd 0.01537f
C31 vgln en_b 0.03583f
C32 vgln m1_1222_3522# 0.01249f
C33 m1_3862_3522# vglp 0.01077f
C34 vsn vgln 0.71755f
C35 m1_342_438# vdd 0.13967f
C36 vdd vss 3.00055f
C37 m1_3862_3522# vss 0.02069f
C38 vsn vss 2.68393f
C39 m1_3422_438# vss 0.04057f
C40 vglp vss 0.48885f
C41 m1_2542_438# vss 0.04057f
C42 en_b vss 0.58213f
C43 vgln vss 0.30142f
C44 m1_1662_438# vss 0.04061f
C45 m1_1222_3522# vss 0.03045f
C46 m1_782_438# vss 0.04119f
C47 m1_342_438# vss 2.30643f
C48 vsp vss 7.60678f
.ends

.subckt r_w2_l1p315 a_n200_n254# a_n200_132# VSUBS
X0 a_n200_132# a_n200_n254# VSUBS ppolyf_u_1k r_width=2u r_length=1.32u
C0 a_n200_132# a_n200_n254# 0.02982f
C1 a_n200_n254# VSUBS 0.42149f
C2 a_n200_132# VSUBS 0.42149f
.ends

.subckt r_w2_l2p625 a_n200_n385# a_n200_263# VSUBS
X0 a_n200_263# a_n200_n385# VSUBS ppolyf_u_1k r_width=2u r_length=2.63u
C0 a_n200_263# a_n200_n385# 0.01591f
C1 a_n200_n385# VSUBS 0.43549f
C2 a_n200_263# VSUBS 0.43549f
.ends

.subckt r_w1_l5p175 a_n100_518# a_n100_n640# VSUBS
X0 a_n100_518# a_n100_n640# VSUBS ppolyf_u_1k r_width=1u r_length=5.18u
C0 a_n100_518# a_n100_n640# 0.00399f
C1 a_n100_n640# VSUBS 0.26263f
C2 a_n100_518# VSUBS 0.26263f
.ends

.subckt r_w1_l2p59 a_n100_n381# a_n100_259# VSUBS
X0 a_n100_259# a_n100_n381# VSUBS ppolyf_u_1k r_width=1u r_length=2.59u
C0 a_n100_259# a_n100_n381# 0.00799f
C1 a_n100_n381# VSUBS 0.25697f
C2 a_n100_259# VSUBS 0.25697f
.ends

.subckt r_w1_l10p35 a_n100_n1157# a_n100_1035# VSUBS
X0 a_n100_1035# a_n100_n1157# VSUBS ppolyf_u_1k r_width=1u r_length=10.35u
C0 a_n100_n1157# VSUBS 0.27003f
C1 a_n100_1035# VSUBS 0.27003f
.ends

.subckt r_w1_l12p86 a_n100_n1408# a_n100_1286# VSUBS
X0 a_n100_1286# a_n100_n1408# VSUBS ppolyf_u_1k r_width=1u r_length=12.86u
C0 a_n100_n1408# VSUBS 0.27003f
C1 a_n100_1286# VSUBS 0.27003f
.ends

.subckt vdacr_vc b0 b1 b2 b3 b4 vdd out a_2392_3416# a_3576_3416# m1_942_4048# a_1800_3416#
+ m1_1822_4048# m1_2900_3120# m1_3542_4048# a_2984_3416# a_4168_3416# m1_2156_3240#
+ m1_3982_4048# m1_1382_4048# vss m1_502_4048#
XXRS0 m1_2156_3240# m1_1822_4048# vss r_w2_l1p315
XXRS1 m1_2900_3120# m1_2156_3240# vss r_w2_l2p625
XXRS3 m1_3542_4048# m1_3982_4048# vss r_w1_l5p175
XXRS2 m1_3542_4048# m1_2900_3120# vss r_w1_l2p59
XXRS4 vss m1_3982_4048# vss r_w1_l10p35
XIB4n a_4168_3416# b4 vss vss n_w0p5_l1
XIB3n a_3576_3416# b3 vss vss n_w0p5_l1
XIB4p vdd a_4168_3416# b4 vdd vss p_w1_l1
XIB2n a_2984_3416# b2 vss vss n_w0p5_l1
XIB3p vdd a_3576_3416# b3 vdd vss p_w1_l1
XIB2p vdd a_2984_3416# b2 vdd vss p_w1_l1
XIB1n a_2392_3416# b1 vss vss n_w0p5_l1
XIB0n a_1800_3416# b0 vss vss n_w0p5_l1
XIB1p vdd a_2392_3416# b1 vdd vss p_w1_l1
XIB0p vdd a_1800_3416# b0 vdd vss p_w1_l1
XXRB0 m1_502_4048# out vss r_w1_l12p86
XSW0 m1_2156_3240# a_1800_3416# m1_1822_4048# a_1800_3416# m1_1822_4048# vss n_w4_l0p28_f2
XXRB1 m1_942_4048# m1_502_4048# vss r_w1_l12p86
XSW2 m1_3542_4048# a_2984_3416# m1_2900_3120# a_2984_3416# m1_2900_3120# vss n_w4_l0p28_f2
XSW1 m1_2900_3120# a_2392_3416# m1_2156_3240# a_2392_3416# m1_2156_3240# vss n_w4_l0p28_f2
XXRB3 m1_1822_4048# m1_1382_4048# vss r_w1_l12p86
XXRB2 m1_1382_4048# m1_942_4048# vss r_w1_l12p86
XSW3 m1_3982_4048# a_3576_3416# m1_3542_4048# a_3576_3416# m1_3542_4048# vss n_w4_l0p28_f2
XSW4 vss a_4168_3416# m1_3982_4048# a_4168_3416# m1_3982_4048# vss n_w4_l0p28_f2
C0 m1_2156_3240# b1 0.03127f
C1 vdd a_4168_3416# 0.22626f
C2 a_3576_3416# m1_3982_4048# 0.26669f
C3 a_3576_3416# b2 0.00239f
C4 m1_2156_3240# m1_2900_3120# 0.35505f
C5 vdd m1_3542_4048# 0
C6 a_1800_3416# m1_1382_4048# 0.01707f
C7 vdd m1_1822_4048# 0.00249f
C8 m1_3982_4048# a_2392_3416# 0
C9 b2 a_2392_3416# 0.02304f
C10 a_1800_3416# m1_2156_3240# 0.05712f
C11 a_2984_3416# m1_2156_3240# 0.08949f
C12 b3 a_2984_3416# 0.00998f
C13 m1_1822_4048# m1_942_4048# 0
C14 vdd b1 0.60145f
C15 a_3576_3416# m1_2156_3240# 0
C16 b4 a_3576_3416# 0.03989f
C17 vdd m1_2900_3120# 0.00446f
C18 m1_2156_3240# a_2392_3416# 0.25323f
C19 b3 a_3576_3416# 0.31847f
C20 m1_2156_3240# m1_3982_4048# 0.00173f
C21 vdd a_1800_3416# 0.16313f
C22 b4 b2 0
C23 vdd a_2984_3416# 0.22246f
C24 a_4168_3416# m1_3542_4048# 0.00878f
C25 b3 a_2392_3416# 0
C26 b3 m1_3982_4048# 0.05346f
C27 b3 b2 0.02623f
C28 m1_1822_4048# m1_3542_4048# 0
C29 vdd a_3576_3416# 0.17218f
C30 m1_2156_3240# m1_1382_4048# 0.00556f
C31 vdd a_2392_3416# 0.23488f
C32 vdd m1_3982_4048# 0.00734f
C33 vdd b2 0.51583f
C34 m1_1822_4048# b1 0.0085f
C35 m1_2900_3120# m1_3542_4048# 0.23213f
C36 vdd b0 0.48837f
C37 b3 b4 0.13917f
C38 m1_2900_3120# m1_1822_4048# 0
C39 out m1_1382_4048# 0.02522f
C40 out m1_502_4048# 0.06298f
C41 a_2984_3416# m1_3542_4048# 0.13514f
C42 a_1800_3416# m1_1822_4048# 0.11392f
C43 a_2984_3416# m1_1822_4048# 0
C44 vdd m1_2156_3240# 0
C45 a_3576_3416# a_4168_3416# 0.04025f
C46 vdd b4 0.96713f
C47 a_3576_3416# m1_3542_4048# 0.21685f
C48 vdd b3 0.69411f
C49 m1_1382_4048# m1_942_4048# 0.11722f
C50 m1_3982_4048# a_4168_3416# 0.09009f
C51 a_1800_3416# b1 0.02676f
C52 m1_502_4048# m1_942_4048# 0.31498f
C53 a_2984_3416# b1 0
C54 a_2392_3416# m1_3542_4048# 0
C55 m1_3982_4048# m1_3542_4048# 0.57866f
C56 a_2392_3416# m1_1822_4048# 0.02442f
C57 a_1800_3416# m1_2900_3120# 0
C58 b2 m1_3542_4048# 0.00783f
C59 a_2984_3416# m1_2900_3120# 0.33054f
C60 m1_3982_4048# m1_1822_4048# 0
C61 a_1800_3416# a_2984_3416# 0
C62 out m1_942_4048# 0.07036f
C63 a_3576_3416# m1_2900_3120# 0.02458f
C64 a_2392_3416# b1 0.1487f
C65 b4 a_4168_3416# 0.27982f
C66 b2 b1 0.02443f
C67 m1_2900_3120# a_2392_3416# 0.12579f
C68 m1_1822_4048# m1_1382_4048# 0.09954f
C69 m1_2156_3240# m1_3542_4048# 0.00287f
C70 a_3576_3416# a_2984_3416# 0.04562f
C71 m1_3982_4048# m1_2900_3120# 0.0302f
C72 m1_1822_4048# m1_502_4048# 0
C73 m1_2900_3120# b2 0.00112f
C74 m1_2156_3240# m1_1822_4048# 0.46064f
C75 b0 b1 0.02243f
C76 b3 a_4168_3416# 0.02366f
C77 a_1800_3416# a_2392_3416# 0.03539f
C78 a_2984_3416# a_2392_3416# 0.06364f
C79 b3 m1_3542_4048# 0
C80 a_2984_3416# m1_3982_4048# 0.00685f
C81 a_2984_3416# b2 0.19562f
C82 a_1800_3416# b0 0.19361f
C83 m1_3982_4048# vss 1.03972f
C84 m1_1382_4048# vss 0.71003f
C85 m1_2900_3120# vss 0.25398f
C86 m1_3542_4048# vss 0.91811f
C87 m1_942_4048# vss 0.38112f
C88 m1_2156_3240# vss 0.45166f
C89 m1_1822_4048# vss 0.22977f
C90 m1_502_4048# vss 0.67554f
C91 out vss 0.78918f
C92 vdd vss 14.93496f
C93 a_1800_3416# vss 0.80682f
C94 b0 vss 0.64361f
C95 a_2392_3416# vss 0.54774f
C96 b1 vss 0.49635f
C97 a_2984_3416# vss 0.60284f
C98 b2 vss 0.58464f
C99 b4 vss 0.57954f
C100 a_3576_3416# vss 0.53451f
C101 b3 vss 0.61339f
C102 a_4168_3416# vss 1.17112f
.ends

.subckt r_w1_l9p86 a_n100_n1108# a_n100_986# VSUBS
X0 a_n100_986# a_n100_n1108# VSUBS ppolyf_u_1k r_width=1u r_length=9.86u
C0 a_n100_n1108# VSUBS 0.27003f
C1 a_n100_986# VSUBS 0.27003f
.ends

.subckt r_w2_l2p5 a_n200_250# a_n200_n372# VSUBS
X0 a_n200_250# a_n200_n372# VSUBS ppolyf_u_1k r_width=2u r_length=2.5u
C0 a_n200_n372# a_n200_250# 0.01672f
C1 a_n200_n372# VSUBS 0.4345f
C2 a_n200_250# VSUBS 0.4345f
.ends

.subckt r_w1_l2p465 a_n100_n369# a_n100_247# VSUBS
X0 a_n100_247# a_n100_n369# VSUBS ppolyf_u_1k r_width=1u r_length=2.47u
C0 a_n100_n369# a_n100_247# 0.00837f
C1 a_n100_n369# VSUBS 0.25651f
C2 a_n100_247# VSUBS 0.25651f
.ends

.subckt r_w1_l4p93 a_n100_n615# a_n100_493# VSUBS
X0 a_n100_493# a_n100_n615# VSUBS ppolyf_u_1k r_width=1u r_length=4.93u
C0 a_n100_n615# a_n100_493# 0.0042f
C1 a_n100_n615# VSUBS 0.2623f
C2 a_n100_493# VSUBS 0.2623f
.ends

.subckt r_w1_l13p145 a_n100_1315# a_n100_n1437# VSUBS
X0 a_n100_1315# a_n100_n1437# VSUBS ppolyf_u_1k r_width=1u r_length=13.15u
C0 a_n100_n1437# VSUBS 0.27003f
C1 a_n100_1315# VSUBS 0.27003f
.ends

.subckt r_w1_l13p39 a_n100_n1461# a_n100_1339# VSUBS
X0 a_n100_1339# a_n100_n1461# VSUBS ppolyf_u_1k r_width=1u r_length=13.39u
C0 a_n100_n1461# VSUBS 0.27003f
C1 a_n100_1339# VSUBS 0.27003f
.ends

.subckt n_w6_l0p28_f2 a_52_n644# a_108_n600# a_n108_n644# a_n196_n600# a_n52_n600#
+ VSUBS
X0 a_108_n600# a_52_n644# a_n52_n600# VSUBS nfet_03v3 ad=2.64p pd=12.88u as=1.56p ps=6.52u w=6u l=0.28u
X1 a_n52_n600# a_n108_n644# a_n196_n600# VSUBS nfet_03v3 ad=1.56p pd=6.52u as=2.64p ps=12.88u w=6u l=0.28u
C0 a_52_n644# a_n52_n600# 0.04695f
C1 a_n196_n600# a_n108_n644# 0.04695f
C2 a_n108_n644# a_n52_n600# 0.04695f
C3 a_52_n644# a_n108_n644# 0.00519f
C4 a_108_n600# a_n52_n600# 0.2597f
C5 a_52_n644# a_108_n600# 0.04695f
C6 a_n196_n600# a_n52_n600# 0.2597f
C7 a_108_n600# VSUBS 0.28641f
C8 a_n52_n600# VSUBS 0.09458f
C9 a_n196_n600# VSUBS 0.28641f
.ends

.subckt vdacr_vt b0 b1 b2 b3 b4 b5 vdd m1_3342_4448# a_3228_3816# m1_5982_4448# a_3820_3816#
+ m1_942_4448# a_5004_3816# m1_502_4448# out a_2636_3816# vss m1_1822_4448# m1_1970_3610#
+ a_2044_3816# m1_4328_3000# a_4412_3816# m1_4648_4446# m1_4488_3600# m1_3600_4920#
+ m1_5542_4448# m1_2702_4448# m1_1382_4448#
XXRS4_0 m1_4648_4446# m1_4328_3000# vss r_w1_l9p86
XXRS4_1 m1_4488_3600# m1_4648_4446# vss r_w1_l9p86
XXRS0 m1_1970_3610# m1_2702_4448# vss r_w2_l2p5
XXRS1 m1_3342_4448# m1_2702_4448# vss r_w1_l2p465
XXRS3 m1_4328_3000# m1_3600_4920# vss r_w1_l9p86
XXRS2 m1_3600_4920# m1_3342_4448# vss r_w1_l4p93
XIB5n a_5004_3816# b5 vss vss n_w0p5_l1
XIB4n a_4412_3816# b4 vss vss n_w0p5_l1
XIB5p vdd a_5004_3816# b5 vdd vss p_w1_l1
XIB3n a_3820_3816# b3 vss vss n_w0p5_l1
XIB4p vdd a_4412_3816# b4 vdd vss p_w1_l1
XIB2n a_3228_3816# b2 vss vss n_w0p5_l1
XIB3p vdd a_3820_3816# b3 vdd vss p_w1_l1
XIB2p vdd a_3228_3816# b2 vdd vss p_w1_l1
XIB1n a_2636_3816# b1 vss vss n_w0p5_l1
XIB0n a_2044_3816# b0 vss vss n_w0p5_l1
XIB1p vdd a_2636_3816# b1 vdd vss p_w1_l1
XIB0p vdd a_2044_3816# b0 vdd vss p_w1_l1
XXRS5_0 m1_4488_3600# m1_5542_4448# vss r_w1_l13p145
XXRS5_1 m1_5542_4448# m1_5982_4448# vss r_w1_l13p145
XXRB0 m1_502_4448# out vss r_w1_l13p39
XSW0 a_2044_3816# m1_1970_3610# a_2044_3816# m1_1970_3610# m1_2702_4448# vss n_w6_l0p28_f2
XXRS5_2 m1_5982_4448# vss vss r_w1_l13p145
XXRB1 m1_942_4448# m1_502_4448# vss r_w1_l13p39
XSW2 a_3228_3816# m1_3342_4448# a_3228_3816# m1_3342_4448# m1_3600_4920# vss n_w6_l0p28_f2
XSW1 a_2636_3816# m1_2702_4448# a_2636_3816# m1_2702_4448# m1_3342_4448# vss n_w6_l0p28_f2
XXRB3 m1_1822_4448# m1_1382_4448# vss r_w1_l13p39
XXRB2 m1_1382_4448# m1_942_4448# vss r_w1_l13p39
XSW3 a_3820_3816# m1_3600_4920# a_3820_3816# m1_3600_4920# m1_4328_3000# vss n_w6_l0p28_f2
XXRB4 m1_1970_3610# m1_1822_4448# vss r_w1_l13p39
XSW4 a_4412_3816# m1_4328_3000# a_4412_3816# m1_4328_3000# m1_4488_3600# vss n_w6_l0p28_f2
XSW5 a_5004_3816# m1_4488_3600# a_5004_3816# m1_4488_3600# vss vss n_w6_l0p28_f2
C0 m1_1970_3610# m1_1822_4448# 0.05422f
C1 m1_942_4448# m1_1822_4448# 0
C2 m1_1822_4448# out 0.01716f
C3 m1_1822_4448# m1_1382_4448# 0.13617f
C4 a_3228_3816# m1_3342_4448# 0.2721f
C5 m1_2702_4448# m1_3342_4448# 0.32043f
C6 m1_1822_4448# a_2636_3816# 0.0315f
C7 m1_3600_4920# m1_1822_4448# 0.02531f
C8 m1_502_4448# m1_1822_4448# 0
C9 m1_1970_3610# a_3228_3816# 0.05212f
C10 m1_1970_3610# m1_2702_4448# 0.34169f
C11 a_2044_3816# m1_1822_4448# 0.00152f
C12 m1_2702_4448# a_4412_3816# -0
C13 m1_5982_4448# m1_4488_3600# 0
C14 m1_5982_4448# m1_4648_4446# 0
C15 m1_1970_3610# m1_3342_4448# 0.00116f
C16 a_3228_3816# a_2636_3816# 0.11112f
C17 a_3228_3816# m1_3600_4920# 0.08395f
C18 m1_2702_4448# a_2636_3816# 0.1678f
C19 b2 a_3228_3816# 0.28704f
C20 vdd a_3228_3816# 0.27287f
C21 m1_2702_4448# m1_3600_4920# 0.03473f
C22 a_5004_3816# a_4412_3816# 0.02705f
C23 m1_5982_4448# m1_4328_3000# 0
C24 a_3228_3816# b3 0.04175f
C25 vdd m1_2702_4448# 0
C26 a_3228_3816# b1 0.02319f
C27 b5 a_5004_3816# 0.15238f
C28 m1_2702_4448# b1 0.01432f
C29 a_2044_3816# a_3228_3816# 0.01538f
C30 m1_3342_4448# a_2636_3816# 0.03732f
C31 m1_4648_4446# m1_2702_4448# 0
C32 m1_3342_4448# m1_3600_4920# 0.50642f
C33 m1_5982_4448# m1_5542_4448# 0.20108f
C34 a_3820_3816# a_3228_3816# 0.095f
C35 a_2044_3816# m1_2702_4448# 0.0396f
C36 b2 m1_3342_4448# 0.02073f
C37 vdd m1_3342_4448# 0.00387f
C38 a_3820_3816# m1_2702_4448# 0.00476f
C39 m1_942_4448# m1_1970_3610# 0
C40 m1_3342_4448# m1_4488_3600# 0
C41 m1_1970_3610# m1_1382_4448# 0
C42 vdd a_5004_3816# 0.24276f
C43 m1_2702_4448# m1_4328_3000# 0
C44 m1_942_4448# out 0.04568f
C45 m1_942_4448# m1_1382_4448# 0.22008f
C46 out m1_1382_4448# 0.04481f
C47 m1_4648_4446# m1_3342_4448# 0.00357f
C48 b5 a_4412_3816# 0.02149f
C49 b4 a_5004_3816# 0.00821f
C50 a_2044_3816# m1_3342_4448# 0
C51 m1_4488_3600# a_5004_3816# 0.08054f
C52 a_3820_3816# m1_3342_4448# 0.13866f
C53 m1_4648_4446# a_5004_3816# 0
C54 m1_3342_4448# m1_4328_3000# 0.04776f
C55 m1_1970_3610# a_2636_3816# 0.26038f
C56 m1_1970_3610# m1_3600_4920# 0.01105f
C57 m1_3600_4920# a_4412_3816# 0.06544f
C58 m1_3600_4920# out 0.00168f
C59 m1_942_4448# m1_502_4448# 0.32053f
C60 m1_502_4448# out 0.05317f
C61 a_5004_3816# m1_4328_3000# 0.00328f
C62 vdd a_4412_3816# 0.37257f
C63 m1_502_4448# m1_1382_4448# 0
C64 a_4412_3816# b3 0.02259f
C65 b4 a_4412_3816# 0.35348f
C66 m1_1970_3610# b1 0.00571f
C67 m1_4488_3600# a_4412_3816# 0.24379f
C68 b5 vdd 0.77239f
C69 b5 b4 0.06082f
C70 m1_4648_4446# a_4412_3816# 0
C71 a_2044_3816# m1_1970_3610# 0.10153f
C72 m1_5542_4448# a_5004_3816# 0.00614f
C73 m1_3600_4920# a_2636_3816# 0
C74 a_2044_3816# m1_1382_4448# 0.00399f
C75 a_3820_3816# a_4412_3816# 0.13807f
C76 b2 a_2636_3816# 0.00158f
C77 vdd a_2636_3816# 0.3449f
C78 vdd m1_3600_4920# 0.01058f
C79 a_2636_3816# b3 0
C80 a_4412_3816# m1_4328_3000# 0.33612f
C81 b5 a_3820_3816# 0
C82 b0 a_2636_3816# 0.00455f
C83 b1 a_2636_3816# 0.52429f
C84 m1_3600_4920# b3 0.0043f
C85 b2 vdd 0.49822f
C86 b2 b3 0.04726f
C87 m1_4488_3600# m1_3600_4920# 0.00423f
C88 vdd b3 0.68874f
C89 b0 vdd 0.59561f
C90 b4 vdd 0.68174f
C91 b2 b1 0.04123f
C92 vdd b1 0.42773f
C93 vdd m1_4488_3600# 0.00711f
C94 a_2044_3816# a_2636_3816# 0.24666f
C95 b4 b3 0.03428f
C96 m1_4648_4446# m1_3600_4920# 0.00845f
C97 b0 b1 0.01967f
C98 b4 m1_4488_3600# 0.01234f
C99 a_3820_3816# a_2636_3816# 0.00239f
C100 a_3820_3816# m1_3600_4920# 0.31917f
C101 a_2044_3816# vdd 0.21896f
C102 a_3820_3816# b2 0.01081f
C103 a_3820_3816# vdd 0.29721f
C104 a_2044_3816# b0 0.1542f
C105 m1_4648_4446# m1_4488_3600# 0.19057f
C106 a_2044_3816# b1 0.01431f
C107 m1_3600_4920# m1_4328_3000# 0.29676f
C108 a_3820_3816# b3 0.24966f
C109 a_3820_3816# b4 0.02144f
C110 a_3820_3816# m1_4488_3600# 0
C111 m1_4328_3000# b3 0.04902f
C112 b4 m1_4328_3000# 0
C113 m1_4488_3600# m1_4328_3000# 0.37579f
C114 m1_5542_4448# m1_3600_4920# 0
C115 m1_4648_4446# m1_4328_3000# 0.34307f
C116 a_3820_3816# m1_4328_3000# 0.13623f
C117 m1_5542_4448# m1_4488_3600# 0.43146f
C118 m1_4648_4446# m1_5542_4448# 0.00178f
C119 m1_2702_4448# m1_1822_4448# 0.01365f
C120 m1_5542_4448# m1_4328_3000# 0.00102f
C121 m1_3342_4448# m1_1822_4448# 0
C122 m1_2702_4448# a_3228_3816# 0.24753f
C123 m1_5982_4448# a_5004_3816# 0.00304f
C124 m1_4488_3600# vss 0.8538f
C125 m1_4328_3000# vss 0.53806f
C126 m1_1382_4448# vss 0.44029f
C127 m1_1822_4448# vss 0.69694f
C128 m1_3342_4448# vss 0.37026f
C129 m1_2702_4448# vss 0.1525f
C130 m1_3600_4920# vss 0.84217f
C131 m1_942_4448# vss 0.30669f
C132 m1_1970_3610# vss 0.29471f
C133 m1_502_4448# vss 0.71325f
C134 out vss 0.81653f
C135 m1_5982_4448# vss 0.81009f
C136 m1_5542_4448# vss 0.39604f
C137 vdd vss 17.44801f
C138 a_2044_3816# vss 1.10805f
C139 b0 vss 0.62622f
C140 a_2636_3816# vss 1.19693f
C141 b1 vss 0.43137f
C142 a_3228_3816# vss 1.02137f
C143 b2 vss 0.41637f
C144 a_3820_3816# vss 0.80739f
C145 b3 vss 0.46252f
C146 b5 vss 0.5235f
C147 a_4412_3816# vss 0.93204f
C148 b4 vss 0.43507f
C149 a_5004_3816# vss 1.4333f
C150 m1_4648_4446# vss 0.32911f
.ends

.subckt p_w0p8_l2 w_n374_n210# a_n288_n80# a_200_n80# a_n200_n124# VSUBS
X0 a_200_n80# a_n200_n124# a_n288_n80# w_n374_n210# pfet_03v3 ad=0.352p pd=2.48u as=0.352p ps=2.48u w=0.8u l=2u
C0 a_n200_n124# a_200_n80# 0.02312f
C1 a_200_n80# w_n374_n210# 0.02527f
C2 a_n288_n80# a_200_n80# 0.0084f
C3 a_n200_n124# w_n374_n210# 0.22666f
C4 a_n200_n124# a_n288_n80# 0.02312f
C5 a_n288_n80# w_n374_n210# 0.02527f
C6 a_200_n80# VSUBS 0.09823f
C7 a_n288_n80# VSUBS 0.09823f
C8 w_n374_n210# VSUBS 0.94248f
.ends

.subckt p_w4_l2_f4 w_n1130_n530# a_n956_n444# a_556_n444# a_n52_n400# a_452_n400#
+ a_n452_n444# a_n556_n400# a_52_n444# a_956_n400# a_n1044_n400# VSUBS
X0 a_n556_n400# a_n956_n444# a_n1044_n400# w_n1130_n530# pfet_03v3 ad=1.04p pd=4.52u as=1.76p ps=8.88u w=4u l=2u
X1 a_n52_n400# a_n452_n444# a_n556_n400# w_n1130_n530# pfet_03v3 ad=1.04p pd=4.52u as=1.04p ps=4.52u w=4u l=2u
X2 a_452_n400# a_52_n444# a_n52_n400# w_n1130_n530# pfet_03v3 ad=1.04p pd=4.52u as=1.04p ps=4.52u w=4u l=2u
X3 a_956_n400# a_556_n444# a_452_n400# w_n1130_n530# pfet_03v3 ad=1.76p pd=8.88u as=1.04p ps=4.52u w=4u l=2u
C0 a_n556_n400# a_n1044_n400# 0.04287f
C1 a_n452_n444# a_n52_n400# 0.11799f
C2 w_n1130_n530# a_556_n444# 0.2233f
C3 a_n956_n444# a_n1044_n400# 0.11799f
C4 w_n1130_n530# a_n1044_n400# 0.12268f
C5 a_956_n400# w_n1130_n530# 0.12268f
C6 a_52_n444# a_452_n400# 0.11799f
C7 w_n1130_n530# a_452_n400# 0.18497f
C8 a_956_n400# a_556_n444# 0.11799f
C9 a_n52_n400# a_452_n400# 0.04287f
C10 a_556_n444# a_452_n400# 0.11799f
C11 a_52_n444# w_n1130_n530# 0.21994f
C12 a_n956_n444# a_n556_n400# 0.11799f
C13 a_n556_n400# w_n1130_n530# 0.18497f
C14 a_52_n444# a_n52_n400# 0.11799f
C15 a_n452_n444# a_52_n444# 0.00519f
C16 a_n956_n444# w_n1130_n530# 0.2233f
C17 a_n556_n400# a_n52_n400# 0.04287f
C18 a_n452_n444# a_n556_n400# 0.11799f
C19 w_n1130_n530# a_n52_n400# 0.18497f
C20 a_52_n444# a_556_n444# 0.00519f
C21 a_956_n400# a_452_n400# 0.04287f
C22 a_n956_n444# a_n452_n444# 0.00519f
C23 a_n452_n444# w_n1130_n530# 0.21994f
C24 a_956_n400# VSUBS 0.19832f
C25 a_452_n400# VSUBS 0.12191f
C26 a_n52_n400# VSUBS 0.11851f
C27 a_n556_n400# VSUBS 0.12191f
C28 a_n1044_n400# VSUBS 0.19832f
C29 w_n1130_n530# VSUBS 7.1868f
.ends

.subckt p_w0p5_l10 a_n1088_n50# a_1000_n50# w_n1174_n180# a_n1000_n94# VSUBS
X0 a_1000_n50# a_n1000_n94# a_n1088_n50# w_n1174_n180# pfet_03v3 ad=0.22p pd=1.88u as=0.22p ps=1.88u w=0.5u l=10u
C0 a_n1000_n94# a_1000_n50# 0.01858f
C1 a_n1000_n94# a_n1088_n50# 0.01858f
C2 a_1000_n50# w_n1174_n180# 0.02013f
C3 a_n1088_n50# w_n1174_n180# 0.02013f
C4 a_n1000_n94# w_n1174_n180# 1.0092f
C5 a_1000_n50# VSUBS 0.30033f
C6 a_n1088_n50# VSUBS 0.30033f
C7 w_n1174_n180# VSUBS 2.53584f
.ends

.subckt n_w2_l2_f4 a_n52_n200# a_452_n200# a_n452_n244# a_n556_n200# a_52_n244# a_956_n200#
+ a_n1044_n200# a_n956_n244# a_556_n244# VSUBS
X0 a_452_n200# a_52_n244# a_n52_n200# VSUBS nfet_03v3 ad=0.52p pd=2.52u as=0.52p ps=2.52u w=2u l=2u
X1 a_956_n200# a_556_n244# a_452_n200# VSUBS nfet_03v3 ad=0.88p pd=4.88u as=0.52p ps=2.52u w=2u l=2u
X2 a_n556_n200# a_n956_n244# a_n1044_n200# VSUBS nfet_03v3 ad=0.52p pd=2.52u as=0.88p ps=4.88u w=2u l=2u
X3 a_n52_n200# a_n452_n244# a_n556_n200# VSUBS nfet_03v3 ad=0.52p pd=2.52u as=0.52p ps=2.52u w=2u l=2u
C0 a_52_n244# a_n52_n200# 0.0587f
C1 a_n452_n244# a_n52_n200# 0.0587f
C2 a_n452_n244# a_n556_n200# 0.0587f
C3 a_n1044_n200# a_n556_n200# 0.02133f
C4 a_556_n244# a_452_n200# 0.0587f
C5 a_956_n200# a_452_n200# 0.02133f
C6 a_n556_n200# a_n956_n244# 0.0587f
C7 a_452_n200# a_52_n244# 0.0587f
C8 a_956_n200# a_556_n244# 0.0587f
C9 a_556_n244# a_52_n244# 0.00519f
C10 a_n452_n244# a_52_n244# 0.00519f
C11 a_n556_n200# a_n52_n200# 0.02133f
C12 a_n452_n244# a_n956_n244# 0.00519f
C13 a_n1044_n200# a_n956_n244# 0.0587f
C14 a_452_n200# a_n52_n200# 0.02133f
C15 a_956_n200# VSUBS 0.26162f
C16 a_452_n200# VSUBS 0.34773f
C17 a_n52_n200# VSUBS 0.34265f
C18 a_n556_n200# VSUBS 0.34773f
C19 a_n1044_n200# VSUBS 0.26162f
.ends

.subckt p_w4_l1_f4 a_252_n400# a_n556_n444# a_n644_n400# a_n252_n444# a_n356_n400#
+ a_n52_n400# a_356_n444# w_n730_n530# a_52_n444# a_556_n400# VSUBS
X0 a_n356_n400# a_n556_n444# a_n644_n400# w_n730_n530# pfet_03v3 ad=1.04p pd=4.52u as=1.76p ps=8.88u w=4u l=1u
X1 a_556_n400# a_356_n444# a_252_n400# w_n730_n530# pfet_03v3 ad=1.76p pd=8.88u as=1.04p ps=4.52u w=4u l=1u
X2 a_n52_n400# a_n252_n444# a_n356_n400# w_n730_n530# pfet_03v3 ad=1.04p pd=4.52u as=1.04p ps=4.52u w=4u l=1u
X3 a_252_n400# a_52_n444# a_n52_n400# w_n730_n530# pfet_03v3 ad=1.04p pd=4.52u as=1.04p ps=4.52u w=4u l=1u
C0 a_n252_n444# a_n556_n444# 0.00519f
C1 w_n730_n530# a_n556_n444# 0.12548f
C2 a_n356_n400# a_n252_n444# 0.08505f
C3 a_n252_n444# a_52_n444# 0.00519f
C4 w_n730_n530# a_252_n400# 0.12997f
C5 w_n730_n530# a_n356_n400# 0.12997f
C6 w_n730_n530# a_52_n444# 0.12212f
C7 w_n730_n530# a_356_n444# 0.12548f
C8 a_n644_n400# a_n556_n444# 0.08505f
C9 a_252_n400# a_n52_n400# 0.07756f
C10 a_n356_n400# a_n52_n400# 0.07756f
C11 a_n52_n400# a_52_n444# 0.08505f
C12 w_n730_n530# a_n252_n444# 0.12212f
C13 a_n356_n400# a_n644_n400# 0.07756f
C14 a_556_n400# a_252_n400# 0.07756f
C15 a_556_n400# a_356_n444# 0.08505f
C16 a_n356_n400# a_n556_n444# 0.08505f
C17 a_n252_n444# a_n52_n400# 0.08505f
C18 w_n730_n530# a_n52_n400# 0.12997f
C19 a_252_n400# a_52_n444# 0.08505f
C20 w_n730_n530# a_n644_n400# 0.09518f
C21 a_252_n400# a_356_n444# 0.08505f
C22 w_n730_n530# a_556_n400# 0.09518f
C23 a_356_n444# a_52_n444# 0.00519f
C24 a_556_n400# VSUBS 0.17216f
C25 a_252_n400# VSUBS 0.0696f
C26 a_n52_n400# VSUBS 0.06619f
C27 a_n356_n400# VSUBS 0.0696f
C28 a_n644_n400# VSUBS 0.17216f
C29 w_n730_n530# VSUBS 4.6428f
.ends

.subckt n_w4_l2_f2 a_n52_n400# a_452_n400# a_n452_n444# a_n540_n400# a_52_n444# VSUBS
X0 a_n52_n400# a_n452_n444# a_n540_n400# VSUBS nfet_03v3 ad=1.04p pd=4.52u as=1.76p ps=8.88u w=4u l=2u
X1 a_452_n400# a_52_n444# a_n52_n400# VSUBS nfet_03v3 ad=1.76p pd=8.88u as=1.04p ps=4.52u w=4u l=2u
C0 a_n452_n444# a_n540_n400# 0.11799f
C1 a_452_n400# a_n52_n400# 0.04287f
C2 a_n52_n400# a_n540_n400# 0.04287f
C3 a_52_n444# a_n452_n444# 0.00519f
C4 a_52_n444# a_n52_n400# 0.11799f
C5 a_52_n444# a_452_n400# 0.11799f
C6 a_n452_n444# a_n52_n400# 0.11799f
C7 a_452_n400# VSUBS 0.33857f
C8 a_n52_n400# VSUBS 0.35281f
C9 a_n540_n400# VSUBS 0.33857f
.ends

.subckt p_w1_l0p5 a_n138_n100# a_50_n100# a_n50_n144# w_n224_n230# VSUBS
X0 a_50_n100# a_n50_n144# a_n138_n100# w_n224_n230# pfet_03v3 ad=0.44p pd=2.88u as=0.44p ps=2.88u w=1u l=0.5u
C0 w_n224_n230# a_n138_n100# 0.0205f
C1 a_50_n100# a_n138_n100# 0.03085f
C2 a_n50_n144# w_n224_n230# 0.07993f
C3 a_n50_n144# a_50_n100# 0.01275f
C4 a_n50_n144# a_n138_n100# 0.01275f
C5 w_n224_n230# a_50_n100# 0.0205f
C6 a_50_n100# VSUBS 0.06546f
C7 a_n138_n100# VSUBS 0.06546f
C8 w_n224_n230# VSUBS 0.61824f
.ends

.subckt p_w4_l2 w_n374_n530# a_n288_n400# a_200_n400# a_n200_n444# VSUBS
X0 a_200_n400# a_n200_n444# a_n288_n400# w_n374_n530# pfet_03v3 ad=1.76p pd=8.88u as=1.76p ps=8.88u w=4u l=2u
C0 w_n374_n530# a_n288_n400# 0.12268f
C1 a_200_n400# a_n288_n400# 0.04287f
C2 a_n200_n444# w_n374_n530# 0.22666f
C3 a_n200_n444# a_200_n400# 0.11799f
C4 a_n200_n444# a_n288_n400# 0.11799f
C5 w_n374_n530# a_200_n400# 0.12268f
C6 a_200_n400# VSUBS 0.20173f
C7 a_n288_n400# VSUBS 0.20173f
C8 w_n374_n530# VSUBS 2.37864f
.ends

.subckt n_w4_l2 a_n288_n400# a_200_n400# a_n200_n444# VSUBS
X0 a_200_n400# a_n200_n444# a_n288_n400# VSUBS nfet_03v3 ad=1.76p pd=8.88u as=1.76p ps=8.88u w=4u l=2u
C0 a_n200_n444# a_200_n400# 0.11799f
C1 a_n288_n400# a_n200_n444# 0.11799f
C2 a_n288_n400# a_200_n400# 0.04287f
C3 a_200_n400# VSUBS 0.34365f
C4 a_n288_n400# VSUBS 0.34365f
.ends

.subckt p_w4_l1 a_n188_n400# a_100_n400# a_n100_n444# w_n274_n530# VSUBS
X0 a_100_n400# a_n100_n444# a_n188_n400# w_n274_n530# pfet_03v3 ad=1.76p pd=8.88u as=1.76p ps=8.88u w=4u l=1u
C0 w_n274_n530# a_n188_n400# 0.09518f
C1 a_100_n400# a_n188_n400# 0.07756f
C2 a_n100_n444# w_n274_n530# 0.12884f
C3 a_n100_n444# a_100_n400# 0.08505f
C4 a_n100_n444# a_n188_n400# 0.08505f
C5 w_n274_n530# a_100_n400# 0.09518f
C6 a_100_n400# VSUBS 0.17557f
C7 a_n188_n400# VSUBS 0.17557f
C8 w_n274_n530# VSUBS 1.74264f
.ends

.subckt r_w1_l14p19 a_n100_1419# a_n100_n1541# VSUBS
X0 a_n100_1419# a_n100_n1541# VSUBS ppolyf_u_1k r_width=1u r_length=14.19u
C0 a_n100_n1541# VSUBS 0.27003f
C1 a_n100_1419# VSUBS 0.27003f
.ends

.subckt p_w0p5_l4 a_n488_n50# a_400_n50# a_n400_n94# w_n574_n180# VSUBS
X0 a_400_n50# a_n400_n94# a_n488_n50# w_n574_n180# pfet_03v3 ad=0.22p pd=1.88u as=0.22p ps=1.88u w=0.5u l=4u
C0 w_n574_n180# a_n488_n50# 0.01856f
C1 a_400_n50# a_n488_n50# 0.0026f
C2 a_n400_n94# w_n574_n180# 0.42229f
C3 a_n400_n94# a_400_n50# 0.01702f
C4 a_n400_n94# a_n488_n50# 0.01702f
C5 w_n574_n180# a_400_n50# 0.01856f
C6 a_400_n50# VSUBS 0.14084f
C7 a_n488_n50# VSUBS 0.14084f
C8 w_n574_n180# VSUBS 1.23984f
.ends

.subckt bias_vi en vglp vgln vth_cmp vth_ref m1_8646_1098# m1_942_738# vreset_src
+ iint m1_8042_6360# ib_x2 m1_7440_2050# m1_5388_6960# m1_7102_850# m1_4894_1238#
+ a_5712_1328# a_2102_5152# m1_4546_7560# m1_502_738# m1_1276_6360# m1_1382_738# vbn_prb
+ vdd a_4976_1528# m1_8332_7080# el a_864_6450# vss ib_r1
XPP vdd vdd vbn_prb a_864_6450# vss p_w0p8_l2
XMO vdd a_864_6450# a_864_6450# vdd m1_1276_6360# a_864_6450# m1_1276_6360# a_864_6450#
+ vdd vdd vss p_w4_l2_f4
XPS vdd m1_7102_850# vdd vgln vss p_w0p5_l10
XOR vss ib_r1 vbn_prb ib_r1 vbn_prb vss vss vbn_prb vbn_prb vss n_w2_l2_f4
XKO a_4976_1528# vglp m1_1276_6360# vglp a_4976_1528# m1_1276_6360# vglp vdd vglp
+ m1_1276_6360# vss p_w4_l1_f4
XMR vdd a_864_6450# a_864_6450# vdd m1_5388_6960# a_864_6450# m1_5388_6960# a_864_6450#
+ vdd vdd vss p_w4_l2_f4
XP1 vdd a_2102_5152# a_2102_5152# vdd vss p_w2_l2
XNS vss m1_7102_850# a_5712_1328# m1_7102_850# a_5712_1328# vss n_w4_l2_f2
XPOFF vdd a_864_6450# en vdd vss p_w1_l0p5
XP2 vdd a_864_6450# a_2102_5152# vdd vss p_w2_l2
XMS2 vss en m1_8646_1098# vss n_w0p5_l1
XMS1 m1_8646_1098# m1_7102_850# a_864_6450# vss n_w0p5_l1
XNT vss m1_4894_1238# a_5712_1328# vss n_w2_l2
XMT vdd vdd m1_8332_7080# a_864_6450# vss p_w4_l2
XKR vreset_src vglp m1_5388_6960# vglp vreset_src m1_5388_6960# vglp vdd vglp m1_5388_6960#
+ vss p_w4_l1_f4
XN1 m1_4894_1238# a_864_6450# vglp vss n_w4_l2
XN2 m1_4894_1238# a_2102_5152# a_4976_1528# vss n_w4_l2
XKT m1_8332_7080# vth_ref vglp vdd vss p_w4_l1
XOX vss m1_7440_2050# vbn_prb m1_7440_2050# vbn_prb vss vss vbn_prb vbn_prb vss n_w2_l2_f4
XXR00 a_4976_1528# m1_502_738# vss r_w1_l14p19
XXR01 m1_502_738# m1_942_738# vss r_w1_l14p19
XXR03 m1_1382_738# vss vss r_w1_l14p19
XXR02 m1_942_738# m1_1382_738# vss r_w1_l14p19
XPB vdd a_5712_1328# a_864_6450# vdd vss p_w0p5_l4
XNB vss a_5712_1328# a_5712_1328# vss n_w2_l2
XMC vdd a_864_6450# a_864_6450# vdd m1_8042_6360# a_864_6450# m1_8042_6360# a_864_6450#
+ vdd vdd vss p_w4_l2_f4
XKC vth_cmp vglp m1_8042_6360# vglp vth_cmp m1_8042_6360# vglp vdd vglp m1_8042_6360#
+ vss p_w4_l1_f4
XME vdd a_864_6450# a_864_6450# vdd m1_4546_7560# a_864_6450# m1_4546_7560# a_864_6450#
+ vdd vdd vss p_w4_l2_f4
XPI vdd vdd iint a_864_6450# vss p_w0p8_l2
XSX2 m1_7440_2050# ib_r1 ib_x2 vss n_w4_l0p5
XKE el vglp m1_4546_7560# vglp el m1_4546_7560# vglp vdd vglp m1_4546_7560# vss p_w4_l1_f4
XDB vss vbn_prb vbn_prb vss n_w2_l2
C0 m1_4546_7560# m1_5388_6960# 0.09335f
C1 m1_8042_6360# vth_ref 0.00285f
C2 el m1_8332_7080# 0.00199f
C3 vbn_prb m1_8042_6360# 0
C4 ib_x2 m1_4894_1238# 0.06226f
C5 en m1_4894_1238# 0
C6 ib_r1 m1_4894_1238# 0.16682f
C7 a_864_6450# m1_5388_6960# 0.32262f
C8 vth_ref m1_5388_6960# 0
C9 vdd m1_942_738# 0.00344f
C10 vglp vdd 5.25107f
C11 vdd a_4976_1528# 1.4633f
C12 a_864_6450# m1_8332_7080# 0.09337f
C13 vgln m1_5388_6960# 0.00536f
C14 a_5712_1328# m1_5388_6960# 0.00317f
C15 a_864_6450# m1_4894_1238# 0.3222f
C16 m1_1382_738# m1_502_738# 0
C17 vth_ref m1_8332_7080# 0.06042f
C18 m1_1382_738# ib_x2 0
C19 vbn_prb m1_4894_1238# 0.02997f
C20 en m1_1382_738# 0.14813f
C21 a_5712_1328# m1_4894_1238# 0.16211f
C22 iint m1_7102_850# 0.3658f
C23 el vth_cmp 0.048f
C24 vglp m1_8042_6360# 0.2232f
C25 el vreset_src 0.03609f
C26 m1_4894_1238# a_2102_5152# 0.06382f
C27 m1_8646_1098# m1_7102_850# -0.00509f
C28 m1_4546_7560# vreset_src 0.00447f
C29 iint ib_x2 0.04728f
C30 en iint 0.17194f
C31 a_864_6450# vth_cmp 0.02777f
C32 vglp m1_5388_6960# 0.15331f
C33 ib_r1 iint 0.10242f
C34 a_864_6450# vreset_src 0.08448f
C35 m1_1382_738# vbn_prb 0
C36 m1_8646_1098# ib_x2 0.01147f
C37 en m1_8646_1098# 0.001f
C38 vth_cmp vth_ref 0.05697f
C39 vglp m1_8332_7080# 0.0652f
C40 vth_ref vreset_src 0.1174f
C41 vglp m1_4894_1238# 0.286f
C42 m1_4894_1238# a_4976_1528# 0.17878f
C43 vgln vreset_src 0
C44 m1_1382_738# a_2102_5152# 0
C45 a_864_6450# iint 0.13343f
C46 vdd m1_8042_6360# 0.53891f
C47 m1_1276_6360# el 0.00217f
C48 ib_x2 m1_7102_850# 0.07339f
C49 a_864_6450# m1_8646_1098# 0.03779f
C50 en m1_7102_850# 0.14198f
C51 iint vbn_prb 0.08998f
C52 a_5712_1328# iint 0.29607f
C53 vgln iint 0.12915f
C54 m1_1276_6360# m1_4546_7560# 0.14038f
C55 ib_r1 m1_7102_850# 0.03826f
C56 iint m1_7440_2050# 0
C57 en m1_502_738# 0.01007f
C58 m1_8646_1098# vbn_prb 0
C59 iint a_2102_5152# 0
C60 vdd m1_5388_6960# 0.62183f
C61 m1_8646_1098# m1_7440_2050# 0.00687f
C62 m1_942_738# m1_1382_738# 0.08765f
C63 a_864_6450# m1_1276_6360# 0.39666f
C64 vglp m1_1382_738# 0.00131f
C65 m1_1382_738# a_4976_1528# 0.00776f
C66 en ib_x2 0.14421f
C67 a_864_6450# m1_7102_850# 0.14649f
C68 vglp vth_cmp 0.28484f
C69 ib_r1 ib_x2 0.20298f
C70 ib_r1 en 0.13773f
C71 m1_4546_7560# el 0.12283f
C72 vdd m1_8332_7080# 0.82484f
C73 vglp vreset_src 0.54612f
C74 vbn_prb m1_7102_850# 0.11192f
C75 a_5712_1328# m1_7102_850# 0.54324f
C76 vgln m1_7102_850# 0.08937f
C77 m1_7440_2050# m1_7102_850# 0.02863f
C78 m1_8042_6360# m1_5388_6960# 0.11312f
C79 a_864_6450# ib_x2 0.02181f
C80 m1_1276_6360# a_2102_5152# 0.00961f
C81 a_864_6450# en 0.33221f
C82 a_864_6450# el 0.02982f
C83 vglp iint 0.04831f
C84 iint a_4976_1528# 0
C85 ib_r1 a_864_6450# 0.24976f
C86 a_864_6450# m1_4546_7560# 0.73f
C87 m1_8042_6360# m1_8332_7080# 0.13476f
C88 el vth_ref 0.71135f
C89 ib_x2 vbn_prb 0.06125f
C90 vglp m1_8646_1098# 0
C91 a_5712_1328# ib_x2 0.10242f
C92 vgln ib_x2 0.26925f
C93 en vbn_prb 0.26578f
C94 a_5712_1328# en 0.05214f
C95 vgln en 0.06792f
C96 ib_x2 m1_7440_2050# 0.08935f
C97 en m1_7440_2050# 0.05869f
C98 ib_r1 vbn_prb 0.81062f
C99 ib_r1 a_5712_1328# 0.15887f
C100 ib_r1 vgln 0.04275f
C101 a_5712_1328# m1_4546_7560# 0
C102 ib_r1 m1_7440_2050# 0.00546f
C103 vdd m1_1382_738# 0.0035f
C104 ib_x2 a_2102_5152# 0.01217f
C105 en a_2102_5152# 0.04646f
C106 vdd vth_cmp 0.17797f
C107 ib_r1 a_2102_5152# 0.11035f
C108 vglp m1_1276_6360# 0.16358f
C109 m1_4546_7560# a_2102_5152# 0.0186f
C110 m1_1276_6360# a_4976_1528# 0.30906f
C111 a_864_6450# vth_ref 0.00723f
C112 vdd vreset_src 0.46224f
C113 a_864_6450# vbn_prb 0.59172f
C114 vglp m1_7102_850# 0.18545f
C115 a_864_6450# a_5712_1328# 0.04659f
C116 a_864_6450# vgln 0.12647f
C117 a_864_6450# m1_7440_2050# 0.06786f
C118 m1_942_738# m1_502_738# 0.42104f
C119 m1_502_738# a_4976_1528# 0.04144f
C120 a_864_6450# a_2102_5152# 0.40639f
C121 a_5712_1328# vbn_prb 0.18056f
C122 vgln vbn_prb 0.23038f
C123 vdd iint 0.18374f
C124 a_5712_1328# vgln 0.3298f
C125 vbn_prb m1_7440_2050# 0.36218f
C126 a_5712_1328# m1_7440_2050# 0.03242f
C127 vgln m1_7440_2050# 0
C128 m1_8042_6360# vth_cmp 0.21651f
C129 vglp ib_x2 0.10572f
C130 ib_x2 a_4976_1528# 0.04795f
C131 en m1_942_738# 0.00966f
C132 vglp en 0.59159f
C133 vglp el 0.41693f
C134 en a_4976_1528# 0.05046f
C135 el a_4976_1528# 0.00185f
C136 m1_8042_6360# vreset_src 0.26401f
C137 vbn_prb a_2102_5152# 0.11077f
C138 a_5712_1328# a_2102_5152# 0.15699f
C139 vgln a_2102_5152# 0.08399f
C140 ib_r1 vglp 0.44719f
C141 ib_r1 a_4976_1528# 0.24273f
C142 vglp m1_4546_7560# 0.73349f
C143 m1_4546_7560# a_4976_1528# 0.00278f
C144 iint m1_8042_6360# 0
C145 vth_cmp m1_5388_6960# 0.00607f
C146 vdd m1_1276_6360# 0.61385f
C147 a_864_6450# vglp 0.83998f
C148 m1_5388_6960# vreset_src 0.26696f
C149 a_864_6450# a_4976_1528# 0.73462f
C150 vdd m1_7102_850# 0.12129f
C151 vth_cmp m1_8332_7080# 0.00111f
C152 vglp vth_ref 0.06719f
C153 vglp vbn_prb 0.48983f
C154 vdd m1_502_738# 0.00342f
C155 vbn_prb a_4976_1528# 0.11005f
C156 m1_8332_7080# vreset_src 0.01543f
C157 vglp vgln 0
C158 a_5712_1328# vglp 0.16841f
C159 a_5712_1328# a_4976_1528# 0.0106f
C160 vgln a_4976_1528# 0
C161 vglp m1_7440_2050# 0.05819f
C162 vdd ib_x2 0
C163 vdd en 0.32674f
C164 vdd el 0.94055f
C165 vglp a_2102_5152# 0.09855f
C166 a_4976_1528# a_2102_5152# 0.4055f
C167 ib_r1 vdd 0
C168 iint m1_4894_1238# 0.00172f
C169 vdd m1_4546_7560# 0.40586f
C170 a_864_6450# vdd 10.38485f
C171 en m1_8042_6360# 0
C172 m1_942_738# a_4976_1528# 0.00922f
C173 vth_cmp vreset_src 0.14964f
C174 vdd vth_ref 0.31053f
C175 vglp a_4976_1528# 0.38892f
C176 vdd vbn_prb 0.24855f
C177 a_5712_1328# vdd 0.56694f
C178 vdd vgln 2.2258f
C179 m1_7102_850# m1_4894_1238# 0
C180 el m1_5388_6960# 0
C181 a_864_6450# m1_8042_6360# 0.5698f
C182 vdd a_2102_5152# 1.73077f
C183 m1_8042_6360# vss -0.29705f
C184 vbn_prb vss 3.71278f
C185 el vss 0.65712f
C186 m1_4546_7560# vss -0.26802f
C187 ib_x2 vss 3.37258f
C188 iint vss 1.91268f
C189 vth_cmp vss 0.07828f
C190 m1_1382_738# vss 1.13003f
C191 m1_942_738# vss 0.5126f
C192 m1_502_738# vss 0.71186f
C193 m1_7440_2050# vss 0.52223f
C194 vth_ref vss 0.57598f
C195 m1_8332_7080# vss -0.04322f
C196 a_2102_5152# vss 0.19991f
C197 a_4976_1528# vss 1.61618f
C198 a_864_6450# vss -0.98223f
C199 m1_4894_1238# vss 0.33472f
C200 vglp vss 1.49743f
C201 vreset_src vss 0.10863f
C202 m1_5388_6960# vss -0.271f
C203 a_5712_1328# vss 1.81802f
C204 m1_8646_1098# vss 0.01901f
C205 en vss 2.7871f
C206 m1_7102_850# vss 0.68137f
C207 m1_1276_6360# vss -0.17835f
C208 ib_r1 vss 1.6597f
C209 vgln vss 0.40803f
C210 vdd vss 64.84496f
.ends

.subckt bias_b1 vth_ref vreset_src ib_r1 ua0 vbn_leak vbn_ref vbp_syn vbp_st vbn_prb
+ el vth_cmp vbn_ax vbp_w ua0_stim_out r0_b0 r0_b1 r0_b2 r0_b3 r0_b4 r2_b0 r2_b1 r2_b2
+ r2_b3 r2_b4 r1_b0 r1_b1 r1_b2 r1_b3 r1_b4 i2_b0 i4_b0 i2_b1 i4_b1 i2_b2 i4_b2 i2_b3
+ i4_b3 i2_b4 i4_b4 i0_b0 i1_b0 i3_b0 i0_b1 i1_b1 i3_b1 i0_b2 i1_b2 i3_b2 i0_b3 i1_b3
+ i3_b3 i0_b4 i1_b4 i3_b4 v0_c0 v0_c1 v0_c2 v0_c3 v0_c4 v0_c5 bias_en ib_x2 ua0_s0
+ ua0_s1 ua0_stim ua0_int vdd vss
XXx0 vbn_leak vdd vss rx_n4
XXx1 vbn_ref vdd vss rx_n2
XXx2 vss vdd vbp_syn rx_p24
XXx3 vbn_ax vdd vss rx_n1
XXx4 vbp_w vdd vss rx_p05
XXg Xm/in_n Xi1/g Xg/m1_4760_1320# Xg/m1_6020_10200# Xg/m1_3298_2050# Xg/m1_5022_10210#
+ Xg/m1_3530_1930# Xg/m1_3898_9610# Xg/a_7580_5314# vss Xi0/g Xg/m1_4906_9490# vdd
+ Xg/m1_6282_1450# Xg/a_1580_5314# Xg/m1_5516_1920# Xg/a_4580_5314# Xg/m1_4538_1930#
+ Xi2/g Xi4/g Xg/a_5188_4156# Xg/m1_3666_9610# Xr/vsp Xr/vsn Xr/vglp Xi3/g Xg/a_3036_4156#
+ Xr/vgln Xm/in_p bias_ladder
XXi0 i0_b0 i0_b1 i0_b2 i0_b3 i0_b4 vbn_leak vss Xi0/m1_988_3644# vdd Xi0/m1_988_2984#
+ Xi0/a_528_4572# Xi0/a_1378_4572# Xi0/a_3078_4572# Xi0/a_3928_4572# Xi0/g Xi0/m1_988_1168#
+ Xi0/a_2228_4572# vss Xi0/m1_650_4492# Xr/vsp Xi0/a_1582_4572# Xi0/a_4132_4572# Xi0/a_2432_4572#
+ Xi0/m1_1460_4102# Xi0/a_732_4572# Xr/vgln Xi0/a_3282_4572# idac_p
XXi1 i1_b0 i1_b1 i1_b2 i1_b3 i1_b4 vbn_ref vss Xi1/m1_988_3644# vdd Xi1/m1_988_2984#
+ Xi1/a_528_4572# Xi1/a_1378_4572# Xi1/a_3078_4572# Xi1/a_3928_4572# Xi1/g Xi1/m1_988_1168#
+ Xi1/a_2228_4572# vss Xi1/m1_650_4492# Xr/vsp Xi1/a_1582_4572# Xi1/a_4132_4572# Xi1/a_2432_4572#
+ Xi1/m1_1460_4102# Xi1/a_732_4572# Xr/vgln Xi1/a_3282_4572# idac_p
XXm ua0 ua0_s0 ua0_s1 ua0_stim ua0_int bias_en Xm/in_n Xm/in_p Xm/iint Xm/a_1744_10100#
+ Xr/en_b vbp_st ua0_stim_out Xm/a_1744_9182# vss vdd Xm/a_1764_11418# Xm/a_2240_11218#
+ Xm/a_420_700# Xm/a_736_7228# Xm/a_736_5516# bias_master
XXi2 i2_b0 i2_b1 i2_b2 i2_b3 i2_b4 vbp_syn Xr/vgln vdd vss Xi2/m1_988_3644# Xi2/a_528_4510#
+ Xi2/a_3928_4510# Xi2/a_3078_4510# Xi2/m1_988_2984# Xi2/a_732_4510# Xi2/a_1582_4510#
+ Xi2/a_3282_4510# Xi2/a_4132_4510# Xi2/a_2432_4510# Xi2/m1_988_1168# vdd Xi2/m1_640_4420#
+ Xi2/a_1378_4510# Xi2/a_2228_4510# Xi2/m1_1500_4102# Xr/vsn Xi2/g idac_n
XXi3 i3_b0 i3_b1 i3_b2 i3_b3 i3_b4 vbn_ax vss Xi3/m1_988_3644# vdd Xi3/m1_988_2984#
+ Xi3/a_528_4572# Xi3/a_1378_4572# Xi3/a_3078_4572# Xi3/a_3928_4572# Xi3/g Xi3/m1_988_1168#
+ Xi3/a_2228_4572# vss Xi3/m1_650_4492# Xr/vsp Xi3/a_1582_4572# Xi3/a_4132_4572# Xi3/a_2432_4572#
+ Xi3/m1_1460_4102# Xi3/a_732_4572# Xr/vgln Xi3/a_3282_4572# idac_p
XXxst vbp_st vdd vss rx_p05
XXi4 i4_b0 i4_b1 i4_b2 i4_b3 i4_b4 vbp_w Xr/vgln vdd vss Xi4/m1_988_3644# Xi4/a_528_4510#
+ Xi4/a_3928_4510# Xi4/a_3078_4510# Xi4/m1_988_2984# Xi4/a_732_4510# Xi4/a_1582_4510#
+ Xi4/a_3282_4510# Xi4/a_4132_4510# Xi4/a_2432_4510# Xi4/m1_988_1168# vdd Xi4/m1_640_4420#
+ Xi4/a_1378_4510# Xi4/a_2228_4510# Xi4/m1_1500_4102# Xr/vsn Xi4/g idac_n
XXd0 r0_b0 r0_b1 r0_b2 r0_b3 r0_b4 vdd Xd0/m1_4222_4048# Xd0/a_2392_3416# Xd0/a_3576_3416#
+ Xd0/m1_942_4048# Xd0/a_1800_3416# Xd0/m1_2262_4048# Xd0/m1_3342_4048# Xd0/m1_4094_3010#
+ Xd0/m1_1382_4048# Xd0/a_2984_3416# el Xd0/a_4168_3416# Xd0/m1_2760_3412# Xd0/m1_1822_4048#
+ vss Xd0/m1_502_4048# vdacr_el
XXd1 r1_b0 r1_b1 r1_b2 r1_b3 r1_b4 vdd Xd1/a_2392_3416# Xd1/a_3576_3416# Xd1/m1_942_4048#
+ Xd1/m1_502_4048# Xd1/a_1800_3416# vreset_src Xd1/m1_2318_2410# Xd1/m1_3492_2640#
+ Xd1/m1_3662_2290# vss Xd1/a_2984_3416# Xd1/a_4168_3416# Xd1/m1_2910_2650# Xd1/m1_3782_4048#
+ Xd1/m1_1716_2640# vdacr_vr
XXr Xr/vgln Xr/en_b Xr/m1_3422_438# Xr/vsp Xr/m1_782_438# Xr/m1_3862_3522# Xr/m1_2542_438#
+ vss vdd Xr/m1_1222_3522# Xr/m1_342_438# Xr/vsn Xr/m1_1662_438# Xr/vglp bias_rails
XXd2 r2_b0 r2_b1 r2_b2 r2_b3 r2_b4 vdd vth_cmp Xd2/a_2392_3416# Xd2/a_3576_3416# Xd2/m1_942_4048#
+ Xd2/a_1800_3416# Xd2/m1_1822_4048# Xd2/m1_2900_3120# Xd2/m1_3542_4048# Xd2/a_2984_3416#
+ Xd2/a_4168_3416# Xd2/m1_2156_3240# Xd2/m1_3982_4048# Xd2/m1_1382_4048# vss Xd2/m1_502_4048#
+ vdacr_vc
XXd3 v0_c0 v0_c1 v0_c2 v0_c3 v0_c4 v0_c5 vdd Xd3/m1_3342_4448# Xd3/a_3228_3816# Xd3/m1_5982_4448#
+ Xd3/a_3820_3816# Xd3/m1_942_4448# Xd3/a_5004_3816# Xd3/m1_502_4448# vth_ref Xd3/a_2636_3816#
+ vss Xd3/m1_1822_4448# Xd3/m1_1970_3610# Xd3/a_2044_3816# Xd3/m1_4328_3000# Xd3/a_4412_3816#
+ Xd3/m1_4648_4446# Xd3/m1_4488_3600# Xd3/m1_3600_4920# Xd3/m1_5542_4448# Xd3/m1_2702_4448#
+ Xd3/m1_1382_4448# vdacr_vt
XXvi bias_en Xr/vglp Xr/vgln vth_cmp vth_ref Xvi/m1_8646_1098# Xvi/m1_942_738# vreset_src
+ Xm/iint Xvi/m1_8042_6360# ib_x2 Xvi/m1_7440_2050# Xvi/m1_5388_6960# Xvi/m1_7102_850#
+ Xvi/m1_4894_1238# Xvi/a_5712_1328# Xvi/a_2102_5152# Xvi/m1_4546_7560# Xvi/m1_502_738#
+ Xvi/m1_1276_6360# Xvi/m1_1382_738# vbn_prb vdd Xvi/a_4976_1528# Xvi/m1_8332_7080#
+ el Xvi/a_864_6450# vss ib_r1 bias_vi
C0 r0_b3 vbn_leak 0
C1 Xr/vglp Xg/a_1580_5314# 0.25002f
C2 Xd3/a_4412_3816# Xd3/a_5004_3816# -0.0118f
C3 vdd Xm/a_1764_11418# -0.01398f
C4 vbn_ref i4_b0 0.9482f
C5 Xi0/g i4_b1 0.08748f
C6 Xi1/a_4132_4572# vbp_st 0
C7 Xg/m1_5516_1920# vbn_ref 0.01716f
C8 vdd Xi1/m1_650_4492# -0.00928f
C9 v0_c1 ua0_int 0.08883f
C10 Xi3/g r0_b4 0.01445f
C11 i0_b3 Xi0/a_4132_4572# 0.03589f
C12 Xi4/g el 0.07553f
C13 r1_b1 Xm/in_n 0
C14 Xvi/m1_5388_6960# Xvi/m1_8042_6360# -0.00678f
C15 Xr/vglp vbn_leak 0.23221f
C16 vth_cmp Xd1/m1_2910_2650# 0.06075f
C17 r0_b1 Xi1/g 0
C18 Xd3/a_3820_3816# v0_c4 0.07617f
C19 Xi0/a_3282_4572# i0_b2 0.00202f
C20 i1_b1 i1_b4 0.16264f
C21 v0_c0 vth_ref 0.19695f
C22 Xr/vgln r0_b2 0.11991f
C23 Xi2/g el 0
C24 v0_c0 Xd3/m1_4648_4446# 0
C25 v0_c2 Xd3/m1_5542_4448# 0.03373f
C26 Xm/iint Xm/in_n 0.03547f
C27 Xi4/a_2228_4510# i4_b1 -0.00275f
C28 Xi0/a_2228_4572# vth_ref 0.04533f
C29 Xd1/m1_3662_2290# Xd1/m1_3492_2640# -0.00362f
C30 ib_x2 vth_ref 0.76743f
C31 Xd1/m1_502_4048# r2_b3 0.04753f
C32 Xr/en_b Xd3/m1_1382_4448# 0.00163f
C33 vdd i2_b3 0.19999f
C34 v0_c2 v0_c1 0.58637f
C35 ib_x2 Xi0/a_528_4572# 0.04267f
C36 Xi3/a_3078_4572# i0_b0 0.15881f
C37 vbp_syn Xi2/m1_988_1168# 0.32161f
C38 Xg/m1_6020_10200# Xi3/g -0.00157f
C39 Xvi/m1_8332_7080# el 0.08385f
C40 Xd2/a_2392_3416# r2_b1 0.02017f
C41 vbn_prb Xd1/m1_1716_2640# 0.08572f
C42 Xi1/a_3282_4572# vbp_st 0.0056f
C43 Xr/vsn Xr/en_b 0
C44 Xr/vsp i4_b0 0.12181f
C45 r0_b0 Xi2/g 0
C46 Xg/m1_4760_1320# Xm/in_n 0.001f
C47 Xd3/m1_1970_3610# Xd3/m1_1822_4448# -0.00535f
C48 i3_b3 i0_b1 0.03728f
C49 r1_b1 i2_b3 0.76358f
C50 Xm/a_736_7228# Xm/a_736_5516# -0.06791f
C51 Xr/vgln Xi2/a_4132_4510# 0.07217f
C52 r2_b2 Xi4/m1_640_4420# 0.14429f
C53 Xi4/a_3282_4510# el 0.01404f
C54 r0_b3 Xi2/m1_988_1168# 0.03735f
C55 r2_b1 Xi2/a_3078_4510# 0.00294f
C56 Xi3/m1_988_2984# ua0_stim_out 0.20276f
C57 i4_b0 Xi3/a_528_4572# 0
C58 i3_b3 i0_b2 0.05202f
C59 Xr/vsn r1_b0 0.09939f
C60 ib_x2 i0_b0 0.00392f
C61 Xm/a_1744_10100# vbp_st 0
C62 vdd Xi3/m1_1460_4102# -0.00385f
C63 v0_c4 ua0_stim 0.02617f
C64 Xi2/m1_1500_4102# vbp_syn 0.00378f
C65 i2_b1 i4_b0 0.09466f
C66 Xi4/g ib_x2 0.3828f
C67 i0_b3 Xr/vsp 0.23195f
C68 el Xvi/m1_8042_6360# 0.208f
C69 vth_cmp Xd1/a_3576_3416# 0.00319f
C70 Xi1/a_732_4572# i4_b0 0
C71 r1_b4 Xg/a_1580_5314# 0.15004f
C72 Xd0/m1_1822_4048# r2_b3 0.0048f
C73 v0_c0 ua0_s1 0.06813f
C74 Xi3/m1_1460_4102# Xi3/m1_650_4492# -0
C75 Xi1/a_3928_4572# vbp_st 0
C76 Xd1/m1_3662_2290# vth_cmp 0.00409f
C77 Xi2/m1_1500_4102# r0_b3 0.01618f
C78 r0_b3 vbp_syn 0.13118f
C79 i4_b1 i2_b0 0
C80 Xi4/g Xvi/m1_4546_7560# 0.01618f
C81 Xi1/m1_650_4492# Xm/in_n 0.07503f
C82 v0_c4 bias_en 0.14299f
C83 r0_b2 r2_b3 0.73005f
C84 r1_b4 vbn_leak 0.00572f
C85 Xr/vsn r2_b1 0.06734f
C86 v0_c3 Xd3/m1_5982_4448# 0.00124f
C87 i1_b3 i1_b2 1.35579f
C88 i3_b4 i1_b3 0.10135f
C89 Xr/vgln Xi3/a_4132_4572# 0
C90 Xvi/m1_1276_6360# r2_b4 0
C91 i4_b0 el 0.0402f
C92 vbp_st i0_b1 0.04843f
C93 Xi1/a_4132_4572# i0_b4 0.00329f
C94 r2_b0 r0_b2 0
C95 Xi3/g Xg/m1_5022_10210# -0.00107f
C96 Xi3/a_1582_4572# i4_b2 0.01789f
C97 Xr/vsn vbp_st 0.85162f
C98 Xd3/a_3820_3816# vdd 0.08059f
C99 vbp_st i0_b2 0.09197f
C100 Xr/vgln Xi4/a_2432_4510# 0.02242f
C101 v0_c5 ua0_stim 0.24145f
C102 ua0_s0 Xd3/m1_4488_3600# 0.07863f
C103 Xr/vglp r0_b3 0.39945f
C104 i2_b2 Xi3/a_1378_4572# 0
C105 r2_b1 Xd2/a_3576_3416# 0.0013f
C106 Xi1/a_3078_4572# vbp_st 0.00993f
C107 v0_c4 Xd3/m1_5542_4448# 0
C108 Xg/m1_6020_10200# Xg/a_5188_4156# -0
C109 bias_en v0_c5 0.10465f
C110 ua0_s0 Xd3/m1_1822_4448# 0
C111 v0_c4 v0_c1 0.83699f
C112 r1_b2 Xd1/a_2392_3416# -0
C113 vth_cmp Xd0/m1_4222_4048# 0
C114 Xr/vgln i4_b4 0.61057f
C115 i1_b1 ua0_stim_out 0.19136f
C116 i2_b2 vbn_ax 0.06538f
C117 vdd Xd1/a_4168_3416# 0.00213f
C118 vdd Xd0/a_3576_3416# 0.04265f
C119 r0_b2 Xi2/g 0.72534f
C120 Xr/vgln i3_b0 0.02498f
C121 Xvi/a_5712_1328# i4_b4 0.07153f
C122 Xvi/a_864_6450# r2_b4 0.32483f
C123 Xr/m1_1222_3522# Xm/in_n 0
C124 Xi1/a_528_4572# i4_b0 0
C125 Xd0/a_4168_3416# r2_b1 0.02818f
C126 Xg/a_4580_5314# vbn_ax 0.00535f
C127 i4_b3 Xm/in_p 0.08437f
C128 vth_cmp Xd1/a_2392_3416# 0.29237f
C129 r2_b1 Xd0/m1_4094_3010# 0.05338f
C130 i2_b2 Xi2/a_3282_4510# 0.04394f
C131 i0_b1 Xi0/a_1378_4572# 0
C132 r1_b4 Xi2/m1_988_1168# 0.00104f
C133 vdd r0_b4 0.59653f
C134 Xr/vgln Xi0/g 0.79671f
C135 vdd Xd1/a_3576_3416# 0
C136 vth_ref Xd3/m1_5982_4448# 0.00246f
C137 i1_b3 Xm/in_p 0.03486f
C138 ib_r1 Xvi/a_864_6450# 0.03419f
C139 r2_b0 Xd1/a_2984_3416# 0
C140 Xd0/a_4168_3416# vbp_st 0.05874f
C141 i2_b4 r0_b3 0.12356f
C142 Xd0/m1_4094_3010# vbp_st 0.00825f
C143 Xi3/g vbn_ax 0.37715f
C144 Xi3/a_2228_4572# i2_b3 0
C145 Xi2/m1_988_3644# r0_b4 0.00444f
C146 Xg/a_3036_4156# r0_b4 0
C147 Xi3/m1_988_3644# Xi3/g -0.11353f
C148 vdd ua0_stim 0.74257f
C149 Xr/vgln Xvi/m1_1382_738# 0
C150 Xi4/m1_640_4420# el 0
C151 Xi0/a_3078_4572# i0_b4 0
C152 v0_c1 v0_c5 0.33542f
C153 Xr/vgln Xi3/a_3928_4572# 0
C154 Xi1/a_3928_4572# i0_b4 0
C155 r1_b1 r0_b4 0.07249f
C156 Xi3/a_1378_4572# i4_b2 0.14617f
C157 r1_b4 vbp_syn 0.06346f
C158 Xd0/m1_502_4048# vbn_prb 0.05771f
C159 bias_en vdd 0.83367f
C160 i2_b4 Xr/vglp 0.01114f
C161 Xi0/m1_1460_4102# ib_r1 0
C162 Xr/vgln Xi4/a_2228_4510# 0.16962f
C163 i0_b3 Xi0/a_2228_4572# 0
C164 i0_b3 ib_x2 0.00305f
C165 i1_b4 Xi1/a_3928_4572# 0.00211f
C166 vdd Xd0/a_2392_3416# 0.01712f
C167 vdd Xg/m1_6020_10200# -0.01918f
C168 Xi3/m1_988_1168# i1_b2 0.00389f
C169 Xg/a_5188_4156# Xg/m1_5022_10210# -0
C170 Xr/m1_782_438# vbp_st 0.00301f
C171 ib_r1 Xr/m1_342_438# 0.00595f
C172 Xr/m1_3422_438# vbp_st 0.00696f
C173 Xd3/a_2044_3816# v0_c0 0.14502f
C174 Xi2/m1_988_2984# Xi2/m1_988_1168# -0.01211f
C175 Xi1/g Xm/in_p 0.0843f
C176 vbn_ax i4_b2 0.56533f
C177 i0_b1 i0_b4 0.20138f
C178 Xm/a_736_7228# ua0_stim_out -0.00291f
C179 Xi3/m1_988_3644# i4_b2 0.18332f
C180 vth_ref i4_b4 0.03969f
C181 vdd Xi0/a_2432_4572# 0.03444f
C182 Xr/vsn i0_b4 0.25052f
C183 Xi3/a_4132_4572# i0_b0 0.17842f
C184 i0_b2 i0_b4 0.17279f
C185 i2_b2 r2_b2 0.03723f
C186 r1_b2 vbn_ax 0.0385f
C187 i4_b4 Xi0/a_528_4572# 0
C188 Xvi/m1_1276_6360# vbn_leak 0.02294f
C189 i1_b4 i0_b1 0.03458f
C190 r1_b4 Xr/vglp 0.06333f
C191 Xd0/m1_3342_4048# r2_b1 0.04877f
C192 ua0_s1 Xd3/m1_5982_4448# 0
C193 Xr/vsn i1_b4 0.1993f
C194 vdd Xd3/m1_5542_4448# 0.00611f
C195 bias_en Xm/iint 3.42398f
C196 Xd2/m1_1382_4048# vbn_prb 0.01986f
C197 Xd2/m1_3982_4048# el 0
C198 Xi1/a_3078_4572# i0_b4 0.0095f
C199 i3_b3 i4_b3 0.01176f
C200 i1_b4 i0_b2 0.04293f
C201 i4_b3 r1_b0 0.49192f
C202 Xi2/m1_988_2984# vbp_syn 0.17745f
C203 Xi0/g r2_b3 0.24197f
C204 r1_b2 vbp_w 0.03557f
C205 Xi0/g vth_ref 0.04556f
C206 vdd Xd1/a_2392_3416# -0.00255f
C207 Xd0/m1_3342_4048# vbp_st 0.0062f
C208 vdd v0_c1 0.93899f
C209 Xd2/a_1800_3416# vbn_prb 0.11371f
C210 vth_cmp vbn_ax 0.07618f
C211 Xi1/a_3078_4572# i1_b4 0
C212 i3_b3 i1_b3 0.06628f
C213 ib_r1 Xvi/m1_4894_1238# 0.11977f
C214 ua0_s0 Xm/a_420_700# 0.1253f
C215 Xi0/g Xi0/a_528_4572# 0.00325f
C216 Xd0/m1_1382_4048# r2_b3 0.0015f
C217 vbn_ref Xg/a_4580_5314# 0.03809f
C218 vbn_ref Xd0/m1_2760_3412# 0.08571f
C219 r2_b2 Xi3/g 0.00532f
C220 Xm/a_736_7228# Xm/a_1744_9182# -0.00181f
C221 Xi2/m1_988_2984# r0_b3 0.07888f
C222 vth_cmp vbp_w 0.09112f
C223 Xr/vgln i2_b0 0.00178f
C224 r2_b0 Xi0/g 0.01153f
C225 i4_b4 i0_b0 0.20487f
C226 r2_b2 Xd2/a_2984_3416# -0
C227 Xi4/g i4_b4 0.12087f
C228 Xm/in_n Xr/m1_1662_438# 0
C229 vbn_ref Xi3/g 0
C230 Xg/a_5188_4156# vbn_ax 0.10276f
C231 i3_b0 i0_b0 0.05346f
C232 r1_b1 Xd1/a_2392_3416# -0.01414f
C233 vdd Xg/m1_5022_10210# -0.02604f
C234 vreset_src i4_b2 0.02749f
C235 r2_b1 Xd1/m1_2318_2410# 0.00173f
C236 Xi3/m1_988_1168# Xm/in_p 0.05098f
C237 Xm/iint Xd3/m1_5542_4448# 0.0535f
C238 i2_b4 r1_b4 0.03823f
C239 ua0_stim Xm/a_1764_11418# -0
C240 Xvi/a_864_6450# vbn_leak 0.48878f
C241 bias_en Xm/in_n 0.03892f
C242 vdd Xi0/a_3928_4572# 0.0023f
C243 v0_c1 Xm/iint 0.01658f
C244 Xi0/g i0_b0 0.05632f
C245 ua0_s1 Xd3/m1_942_4448# 0
C246 Xg/a_3036_4156# Xg/m1_5022_10210# -0
C247 Xi4/a_2432_4510# Xi4/a_3282_4510# -0.0019f
C248 i4_b3 vbp_st 0.0928f
C249 r2_b2 i4_b2 0.06166f
C250 bias_en Xm/a_1764_11418# 0.00152f
C251 Xd0/a_2984_3416# r2_b3 0.00725f
C252 i2_b3 r0_b4 0.04195f
C253 Xi3/a_732_4572# i4_b2 0.02596f
C254 r1_b0 Xi1/g 0.15753f
C255 i2_b2 Xr/vsp 0.10583f
C256 Xr/vgln r0_b1 0.03801f
C257 Xi4/g Xvi/m1_1382_738# 0.06624f
C258 i1_b3 vbp_st 0.00118f
C259 Xi0/g Xi2/g 0.20658f
C260 Xi0/g Xg/a_7580_5314# 0.23063f
C261 Xr/vsp Xg/a_4580_5314# 0.08953f
C262 Xi2/m1_640_4420# Xr/vsn -0.01819f
C263 Xi3/a_3928_4572# i0_b0 0.01385f
C264 vth_cmp vreset_src 1.05705f
C265 vbn_ref i4_b2 0.05042f
C266 Xi2/a_1582_4510# vbp_syn 0.01159f
C267 i2_b2 Xi3/a_528_4572# 0
C268 r1_b2 r2_b2 0.13762f
C269 Xr/vgln vbn_prb 0.00942f
C270 vdd Xi3/a_1378_4572# -0
C271 Xi1/g Xg/m1_4906_9490# -0
C272 Xi4/a_3282_4510# i4_b4 0
C273 i2_b2 i2_b1 0.21129f
C274 Xvi/a_5712_1328# vbn_prb -0.01779f
C275 Xm/iint Xi0/a_3928_4572# 0
C276 Xr/vsp Xi3/g 0.5561f
C277 vth_cmp r2_b2 0.03294f
C278 Xi0/g Xvi/m1_8332_7080# 0
C279 r1_b2 vbn_ref 0.04545f
C280 r2_b1 Xi1/g 0.00679f
C281 i2_b0 r2_b3 0.16138f
C282 i4_b1 Xm/in_p 0.05033f
C283 Xg/m1_4538_1930# vbp_st 0
C284 Xd0/m1_942_4048# vbn_leak 0.01379f
C285 vdd vbn_ax 1.295f
C286 vdd Xi3/m1_988_3644# -0.01979f
C287 Xi2/a_3078_4510# ua0_stim_out 0.03215f
C288 ib_x2 Xi0/a_1582_4572# 0.02006f
C289 vth_cmp vbn_ref 0.04365f
C290 Xi3/m1_650_4492# vbn_ax -0.00481f
C291 Xi1/g vbp_st 0.35419f
C292 r2_b2 Xg/a_5188_4156# 0
C293 Xi2/a_3282_4510# vdd 0
C294 i2_b1 Xi3/g 0
C295 v0_c0 ua0_int 0.25649f
C296 Xg/a_3036_4156# vbn_ax 0.07318f
C297 Xi3/m1_988_3644# Xi3/m1_650_4492# -0.06116f
C298 vdd vbp_w 0.86519f
C299 vdd Xi4/a_1582_4510# 0.00169f
C300 Xd3/m1_1382_4448# ua0_stim_out 0.05308f
C301 r2_b0 i2_b0 0.0527f
C302 r2_b1 Xd1/m1_1716_2640# 0.00301f
C303 r1_b1 vbn_ax 0.03382f
C304 vbn_ref Xg/a_5188_4156# 0.19797f
C305 Xr/vsp i4_b2 0.76167f
C306 Xvi/m1_1276_6360# Xr/vglp -0
C307 Xd0/m1_2760_3412# el 0.00607f
C308 i0_b1 ua0_stim_out 0.03842f
C309 r2_b2 Xvi/m1_502_738# 0
C310 vdd Xi1/m1_988_2984# -0.03463f
C311 r1_b1 vbp_w 0.03067f
C312 Xi4/a_2228_4510# Xi4/a_3282_4510# -0
C313 ua0_stim_out i0_b2 0.12286f
C314 r0_b1 r2_b3 0.50359f
C315 Xi3/a_528_4572# i4_b2 0.01216f
C316 i4_b0 i3_b0 0.05752f
C317 vbn_ref Xg/m1_3530_1930# 0.01628f
C318 v0_c2 v0_c0 0.0339f
C319 r1_b2 Xr/vsp 0.20083f
C320 Xd2/m1_2156_3240# r2_b3 0.00192f
C321 Xr/vsn r1_b3 0.66261f
C322 i2_b2 r0_b0 0.00135f
C323 vth_cmp Xvi/m1_5388_6960# -0.00217f
C324 vbn_prb r2_b3 0.14215f
C325 Xi0/g i4_b0 0.0446f
C326 v0_c2 ib_x2 1.58513f
C327 i0_b3 i4_b4 0.27867f
C328 vbn_prb Xd1/m1_942_4048# 0.08054f
C329 vdd vreset_src 2.70325f
C330 el Xd1/m1_3492_2640# 0.01097f
C331 Xi1/g Xi0/a_1378_4572# 0
C332 vdd Xi0/m1_988_1168# -0.11391f
C333 r2_b0 r0_b1 0.13345f
C334 i2_b1 r1_b2 0.02889f
C335 Xi4/m1_988_1168# r2_b4 0.06185f
C336 r2_b0 vbn_prb 0.12466f
C337 r2_b0 Xd2/m1_2156_3240# 0
C338 Xd3/a_3820_3816# bias_en 0.04208f
C339 r2_b1 Xi2/a_3928_4510# 0
C340 i1_b3 i0_b4 0.01466f
C341 vdd Xi0/a_4132_4572# -0.01574f
C342 Xr/vglp Xvi/a_864_6450# 0.73344f
C343 Xd0/a_3576_3416# r0_b4 0.00186f
C344 Xr/vsp Xg/a_5188_4156# 0.05648f
C345 i4_b1 r1_b0 0.08634f
C346 r2_b3 Xg/m1_3666_9610# 0
C347 vdd r2_b2 1.31895f
C348 ib_r1 Xi0/m1_650_4492# 0.02076f
C349 r1_b1 vreset_src 0
C350 i4_b2 el 0.04389f
C351 i1_b4 i1_b3 0.0067f
C352 r2_b2 Xg/a_3036_4156# 0.00387f
C353 Xi1/a_528_4572# Xi3/g 0
C354 Xr/vgln i1_b2 0.14438f
C355 vdd vbn_ref 1.03469f
C356 Xm/iint vreset_src 0.03925f
C357 Xi4/g vbn_prb 0.40014f
C358 i3_b4 Xr/vgln 0.00114f
C359 r1_b1 r2_b2 0.23039f
C360 r0_b1 Xi2/g 0.29074f
C361 Xm/iint Xi0/m1_988_1168# 0.03032f
C362 Xi3/a_1378_4572# i2_b3 0
C363 i3_b4 v0_c3 0.00114f
C364 Xr/en_b Xr/m1_3862_3522# 0
C365 Xm/iint Xi0/a_4132_4572# 0
C366 r1_b1 vbn_ref 0.03552f
C367 Xi1/m1_988_2984# Xm/in_n 0.28661f
C368 vth_cmp el 1.05616f
C369 Xr/vglp Xr/m1_342_438# 0.15599f
C370 Xr/vsn Xr/m1_2542_438# -0.0015f
C371 Xi1/g i0_b4 0.06078f
C372 Xd3/a_3820_3816# v0_c1 0.05588f
C373 vbn_ax i2_b3 0
C374 i4_b1 vbp_st 0.28087f
C375 Xg/m1_6020_10200# r0_b4 0.0013f
C376 Xi1/m1_650_4492# Xi1/m1_988_2984# -0.02402f
C377 bias_en ua0_stim 0.02263f
C378 vdd Xvi/m1_5388_6960# -0.07784f
C379 Xi2/a_3282_4510# i2_b3 0.0026f
C380 vreset_src Xm/in_n 0.31594f
C381 vth_cmp r0_b0 0.02248f
C382 i4_b0 i2_b0 0.01316f
C383 Xm/iint Xi0/m1_988_2984# 0.03477f
C384 i2_b2 r0_b2 0.03414f
C385 vdd Xr/vsp 1.95025f
C386 v0_c4 v0_c0 0.10885f
C387 Xr/vsn r2_b4 0.34453f
C388 Xm/iint Xi0/m1_988_3644# 0.08239f
C389 Xr/vgln Xi0/a_732_4572# 0.00524f
C390 Xr/vsp Xi3/m1_650_4492# -0.02248f
C391 vbn_ref Xg/m1_4760_1320# 0.01642f
C392 Xr/vsp Xg/a_3036_4156# 0.04346f
C393 i1_b0 Xi3/m1_988_2984# 0.00629f
C394 vdd Xi3/a_3282_4572# 0.06516f
C395 Xi1/m1_650_4492# vreset_src 0
C396 v0_c4 ib_x2 0.07356f
C397 Xd0/m1_502_4048# r2_b1 0.05146f
C398 Xr/vgln Xm/in_p 0.08948f
C399 r1_b1 Xr/vsp 0.00595f
C400 vdd Xi4/a_528_4510# 0.00162f
C401 Xi3/m1_988_3644# Xi3/m1_1460_4102# -0
C402 i2_b1 vdd 0.38256f
C403 vth_ref i1_b2 0
C404 i3_b4 vth_ref 0
C405 Xm/a_736_7228# ua0_s0 0.34364f
C406 r0_b2 Xi3/g 0
C407 vbn_ref Xm/in_n 0.02005f
C408 v0_c3 Xd3/a_5004_3816# 0.02827f
C409 Xm/iint Xr/vsp 0.22132f
C410 Xd2/a_4168_3416# r2_b3 0.12659f
C411 vdd Xi1/m1_1460_4102# -0.01756f
C412 i1_b1 Xi1/a_2432_4572# 0.00184f
C413 v0_c1 ua0_stim 0.03788f
C414 vth_cmp Xd1/m1_502_4048# 0.00188f
C415 i2_b2 Xi2/a_4132_4510# 0.05269f
C416 i2_b1 r1_b1 0.25404f
C417 bias_en Xd3/m1_5542_4448# 0.00977f
C418 v0_c2 Xd3/m1_5982_4448# 0.18335f
C419 i4_b4 Xi0/a_1582_4572# 0
C420 Xi0/a_3282_4572# Xr/vgln -0
C421 vth_cmp Xvi/m1_4546_7560# 0.00581f
C422 bias_en v0_c1 0.04174f
C423 r0_b4 Xg/m1_5022_10210# 0.06803f
C424 Xd2/m1_3542_4048# Xd2/a_3576_3416# -0
C425 vdd el 1.60891f
C426 v0_c5 ib_x2 0.38836f
C427 i4_b3 ua0_stim_out 0.19043f
C428 r2_b2 i2_b3 0.04727f
C429 Xd2/m1_1382_4048# r2_b1 0.05464f
C430 Xr/vgln Xi4/a_1378_4510# 0
C431 r2_b0 Xd2/a_4168_3416# 0.02089f
C432 Xd3/m1_4328_3000# vth_ref 0.00119f
C433 i1_b2 i0_b0 0.0533f
C434 i1_b0 Xi1/a_1378_4572# 0
C435 i3_b4 i0_b0 0.11369f
C436 Xd2/a_1800_3416# r2_b1 0.12235f
C437 Xd0/a_1800_3416# vdd 0.03185f
C438 i4_b3 r1_b3 0.24955f
C439 i1_b3 ua0_stim_out 0.03675f
C440 Xd3/m1_4648_4446# Xd3/m1_4328_3000# -0.00215f
C441 Xr/vsn Xg/m1_3298_2050# 0.01745f
C442 Xi0/a_732_4572# vth_ref 0.04202f
C443 Xr/vsp Xm/in_n 0.15912f
C444 vdd r0_b0 0.72984f
C445 Xr/vgln Xi4/a_4132_4510# 0.06597f
C446 Xr/vgln Xr/en_b 0.08733f
C447 bias_en Xi0/a_3928_4572# 0
C448 Xg/m1_6020_10200# Xg/m1_5022_10210# -0.0182f
C449 r2_b3 Xm/in_p 0.10075f
C450 vdd Xi3/a_3078_4572# 0.14249f
C451 i1_b1 i1_b0 0.13925f
C452 vth_ref Xm/in_p 0.18694f
C453 i3_b3 Xr/vgln 0.02707f
C454 Xr/vgln r1_b0 0.04273f
C455 Xi1/m1_650_4492# Xr/vsp -0.00413f
C456 vdd Xi1/a_528_4572# 0
C457 vdd v0_c0 0.70606f
C458 Xd3/m1_4648_4446# Xm/in_p 0.00206f
C459 Xr/vsn Xg/a_1580_5314# -0.01542f
C460 ib_r1 Xr/m1_782_438# 0.00907f
C461 vbn_ax r0_b4 0.19653f
C462 i2_b4 i3_b2 0
C463 r2_b0 Xm/in_p 0.06922f
C464 i0_b1 vbn_leak 0.0025f
C465 vdd Xi0/a_2228_4572# 0.04047f
C466 i1_b1 Xi1/a_2228_4572# 0.00531f
C467 Xi1/g ua0_stim_out 0.14897f
C468 i1_b0 i3_b2 0.03127f
C469 Xr/vsn vbn_leak 0.0453f
C470 vdd ib_x2 0.77446f
C471 i0_b2 vbn_leak 0.00221f
C472 Xi0/a_3282_4572# vth_ref 0.05453f
C473 Xm/in_n Xi1/m1_1460_4102# 0
C474 r1_b3 Xi1/g 0.214f
C475 vbp_w r0_b4 0.03725f
C476 Xd3/m1_4328_3000# ua0_s1 0.04265f
C477 Xi2/a_1378_4510# Xr/vgln 0
C478 Xi4/m1_988_3644# Xi4/m1_988_2984# -0.01804f
C479 Xr/vgln Xvi/m1_7102_850# 0.00693f
C480 Xr/vgln r2_b1 0.17192f
C481 vdd Xvi/m1_4546_7560# 0.0254f
C482 Xm/a_1744_10100# ua0_s0 0.00698f
C483 i0_b0 Xm/in_p 0.09069f
C484 i2_b2 i3_b0 0.0041f
C485 r1_b2 Xd1/a_2984_3416# 0
C486 Xm/in_n el 0.00435f
C487 Xvi/m1_1276_6360# Xvi/a_864_6450# -0.04335f
C488 Xd1/m1_3782_4048# el 0.0302f
C489 v0_c0 Xm/iint 0.61795f
C490 Xvi/a_5712_1328# Xvi/m1_7102_850# -0.01155f
C491 Xr/vgln vbp_st 0.6601f
C492 Xg/m1_6020_10200# vbn_ax 0.03077f
C493 i2_b1 i2_b3 1.04195f
C494 i2_b2 Xi0/g 0.06058f
C495 v0_c4 Xd3/m1_5982_4448# 0.00192f
C496 vth_cmp Xd1/a_2984_3416# 0.01916f
C497 Xi3/a_1378_4572# Xi3/a_1582_4572# -0
C498 ua0_s0 Xd3/m1_1382_4448# 0
C499 Xi0/g Xg/a_4580_5314# 0.06324f
C500 Xm/iint ib_x2 0.96699f
C501 ua0_s1 Xm/in_p 0.00225f
C502 Xr/en_b vth_ref 0.10513f
C503 Xd3/a_2636_3816# Xd3/a_3228_3816# -0.01093f
C504 vth_ref Xd3/m1_3600_4920# 0
C505 bias_en Xvi/m1_942_738# 0.01089f
C506 Xi4/a_2432_4510# i4_b2 0
C507 Xr/vsp Xi3/m1_1460_4102# -0.00363f
C508 ua0_s1 Xd3/a_5004_3816# 0.09021f
C509 Xd3/m1_4648_4446# Xd3/m1_3600_4920# -0.00239f
C510 r1_b0 r2_b3 0
C511 Xvi/a_2102_5152# r2_b4 0.09944f
C512 Xd0/m1_2760_3412# Xd0/m1_1382_4048# -0
C513 i4_b3 r2_b4 0.03239f
C514 Xd2/m1_3982_4048# vbn_prb 0.06552f
C515 vdd Xd0/m1_1822_4048# 0
C516 Xi3/m1_988_1168# ua0_stim_out 0.04331f
C517 Xi0/g Xi3/g 0.12839f
C518 Xd0/a_4168_3416# vbn_leak 0.13049f
C519 Xi3/m1_988_3644# Xi3/a_1582_4572# -0.00117f
C520 Xd0/m1_4094_3010# vbn_leak 0.06713f
C521 Xd3/a_4412_3816# ua0_s0 0.06316f
C522 vdd r0_b2 0.41403f
C523 ib_r1 Xvi/a_2102_5152# 0.00658f
C524 vbn_ref Xd1/a_4168_3416# 0.00993f
C525 vbn_ref Xd0/a_3576_3416# 0.06952f
C526 Xr/vsn Xi2/m1_988_1168# -0.07119f
C527 r2_b3 Xg/m1_4906_9490# 0.09158f
C528 r2_b2 r0_b4 0.65534f
C529 i3_b4 i0_b3 0.04342f
C530 i0_b3 i1_b2 0.20275f
C531 Xi2/a_3928_4510# ua0_stim_out 0.08268f
C532 bias_en vreset_src 0.04284f
C533 Xr/vgln Xi0/a_1378_4572# 0.00198f
C534 r2_b0 r1_b0 0.57278f
C535 r0_b2 Xi2/m1_988_3644# 0
C536 i4_b2 i3_b0 0.09127f
C537 ib_x2 Xm/in_n 0.08274f
C538 r1_b1 r0_b2 0.07065f
C539 bias_en Xi0/m1_988_1168# 0.03582f
C540 r2_b1 r2_b3 1.37875f
C541 vbn_ref r0_b4 0.00565f
C542 vbp_w Xi4/m1_988_2984# -0.00969f
C543 r2_b1 Xd1/m1_942_4048# 0.04807f
C544 Xi0/g i4_b2 0.08977f
C545 i2_b4 i3_b1 0.0699f
C546 i3_b3 i0_b0 0.02905f
C547 bias_en Xi0/a_4132_4572# 0
C548 Xg/m1_4538_1930# r2_b4 0
C549 Xr/vsn vbp_syn 0.23938f
C550 r2_b0 Xg/m1_4906_9490# 0.00267f
C551 vbp_st r2_b3 0.19796f
C552 i1_b0 i3_b1 0.03143f
C553 Xd1/m1_1716_2640# Xd1/a_1800_3416# -0.01007f
C554 ua0_s1 Xd3/m1_3600_4920# 0.0382f
C555 vdd Xi2/a_4132_4510# 0
C556 r2_b0 r2_b1 0.34165f
C557 vth_ref vbp_st 0.0425f
C558 Xr/en_b ua0_s1 0.19167f
C559 Xg/m1_6020_10200# r2_b2 0.02067f
C560 r1_b2 Xi0/g 0.30425f
C561 Xi1/g r2_b4 0.14331f
C562 r1_b0 Xi2/g 0.04046f
C563 i4_b1 ua0_stim_out 0.06836f
C564 Xr/vsn r0_b3 0.28888f
C565 vdd Xd1/a_2984_3416# -0.01649f
C566 Xg/a_7580_5314# r1_b0 0.09001f
C567 i4_b0 Xm/in_p 0.04483f
C568 i4_b1 r1_b3 0.19963f
C569 vbn_ref Xd0/a_2392_3416# 0.06821f
C570 i2_b2 i2_b0 0.03833f
C571 ua0 ua0_s1 0.00428f
C572 Xi4/a_2228_4510# i4_b2 -0.00563f
C573 r2_b0 vbp_st 0.59385f
C574 bias_en Xi0/m1_988_2984# 0.0823f
C575 el Xd1/m1_2910_2650# 0.00111f
C576 Xg/m1_3298_2050# i4_b3 0.01373f
C577 ua0_s1 Xd3/m1_502_4448# 0
C578 Xd0/m1_3342_4048# vbn_leak 0.06345f
C579 Xi4/g Xvi/m1_7102_850# 0
C580 bias_en Xi0/m1_988_3644# 0.02666f
C581 vdd Xd3/m1_5982_4448# 0.00118f
C582 Xr/vsn Xi1/a_2432_4572# 0
C583 Xr/vgln i0_b4 0.26825f
C584 Xr/vsn Xr/vglp 1.10979f
C585 Xr/vsp r0_b4 0.2335f
C586 vth_cmp Xd0/m1_1382_4048# 0
C587 i0_b3 Xm/in_p 0.04288f
C588 Xvi/m1_502_738# i4_b4 0
C589 v0_c3 Xd3/a_3228_3816# 0
C590 Xi0/g Xg/a_5188_4156# 0.08054f
C591 vbp_st i0_b0 0.04467f
C592 Xr/vgln i1_b4 0.0513f
C593 r2_b1 Xi2/g 0.25319f
C594 Xi3/g i2_b0 0
C595 Xi4/m1_1500_4102# Xi4/m1_988_2984# -0.00132f
C596 Xi4/g vbp_st 0.29566f
C597 vbn_ref Xd0/m1_4222_4048# 0
C598 vdd Xi3/a_4132_4572# 0.02785f
C599 Xi2/a_528_4510# Xr/vgln -0.01091f
C600 v0_c3 i1_b4 0.00522f
C601 r2_b2 Xi4/m1_988_2984# 0.24329f
C602 vth_ref Xi0/a_1378_4572# 0.04885f
C603 i4_b3 Xg/a_1580_5314# 0.09116f
C604 i2_b2 r0_b1 0.03972f
C605 i2_b1 r0_b4 0.07039f
C606 Xi1/m1_988_3644# vbp_st 0.14877f
C607 Xi2/g vbp_st 0.19578f
C608 Xm/a_736_7228# Xm/a_420_700# -0.00131f
C609 vdd Xi4/a_2432_4510# 0
C610 Xg/a_7580_5314# vbp_st 0.0477f
C611 bias_en Xr/vsp 0.61026f
C612 Xi3/m1_988_3644# vbn_ax -0.0087f
C613 Xi4/m1_988_3644# r2_b2 0.03475f
C614 ua0_s1 vbp_st 0.34918f
C615 Xvi/a_2102_5152# vbn_leak 0.06007f
C616 Xi0/a_3282_4572# i0_b3 0.03338f
C617 i4_b3 vbn_leak 0.40223f
C618 vbp_w vbn_ax 0.41879f
C619 Xg/m1_6020_10200# Xr/vsp -0.01703f
C620 Xm/iint Xd3/m1_5982_4448# 0.12759f
C621 Xd1/m1_2318_2410# vbn_leak 0.00327f
C622 r2_b2 Xg/m1_5022_10210# 0.04438f
C623 i1_b1 Xi1/a_1582_4572# 0.00558f
C624 Xd0/m1_2262_4048# r2_b3 0.01505f
C625 Xd0/m1_2760_3412# vbn_prb 0.05825f
C626 Xd3/a_2636_3816# ua0_stim_out 0
C627 i1_b0 i0_b1 0.43222f
C628 r0_b2 i2_b3 0.05519f
C629 vdd i4_b4 1.25968f
C630 Xd2/m1_3982_4048# Xd2/a_4168_3416# -0.00539f
C631 Xg/m1_6282_1450# vbp_st 0.05162f
C632 i1_b0 i0_b2 0.00154f
C633 Xd3/a_4412_3816# Xd3/m1_4488_3600# -0.00966f
C634 vdd i3_b0 0.00314f
C635 r1_b2 i2_b0 0.02898f
C636 i4_b0 r1_b0 0.54341f
C637 Xg/m1_4538_1930# Xg/a_1580_5314# -0
C638 i1_b1 Xi3/m1_988_2984# 0
C639 Xd1/m1_3662_2290# el 0.03919f
C640 vbn_prb Xd1/m1_3492_2640# 0.06283f
C641 Xd3/a_2636_3816# Xd3/m1_3342_4448# -0
C642 Xd2/a_2984_3416# vbn_prb 0.02812f
C643 Xvi/a_4976_1528# r2_b4 0.17287f
C644 vth_ref i0_b4 0.88789f
C645 Xm/a_2240_11218# Xr/en_b -0.08171f
C646 Xi1/g Xg/a_1580_5314# -0.04676f
C647 Xi2/m1_640_4420# Xr/vgln 0
C648 vdd Xi0/g 0.33788f
C649 Xr/vsn Xi1/a_2228_4572# 0
C650 Xr/vsn r1_b4 0.15836f
C651 i3_b3 i0_b3 0.04198f
C652 r0_b0 r0_b4 0.06287f
C653 vth_cmp i2_b0 0
C654 i1_b4 vth_ref 0.13295f
C655 Xi0/g Xg/a_3036_4156# -0.00281f
C656 ib_r1 Xvi/a_4976_1528# 0.03396f
C657 Xr/vglp Xr/m1_782_438# 0.00436f
C658 i4_b1 r2_b4 0.11261f
C659 Xm/iint Xd3/m1_942_4448# 0.04558f
C660 Xm/iint i4_b4 2.85024f
C661 vbp_w vreset_src 0.04185f
C662 Xi1/g vbn_leak 0.04764f
C663 r2_b3 Xg/m1_3898_9610# 0.00248f
C664 Xi2/a_4132_4510# i2_b3 0.00192f
C665 vdd Xi3/a_3928_4572# 0.21988f
C666 vreset_src Xi4/a_1582_4510# 0.00101f
C667 Xi1/m1_988_1168# i0_b1 0.00129f
C668 Xr/vsn Xi1/m1_988_1168# 0.10917f
C669 r2_b2 vbn_ax 0.04675f
C670 Xi3/a_732_4572# vbn_ax 0.02188f
C671 vdd Xi4/a_2228_4510# 0.09632f
C672 Xi1/m1_988_1168# i0_b2 0.00496f
C673 Xr/vsp Xg/m1_5022_10210# -0.00393f
C674 r2_b2 vbp_w 0.03028f
C675 i4_b0 vbp_st 0.78235f
C676 Xi0/g Xm/iint 0.26687f
C677 Xr/vsp Xi0/a_3928_4572# 0.00173f
C678 i0_b0 i0_b4 0.36967f
C679 vbn_ref vbn_ax 0.04388f
C680 Xg/m1_5516_1920# vbp_st 0.00566f
C681 i1_b1 Xi1/a_1378_4572# 0.00897f
C682 v0_c0 ua0_stim 0.04447f
C683 r0_b0 Xd0/a_2392_3416# 0.00211f
C684 Xd0/m1_4222_4048# el 0.054f
C685 Xi3/a_2432_4572# i3_b0 0.00114f
C686 i3_b4 v0_c2 0
C687 Xm/a_736_5516# ua0_s1 0.26198f
C688 vbn_ref vbp_w 0.21039f
C689 i1_b4 i0_b0 0.1557f
C690 vth_cmp vbn_prb 0.20424f
C691 vdd Xd0/a_2984_3416# 0.03464f
C692 Xi2/m1_988_2984# Xr/vsn -0.02154f
C693 bias_en v0_c0 0.2851f
C694 i4_b4 Xm/in_n 0.06065f
C695 i0_b3 vbp_st 0.04276f
C696 ua0_s1 Xd3/a_3228_3816# 0.12256f
C697 Xr/vgln Xi4/a_3078_4510# 0.04467f
C698 Xm/a_2240_11218# vbp_st 0
C699 Xr/vgln ua0_stim_out 0.87749f
C700 vbn_ref Xi1/m1_988_2984# -0
C701 Xi2/m1_640_4420# r2_b3 0
C702 Xr/vgln r1_b3 0.06572f
C703 bias_en ib_x2 0.6873f
C704 Xd3/a_2636_3816# Xd3/m1_2702_4448# -0.00175f
C705 Xi4/m1_988_3644# el 0
C706 Xi0/g Xm/in_n 0.06981f
C707 r2_b2 vreset_src 0.0323f
C708 v0_c2 Xd3/m1_4328_3000# 0.04205f
C709 i4_b1 Xg/m1_3298_2050# 0.00288f
C710 Xr/vsp vbn_ax 0.46979f
C711 vdd i2_b0 0.22493f
C712 Xvi/m1_502_738# vbn_prb 0.02186f
C713 Xr/vglp i4_b3 0.26061f
C714 Xi3/m1_988_3644# Xr/vsp -0.0148f
C715 r2_b2 Xi4/m1_1500_4102# 0.00898f
C716 Xi0/g Xi1/m1_650_4492# 0
C717 Xi2/m1_640_4420# r2_b0 0.00905f
C718 ua0_int Xd3/a_5004_3816# 0
C719 i1_b1 i3_b2 0.03386f
C720 Xi3/g i1_b2 0.00141f
C721 v0_c0 Xd3/m1_5542_4448# 0
C722 ib_x2 Xi0/a_2432_4572# 0.03656f
C723 Xi3/a_528_4572# vbn_ax 0.11247f
C724 v0_c1 v0_c0 0.22067f
C725 r0_b2 r0_b4 0.48232f
C726 i2_b3 i3_b0 0.12416f
C727 i2_b1 vbn_ax 0
C728 r1_b1 i2_b0 0.04323f
C729 vbn_ref r2_b2 0.04289f
C730 i4_b1 Xg/a_1580_5314# 0.09402f
C731 Xvi/a_4976_1528# vbn_leak 0.03673f
C732 Xr/vsp Xi1/m1_988_2984# -0.00828f
C733 v0_c2 Xd3/a_5004_3816# 0.10588f
C734 v0_c1 ib_x2 0.46143f
C735 i2_b1 Xi2/a_3282_4510# 0
C736 r0_b3 Xi1/g 0.11194f
C737 Xi3/a_2228_4572# i3_b0 0.0011f
C738 Xi4/a_528_4510# vbp_w -0
C739 vdd r0_b1 0.17132f
C740 Xr/vsn Xvi/m1_1276_6360# 0.00823f
C741 i4_b1 vbn_leak 0.2516f
C742 Xr/vglp Xg/m1_4538_1930# 0.01427f
C743 Xi2/m1_640_4420# Xi2/g -0.05041f
C744 ua0_stim_out r2_b3 0.11912f
C745 i2_b4 i4_b3 0.18555f
C746 Xvi/m1_5388_6960# vreset_src -0.00368f
C747 vdd vbn_prb 0.08552f
C748 Xr/vgln Xi2/a_732_4510# -0.00872f
C749 Xd2/m1_3982_4048# r2_b1 0.05658f
C750 r0_b2 Xd0/a_2392_3416# -0.00435f
C751 vth_ref ua0_stim_out 0.71996f
C752 i2_b2 Xm/in_p 1.168f
C753 r1_b3 r2_b3 0.00162f
C754 vbn_ax el 0.01091f
C755 Xr/vsp vreset_src 0.85222f
C756 Xr/vglp Xi1/g 0.26479f
C757 r1_b1 r0_b1 0.65587f
C758 Xr/vsp Xi0/m1_988_1168# 0.09154f
C759 Xd3/m1_4648_4446# ua0_stim_out 0.00304f
C760 vbp_w el 0.0434f
C761 Xm/a_2240_11218# Xm/a_736_5516# -0.15708f
C762 ua0_int Xr/en_b 0.49502f
C763 ib_x2 Xi0/a_3928_4572# 0.04365f
C764 Xi1/m1_988_2984# Xi1/m1_1460_4102# -0.01437f
C765 r2_b0 ua0_stim_out 0.16969f
C766 el Xi4/a_1582_4510# 0.01528f
C767 i0_b3 i0_b4 0.09798f
C768 Xr/vsp Xi0/a_4132_4572# 0.04554f
C769 Xr/vsp r2_b2 0.08557f
C770 Xi3/g Xm/in_p 0.56733f
C771 r0_b0 vbn_ax 0.34033f
C772 Xi4/a_528_4510# vreset_src 0.00118f
C773 r2_b0 r1_b3 0.12317f
C774 r1_b4 i4_b3 0.18562f
C775 Xd3/m1_4648_4446# Xd3/m1_3342_4448# -0.00342f
C776 i0_b3 i1_b4 0.04465f
C777 ua0_int ua0 0.18886f
C778 Xd3/a_2636_3816# Xd3/m1_1970_3610# -0
C779 Xm/iint vbn_prb 0.06495f
C780 Xr/vsn Xvi/a_864_6450# 0.06819f
C781 Xr/vgln r2_b4 0.34895f
C782 vbn_ref Xr/vsp 0.03293f
C783 i1_b1 Xi1/a_4132_4572# 0
C784 Xi2/a_2228_4510# Xr/vgln 0.16923f
C785 Xd0/m1_502_4048# vbn_leak 0.01789f
C786 v0_c2 Xd3/m1_3600_4920# 0.1962f
C787 i0_b0 ua0_stim_out 0.04733f
C788 vbp_w r0_b0 0.30509f
C789 i2_b1 r2_b2 0.21517f
C790 Xvi/a_5712_1328# r2_b4 0.07767f
C791 Xd3/a_2044_3816# Xd3/a_3228_3816# -0
C792 Xr/vgln ib_r1 0.09865f
C793 r2_b2 Xi4/a_528_4510# 0
C794 Xi4/g r1_b3 0.00891f
C795 i2_b4 Xi1/g 0.22486f
C796 Xi2/g ua0_stim_out 0
C797 i1_b1 i3_b1 0.0918f
C798 Xg/a_7580_5314# ua0_stim_out 0.00371f
C799 Xvi/a_5712_1328# ib_r1 0.28968f
C800 vreset_src el 2.05368f
C801 i1_b0 Xi1/g 0.00159f
C802 r0_b3 Xi2/a_3928_4510# 0
C803 bias_en Xd3/m1_5982_4448# 0.19822f
C804 ua0_s1 ua0_stim_out 0.4426f
C805 r1_b3 Xi2/g 0.05838f
C806 Xi1/a_732_4572# vbn_ref 0.00878f
C807 i4_b2 Xm/in_p 0.10633f
C808 Xg/a_7580_5314# r1_b3 0.1022f
C809 r0_b2 Xg/m1_5022_10210# 0.00856f
C810 i2_b0 i2_b3 0.15564f
C811 Xi4/m1_1500_4102# el 0
C812 ua0_int vbp_st -0.0586f
C813 Xr/vsn Xr/m1_342_438# 0.17312f
C814 v0_c4 Xm/in_p 0
C815 r2_b2 el 0.03324f
C816 vbn_ref Xi1/m1_1460_4102# -0.02981f
C817 i1_b1 Xi1/a_3282_4572# 0.00135f
C818 r1_b2 Xm/in_p 0.0498f
C819 i2_b2 r1_b0 0.04759f
C820 Xd1/m1_942_4048# Xd1/a_1800_3416# -0
C821 Xd1/m1_3782_4048# vbn_prb 0.05911f
C822 ua0_s1 Xd3/m1_3342_4448# 0.04858f
C823 v0_c4 Xd3/a_5004_3816# 0.06362f
C824 i3_b2 i3_b1 0.522f
C825 r1_b4 Xi1/g 0.35189f
C826 Xg/a_4580_5314# r1_b0 0.2143f
C827 vbn_ref el 0.25981f
C828 r2_b0 Xd1/a_1800_3416# 0.00471f
C829 ua0_s1 Xm/a_1744_9182# 0.08345f
C830 i2_b2 Xg/m1_4906_9490# 0
C831 Xr/vglp Xvi/a_4976_1528# -0.01108f
C832 Xi1/g Xi1/m1_988_1168# -0.16117f
C833 r2_b3 r2_b4 0.07185f
C834 Xi3/g r1_b0 0.36555f
C835 r0_b1 i2_b3 0.39227f
C836 vth_ref r2_b4 0.13433f
C837 i1_b1 Xi1/a_3928_4572# 0.00139f
C838 vdd i1_b2 0.09609f
C839 Xd0/a_1800_3416# vbn_ref 0.07214f
C840 Xi2/a_1378_4510# i2_b2 0
C841 i2_b2 r2_b1 0.04473f
C842 bias_en Xd3/m1_942_4448# 0
C843 Xd3/a_2636_3816# ua0_s0 0.06848f
C844 Xi2/a_2432_4510# Xr/vgln 0.04661f
C845 i3_b4 vdd 0.01364f
C846 bias_en i4_b4 0.41158f
C847 Xr/vglp i4_b1 0.05314f
C848 i1_b0 Xi3/m1_988_1168# 0.13663f
C849 vbn_ref r0_b0 0.01075f
C850 Xd0/m1_2760_3412# r2_b1 0.09474f
C851 ib_x2 vreset_src 0.07186f
C852 ib_r1 vth_ref 0.58246f
C853 Xi3/g Xg/m1_4906_9490# -0.00179f
C854 v0_c5 Xd3/a_5004_3816# 0.00742f
C855 i2_b1 Xi3/a_528_4572# 0
C856 r2_b0 r2_b4 0.06416f
C857 Xd1/m1_502_4048# vreset_src 0.0357f
C858 Xr/vsp Xi1/m1_1460_4102# -0.00588f
C859 r0_b2 vbn_ax 0.24795f
C860 i2_b4 Xi2/a_3928_4510# 0.00153f
C861 Xd2/m1_3542_4048# r2_b3 0.06543f
C862 ib_x2 Xi0/m1_988_1168# 0.00626f
C863 vdd Xd2/a_4168_3416# 0
C864 Xr/vgln Xg/a_1580_5314# -0.00411f
C865 Xg/a_4580_5314# vbp_st 0.14831f
C866 i4_b0 ua0_stim_out 0.04603f
C867 i1_b1 i0_b1 0.82655f
C868 bias_en Xi0/g 0.55479f
C869 Xvi/m1_5388_6960# el 0.14894f
C870 vreset_src Xvi/m1_4546_7560# 0.25151f
C871 Xd0/m1_2760_3412# vbp_st 0.00284f
C872 r0_b2 vbp_w 0.04655f
C873 ib_x2 Xi0/a_4132_4572# 0.0404f
C874 Xi1/a_528_4572# vbn_ref 0.01905f
C875 Xi3/m1_988_1168# r1_b4 0
C876 i1_b1 i0_b2 0.13452f
C877 i4_b4 Xi0/a_2432_4572# 0
C878 r1_b0 i4_b2 0.18927f
C879 Xg/m1_6020_10200# Xi0/g -0.0038f
C880 Xm/iint i1_b2 0.20112f
C881 r2_b1 Xd1/m1_3492_2640# 0.05431f
C882 i4_b0 r1_b3 0.00482f
C883 vdd Xd3/m1_4328_3000# 0.21757f
C884 i3_b4 Xm/iint 0.03832f
C885 bias_en Xvi/m1_1382_738# 0.02644f
C886 Xd2/a_2984_3416# r2_b1 0.00469f
C887 r2_b0 Xd2/m1_3542_4048# 0
C888 Xr/vgln vbn_leak 0.67184f
C889 Xi4/g r2_b4 0.75674f
C890 i1_b1 Xi1/a_3078_4572# 0.0052f
C891 Xvi/m1_1276_6360# Xvi/a_2102_5152# -0
C892 ua0_s1 Xd3/m1_2702_4448# 0.11539f
C893 i0_b3 ua0_stim_out 0.04491f
C894 i3_b2 i0_b1 0.02942f
C895 i2_b4 i4_b1 0.03936f
C896 Xvi/a_5712_1328# vbn_leak 0.00238f
C897 Xi2/g r2_b4 0.38193f
C898 r1_b2 r1_b0 0.41037f
C899 vdd Xi0/a_732_4572# 0.03901f
C900 ua0_int Xm/a_736_5516# 0.28172f
C901 Xm/a_2240_11218# ua0_stim_out 0.00369f
C902 Xg/a_7580_5314# r2_b4 0.02752f
C903 ib_x2 Xi0/m1_988_2984# 0.02238f
C904 Xi4/a_528_4510# el 0.01302f
C905 i3_b2 i0_b2 0.08058f
C906 ib_r1 Xvi/m1_8646_1098# 0.00199f
C907 ib_x2 Xi0/m1_988_3644# 0.0294f
C908 vth_cmp r1_b0 0.04802f
C909 ua0_int Xd3/a_3228_3816# 0
C910 vdd Xm/in_p 2.19856f
C911 vbn_prb Xd1/m1_2910_2650# 0.06446f
C912 vdd Xd3/a_5004_3816# 0.11543f
C913 Xd3/a_2044_3816# ua0_stim_out 0
C914 Xi3/m1_650_4492# Xm/in_p 0.21836f
C915 Xm/iint Xd3/m1_4328_3000# 0.00769f
C916 i4_b2 vbp_st 0.39018f
C917 Xg/m1_6282_1450# r2_b4 0.00771f
C918 Xg/a_5188_4156# r1_b0 0.03066f
C919 i2_b1 r0_b0 0.31425f
C920 i2_b0 r0_b4 0.06873f
C921 r1_b4 i4_b1 0.10838f
C922 Xi4/a_3282_4510# r2_b4 0.00623f
C923 i4_b4 Xi0/a_3928_4572# 0.00143f
C924 Xm/a_2240_11218# Xm/a_1744_9182# -0.04415f
C925 r0_b2 r2_b2 0.1051f
C926 r1_b1 Xm/in_p 0.01632f
C927 vth_cmp r2_b1 0.09217f
C928 Xvi/a_864_6450# Xvi/a_2102_5152# -0.01839f
C929 v0_c2 Xd3/a_3228_3816# 0.15589f
C930 r2_b3 Xg/a_1580_5314# 0.05681f
C931 ib_x2 Xr/vsp 0.10321f
C932 Xi0/a_3282_4572# vdd 0.01443f
C933 r1_b2 vbp_st 0.08997f
C934 vbn_ref Xd0/m1_1822_4048# 0.0697f
C935 Xvi/m1_5388_6960# Xvi/m1_4546_7560# -0
C936 Xg/a_5188_4156# Xg/m1_4906_9490# -0
C937 v0_c2 i1_b4 0
C938 vdd Xi4/a_1378_4510# 0.00302f
C939 r0_b2 vbn_ref 0.00311f
C940 v0_c3 ua0_s0 0.0444f
C941 Xr/vgln Xi2/m1_988_1168# 0.00426f
C942 Xm/iint Xm/in_p 0.26119f
C943 Xvi/m1_8042_6360# r2_b4 0.01043f
C944 vbn_leak r2_b3 0.05332f
C945 vth_cmp vbp_st 0.04543f
C946 vth_ref vbn_leak 0.16653f
C947 Xi4/g Xg/m1_3298_2050# -0.00801f
C948 Xi3/m1_988_2984# i4_b3 0.17475f
C949 r2_b0 Xg/a_1580_5314# 0.0037f
C950 Xi0/a_528_4572# vbn_leak 0.00328f
C951 Xd1/a_4168_3416# vbn_prb 0.00212f
C952 Xd0/a_3576_3416# vbn_prb 0
C953 r0_b1 r0_b4 0.05207f
C954 Xi3/a_1378_4572# i3_b0 0
C955 Xg/m1_3298_2050# Xi2/g 0.09473f
C956 Xi1/a_4132_4572# i0_b1 0
C957 Xg/a_5188_4156# vbp_st 0.01632f
C958 Xd0/a_1800_3416# r0_b0 0.00672f
C959 vdd Xd3/m1_3600_4920# 0.01427f
C960 Xi3/a_2432_4572# Xm/in_p 0
C961 vdd Xi4/a_4132_4510# 0
C962 r2_b0 vbn_leak 0.26015f
C963 Xr/vsn Xi1/a_4132_4572# 0.12206f
C964 vdd Xr/en_b 0.85403f
C965 Xi2/m1_1500_4102# Xr/vgln 0
C966 Xr/vgln vbp_syn 0.21996f
C967 Xd1/a_3576_3416# vbn_prb 0.005f
C968 i4_b0 r2_b4 0.03903f
C969 vbn_prb r0_b4 0
C970 Xr/vgln Xi4/a_3928_4510# 0.03963f
C971 Xi4/g Xg/a_1580_5314# -0
C972 Xg/m1_5516_1920# r2_b4 0
C973 i3_b3 vdd 0.05884f
C974 Xr/vgln r0_b3 0.04804f
C975 Xd1/m1_3662_2290# vbn_prb 0.06259f
C976 Xg/m1_3530_1930# vbp_st 0
C977 Xi1/a_3078_4572# Xi1/a_4132_4572# 0
C978 ua0_s1 Xd3/m1_1970_3610# 0.02245f
C979 vdd r1_b0 1.86566f
C980 vbn_ax i3_b0 0.12667f
C981 i3_b1 i0_b1 0.06275f
C982 vdd ua0 -0.05796f
C983 Xm/in_n Xm/in_p 0.00175f
C984 i0_b0 vbn_leak 0.07554f
C985 Xi2/g Xg/a_1580_5314# -0.0127f
C986 Xi4/g vbn_leak 0.03223f
C987 Xd1/m1_502_4048# el 0.00985f
C988 Xg/a_7580_5314# Xg/a_1580_5314# -0.02458f
C989 i1_b4 Xi3/g 0
C990 r0_b2 Xr/vsp 0.07198f
C991 i3_b1 i0_b2 0.03096f
C992 Xm/a_1764_11418# Xm/in_p -0.01014f
C993 Xg/a_3036_4156# r1_b0 0.0342f
C994 Xi0/g vbn_ax 0.13049f
C995 Xr/vsn Xi4/m1_988_1168# -0.03342f
C996 Xvi/m1_942_738# i4_b4 0
C997 bias_en vbn_prb 0.63818f
C998 Xvi/m1_4546_7560# el 0.02363f
C999 r0_b1 Xd0/a_2392_3416# 0
C1000 r0_b4 Xg/m1_3666_9610# 0.02587f
C1001 Xvi/m1_4894_1238# Xvi/a_2102_5152# 0
C1002 Xr/vgln Xr/vglp 1.31327f
C1003 Xm/iint Xd3/m1_3600_4920# 0.0991f
C1004 vdd Xg/m1_4906_9490# -0.02615f
C1005 Xi4/a_2432_4510# vreset_src 0
C1006 r1_b1 r1_b0 0.35029f
C1007 Xm/iint Xr/en_b 0.07735f
C1008 Xr/vgln Xi1/a_2432_4572# 0.06685f
C1009 vbn_prb Xd0/a_2392_3416# 0
C1010 i0_b3 ib_r1 0.00415f
C1011 Xi2/m1_988_1168# r2_b3 0.09203f
C1012 Xi2/a_1378_4510# vdd 0.00452f
C1013 i2_b1 r0_b2 0.08909f
C1014 vdd Xvi/m1_7102_850# 0
C1015 Xr/vsn Xi1/a_3282_4572# 0.00609f
C1016 Xd3/m1_4648_4446# ua0_s0 0
C1017 Xg/a_3036_4156# Xg/m1_4906_9490# -0.00191f
C1018 vdd r2_b1 1.38877f
C1019 i3_b3 Xm/iint 0.01608f
C1020 Xvi/a_5712_1328# Xr/vglp 0.00833f
C1021 Xvi/m1_8332_7080# vbn_leak 0.11746f
C1022 Xi0/g Xi1/m1_988_2984# 0
C1023 Xm/iint Xd3/m1_502_4448# 0.06497f
C1024 vdd vbp_st 2.80348f
C1025 Xi2/m1_988_3644# r2_b1 0.14309f
C1026 vreset_src i4_b4 0.09324f
C1027 v0_c4 Xd3/a_3228_3816# 0.00274f
C1028 r1_b1 r2_b1 0.62775f
C1029 v0_c0 ib_x2 0.06681f
C1030 Xvi/m1_942_738# Xvi/m1_1382_738# 0
C1031 Xi4/a_732_4510# i4_b0 0
C1032 Xvi/m1_1276_6360# Xvi/a_4976_1528# -0
C1033 r2_b0 Xi2/m1_988_1168# 0.03489f
C1034 Xd0/m1_4222_4048# vbn_prb 0.0385f
C1035 Xi0/m1_988_1168# i4_b4 0.04893f
C1036 i0_b1 Xi0/a_3078_4572# 0
C1037 Xd0/m1_1822_4048# el 0
C1038 vbp_syn r2_b3 0.0388f
C1039 Xi4/a_3282_4510# vbn_leak 0
C1040 Xg/a_3036_4156# vbp_st 0.13114f
C1041 Xi1/a_3928_4572# i0_b1 0
C1042 Xi3/a_2228_4572# Xm/in_p 0.00124f
C1043 Xi4/m1_640_4420# r2_b4 0.08071f
C1044 ua0_int ua0_stim_out -0
C1045 i0_b2 Xi0/a_3078_4572# 0.0017f
C1046 i4_b0 Xg/m1_3298_2050# 0
C1047 Xr/vsn Xi1/a_3928_4572# 0.02607f
C1048 i1_b1 i1_b3 0.11994f
C1049 Xi0/a_2228_4572# ib_x2 0.01717f
C1050 i4_b4 Xi0/a_4132_4572# 0.00139f
C1051 r2_b2 i4_b4 0.0526f
C1052 Xd1/a_2392_3416# vbn_prb 0.00219f
C1053 Xr/en_b Xm/in_n 0.06448f
C1054 i2_b4 Xr/vgln 0.03751f
C1055 r1_b1 vbp_st 0.03941f
C1056 Xi0/g vreset_src 0.0448f
C1057 Xm/iint Xvi/m1_7102_850# 0.04018f
C1058 r0_b3 r2_b3 0.10236f
C1059 i2_b1 Xi2/a_4132_4510# 0
C1060 Xvi/m1_8042_6360# vbn_leak 0.24053f
C1061 Xd0/a_1800_3416# Xd0/m1_1822_4048# -0
C1062 Xi0/g Xi0/m1_988_1168# 0.11469f
C1063 r2_b0 vbp_syn 0.07563f
C1064 Xm/a_1764_11418# Xr/en_b 0.00211f
C1065 Xr/vgln i1_b0 0.20512f
C1066 i4_b3 i3_b2 0.05007f
C1067 Xi3/m1_1460_4102# Xm/in_p 0.03551f
C1068 Xm/iint vbp_st 0.03721f
C1069 ua0_s0 ua0_s1 2.15359f
C1070 Xm/in_n Xd3/m1_502_4448# 0
C1071 Xi2/g Xi2/m1_988_1168# -0.28643f
C1072 Xi0/g r2_b2 0
C1073 v0_c2 ua0_stim_out 0
C1074 i1_b3 i3_b2 0.02973f
C1075 r2_b0 r0_b3 0
C1076 Xr/vsn i0_b1 0.04032f
C1077 i4_b0 Xg/a_1580_5314# 0.05226f
C1078 r0_b2 r0_b0 0.19207f
C1079 Xr/vglp r2_b3 0.41265f
C1080 i4_b4 Xi0/m1_988_2984# 0.04961f
C1081 vdd Xi0/a_1378_4572# 0.02734f
C1082 i0_b1 i0_b2 0.19569f
C1083 Xr/vsn i0_b2 0.04531f
C1084 i4_b4 Xi0/m1_988_3644# 0.12489f
C1085 Xi4/a_2228_4510# vreset_src 0.05679f
C1086 Xvi/a_864_6450# Xvi/a_4976_1528# -0.00916f
C1087 ua0_int Xm/a_1744_9182# -0
C1088 Xr/vglp vth_ref 0.51978f
C1089 Xr/vgln Xi1/a_2228_4572# 0.08672f
C1090 Xr/vgln r1_b4 0.03777f
C1091 vbn_ax i2_b0 0.00181f
C1092 Xi0/g vbn_ref 0.12531f
C1093 i4_b0 vbn_leak 0.24221f
C1094 Xg/m1_4760_1320# vbp_st 0
C1095 Xr/vsn Xi1/a_3078_4572# 0.1305f
C1096 v0_c2 Xd3/m1_3342_4448# 0.13776f
C1097 i2_b2 ua0_stim_out 0.48507f
C1098 r2_b0 Xr/vglp 0.30975f
C1099 Xi2/a_3282_4510# i2_b0 0
C1100 Xi0/g Xi0/m1_988_2984# 0.00978f
C1101 Xd1/m1_3782_4048# r2_b1 0.04557f
C1102 vbn_ref Xd0/m1_1382_4048# 0.00141f
C1103 Xi2/g vbp_syn 0.86238f
C1104 vbp_w i2_b0 0.0396f
C1105 ib_r1 Xvi/m1_7440_2050# 0.06188f
C1106 Xr/vgln Xi1/m1_988_1168# 0.00623f
C1107 r1_b0 i2_b3 0.03515f
C1108 i2_b2 r1_b3 0.03773f
C1109 vdd Xd0/m1_2262_4048# 0
C1110 Xg/a_4580_5314# ua0_stim_out 0.00273f
C1111 bias_en i1_b2 0
C1112 i0_b3 vbn_leak 0
C1113 Xm/in_n vbp_st 1.53043f
C1114 Xg/a_4580_5314# r1_b3 0.45455f
C1115 r0_b3 Xi2/g 0.25957f
C1116 Xr/vsp i4_b4 0.13913f
C1117 i2_b4 r2_b3 0.10713f
C1118 Xd2/m1_3542_4048# Xd2/m1_3982_4048# -0
C1119 Xi4/g Xr/vglp 1.4139f
C1120 Xm/a_1764_11418# vbp_st 0.05979f
C1121 r0_b1 vbn_ax 0.23902f
C1122 Xi3/g ua0_stim_out 0.91876f
C1123 Xi1/m1_650_4492# vbp_st 0.18486f
C1124 Xr/vglp Xvi/m1_8646_1098# 0.00118f
C1125 vdd Xd3/a_3228_3816# 0.06909f
C1126 Xi3/g r1_b3 0.15806f
C1127 Xi2/m1_988_2984# Xr/vgln 0.00145f
C1128 vbn_ax vbn_prb 0.00559f
C1129 vdd i0_b4 0.49001f
C1130 Xr/vglp Xi2/g 0.07725f
C1131 Xd3/m1_4488_3600# vth_ref 0.00169f
C1132 Xi3/a_528_4572# i3_b0 0.00426f
C1133 vbp_w r0_b1 0.10871f
C1134 vbn_ref Xd0/a_2984_3416# 0.06342f
C1135 r2_b1 i2_b3 0.03279f
C1136 Xr/vglp Xg/a_7580_5314# 0
C1137 Xi0/g Xr/vsp 0.41738f
C1138 i2_b4 r2_b0 0.02779f
C1139 Xi4/a_2432_4510# el 0.01678f
C1140 vdd i1_b4 0.34426f
C1141 i1_b1 Xi3/m1_988_1168# 0.00512f
C1142 i2_b1 i3_b0 0
C1143 bias_en Xd3/m1_4328_3000# 0.04427f
C1144 Xi2/a_528_4510# vdd 0.11741f
C1145 vdd Xg/m1_3898_9610# -0
C1146 r0_b4 Xm/in_p 0.18976f
C1147 Xvi/m1_942_738# vbn_prb 0.01818f
C1148 i4_b2 ua0_stim_out 0.19327f
C1149 i4_b3 i3_b1 0.12999f
C1150 r2_b2 i2_b0 0.08433f
C1151 i2_b4 i0_b0 0.00264f
C1152 i3_b4 v0_c1 0
C1153 v0_c2 Xd3/m1_2702_4448# 0.02285f
C1154 Xi3/a_3078_4572# Xi3/a_4132_4572# -0.00568f
C1155 i4_b4 el 0.06968f
C1156 Xr/vsn Xr/m1_3422_438# -0.00854f
C1157 Xm/a_2240_11218# ua0_s0 0.08833f
C1158 r1_b3 i4_b2 1.36832f
C1159 Xm/iint Xd3/a_3228_3816# 0.00155f
C1160 Xd3/a_3820_3816# Xd3/m1_3600_4920# -0.01077f
C1161 v0_c4 ua0_stim_out 0.00273f
C1162 Xm/iint i0_b4 0.07991f
C1163 ua0_stim Xd3/a_5004_3816# 0
C1164 i1_b0 i0_b0 0.3469f
C1165 r1_b2 ua0_stim_out 0.05514f
C1166 r2_b0 r1_b4 0.049f
C1167 Xm/iint i1_b4 0.16199f
C1168 Xd2/m1_2900_3120# r2_b3 0.0081f
C1169 bias_en Xm/in_p 1.47473f
C1170 Xr/vglp Xvi/m1_8042_6360# 0.05018f
C1171 r1_b2 r1_b3 1.47546f
C1172 bias_en Xd3/a_5004_3816# 0.12594f
C1173 vth_cmp ua0_stim_out 0
C1174 vreset_src vbn_prb 0.07928f
C1175 Xd3/a_2044_3816# ua0_s0 0.08087f
C1176 Xg/m1_6020_10200# Xm/in_p 0.00224f
C1177 Xd3/m1_4488_3600# ua0_s1 0.03708f
C1178 r2_b2 r0_b1 0
C1179 r2_b1 Xd1/m1_2910_2650# 0.01493f
C1180 vth_cmp r1_b3 0
C1181 Xi2/m1_988_2984# r2_b3 0
C1182 v0_c1 Xd3/m1_4328_3000# 0
C1183 el Xd0/m1_1382_4048# 0.07085f
C1184 i2_b2 r2_b4 0.0409f
C1185 Xi3/a_3078_4572# i4_b4 0.00202f
C1186 r2_b2 vbn_prb 0.00142f
C1187 Xg/a_5188_4156# ua0_stim_out 0.06744f
C1188 Xi2/m1_640_4420# vdd 0.00167f
C1189 i2_b2 Xi2/a_2228_4510# 0.04117f
C1190 Xr/vgln Xvi/m1_1276_6360# 0.12477f
C1191 ua0_s1 Xd3/m1_1822_4448# 0
C1192 Xi2/a_4132_4510# r0_b2 0.00646f
C1193 Xi3/a_3078_4572# i3_b0 0
C1194 Xm/in_n i0_b4 0.06545f
C1195 i4_b0 Xr/vglp 0.03816f
C1196 vbn_ref r0_b1 0.00282f
C1197 r1_b4 Xi2/g 0.05532f
C1198 v0_c0 Xd3/m1_942_4448# 0
C1199 Xg/a_4580_5314# r2_b4 0.34255f
C1200 Xi3/a_1582_4572# Xm/in_p 0
C1201 Xi1/m1_988_1168# i0_b0 0.4468f
C1202 Xd0/a_1800_3416# Xd0/m1_1382_4048# -0.01662f
C1203 Xg/a_5188_4156# r1_b3 0.04979f
C1204 r1_b4 Xg/a_7580_5314# 0.04317f
C1205 Xi4/a_2228_4510# el 0.08374f
C1206 Xi2/m1_988_2984# r2_b0 0
C1207 vbn_ref vbn_prb 0.13227f
C1208 Xi2/m1_640_4420# Xi2/m1_988_3644# -0
C1209 Xd3/m1_5542_4448# Xm/in_p 0.0707f
C1210 Xd3/a_5004_3816# Xd3/m1_5542_4448# -0
C1211 Xi1/m1_650_4492# i0_b4 0.0537f
C1212 Xi0/a_2228_4572# i4_b4 0.00113f
C1213 ua0_stim Xr/en_b 0.63669f
C1214 Xi3/g r2_b4 0.40299f
C1215 ib_x2 i4_b4 1.60786f
C1216 v0_c1 Xd3/a_5004_3816# 0.07732f
C1217 i0_b3 Xr/vglp 0
C1218 Xi0/g Xi1/a_528_4572# 0
C1219 r2_b2 Xg/m1_3666_9610# 0.01574f
C1220 Xr/vsn Xvi/a_2102_5152# 0
C1221 Xr/vsn i4_b3 0.42625f
C1222 bias_en Xd3/m1_3600_4920# 0.08591f
C1223 i4_b4 Xvi/m1_4546_7560# 0
C1224 bias_en Xr/en_b 0.22655f
C1225 i2_b1 i2_b0 2.07001f
C1226 ua0_stim ua0 0.4224f
C1227 Xd0/a_3576_3416# r2_b1 0
C1228 i1_b3 i0_b1 0.02769f
C1229 r0_b4 Xg/m1_4906_9490# 0.15754f
C1230 Xi0/g ib_x2 0.07712f
C1231 Xr/vgln Xvi/a_864_6450# 0.87736f
C1232 Xr/vgln Xi1/a_1582_4572# 0.06008f
C1233 Xr/vsn i1_b3 0.00145f
C1234 i1_b3 i0_b2 0.03306f
C1235 Xi2/m1_988_2984# Xi2/g -0.12439f
C1236 i2_b4 i4_b0 0.17107f
C1237 bias_en ua0 0.09586f
C1238 Xd1/a_4168_3416# vbp_st 0.01047f
C1239 r2_b1 r0_b4 0.05809f
C1240 Xvi/a_5712_1328# Xvi/a_864_6450# -0.00294f
C1241 vth_cmp Xd1/a_1800_3416# 0.0169f
C1242 i4_b2 r2_b4 0.03921f
C1243 bias_en Xd3/m1_502_4448# 0.00259f
C1244 v0_c2 Xd3/m1_1970_3610# 0.00334f
C1245 Xd0/a_3576_3416# vbp_st 0.04583f
C1246 ib_x2 Xvi/m1_1382_738# 0.00756f
C1247 vdd Xi4/a_3078_4510# 0
C1248 i1_b0 i4_b0 0.00284f
C1249 Xi1/a_3078_4572# i1_b3 0
C1250 Xd0/a_2984_3416# r0_b0 0
C1251 Xd1/m1_3662_2290# r2_b1 0.03887f
C1252 vdd ua0_stim_out 2.20235f
C1253 vbp_st r0_b4 0.07012f
C1254 Xr/vgln Xi3/m1_988_2984# 0.09018f
C1255 Xi3/m1_650_4492# ua0_stim_out 0.07834f
C1256 vdd r1_b3 1.10957f
C1257 i2_b2 Xi2/a_2432_4510# 0.01541f
C1258 Xr/vsn Xg/m1_4538_1930# 0.06344f
C1259 r1_b2 r2_b4 0.03829f
C1260 Xg/a_3036_4156# ua0_stim_out 0.06691f
C1261 Xi2/m1_988_3644# ua0_stim_out 0
C1262 i2_b1 r0_b1 0.31641f
C1263 Xg/m1_6020_10200# Xg/m1_4906_9490# -0.00217f
C1264 bias_en Xvi/m1_7102_850# 0.04223f
C1265 Xi1/g i0_b1 0.01213f
C1266 vdd Xd3/m1_3342_4448# 0.00961f
C1267 v0_c1 Xd3/m1_3600_4920# 0
C1268 r1_b1 ua0_stim_out 0.04353f
C1269 i4_b0 r1_b4 0.50931f
C1270 Xr/m1_1662_438# vbp_st 0.01279f
C1271 Xr/vsn Xi1/g 0.51312f
C1272 Xg/a_3036_4156# r1_b3 0.04871f
C1273 Xr/vgln Xr/m1_342_438# 0.15094f
C1274 vth_cmp r2_b4 0.11733f
C1275 r2_b1 Xd0/a_2392_3416# 0.00164f
C1276 Xi1/g i0_b2 0
C1277 Xr/vsp Xg/m1_3666_9610# 0
C1278 vdd Xm/a_1744_9182# -0.03715f
C1279 r1_b1 r1_b3 0.1308f
C1280 bias_en vbp_st 0.2243f
C1281 r0_b0 i2_b0 1.31286f
C1282 Xi1/a_3078_4572# Xi1/g -0
C1283 Xm/iint ua0_stim_out 0.71435f
C1284 Xg/a_4580_5314# Xg/a_1580_5314# -0.02822f
C1285 Xm/a_420_700# ua0_s1 0.1932f
C1286 Xg/a_5188_4156# r2_b4 0.07356f
C1287 Xd0/a_2392_3416# vbp_st 0.0387f
C1288 vbn_ax Xm/in_p 0.52042f
C1289 Xi3/m1_988_3644# Xm/in_p 0.23559f
C1290 vreset_src Xd2/a_4168_3416# 0.00101f
C1291 ua0_int ua0_s0 0.32338f
C1292 Xd2/m1_502_4048# vbn_prb 0.00745f
C1293 Xd0/m1_4222_4048# r2_b1 0.0419f
C1294 Xr/vglp Xvi/m1_7440_2050# 0.0807f
C1295 el vbn_prb 0.72828f
C1296 Xd0/m1_2760_3412# vbn_leak 0.10605f
C1297 Xi3/g Xg/a_1580_5314# -0.00196f
C1298 Xm/iint Xd3/m1_3342_4448# 0.00268f
C1299 Xvi/a_864_6450# vth_ref 0.28794f
C1300 Xr/vgln Xi1/a_1378_4572# 0.15825f
C1301 Xd0/a_1800_3416# r0_b1 -0.01607f
C1302 Xvi/m1_502_738# r2_b4 0.00333f
C1303 Xd3/a_3820_3816# Xd3/a_3228_3816# -0.03171f
C1304 i0_b3 Xi1/m1_988_1168# 0
C1305 Xvi/a_5712_1328# Xvi/m1_4894_1238# -0.00333f
C1306 Xd0/a_1800_3416# vbn_prb 0.00231f
C1307 vdd Xi2/a_732_4510# 0.08102f
C1308 vdd Xd1/a_1800_3416# -0
C1309 r0_b1 r0_b0 0.26126f
C1310 v0_c2 ua0_s0 0.10335f
C1311 r0_b0 vbn_prb 0.00307f
C1312 Xm/in_n ua0_stim_out 0
C1313 Xg/m1_5022_10210# Xg/m1_4906_9490# -0.0017f
C1314 Xd1/m1_3492_2640# vbn_leak 0.08447f
C1315 Xr/vgln i1_b1 0.32782f
C1316 Xm/a_1764_11418# ua0_stim_out -0.00741f
C1317 r2_b1 Xg/m1_5022_10210# 0
C1318 Xi4/a_1378_4510# Xi4/a_1582_4510# -0
C1319 vth_ref Xr/m1_342_438# 0.10645f
C1320 i4_b2 Xg/a_1580_5314# 0.05409f
C1321 vdd Xd3/m1_2702_4448# 0.00674f
C1322 Xi4/g Xvi/a_864_6450# 0.36938f
C1323 Xi3/a_4132_4572# i4_b4 0.00134f
C1324 Xd0/m1_942_4048# r2_b3 0.00351f
C1325 Xm/a_736_5516# ua0_stim 0
C1326 i4_b2 vbn_leak 0.28627f
C1327 vdd r2_b4 2.26519f
C1328 Xi2/a_2228_4510# vdd 0.01271f
C1329 r1_b2 Xg/a_1580_5314# 0.18228f
C1330 Xr/vsp i1_b2 0.0871f
C1331 Xr/vgln i3_b2 0.14308f
C1332 Xi3/a_732_4572# Xm/in_p 0.01713f
C1333 r2_b2 Xm/in_p 0.14157f
C1334 ib_x2 vbn_prb 0.25691f
C1335 vbn_ax r1_b0 0.19652f
C1336 vdd ib_r1 0.35025f
C1337 Xr/vsn Xvi/a_4976_1528# 0.35138f
C1338 Xd1/m1_502_4048# vbn_prb 0.03849f
C1339 bias_en Xm/a_736_5516# 0.31702f
C1340 i2_b3 ua0_stim_out 0.054f
C1341 r1_b2 vbn_leak 0.08381f
C1342 Xi2/a_528_4510# r0_b4 0
C1343 r0_b2 i2_b0 0.10012f
C1344 r1_b1 r2_b4 0.04103f
C1345 r1_b3 i2_b3 0.0328f
C1346 r0_b4 Xg/m1_3898_9610# 0.02423f
C1347 Xi4/a_1378_4510# vreset_src 0
C1348 Xvi/a_864_6450# Xvi/m1_8332_7080# -0.00731f
C1349 vbp_w r1_b0 0.04018f
C1350 Xg/m1_3298_2050# Xg/m1_3530_1930# -0
C1351 Xm/iint Xd3/m1_2702_4448# 0.06069f
C1352 bias_en Xd3/a_3228_3816# 0.09293f
C1353 bias_en i0_b4 0.07662f
C1354 Xr/vsn i4_b1 0.3968f
C1355 i2_b2 vbp_syn 0
C1356 vth_cmp vbn_leak 0.55889f
C1357 Xi2/m1_1500_4102# i2_b2 0
C1358 bias_en i1_b4 0.64359f
C1359 i4_b4 i3_b0 0.09542f
C1360 vbn_ax r2_b1 0.04394f
C1361 i2_b2 r0_b3 0.20759f
C1362 Xi3/m1_1460_4102# ua0_stim_out 0.0132f
C1363 Xm/iint ib_r1 0.40538f
C1364 Xi0/g i4_b4 0.2595f
C1365 Xi4/a_4132_4510# vreset_src 0.00154f
C1366 Xr/m1_2542_438# Xm/in_n 0.00356f
C1367 vbp_w r2_b1 0.05377f
C1368 Xi2/a_3282_4510# r2_b1 0.00385f
C1369 Xvi/a_864_6450# Xvi/m1_8042_6360# -0.02506f
C1370 vbn_ax vbp_st 0.2011f
C1371 Xi4/a_732_4510# vdd 0.01461f
C1372 Xi4/a_2228_4510# Xi4/a_2432_4510# -0.00343f
C1373 Xd0/m1_1822_4048# vbn_prb 0.06391f
C1374 r0_b2 r0_b1 0.13726f
C1375 Xi2/a_4132_4510# i2_b0 0
C1376 i4_b4 Xvi/m1_1382_738# 0
C1377 vreset_src r1_b0 0.02515f
C1378 v0_c4 ua0_s0 0.1063f
C1379 i2_b2 Xr/vglp 0.06462f
C1380 Xi4/a_4132_4510# r2_b2 0
C1381 vbp_w vbp_st 0.03836f
C1382 Xi3/g r0_b3 0
C1383 Xr/vsp Xm/in_p 0.45109f
C1384 Xi3/a_3928_4572# i4_b4 0.00327f
C1385 Xg/a_4580_5314# Xr/vglp 0
C1386 Xi2/m1_640_4420# r0_b4 0.09582f
C1387 Xd2/a_4168_3416# el 0.01419f
C1388 i4_b3 Xi1/g 0.03663f
C1389 v0_c1 Xd3/a_3228_3816# 0.02129f
C1390 Xi2/a_2432_4510# vdd 0.0021f
C1391 Xm/in_n r2_b4 0.11277f
C1392 Xr/vgln Xi1/a_4132_4572# 0.05268f
C1393 vdd Xd3/m1_1970_3610# 0.00541f
C1394 Xi3/a_3282_4572# Xm/in_p 0.00204f
C1395 Xi3/a_528_4572# Xm/in_p 0.08949f
C1396 v0_c1 i1_b4 0.00369f
C1397 Xi1/m1_988_2984# vbp_st 0.20606f
C1398 r2_b2 r1_b0 0.20003f
C1399 i1_b1 i0_b0 0.11549f
C1400 Xi3/g Xr/vglp 0.02659f
C1401 v0_c2 Xd3/m1_4488_3600# 0.05595f
C1402 i3_b4 Xi3/a_3078_4572# -0
C1403 vreset_src r2_b1 0.05204f
C1404 vdd Xg/a_1580_5314# -0.07548f
C1405 r0_b2 Xg/m1_3666_9610# 0.01275f
C1406 Xi0/a_3282_4572# Xr/vsp 0
C1407 vbn_ref r1_b0 0.61193f
C1408 Xr/vgln i3_b1 0.05471f
C1409 r2_b2 Xg/m1_4906_9490# 0.07095f
C1410 i3_b4 v0_c0 0.02247f
C1411 v0_c5 ua0_s0 0.08391f
C1412 vreset_src vbp_st 0.00353f
C1413 Xr/vgln Xi4/m1_988_1168# 0
C1414 Xi0/a_3928_4572# i0_b4 0.00424f
C1415 Xg/a_3036_4156# Xg/a_1580_5314# -0.00533f
C1416 Xd3/a_3820_3816# Xd3/m1_3342_4448# -0.00415f
C1417 i2_b4 i2_b2 0.58476f
C1418 vdd vbn_leak 2.52869f
C1419 r2_b2 r2_b1 0.15033f
C1420 i3_b2 i0_b0 0.02692f
C1421 i2_b3 r2_b4 0.03645f
C1422 ib_x2 i1_b2 0.0045f
C1423 vbn_prb Xd1/a_2984_3416# 0.00141f
C1424 Xr/vgln Xi1/a_3282_4572# 0.04877f
C1425 Xm/iint Xd3/m1_1970_3610# 0.13235f
C1426 vth_cmp vbp_syn 0.07417f
C1427 Xi2/a_2228_4510# i2_b3 0
C1428 i3_b4 ib_x2 0
C1429 vbn_ref r2_b1 0.09831f
C1430 Xr/vglp i4_b2 0.03524f
C1431 r2_b2 vbp_st 0.04204f
C1432 Xd1/a_4168_3416# r1_b3 0.00149f
C1433 r1_b1 vbn_leak 0.0377f
C1434 Xr/vsp Xr/en_b 0.42979f
C1435 Xi3/m1_988_1168# i4_b3 0.00757f
C1436 i2_b4 Xi3/g 0.00176f
C1437 r0_b4 ua0_stim_out 0.18245f
C1438 r1_b2 Xr/vglp 0.03944f
C1439 v0_c0 Xd3/m1_4328_3000# 0.0021f
C1440 i2_b2 r1_b4 0.23217f
C1441 vbn_ref vbp_st 0.65978f
C1442 i1_b0 Xi3/g 0.38977f
C1443 Xm/iint vbn_leak 0.00155f
C1444 Xr/vgln Xi0/a_3078_4572# 0
C1445 Xd1/a_3576_3416# r1_b3 0.0054f
C1446 Xi3/m1_988_1168# i1_b3 0
C1447 Xr/vsp r1_b0 0.77848f
C1448 Xg/m1_3298_2050# Xm/in_n 0.00687f
C1449 ua0_stim ua0_stim_out -0.08179f
C1450 r1_b4 Xg/a_4580_5314# 0.10544f
C1451 Xd1/m1_3662_2290# r1_b3 -0
C1452 Xr/vgln Xi1/a_3928_4572# 0.05581f
C1453 Xr/vgln Xi2/a_3078_4510# 0.05816f
C1454 i3_b3 Xi3/a_3282_4572# 0
C1455 vth_cmp Xr/vglp 0.08836f
C1456 Xi3/a_3078_4572# Xm/in_p 0.00485f
C1457 Xi4/a_1378_4510# el 0.01178f
C1458 Xr/vsp Xg/m1_4906_9490# -0.00394f
C1459 bias_en ua0_stim_out 0.05851f
C1460 vdd ua0_s0 0.65349f
C1461 Xi3/g r1_b4 0.09488f
C1462 i2_b1 r1_b0 0.0307f
C1463 i2_b4 i4_b2 0.16958f
C1464 v0_c0 Xm/in_p 0.38984f
C1465 Xg/m1_6020_10200# ua0_stim_out 0.09782f
C1466 Xvi/a_4976_1528# Xvi/a_2102_5152# -0.01059f
C1467 ib_x2 Xi0/a_732_4572# 0.0446f
C1468 Xm/a_736_7228# ua0_s1 0.4516f
C1469 Xr/vglp Xg/a_5188_4156# -0.00793f
C1470 Xr/vgln i0_b1 0.16032f
C1471 Xr/vsp r2_b1 0.10672f
C1472 vth_ref Xi0/m1_650_4492# 0
C1473 bias_en Xd3/m1_3342_4448# 0.06473f
C1474 ib_x2 Xm/in_p 0.04209f
C1475 ua0_int Xm/a_420_700# 0.09906f
C1476 i4_b4 vbn_prb 0.05708f
C1477 Xi4/a_4132_4510# el 0.01627f
C1478 Xd3/a_3820_3816# Xd3/m1_2702_4448# -0.00154f
C1479 Xr/vgln Xr/vsn 1.69189f
C1480 i2_b4 r1_b2 0.04147f
C1481 Xr/vgln i0_b2 0.17291f
C1482 i4_b1 i4_b3 0.19549f
C1483 Xr/vglp Xg/m1_3530_1930# 0.06241f
C1484 Xi1/a_4132_4572# i0_b0 0.01734f
C1485 Xi2/a_528_4510# vbp_w 0.1535f
C1486 Xr/vsp vbp_st 0.14161f
C1487 v0_c4 Xd3/m1_4488_3600# 0
C1488 Xvi/a_864_6450# Xvi/m1_7440_2050# -0.02481f
C1489 Xd1/m1_3782_4048# vbn_leak 0.00325f
C1490 Xr/vgln Xi1/a_3078_4572# 0.0729f
C1491 Xi2/a_1378_4510# i2_b1 0
C1492 bias_en Xm/a_1744_9182# 0.14795f
C1493 i2_b1 r2_b1 0.02824f
C1494 v0_c3 Xd3/a_4412_3816# 0.01264f
C1495 r1_b0 el 0.00307f
C1496 Xm/iint ua0_s0 0
C1497 Xd3/m1_5542_4448# ua0_stim_out 0.07344f
C1498 vdd vbp_syn 0.84804f
C1499 Xd2/a_2392_3416# r2_b3 0.00271f
C1500 r1_b4 i4_b2 0.26664f
C1501 i3_b1 i0_b0 0.03276f
C1502 i0_b3 i1_b1 0.00163f
C1503 vdd Xi4/a_3928_4510# 0
C1504 v0_c1 ua0_stim_out 0
C1505 vreset_src i0_b4 0.04636f
C1506 Xi0/a_3282_4572# ib_x2 0.01361f
C1507 Xi2/m1_988_3644# vbp_syn 0.13471f
C1508 vdd r0_b3 0.65477f
C1509 Xvi/m1_1382_738# vbn_prb 0.01822f
C1510 Xi1/a_732_4572# vbp_st 0.00737f
C1511 vbn_prb Xd0/m1_1382_4048# 0.06162f
C1512 r1_b2 r1_b4 0.75878f
C1513 vbn_ref Xd0/m1_2262_4048# 0.05247f
C1514 Xi4/g Xi4/m1_988_1168# 0.31486f
C1515 vth_ref Xi0/a_3078_4572# 0.06676f
C1516 Xd2/m1_502_4048# r2_b1 0.00172f
C1517 Xd2/a_2392_3416# r2_b0 0.02213f
C1518 Xi0/a_4132_4572# i0_b4 0
C1519 Xg/m1_4538_1930# i4_b1 0.00159f
C1520 Xi1/m1_1460_4102# vbp_st 0.08619f
C1521 v0_c1 Xd3/m1_3342_4448# 0
C1522 Xi2/m1_640_4420# vbn_ax 0.01053f
C1523 v0_c0 Xd3/m1_3600_4920# 0.19296f
C1524 Xi2/m1_988_3644# r0_b3 0.04728f
C1525 i3_b3 Xi3/a_3078_4572# 0.00547f
C1526 i0_b3 i3_b2 0.21418f
C1527 Xvi/m1_7102_850# el 0
C1528 r2_b1 el 0.18414f
C1529 Xg/m1_5022_10210# ua0_stim_out 0.02649f
C1530 vdd Xr/vglp 2.44908f
C1531 r1_b1 r0_b3 0.09819f
C1532 i4_b1 Xi1/g 0.19803f
C1533 vbn_ref i0_b4 0.00165f
C1534 Xi2/m1_640_4420# vbp_w 0.03481f
C1535 r0_b2 Xm/in_p 0.22929f
C1536 el vbp_st 0.05701f
C1537 Xd0/a_1800_3416# r2_b1 0
C1538 Xr/vglp Xg/a_3036_4156# 0.16636f
C1539 Xr/vsn r2_b3 0.25953f
C1540 Xi2/a_1582_4510# i2_b2 0
C1541 vth_ref i0_b1 0.03844f
C1542 ua0_s0 Xm/a_1764_11418# 0.00661f
C1543 r1_b4 Xg/a_5188_4156# 0.04012f
C1544 v0_c0 Xd3/m1_502_4448# 0
C1545 r2_b2 Xg/m1_3898_9610# 0.02264f
C1546 r0_b0 r2_b1 0.04146f
C1547 Xr/vsn vth_ref 0.06134f
C1548 Xd0/a_2984_3416# vbn_prb 0
C1549 bias_en Xd3/m1_2702_4448# 0.08968f
C1550 i3_b3 ib_x2 0.00151f
C1551 vth_ref i0_b2 0.04542f
C1552 Xd0/a_1800_3416# vbp_st 0.06512f
C1553 r1_b1 Xr/vglp 0.00146f
C1554 Xi1/a_3928_4572# i0_b0 0
C1555 bias_en r2_b4 0.00234f
C1556 ib_r1 Xr/m1_1662_438# 0.00936f
C1557 Xm/iint Xr/vglp 0.21665f
C1558 r0_b0 vbp_st 0.09615f
C1559 Xr/vsn r2_b0 0.28536f
C1560 Xm/a_736_7228# Xm/a_2240_11218# -0.04128f
C1561 Xm/a_1744_10100# ua0_s1 0.0911f
C1562 r2_b3 Xd2/a_3576_3416# 0.20699f
C1563 i2_b4 vdd 0.23125f
C1564 r0_b1 i2_b0 0.38672f
C1565 bias_en ib_r1 0.84966f
C1566 Xi1/a_528_4572# vbp_st 0.00622f
C1567 vdd Xd3/m1_4488_3600# 0.29825f
C1568 vdd i1_b0 0.82862f
C1569 i0_b0 i0_b1 0.26022f
C1570 ib_x2 Xvi/m1_7102_850# 0.04609f
C1571 Xg/m1_4760_1320# Xr/vglp 0.00623f
C1572 Xd1/m1_2910_2650# vbn_leak 0.01256f
C1573 Xr/vsp i0_b4 0.28179f
C1574 Xr/vsn i0_b0 0.04558f
C1575 vbn_ax ua0_stim_out 0.16719f
C1576 i0_b0 i0_b2 0
C1577 i4_b4 i1_b2 0.12421f
C1578 Xd1/m1_502_4048# r2_b1 0.04589f
C1579 Xi4/g Xr/vsn 0.63217f
C1580 i1_b0 Xi3/m1_650_4492# 0.00332f
C1581 Xi3/m1_988_3644# ua0_stim_out 0.00756f
C1582 vbn_ax r1_b3 0.12026f
C1583 r2_b0 Xd2/a_3576_3416# 0.01957f
C1584 ua0_s1 Xd3/m1_1382_4448# 0
C1585 i3_b4 i4_b4 0.08566f
C1586 vbp_w ua0_stim_out 0.01182f
C1587 i2_b4 r1_b1 0.79024f
C1588 Xi1/a_3078_4572# i0_b0 0.01029f
C1589 Xr/vsp i1_b4 0.08594f
C1590 Xi2/a_3282_4510# ua0_stim_out 0.05436f
C1591 ib_x2 vbp_st 0.0391f
C1592 Xr/vsn Xi1/m1_988_3644# 0.02786f
C1593 Xr/vsn Xi2/g 0.29713f
C1594 i3_b4 i3_b0 0
C1595 Xr/vsn Xg/a_7580_5314# -0.00424f
C1596 vdd Xi1/a_2228_4572# 0
C1597 Xd3/m1_5982_4448# Xm/in_p 0.03248f
C1598 Xr/vglp Xm/in_n 0.23204f
C1599 vbp_w r1_b3 0.05147f
C1600 Xr/vsp Xg/m1_3898_9610# -0
C1601 Xd3/a_5004_3816# Xd3/m1_5982_4448# -0.00289f
C1602 vdd r1_b4 1.24452f
C1603 el Xd0/m1_2262_4048# 0
C1604 Xd3/a_4412_3816# ua0_s1 0.09098f
C1605 Xi4/m1_988_2984# r2_b4 0.05108f
C1606 r1_b4 Xg/a_3036_4156# 0.06468f
C1607 Xi3/a_4132_4572# Xm/in_p 0
C1608 Xm/iint Xd3/m1_4488_3600# 0.05517f
C1609 i0_b3 i3_b1 0.00329f
C1610 vdd Xi1/m1_988_1168# -0.09079f
C1611 r0_b3 i2_b3 0.06295f
C1612 Xi4/m1_988_3644# r2_b4 0.20856f
C1613 i3_b4 Xi3/a_3928_4572# 0
C1614 r1_b1 r1_b4 0.04172f
C1615 Xd2/m1_2156_3240# vbn_prb 0.1146f
C1616 Xr/vsn Xg/m1_6282_1450# 0.09501f
C1617 r0_b4 Xg/a_1580_5314# 0.00104f
C1618 r0_b2 Xg/m1_4906_9490# 0.00376f
C1619 Xd1/a_4168_3416# vbn_leak 0.08777f
C1620 Xd0/m1_1822_4048# r2_b1 0.04306f
C1621 Xm/iint Xd3/m1_1822_4448# 0.09058f
C1622 Xd0/a_3576_3416# vbn_leak 0.02233f
C1623 Xi4/a_3078_4510# vreset_src 0
C1624 Xr/vgln Xvi/a_2102_5152# 0.04512f
C1625 Xr/vgln i4_b3 0.73674f
C1626 r0_b2 r2_b1 0.70477f
C1627 Xi0/a_732_4572# i4_b4 0.00113f
C1628 bias_en Xd3/m1_1970_3610# 0.02343f
C1629 Xvi/a_5712_1328# Xvi/a_2102_5152# -0.02659f
C1630 ib_x2 Xi0/a_1378_4572# 0.04251f
C1631 Xd1/a_3576_3416# vbn_leak 0.13044f
C1632 r0_b4 vbn_leak 0
C1633 Xi3/m1_988_2984# Xi3/g -0.12912f
C1634 Xr/vglp i2_b3 0
C1635 vth_cmp Xvi/m1_1276_6360# 0.00705f
C1636 Xr/vgln i1_b3 0.08198f
C1637 Xd0/m1_1822_4048# vbp_st 0
C1638 Xi2/m1_988_2984# vdd -0
C1639 i4_b4 Xm/in_p 0.03805f
C1640 Xd1/m1_3662_2290# vbn_leak 0.11781f
C1641 Xd3/m1_942_4448# Xm/in_p 0.08881f
C1642 Xd3/a_3820_3816# ua0_s0 0.07901f
C1643 r0_b2 vbp_st 0.0333f
C1644 r2_b2 ua0_stim_out 0.28779f
C1645 i3_b0 Xm/in_p 0.02433f
C1646 Xi2/m1_988_2984# Xi2/m1_988_3644# -0.01859f
C1647 vbp_w Xi2/a_732_4510# 0.11875f
C1648 r2_b2 r1_b3 0.13858f
C1649 i0_b3 Xi0/a_3078_4572# 0.07577f
C1650 bias_en vbn_leak 0.00112f
C1651 Xr/vgln Xg/m1_4538_1930# -0.00829f
C1652 Xi0/g Xm/in_p 0.0631f
C1653 Xr/vsn i4_b0 0.77479f
C1654 vbn_ref r1_b3 0.03746f
C1655 Xd0/a_2392_3416# vbn_leak 0.01978f
C1656 Xi2/a_4132_4510# r2_b1 0.00103f
C1657 Xi2/a_528_4510# r0_b0 0.00892f
C1658 v0_c0 i0_b4 0.01258f
C1659 Xi0/a_3282_4572# i4_b4 0
C1660 Xr/m1_1222_3522# Xr/vglp 0.01394f
C1661 v0_c0 Xd3/a_3228_3816# 0
C1662 Xi3/m1_988_2984# i4_b2 0.06016f
C1663 Xr/vsn Xg/m1_5516_1920# 0.08464f
C1664 Xr/vgln Xi1/g 0.13512f
C1665 v0_c1 Xd3/m1_1970_3610# 0
C1666 vbn_ax r2_b4 0.05505f
C1667 Xi3/a_3928_4572# Xm/in_p 0
C1668 i2_b4 i2_b3 1.44857f
C1669 v0_c0 i1_b4 0.09983f
C1670 vdd Xm/a_420_700# -0.01416f
C1671 Xi1/a_1378_4572# Xi3/g 0
C1672 vbp_w r2_b4 0.22988f
C1673 i0_b3 i0_b1 0
C1674 ib_x2 i0_b4 0.14053f
C1675 Xi2/a_2228_4510# Xi2/a_3282_4510# -0
C1676 Xr/vsn i0_b3 0.04248f
C1677 Xd2/m1_1822_4048# vbn_prb 0.05645f
C1678 Xd1/m1_2318_2410# r2_b3 0
C1679 Xi1/m1_988_1168# Xm/in_n 0.32765f
C1680 Xi4/a_1582_4510# r2_b4 0.00565f
C1681 i0_b3 i0_b2 0.4575f
C1682 Xd0/m1_4222_4048# vbn_leak 0.00405f
C1683 Xi2/m1_988_1168# r0_b4 0.04869f
C1684 i2_b4 Xi3/a_2228_4572# 0
C1685 ib_x2 i1_b4 0.12706f
C1686 ua0_stim ua0_s0 0.17701f
C1687 vreset_src Xd1/a_1800_3416# 0.0064f
C1688 Xi2/a_1582_4510# vdd 0.00836f
C1689 Xvi/m1_942_738# r2_b4 0.00444f
C1690 Xi4/a_4132_4510# i4_b4 0.01777f
C1691 Xm/a_736_7228# ua0_int -0.04056f
C1692 Xr/en_b Xd3/m1_942_4448# 0.00527f
C1693 Xd1/a_2392_3416# vbn_leak 0.00406f
C1694 Xr/vsp ua0_stim_out 0.51961f
C1695 r1_b4 i2_b3 0.03877f
C1696 Xd0/m1_1822_4048# Xd0/m1_2262_4048# 0
C1697 bias_en ua0_s0 0.84293f
C1698 i3_b3 i4_b4 0.28047f
C1699 vdd Xvi/m1_1276_6360# 0.06016f
C1700 Xr/vsp r1_b3 0.05198f
C1701 i1_b1 Xi3/g 0.09057f
C1702 Xi3/a_528_4572# ua0_stim_out 0
C1703 Xi2/m1_1500_4102# r0_b4 0.00143f
C1704 vbp_syn r0_b4 0.07569f
C1705 i3_b3 i3_b0 0.00881f
C1706 Xr/vgln Xi3/m1_988_1168# 0.21056f
C1707 i2_b1 ua0_stim_out 0.08026f
C1708 i4_b3 i0_b0 0
C1709 vreset_src r2_b4 0.13826f
C1710 vth_cmp Xd0/m1_942_4048# 0
C1711 Xi4/g Xvi/a_2102_5152# 0.12159f
C1712 Xi4/g i4_b3 0.19869f
C1713 r0_b3 r0_b4 1.14581f
C1714 i2_b1 r1_b3 0.02511f
C1715 Xr/vsn Xi4/m1_640_4420# 0.00992f
C1716 Xi0/g r1_b0 0.20002f
C1717 Xi1/g r2_b3 0.15979f
C1718 i1_b3 i0_b0 0.04487f
C1719 ib_r1 vreset_src 0.36201f
C1720 Xd2/a_4168_3416# vbn_prb 0.08349f
C1721 Xi4/m1_1500_4102# r2_b4 0.07274f
C1722 i4_b3 Xi2/g 0.25783f
C1723 r2_b2 r2_b4 0.22066f
C1724 Xvi/m1_7102_850# i4_b4 0.03805f
C1725 Xi4/a_732_4510# vbp_w 0
C1726 Xg/a_7580_5314# i4_b3 0.04425f
C1727 ua0_s0 Xd3/m1_5542_4448# 0
C1728 Xr/vgln Xi2/a_3928_4510# 0.06306f
C1729 Xi0/m1_988_1168# ib_r1 0.39412f
C1730 Xi1/g Xi0/a_528_4572# 0
C1731 i3_b3 Xi3/a_3928_4572# 0.00218f
C1732 Xi4/a_3078_4510# el 0.00713f
C1733 Xr/vglp r0_b4 0.57361f
C1734 vdd Xvi/a_864_6450# 0.47183f
C1735 v0_c1 ua0_s0 0.08015f
C1736 i4_b4 vbp_st 0.04193f
C1737 vbn_ref r2_b4 0.08897f
C1738 Xi2/a_2432_4510# Xi2/a_3282_4510# -0.00636f
C1739 r2_b0 Xi1/g 0.07785f
C1740 Xd1/m1_1716_2640# r2_b3 0
C1741 r0_b2 Xg/m1_3898_9610# 0.02108f
C1742 Xr/vgln Xvi/a_4976_1528# 0.1199f
C1743 vbn_ax Xg/a_1580_5314# 0.17703f
C1744 i3_b2 i4_b2 0
C1745 Xi4/g Xg/m1_4538_1930# -0.00873f
C1746 Xm/a_420_700# Xm/a_1764_11418# -0.00278f
C1747 r2_b1 Xd0/m1_1382_4048# 0.05545f
C1748 vdd Xi3/m1_988_2984# -0.02195f
C1749 Xvi/a_5712_1328# Xvi/a_4976_1528# -0.00127f
C1750 bias_en Xr/vglp 0.31715f
C1751 Xi0/g vbp_st 0.11505f
C1752 Xi1/g i0_b0 0.82292f
C1753 Xr/vgln i4_b1 0.24542f
C1754 r0_b0 ua0_stim_out 0.11315f
C1755 Xg/m1_4538_1930# Xi2/g 0.02765f
C1756 Xi3/m1_988_2984# Xi3/m1_650_4492# -0.00292f
C1757 ib_r1 Xi0/m1_988_2984# 0.08707f
C1758 Xi4/a_732_4510# vreset_src 0
C1759 vbn_ax vbn_leak 0.00385f
C1760 Xg/m1_6020_10200# Xr/vglp -0.0252f
C1761 Xi3/a_3078_4572# ua0_stim_out 0.00125f
C1762 ib_r1 Xi0/m1_988_3644# 0
C1763 Xm/iint Xvi/a_864_6450# 0.03297f
C1764 r0_b0 r1_b3 0
C1765 vdd Xr/m1_342_438# -0
C1766 vbp_w vbn_leak 0.27726f
C1767 Xi2/g Xi1/g 0.00831f
C1768 Xg/a_7580_5314# Xi1/g -0.00169f
C1769 i2_b4 r0_b4 0.04897f
C1770 Xvi/m1_5388_6960# r2_b4 0.20788f
C1771 ua0_int Xm/a_1744_10100# 0
C1772 v0_c0 ua0_stim_out 0.14058f
C1773 i4_b4 Xi0/a_1378_4572# 0
C1774 i2_b2 i3_b1 0
C1775 Xd2/a_1800_3416# Xd2/m1_1382_4048# -0.01411f
C1776 Xd2/m1_3982_4048# Xd2/a_3576_3416# -0.00658f
C1777 Xr/vsp r2_b4 0.08668f
C1778 Xd0/a_2984_3416# r2_b1 0
C1779 Xi2/m1_640_4420# r0_b2 0.12447f
C1780 Xm/iint Xi0/m1_1460_4102# 0.04572f
C1781 Xd1/a_4168_3416# r1_b4 0.01306f
C1782 ib_x2 ua0_stim_out 0.04266f
C1783 r1_b0 i2_b0 0.04856f
C1784 v0_c0 Xd3/m1_3342_4448# 0.03675f
C1785 Xm/in_p Xg/m1_3666_9610# 0.00359f
C1786 Xr/vsp ib_r1 0.24489f
C1787 i4_b0 i4_b3 0.13614f
C1788 i2_b1 r2_b4 0.03214f
C1789 el Xd1/a_1800_3416# 0.07092f
C1790 vdd Xi1/a_1378_4572# 0
C1791 Xd0/a_2984_3416# vbp_st 0.03887f
C1792 Xi4/a_528_4510# r2_b4 0.00561f
C1793 vbn_ref Xg/m1_3298_2050# 0.0208f
C1794 bias_en Xd3/m1_4488_3600# 0.05165f
C1795 i3_b4 i1_b2 0.03576f
C1796 Xi3/m1_988_1168# i0_b0 0.04759f
C1797 vreset_src vbn_leak 0.0548f
C1798 r2_b2 Xg/a_1580_5314# 0.07755f
C1799 Xd3/a_4412_3816# ua0_int 0
C1800 bias_en Xd3/m1_1822_4448# 0
C1801 vbn_ax Xi2/m1_988_1168# 0.60958f
C1802 r2_b1 i2_b0 0.05447f
C1803 r0_b0 Xi2/a_732_4510# 0.02689f
C1804 Xr/vglp Xg/m1_5022_10210# -0.01645f
C1805 r0_b1 r1_b0 0.02389f
C1806 i4_b4 i0_b4 0.04508f
C1807 r2_b2 vbn_leak 0.12965f
C1808 vbn_ref Xg/a_1580_5314# 0.02027f
C1809 i1_b1 vdd 0.37523f
C1810 i2_b2 Xi2/a_3078_4510# 0.01522f
C1811 i2_b4 Xi3/a_1582_4572# 0
C1812 i0_b3 i1_b3 0.14607f
C1813 el r2_b4 0.12975f
C1814 i4_b0 Xg/m1_4538_1930# 0
C1815 i1_b1 Xi3/m1_650_4492# 0
C1816 Xm/iint Xvi/m1_4894_1238# 0
C1817 i3_b1 i4_b2 0.13862f
C1818 i1_b4 i4_b4 0.03898f
C1819 Xm/in_n Xr/m1_342_438# 0.04238f
C1820 vbn_ref vbn_leak 0.44203f
C1821 Xd3/a_4412_3816# v0_c2 0.07418f
C1822 i4_b0 Xi1/g 0.08098f
C1823 Xi2/m1_988_2984# r0_b4 0.1902f
C1824 r0_b2 ua0_stim_out 0.05675f
C1825 vbn_ax vbp_syn 0.51719f
C1826 Xi4/g Xvi/a_4976_1528# 0.07679f
C1827 v0_c1 Xd3/m1_4488_3600# 0
C1828 vdd i3_b2 0.00736f
C1829 vbp_w vbp_syn 0.68425f
C1830 r0_b1 r2_b1 0.07492f
C1831 Xd2/m1_942_4048# vbn_prb 0.00614f
C1832 vbn_ax r0_b3 0.04532f
C1833 Xi2/m1_1500_4102# vbp_w 0
C1834 Xi2/a_2228_4510# r0_b0 0.00225f
C1835 Xi4/g i4_b1 0.03847f
C1836 Xd2/m1_2156_3240# r2_b1 0.10343f
C1837 Xd0/m1_502_4048# r2_b3 0.01738f
C1838 Xr/vsn Xg/a_4580_5314# 0.03139f
C1839 r2_b1 vbn_prb 1.43498f
C1840 v0_c0 Xd3/m1_2702_4448# 0.04301f
C1841 i0_b3 Xi1/g 0
C1842 Xi2/a_3282_4510# r0_b3 0
C1843 i2_b4 Xg/m1_5022_10210# 0
C1844 i1_b2 Xm/in_p 0.03638f
C1845 vbp_w r0_b3 0.03771f
C1846 i3_b4 Xm/in_p 0
C1847 i4_b1 Xi2/g 0.32659f
C1848 r0_b1 vbp_st 0.06246f
C1849 Xr/vsp Xg/a_1580_5314# 0.0831f
C1850 Xi2/a_2432_4510# i2_b1 0
C1851 i4_b1 Xg/a_7580_5314# 0.08515f
C1852 Xi3/g i0_b1 0
C1853 Xr/vglp vbn_ax 0.29132f
C1854 vbn_prb vbp_st 0.20576f
C1855 Xvi/m1_5388_6960# vbn_leak 0.03946f
C1856 Xr/vsn Xi3/g -0.00549f
C1857 Xi2/a_4132_4510# ua0_stim_out 0.08937f
C1858 Xm/a_736_7228# vdd -0.00979f
C1859 Xr/vsp vbn_leak 0.00205f
C1860 Xi4/a_732_4510# el 0.01811f
C1861 ib_x2 r2_b4 0.10097f
C1862 r2_b1 Xg/m1_3666_9610# 0.00389f
C1863 Xi3/m1_988_2984# Xi3/m1_1460_4102# -0.02109f
C1864 i2_b4 Xi3/a_1378_4572# 0
C1865 ua0_stim Xm/a_420_700# 0.15989f
C1866 Xvi/m1_4546_7560# r2_b4 0
C1867 Xi4/a_3928_4510# vreset_src 0
C1868 r1_b3 Xd1/a_2984_3416# -0.00141f
C1869 Xd3/m1_4328_3000# Xm/in_p 0.00437f
C1870 ib_x2 ib_r1 0.34461f
C1871 Xd3/m1_4328_3000# Xd3/a_5004_3816# -0.00248f
C1872 Xd3/m1_5982_4448# ua0_stim_out 0.04935f
C1873 bias_en Xm/a_420_700# 0.10526f
C1874 Xr/vgln Xvi/a_5712_1328# 0.00925f
C1875 Xr/vsn i4_b2 0.32662f
C1876 r2_b2 Xi4/a_3928_4510# 0
C1877 i2_b4 vbn_ax 0.09122f
C1878 Xd2/a_2984_3416# Xd2/a_3576_3416# -0.00396f
C1879 vdd Xi1/a_4132_4572# 0.00493f
C1880 Xi3/a_4132_4572# ua0_stim_out 0
C1881 vbn_ref vbp_syn 0.04633f
C1882 Xr/vglp vreset_src 0.46388f
C1883 r2_b2 r0_b3 0.20623f
C1884 Xi2/a_2432_4510# r0_b0 0
C1885 r2_b0 Xd2/a_1800_3416# 0.01647f
C1886 Xr/vsn r1_b2 0.06695f
C1887 Xi0/m1_988_1168# Xr/vglp 0.20884f
C1888 Xd2/m1_1822_4048# r2_b1 0.19617f
C1889 Xd3/a_4412_3816# v0_c4 0.08183f
C1890 i3_b3 i1_b2 0.06138f
C1891 el vbn_leak 1.72319f
C1892 vbn_ref r0_b3 0.0052f
C1893 i3_b3 i3_b4 0.90165f
C1894 vdd i3_b1 0.00933f
C1895 Xr/vsn vth_cmp 0.21353f
C1896 vdd Xi0/m1_650_4492# -0.03392f
C1897 Xd3/a_2636_3816# ua0_s1 0.0517f
C1898 Xi2/a_528_4510# i2_b0 -0.00474f
C1899 r2_b2 Xr/vglp 0.50523f
C1900 i4_b0 i4_b1 1.62171f
C1901 vbn_prb Xd0/m1_2262_4048# 0.07452f
C1902 r1_b4 vbn_ax 0.12315f
C1903 Xi4/a_3078_4510# i4_b4 0.00113f
C1904 Xd0/a_1800_3416# vbn_leak 0.04985f
C1905 i4_b4 ua0_stim_out 0.08002f
C1906 Xg/m1_5516_1920# i4_b1 0.00308f
C1907 Xd3/m1_942_4448# ua0_stim_out 0.04365f
C1908 v0_c0 Xd3/m1_1970_3610# 0.188f
C1909 vbn_ref Xr/vglp 0.0359f
C1910 Xi1/a_2432_4572# vbn_ref 0
C1911 Xr/vsn Xg/a_5188_4156# -0.11367f
C1912 vdd Xi1/a_3282_4572# 0.00372f
C1913 Xd3/m1_4328_3000# Xd3/m1_3600_4920# -0.03499f
C1914 r0_b0 vbn_leak 0
C1915 vbp_w r1_b4 0.17726f
C1916 i3_b2 i2_b3 0
C1917 Xr/vgln r2_b3 0.03291f
C1918 Xm/a_736_7228# Xm/a_1764_11418# -0.04109f
C1919 Xr/vgln vth_ref 0.37279f
C1920 Xd3/a_4412_3816# v0_c5 -0.00245f
C1921 Xr/vgln Xi0/a_528_4572# 0.00491f
C1922 Xr/vsn Xg/m1_3530_1930# 0.03911f
C1923 Xi0/g ua0_stim_out 0.10448f
C1924 Xi3/a_2228_4572# i3_b2 0
C1925 Xr/vsn Xvi/m1_502_738# 0.08418f
C1926 Xm/iint Xi0/m1_650_4492# 0.10546f
C1927 r2_b1 Xd2/a_4168_3416# 0
C1928 Xr/vgln r2_b0 0.03907f
C1929 bias_en Xvi/a_864_6450# 0.0491f
C1930 vdd Xi0/a_3078_4572# 0.01213f
C1931 i1_b2 vbp_st 0.00173f
C1932 Xi0/g r1_b3 0.10306f
C1933 Xr/vsp r0_b3 0.28127f
C1934 i2_b4 r2_b2 0.03165f
C1935 Xr/en_b Xm/in_p 0.13219f
C1936 Xd3/m1_3600_4920# Xm/in_p 0.06206f
C1937 vdd Xi2/a_3078_4510# 0
C1938 i2_b4 Xi3/a_732_4572# 0.00209f
C1939 vdd Xi1/a_3928_4572# 0.0111f
C1940 Xi2/m1_988_2984# vbn_ax 0.01736f
C1941 Xi3/a_3928_4572# ua0_stim_out 0
C1942 i2_b1 vbp_syn 0.01939f
C1943 ib_x2 vbn_leak 0.27239f
C1944 Xi1/m1_988_1168# Xi1/m1_988_2984# -0
C1945 Xd0/a_4168_3416# vth_cmp 0
C1946 Xr/vglp Xvi/m1_5388_6960# 0.1575f
C1947 vth_cmp Xd0/m1_4094_3010# 0
C1948 i3_b3 Xm/in_p 0
C1949 r1_b0 Xm/in_p 0.03252f
C1950 Xr/vsp Xr/vglp 0.69586f
C1951 Xr/vgln i0_b0 0.1342f
C1952 i2_b1 r0_b3 0.07034f
C1953 bias_en Xi0/m1_1460_4102# 0.016f
C1954 Xvi/m1_4546_7560# vbn_leak 0.01748f
C1955 Xr/vgln Xi4/g -0.05093f
C1956 Xd3/m1_502_4448# Xm/in_p 0.06323f
C1957 i1_b0 vbn_ref 0.2164f
C1958 Xg/a_4580_5314# i4_b3 0.17097f
C1959 vdd i0_b1 0.80442f
C1960 vreset_src Xi1/m1_988_1168# 0.19293f
C1961 Xr/vsn vdd 1.62666f
C1962 Xi4/g Xvi/a_5712_1328# 0.09199f
C1963 Xm/iint Xi0/a_3078_4572# 0
C1964 Xr/vgln Xi1/m1_988_3644# 0
C1965 r2_b2 r1_b4 0.15416f
C1966 Xr/vgln Xi2/g 0.69864f
C1967 Xm/in_p Xg/m1_4906_9490# 0.00581f
C1968 el vbp_syn 0.0683f
C1969 vdd i0_b2 1.94804f
C1970 Xr/vgln Xg/a_7580_5314# -0.00742f
C1971 Xd3/a_4412_3816# vdd 0.17394f
C1972 Xi4/a_3928_4510# el 0.01311f
C1973 Xr/vsn Xg/a_3036_4156# -0.00336f
C1974 vdd Xi1/a_3078_4572# -0.00159f
C1975 v0_c0 ua0_s0 0.05963f
C1976 Xr/vsn Xi2/m1_988_3644# -0.00486f
C1977 Xi3/g i4_b3 0.80615f
C1978 r2_b1 Xm/in_p 0.20338f
C1979 Xi4/a_2432_4510# r2_b4 0.00751f
C1980 vbn_ref r1_b4 0.1078f
C1981 Xi2/m1_640_4420# r0_b1 0.01965f
C1982 Xd1/m1_942_4048# r2_b3 0.07707f
C1983 v0_c3 ua0_s1 0.04094f
C1984 Xr/vgln Xvi/m1_8332_7080# 0.0037f
C1985 Xr/vsn r1_b1 0.40364f
C1986 Xm/iint Xd3/m1_1382_4448# 0.0526f
C1987 Xi1/a_2432_4572# Xi1/m1_1460_4102# -0
C1988 Xd0/m1_1822_4048# vbn_leak 0.07365f
C1989 ib_x2 ua0_s0 0.0025f
C1990 vdd Xd2/a_3576_3416# -0.05331f
C1991 vth_ref Xi0/a_528_4572# 0.04601f
C1992 Xr/vgln Xg/m1_6282_1450# -0.00136f
C1993 vbp_st Xm/in_p 0.08877f
C1994 Xi3/g i1_b3 0
C1995 Xd3/m1_4648_4446# vth_ref 0
C1996 r0_b0 vbp_syn 0.14584f
C1997 i2_b4 Xr/vsp 0.03901f
C1998 r0_b2 vbn_leak 0
C1999 r2_b0 r2_b3 1.5295f
C2000 Xr/vsn Xm/iint 0.02609f
C2001 Xr/vgln Xi4/a_3282_4510# 0.07251f
C2002 i3_b1 i2_b3 0
C2003 Xm/iint i0_b2 0
C2004 bias_en Xvi/m1_4894_1238# 0.02325f
C2005 i4_b4 r2_b4 0.37771f
C2006 Xr/vglp el 0.34429f
C2007 vth_cmp Xd0/m1_3342_4048# 0
C2008 i1_b0 Xr/vsp 0.31829f
C2009 r0_b0 r0_b3 0.19478f
C2010 i2_b2 Xi1/g 0.31813f
C2011 i2_b4 Xi3/a_528_4572# 0.00265f
C2012 i2_b0 ua0_stim_out 0.07532f
C2013 ua0 Xr/en_b -0.00118f
C2014 r1_b3 i2_b0 0.12553f
C2015 Xr/en_b Xd3/m1_502_4448# 0.15598f
C2016 Xg/a_4580_5314# Xi1/g 0.19969f
C2017 i4_b3 i4_b2 0.39721f
C2018 Xi3/a_2228_4572# i3_b1 0
C2019 ib_r1 i4_b4 0.08159f
C2020 Xr/vgln Xvi/m1_8042_6360# 0.00816f
C2021 Xd0/a_4168_3416# vdd 0.02428f
C2022 i2_b4 i2_b1 0.00267f
C2023 vdd Xd0/m1_4094_3010# 0
C2024 vth_ref i0_b0 0.04493f
C2025 Xr/vsn Xg/m1_4760_1320# 0.07049f
C2026 Xi0/g r2_b4 0.43518f
C2027 i0_b0 Xi0/a_528_4572# 0
C2028 Xi4/g vth_ref 0.11704f
C2029 i1_b0 Xi1/a_732_4572# 0
C2030 Xr/vsp r1_b4 0.12385f
C2031 i3_b4 i0_b4 0.19143f
C2032 r1_b2 i4_b3 0.65949f
C2033 Xi3/g Xi1/g 0.13291f
C2034 Xi2/g r2_b3 0.24205f
C2035 Xg/a_7580_5314# r2_b3 0.12927f
C2036 Xvi/m1_1382_738# r2_b4 0.00435f
C2037 vth_ref Xi2/g 0.00263f
C2038 i1_b4 i1_b2 0.33041f
C2039 Xm/in_n i0_b1 0.04754f
C2040 i3_b4 i1_b4 0.12922f
C2041 Xi0/g ib_r1 0.67572f
C2042 r1_b4 Xi3/a_528_4572# 0.00325f
C2043 vth_cmp i4_b3 1.0054f
C2044 Xr/vsp Xi1/m1_988_1168# 0.08455f
C2045 Xr/vsn Xm/in_n 1.17387f
C2046 Xr/vgln i4_b0 0.25705f
C2047 r0_b1 ua0_stim_out 0.03758f
C2048 Xm/in_n i0_b2 0.03924f
C2049 vth_cmp Xd1/m1_2318_2410# 0.07495f
C2050 r0_b1 r1_b3 0.0011f
C2051 i2_b1 r1_b4 0.03903f
C2052 Xd1/a_2984_3416# vbn_leak 0.14517f
C2053 Xi2/a_3078_4510# i2_b3 0.00175f
C2054 r2_b1 r1_b0 0
C2055 Xi4/a_2228_4510# r2_b4 0.00565f
C2056 Xr/vgln Xg/m1_5516_1920# -0.01576f
C2057 Xr/en_b vbp_st 0.04844f
C2058 r2_b0 Xi2/g 0.36964f
C2059 Xd3/m1_4648_4446# ua0_s1 0
C2060 Xr/vsn Xi1/m1_650_4492# 0.11807f
C2061 r2_b0 Xg/a_7580_5314# 0.06498f
C2062 Xvi/m1_8332_7080# vth_ref 0.10767f
C2063 Xg/a_5188_4156# i4_b3 0.17487f
C2064 r0_b2 Xi2/m1_988_1168# 0.449f
C2065 ib_x2 Xr/vglp 0.57504f
C2066 Xr/vgln i0_b3 0.13945f
C2067 Xvi/m1_1276_6360# vreset_src 0.2075f
C2068 Xi1/g i4_b2 0.12473f
C2069 r1_b0 vbp_st 0.0464f
C2070 Xi1/a_3078_4572# Xi1/m1_650_4492# -0.00108f
C2071 Xd2/m1_942_4048# r2_b1 0.00238f
C2072 Xd3/m1_502_4448# vbp_st 0
C2073 Xi2/a_732_4510# i2_b0 -0.00156f
C2074 Xr/vglp Xvi/m1_4546_7560# -0.00848f
C2075 Xm/a_736_7228# ua0_stim -0
C2076 i4_b3 Xg/m1_3530_1930# 0.00207f
C2077 Xi4/g Xi2/g 0.04581f
C2078 Xi3/m1_988_2984# vbn_ax -0
C2079 i2_b2 Xi2/a_3928_4510# 0.05551f
C2080 i2_b4 Xi3/a_3078_4572# 0
C2081 r1_b2 Xi1/g 0.1509f
C2082 Xi2/a_1378_4510# r2_b1 0.00127f
C2083 ua0_stim_out Xg/m1_3666_9610# 0.00728f
C2084 vdd Xd0/m1_3342_4048# 0
C2085 Xi3/g Xi3/m1_988_1168# 0.04101f
C2086 Xi3/m1_988_3644# Xi3/m1_988_2984# -0.02518f
C2087 vth_ref Xvi/m1_8042_6360# 0.15535f
C2088 Xi2/m1_1500_4102# r0_b2 0.00135f
C2089 r0_b2 vbp_syn 0.1653f
C2090 i1_b0 Xi3/a_3078_4572# 0.00797f
C2091 i0_b4 Xm/in_p 0.04034f
C2092 Xm/a_736_7228# bias_en 0.24528f
C2093 Xg/a_7580_5314# Xi2/g -0.02003f
C2094 r2_b1 vbp_st 0.05548f
C2095 i1_b4 Xm/in_p 0.05675f
C2096 i1_b0 Xi1/a_528_4572# 0.00536f
C2097 v0_c0 Xd3/m1_4488_3600# 0
C2098 r0_b2 r0_b3 0.8033f
C2099 r0_b0 r1_b4 0.01268f
C2100 i2_b0 r2_b4 0.06661f
C2101 Xvi/a_864_6450# vreset_src 0.35317f
C2102 i2_b2 i4_b1 0.47535f
C2103 i4_b4 vbn_leak 0.0473f
C2104 v0_c0 Xd3/m1_1822_4448# 0.03706f
C2105 Xg/a_5188_4156# Xi1/g -0.00184f
C2106 ua0_s0 Xd3/m1_5982_4448# 0
C2107 Xi2/g Xg/m1_6282_1450# 0.04532f
C2108 Xr/vsn Xr/m1_1222_3522# -0
C2109 vth_cmp Xd1/m1_1716_2640# 0.06676f
C2110 Xi0/g Xg/a_1580_5314# -0.06243f
C2111 Xg/a_4580_5314# i4_b1 0.0523f
C2112 Xi3/m1_988_1168# i4_b2 0.00194f
C2113 r0_b2 Xr/vglp 0.47236f
C2114 vdd i4_b3 1.25671f
C2115 vdd Xvi/a_2102_5152# -0.04023f
C2116 vbn_prb Xd1/a_1800_3416# 0.00375f
C2117 Xi4/g Xvi/m1_8042_6360# 0
C2118 Xr/m1_782_438# Xm/in_n 0
C2119 r2_b2 Xvi/a_864_6450# 0
C2120 Xm/in_n Xr/m1_3422_438# 0.05667f
C2121 i4_b3 Xi3/m1_650_4492# 0.04054f
C2122 r2_b0 i4_b0 0.0143f
C2123 Xi0/g vbn_leak 0.04839f
C2124 Xg/a_3036_4156# i4_b3 0.10803f
C2125 Xd3/a_2636_3816# ua0_int 0.00467f
C2126 vdd i1_b3 0.0847f
C2127 Xi3/g i4_b1 0.14384f
C2128 Xi2/a_4132_4510# r0_b3 0
C2129 i0_b3 vth_ref 0.34884f
C2130 r1_b1 i4_b3 0.00156f
C2131 vreset_src Xr/m1_342_438# 0
C2132 Xd0/m1_1382_4048# vbn_leak 0.04436f
C2133 Xd3/m1_3600_4920# Xd3/a_3228_3816# -0.00578f
C2134 bias_en Xi0/m1_650_4492# 0.17657f
C2135 Xi2/a_1582_4510# i2_b1 0.00104f
C2136 Xm/iint Xvi/a_2102_5152# 0
C2137 Xi4/g i4_b0 0.20977f
C2138 Xd3/a_2636_3816# v0_c2 0.03275f
C2139 i1_b2 ua0_stim_out 0.04919f
C2140 Xvi/m1_8332_7080# Xvi/m1_8042_6360# -0.03609f
C2141 i3_b3 i0_b4 0.02776f
C2142 Xvi/a_5712_1328# Xvi/m1_7440_2050# -0.00291f
C2143 Xi4/a_2228_4510# vbn_leak 0.00286f
C2144 Xi4/g Xg/m1_5516_1920# -0.00735f
C2145 ua0_s0 Xd3/m1_942_4448# 0
C2146 i2_b4 r0_b2 0.07538f
C2147 i4_b0 Xi2/g 0.72202f
C2148 ib_r1 vbn_prb 0.09278f
C2149 i4_b0 Xg/a_7580_5314# 0.06481f
C2150 r2_b1 Xd0/m1_2262_4048# 0.03381f
C2151 i3_b3 i1_b4 0.00138f
C2152 Xm/iint i1_b3 0.00217f
C2153 Xg/m1_5516_1920# Xi2/g 0.03095f
C2154 vdd Xi1/g 0.96622f
C2155 i4_b1 i4_b2 0.43075f
C2156 Xd2/m1_3542_4048# vbn_prb 0.1138f
C2157 Xg/m1_5516_1920# Xg/a_7580_5314# -0
C2158 Xi3/a_1582_4572# i3_b1 -0
C2159 Xi3/a_2432_4572# i4_b3 0.01777f
C2160 Xvi/a_864_6450# Xvi/m1_5388_6960# -0.07115f
C2161 Xd0/a_2984_3416# vbn_leak 0.0166f
C2162 Xd0/m1_2262_4048# vbp_st 0.00397f
C2163 Xg/a_3036_4156# Xi1/g -0.0137f
C2164 Xi2/a_2432_4510# i2_b0 0
C2165 r1_b2 i4_b1 0.65116f
C2166 vth_cmp Xvi/a_4976_1528# 0.00454f
C2167 bias_en Xm/a_1744_10100# 0.00109f
C2168 Xr/vgln Xi0/a_1582_4572# 0.00439f
C2169 vbn_ref Xd0/m1_942_4048# 0
C2170 Xd3/m1_4328_3000# ua0_stim_out 0.00118f
C2171 bias_en Xi0/a_3078_4572# 0
C2172 r1_b1 Xi1/g 0
C2173 Xvi/m1_1276_6360# el 0.02866f
C2174 i4_b3 Xm/in_n 0.39244f
C2175 i2_b4 Xi2/a_4132_4510# 0
C2176 vth_cmp i4_b1 0.03353f
C2177 Xm/a_2240_11218# ua0_s1 0.0146f
C2178 Xr/vsn r0_b4 0.20947f
C2179 Xi4/a_3928_4510# i4_b4 0.07627f
C2180 vbp_st i0_b4 0.1434f
C2181 Xi3/m1_988_2984# Xr/vsp -0.03949f
C2182 Xi2/a_1582_4510# r0_b0 0
C2183 Xi1/a_1378_4572# vbn_ref 0
C2184 bias_en Xd3/m1_1382_4448# 0
C2185 Xd3/m1_4328_3000# Xd3/m1_3342_4448# -0.0381f
C2186 Xi2/a_528_4510# r2_b1 0.00534f
C2187 r2_b1 Xg/m1_3898_9610# 0
C2188 i1_b4 vbp_st 0
C2189 i4_b1 Xg/a_5188_4156# 0.21708f
C2190 Xi3/m1_988_2984# Xi3/a_3282_4572# -0
C2191 Xd3/a_4412_3816# ua0_stim 0
C2192 Xd3/a_2044_3816# ua0_s1 0.06301f
C2193 ua0_stim_out Xm/in_p 2.98254f
C2194 Xi4/g Xi4/m1_640_4420# 0
C2195 Xd2/m1_3982_4048# r2_b3 0.13797f
C2196 Xr/vsp Xr/m1_342_438# 0.00636f
C2197 v0_c3 ua0_int 0.18748f
C2198 vdd Xi3/m1_988_1168# -0.04554f
C2199 Xr/vsn bias_en 0.38065f
C2200 r1_b3 Xm/in_p 0.04473f
C2201 bias_en i0_b2 0.01142f
C2202 i4_b1 Xg/m1_3530_1930# 0.00221f
C2203 Xd3/a_4412_3816# bias_en 0.03933f
C2204 i4_b3 i2_b3 0.02034f
C2205 Xr/vglp i4_b4 0.98288f
C2206 Xg/m1_4538_1930# Xm/in_n 0.00391f
C2207 i1_b1 vbn_ref 0.01924f
C2208 Xi2/m1_988_2984# r0_b2 0.23552f
C2209 Xvi/a_864_6450# el 0.44803f
C2210 Xd3/m1_3342_4448# Xm/in_p 0.00485f
C2211 vdd Xi2/a_3928_4510# 0
C2212 r2_b0 Xd2/m1_3982_4048# 0
C2213 Xi1/g Xm/in_n 0.48515f
C2214 Xd0/m1_502_4048# vth_cmp 0
C2215 v0_c3 v0_c2 0.10937f
C2216 Xg/m1_5516_1920# i4_b0 0
C2217 Xi3/a_1378_4572# i3_b1 0
C2218 Xi3/a_2228_4572# i4_b3 0.13235f
C2219 i1_b0 Xi3/a_4132_4572# 0.00506f
C2220 r0_b1 vbn_leak 0
C2221 Xi0/g Xr/vglp 0.22583f
C2222 i0_b2 Xi0/a_2432_4572# 0
C2223 vbn_prb vbn_leak 0.42727f
C2224 vdd Xvi/a_4976_1528# -0.34461f
C2225 vth_ref Xi0/a_1582_4572# 0.03976f
C2226 Xi1/m1_650_4492# Xi1/g -0.00401f
C2227 Xi2/m1_640_4420# r2_b1 0.16633f
C2228 i2_b2 Xr/vgln 0.30206f
C2229 Xvi/m1_1276_6360# Xvi/m1_4546_7560# -0.00987f
C2230 Xr/vgln Xg/a_4580_5314# -0
C2231 i4_b3 Xi3/m1_1460_4102# 0.01012f
C2232 vbn_ax i3_b1 0
C2233 i2_b4 i4_b4 0.01174f
C2234 Xd2/a_4168_3416# r2_b4 -0
C2235 Xi3/m1_988_3644# i3_b1 -0
C2236 Xd3/a_4412_3816# v0_c1 0.05926f
C2237 vdd i4_b1 0.16882f
C2238 Xr/vsn Xi4/m1_988_2984# -0.01703f
C2239 Xr/en_b ua0_stim_out 0.24294f
C2240 Xd3/m1_3600_4920# ua0_stim_out 0.00515f
C2241 i4_b1 Xi3/m1_650_4492# 0
C2242 i2_b4 i3_b0 0.13671f
C2243 i1_b0 i4_b4 0.17685f
C2244 i1_b1 Xr/vsp 0.31907f
C2245 Xr/vgln Xi3/g 0.49554f
C2246 Xi1/g i2_b3 0
C2247 Xi4/m1_988_3644# Xr/vsn -0.00231f
C2248 i4_b1 Xg/a_3036_4156# 0
C2249 Xd0/m1_942_4048# el 0.05085f
C2250 i1_b0 i3_b0 0.07359f
C2251 Xd3/m1_3600_4920# Xd3/m1_3342_4448# -0.00282f
C2252 r1_b0 ua0_stim_out 0.04855f
C2253 i2_b4 Xi0/g 0
C2254 r1_b1 i4_b1 0.07884f
C2255 Xm/iint Xvi/a_4976_1528# 0
C2256 Xd2/m1_3542_4048# Xd2/a_4168_3416# -0.00449f
C2257 ib_x2 Xvi/a_864_6450# 0.07964f
C2258 Xi0/a_3928_4572# i0_b1 0
C2259 Xd3/m1_502_4448# ua0_stim_out 0.09818f
C2260 r1_b0 r1_b3 0.16179f
C2261 vbp_syn i2_b0 0.20106f
C2262 Xi0/a_3928_4572# i0_b2 0.006f
C2263 Xd3/m1_2702_4448# Xm/in_p 0
C2264 Xvi/a_864_6450# Xvi/m1_4546_7560# -0.01325f
C2265 ua0_stim_out Xg/m1_4906_9490# 0.03576f
C2266 r0_b3 i2_b0 0.06373f
C2267 i1_b4 i0_b4 0.66767f
C2268 r0_b1 Xi2/m1_988_1168# 0.14973f
C2269 v0_c2 Xd3/m1_4648_4446# 0.00186f
C2270 r1_b4 i3_b0 0.03187f
C2271 Xi1/a_3282_4572# Xi1/m1_988_2984# -0
C2272 Xi2/a_1378_4510# ua0_stim_out 0.00931f
C2273 Xi3/a_3282_4572# i3_b2 0
C2274 i1_b0 Xi3/a_3928_4572# 0.0019f
C2275 ib_x2 Xi0/m1_1460_4102# 0.01175f
C2276 r2_b1 ua0_stim_out 0.13733f
C2277 r2_b4 Xm/in_p 0.03497f
C2278 Xr/vgln i4_b2 0.15044f
C2279 Xi0/g r1_b4 0.12686f
C2280 i2_b2 r2_b3 0.03343f
C2281 Xg/m1_4760_1320# i4_b1 0.00166f
C2282 Xr/vgln r1_b2 0.34815f
C2283 Xd0/m1_2760_3412# r2_b3 0.01249f
C2284 vbp_st ua0_stim_out 0.05635f
C2285 r0_b1 vbp_syn 0.05447f
C2286 ua0_int ua0_s1 0.73824f
C2287 v0_c3 v0_c4 1.42285f
C2288 vbn_prb vbp_syn 0.13148f
C2289 r1_b3 vbp_st 0.53264f
C2290 Xd3/a_2636_3816# vdd 0.06286f
C2291 i2_b2 r2_b0 0.036f
C2292 Xi4/m1_988_1168# r2_b2 0.06667f
C2293 Xr/vsn vbn_ax 0.39287f
C2294 r0_b1 r0_b3 0.04268f
C2295 Xi3/g r2_b3 0.37985f
C2296 Xr/vgln vth_cmp 0.06317f
C2297 i4_b1 Xm/in_n 0.27528f
C2298 Xi4/a_1378_4510# r2_b4 0.00477f
C2299 Xi2/a_3928_4510# i2_b3 0
C2300 Xd1/m1_3492_2640# r2_b3 0.08633f
C2301 Xr/vsn vbp_w 0.46918f
C2302 Xd2/a_2984_3416# r2_b3 0.02071f
C2303 r1_b0 Xd1/a_1800_3416# 0.00473f
C2304 v0_c2 ua0_s1 0.36319f
C2305 Xd3/m1_3600_4920# Xd3/m1_2702_4448# -0
C2306 Xd2/a_1800_3416# vdd -0.0036f
C2307 ib_x2 Xvi/m1_4894_1238# 0
C2308 r2_b0 Xi3/g 0.19665f
C2309 Xd2/a_2392_3416# r2_b2 0.00144f
C2310 Xi4/g Xg/a_4580_5314# -0
C2311 Xr/vsn Xi1/m1_988_2984# 0.10778f
C2312 Xd3/a_2636_3816# Xm/iint 0.01729f
C2313 i2_b4 i2_b0 0.00104f
C2314 bias_en Xvi/a_2102_5152# 0.24884f
C2315 Xi4/a_4132_4510# r2_b4 0.01581f
C2316 Xr/vglp vbn_prb 0.24326f
C2317 Xr/vgln Xg/m1_3530_1930# -0.06903f
C2318 v0_c3 v0_c5 0.24496f
C2319 r2_b0 Xd2/a_2984_3416# 0.01565f
C2320 Xr/vgln Xvi/m1_502_738# 0
C2321 r2_b1 Xi2/a_732_4510# 0.00529f
C2322 r0_b3 Xg/m1_3666_9610# 0.03456f
C2323 i4_b1 i2_b3 0.15232f
C2324 Xg/a_4580_5314# Xi2/g -0.00165f
C2325 Xg/a_4580_5314# Xg/a_7580_5314# -0.03634f
C2326 Xi3/g i0_b0 0.03499f
C2327 Xi3/a_3078_4572# i3_b2 0.001f
C2328 vreset_src i0_b1 0.04492f
C2329 r1_b0 r2_b4 0.22502f
C2330 r1_b2 r2_b3 0
C2331 Xr/vsn vreset_src 0.02837f
C2332 v0_c4 vth_ref 0.94844f
C2333 Xd3/m1_1970_3610# Xm/in_p 0.00141f
C2334 Xi1/g r0_b4 0.12568f
C2335 r2_b0 i4_b2 0.01386f
C2336 vreset_src i0_b2 0.04319f
C2337 Xr/vsp Xi0/m1_650_4492# 0.09313f
C2338 Xi3/g Xg/a_7580_5314# -0.06909f
C2339 r1_b4 i2_b0 0.08941f
C2340 i0_b3 Xi0/a_1582_4572# 0
C2341 Xi3/a_1582_4572# i4_b3 0.00577f
C2342 Xi3/a_3282_4572# i3_b1 0
C2343 Xr/vsn Xi4/m1_1500_4102# -0
C2344 Xr/m1_2542_438# vbp_st 0.06594f
C2345 vth_cmp r2_b3 0.05356f
C2346 i2_b4 r0_b1 0.0884f
C2347 Xi0/a_732_4572# vbn_leak 0
C2348 Xr/vsn r2_b2 0.70042f
C2349 vth_cmp vth_ref 0.18334f
C2350 r2_b1 r2_b4 0
C2351 Xi0/a_4132_4572# i0_b2 0.00223f
C2352 vth_cmp Xd1/m1_942_4048# 0.00567f
C2353 r2_b0 r1_b2 0.04732f
C2354 Xvi/m1_7102_850# r2_b4 0
C2355 Xvi/m1_1276_6360# i4_b4 0
C2356 Xi2/a_2228_4510# r2_b1 0.00287f
C2357 Xr/vgln vdd 6.0278f
C2358 Xi4/g i4_b2 0.04433f
C2359 Xg/a_5188_4156# r2_b3 0.00401f
C2360 ua0_stim_out i0_b4 0.04144f
C2361 Xr/vsn vbn_ref 0.31229f
C2362 Xr/vgln Xi3/m1_650_4492# 0.00537f
C2363 vdd Xvi/a_5712_1328# 0.0014f
C2364 r2_b0 vth_cmp 0.10842f
C2365 Xg/m1_6020_10200# Xi1/g 0
C2366 v0_c3 vdd 0.51944f
C2367 ib_r1 Xvi/m1_7102_850# 0.12354f
C2368 vbp_st r2_b4 0.06578f
C2369 ua0_int Xm/a_2240_11218# 0.51426f
C2370 Xr/vgln Xg/a_3036_4156# -0.00413f
C2371 Xi2/g i4_b2 0.12617f
C2372 Xg/a_7580_5314# i4_b2 0.08554f
C2373 i1_b4 ua0_stim_out 0.12968f
C2374 Xd2/m1_3542_4048# r2_b1 0.06645f
C2375 r2_b2 Xd2/a_3576_3416# -0.0021f
C2376 Xr/vsp Xi0/a_3078_4572# 0.07021f
C2377 r0_b1 r1_b4 0.12852f
C2378 Xi4/g r1_b2 0.03687f
C2379 Xr/vgln r1_b1 0.696f
C2380 Xr/vsp Xi1/a_3928_4572# 0
C2381 ua0_s0 Xd3/m1_4328_3000# 0.09094f
C2382 ib_r1 vbp_st 0.03117f
C2383 Xm/a_736_5516# Xm/a_1744_9182# -0.00501f
C2384 Xd3/m1_3342_4448# Xd3/a_3228_3816# -0.01599f
C2385 r2_b0 Xg/a_5188_4156# 0.07028f
C2386 Xi2/a_528_4510# ua0_stim_out 0.00166f
C2387 r1_b2 Xi2/g 0.13023f
C2388 ua0_stim_out Xg/m1_3898_9610# 0.01056f
C2389 i2_b2 i4_b0 0.19881f
C2390 Xi4/g vth_cmp 0.03892f
C2391 Xd3/a_2044_3816# ua0_int 0.00326f
C2392 r1_b2 Xg/a_7580_5314# 0.05291f
C2393 Xd3/m1_1970_3610# Xd3/m1_3600_4920# -0
C2394 v0_c4 ua0_s1 0.04376f
C2395 Xr/vgln Xm/iint 0.13642f
C2396 i4_b0 Xg/a_4580_5314# 0.08541f
C2397 Xvi/a_864_6450# i4_b4 0.12292f
C2398 v0_c3 Xm/iint 0.91323f
C2399 Xm/iint Xvi/a_5712_1328# 0.08329f
C2400 Xi4/a_3282_4510# i4_b2 -0.00431f
C2401 Xr/vsp i0_b1 0.78594f
C2402 Xi2/a_3928_4510# r0_b4 0
C2403 Xr/vsn Xr/vsp 0.48124f
C2404 Xd2/m1_2900_3120# vbn_prb 0.07194f
C2405 v0_c2 Xd3/a_2044_3816# 0.00496f
C2406 i4_b0 Xi3/g 0.07492f
C2407 ua0_s0 Xd3/a_5004_3816# 0.06808f
C2408 Xi3/a_1378_4572# i4_b3 0.00164f
C2409 Xi3/a_3078_4572# i3_b1 0
C2410 Xr/vsp i0_b2 0.52131f
C2411 Xg/a_5188_4156# Xi2/g -0.10115f
C2412 Xd0/a_4168_3416# vbn_ref 0.0869f
C2413 Xr/vgln Xi3/a_2432_4572# 0.16088f
C2414 Xi0/m1_1460_4102# i4_b4 0.10519f
C2415 Xi4/a_4132_4510# vbn_leak 0
C2416 Xi0/g Xvi/a_864_6450# 0
C2417 Xi4/g Xg/m1_3530_1930# -0.03847f
C2418 Xg/a_7580_5314# Xg/a_5188_4156# -0.02232f
C2419 r1_b0 Xg/a_1580_5314# 0.23275f
C2420 vbn_ref Xd0/m1_4094_3010# 0.0964f
C2421 Xi1/a_3078_4572# Xr/vsp -0
C2422 vdd r2_b3 1.33458f
C2423 Xi4/g Xvi/m1_502_738# 0.10442f
C2424 Xi2/a_2432_4510# r2_b1 0.00445f
C2425 vdd vth_ref 1.667f
C2426 Xi1/g Xg/m1_5022_10210# -0
C2427 vdd Xi0/a_528_4572# 0.03238f
C2428 Xi2/g Xg/m1_3530_1930# 0.2191f
C2429 Xg/a_3036_4156# r2_b3 0.05146f
C2430 v0_c5 ua0_s1 0.10112f
C2431 r1_b0 vbn_leak 0.12473f
C2432 Xr/vgln Xm/in_n 0.13778f
C2433 vdd Xd3/m1_4648_4446# 0.12461f
C2434 i4_b3 vbn_ax 0.09798f
C2435 Xg/m1_3298_2050# vbp_st 0
C2436 Xi3/m1_988_3644# i4_b3 0.14895f
C2437 r1_b1 r2_b3 0.16241f
C2438 r2_b0 vdd 1.91901f
C2439 Xi2/a_1582_4510# i2_b0 0
C2440 ib_x2 Xi0/m1_650_4492# 0.01714f
C2441 vth_cmp Xvi/m1_8042_6360# -0.00368f
C2442 Xr/vsn Xi1/m1_1460_4102# 0.06043f
C2443 Xr/vgln Xi1/m1_650_4492# 0.00447f
C2444 Xi2/a_528_4510# Xi2/a_732_4510# -0.00176f
C2445 i4_b0 i4_b2 0.32024f
C2446 bias_en Xvi/a_4976_1528# 0.06782f
C2447 Xd3/m1_2702_4448# Xd3/a_3228_3816# -0.0284f
C2448 r2_b0 Xg/a_3036_4156# 0.08821f
C2449 Xi1/a_3078_4572# Xi1/m1_1460_4102# -0
C2450 Xr/vsn el 0.04465f
C2451 vbp_st Xg/a_1580_5314# 0.07585f
C2452 r2_b1 vbn_leak 0.05351f
C2453 Xm/iint vth_ref 0.06101f
C2454 r0_b3 Xm/in_p 0.16348f
C2455 i1_b1 Xi3/a_4132_4572# 0
C2456 vdd i0_b0 1.91544f
C2457 Xvi/m1_7102_850# vbn_leak 0
C2458 r2_b0 r1_b1 0.20175f
C2459 Xi4/g vdd 0.7424f
C2460 r1_b2 i4_b0 0.25753f
C2461 Xd3/a_3820_3816# Xd3/a_2636_3816# -0.00105f
C2462 i1_b0 i1_b2 0.01846f
C2463 Xm/iint Xi0/a_528_4572# 0
C2464 ua0_s0 Xr/en_b 0.17326f
C2465 ua0_s0 Xd3/m1_3600_4920# 0.05161f
C2466 Xi3/m1_650_4492# i0_b0 0.04051f
C2467 Xd3/m1_4648_4446# Xm/iint 0.01515f
C2468 Xr/vgln i2_b3 0.19257f
C2469 i3_b4 i1_b0 0.14471f
C2470 vth_cmp i4_b0 0.02845f
C2471 vbp_st vbn_leak 0.00406f
C2472 vdd Xi1/m1_988_3644# -0.00654f
C2473 Xi4/g Xg/a_3036_4156# -0.01461f
C2474 vbn_ref Xd0/m1_3342_4048# 0.09631f
C2475 vdd Xi2/g 0.63852f
C2476 vdd Xg/a_7580_5314# -0.09003f
C2477 Xr/vglp Xm/in_p 0.27007f
C2478 ua0 ua0_s0 0.11343f
C2479 vreset_src i4_b3 0.05859f
C2480 vbn_ax Xi1/g 0.34415f
C2481 vdd ua0_s1 0.47625f
C2482 Xr/vgln Xi3/a_2228_4572# 0.03155f
C2483 Xvi/a_2102_5152# vreset_src 0
C2484 ib_x2 Xi0/a_3078_4572# 0.11758f
C2485 Xi4/g r1_b1 0
C2486 Xg/a_3036_4156# Xi2/g 0
C2487 Xi1/a_2228_4572# i1_b2 0
C2488 ua0_s0 Xd3/m1_502_4448# 0
C2489 Xr/vsn r0_b0 0
C2490 Xi3/a_3078_4572# i0_b1 0.0038f
C2491 v0_c0 Xd3/m1_1382_4448# 0.00391f
C2492 Xi2/m1_988_3644# Xi2/g -0.03528f
C2493 i1_b1 i4_b4 0.05379f
C2494 i4_b0 Xg/a_5188_4156# 0.13589f
C2495 r1_b1 Xi2/g 0.03051f
C2496 vdd Xvi/m1_8332_7080# 0.03294f
C2497 Xd1/m1_3782_4048# r2_b3 0.05183f
C2498 Xd3/m1_4328_3000# Xd3/m1_4488_3600# -0
C2499 i1_b1 i3_b0 0.00111f
C2500 r2_b2 i4_b3 0.04299f
C2501 r1_b3 ua0_stim_out 0.07775f
C2502 vth_ref Xm/in_n 0.04629f
C2503 Xr/vsn Xi1/a_528_4572# 0
C2504 Xr/vgln Xr/m1_1222_3522# 0.00424f
C2505 Xr/vgln Xi3/m1_1460_4102# 0.10004f
C2506 Xi4/a_4132_4510# Xi4/a_3928_4510# -0
C2507 vdd Xi4/a_3282_4510# 0
C2508 i4_b0 Xg/m1_3530_1930# 0
C2509 Xi0/a_2228_4572# i0_b1 0
C2510 Xi1/g Xi1/m1_988_2984# -0.04381f
C2511 Xd3/m1_3342_4448# ua0_stim_out 0
C2512 Xd0/a_4168_3416# el 0
C2513 ib_x2 i0_b1 0.00388f
C2514 vbn_ref i4_b3 0.1788f
C2515 Xd0/m1_4094_3010# el 0.0095f
C2516 i4_b4 i3_b2 0.04298f
C2517 Xr/vsn ib_x2 0.08505f
C2518 Xi4/g Xg/m1_4760_1320# -0.01728f
C2519 Xm/iint ua0_s1 0.02287f
C2520 Xd3/a_2636_3816# ua0_stim 0
C2521 Xi0/a_2228_4572# i0_b2 0.00149f
C2522 r2_b1 Xi2/m1_988_1168# 0.04574f
C2523 i2_b4 Xm/in_p 0.04856f
C2524 ib_x2 i0_b2 0.00542f
C2525 vdd Xvi/m1_8042_6360# -0.01251f
C2526 ua0_s0 vbp_st 0.16236f
C2527 i3_b2 i3_b0 0.16188f
C2528 i1_b0 Xm/in_p 0.06285f
C2529 Xd3/m1_4488_3600# Xm/in_p 0.04277f
C2530 i1_b1 Xi3/a_3928_4572# 0
C2531 Xg/m1_4760_1320# Xi2/g 0.01825f
C2532 Xd3/a_2636_3816# bias_en 0.04386f
C2533 Xd3/m1_4488_3600# Xd3/a_5004_3816# -0.01338f
C2534 i2_b3 r2_b3 0.03641f
C2535 vreset_src Xi1/g 0.50946f
C2536 v0_c2 ua0_int 0.0784f
C2537 Xd0/a_4168_3416# r0_b0 0.00199f
C2538 Xm/in_n i0_b0 0.20955f
C2539 Xr/en_b Xr/vglp 0.18361f
C2540 Xi4/g Xm/in_n 0.09259f
C2541 Xvi/a_864_6450# vbn_prb -0.04282f
C2542 Xd3/m1_1822_4448# Xm/in_p 0.05372f
C2543 Xd3/m1_1970_3610# Xd3/a_3228_3816# -0
C2544 Xi2/a_1378_4510# vbp_syn 0.01675f
C2545 r2_b1 vbp_syn 0.22382f
C2546 Xd0/m1_2262_4048# vbn_leak 0.06176f
C2547 Xi2/m1_1500_4102# r2_b1 0.05137f
C2548 Xi1/m1_650_4492# i0_b0 0.012f
C2549 Xi2/g Xm/in_n 0.37799f
C2550 Xr/vglp r1_b0 0.13991f
C2551 r0_b3 Xg/m1_4906_9490# 0
C2552 vdd i4_b0 0.30902f
C2553 r2_b0 i2_b3 0.03127f
C2554 vbn_ref Xg/m1_4538_1930# 0.01809f
C2555 Xd3/a_3820_3816# v0_c3 0.00129f
C2556 r1_b4 Xm/in_p 0.05001f
C2557 r2_b2 Xi1/g 0.12035f
C2558 Xi3/a_3928_4572# i3_b2 0
C2559 ua0_s1 Xm/in_n 0
C2560 vreset_src Xd1/m1_1716_2640# 0
C2561 Xi2/a_732_4510# ua0_stim_out 0
C2562 vbp_syn vbp_st 0.39742f
C2563 Xr/vsp i4_b3 0.24037f
C2564 r2_b1 r0_b3 1.07767f
C2565 i4_b0 Xg/a_3036_4156# 0.05103f
C2566 vbn_ref Xi1/g 0.10437f
C2567 Xm/a_1764_11418# ua0_s1 0.48262f
C2568 Xr/vglp Xg/m1_4906_9490# -0.03889f
C2569 r1_b1 i4_b0 0.06087f
C2570 i0_b3 vdd 0.2592f
C2571 r0_b3 vbp_st 0.0459f
C2572 Xr/vsn r0_b2 0.25156f
C2573 Xi3/a_3282_4572# i4_b3 0
C2574 Xr/vsp i1_b3 0.21611f
C2575 Xd3/a_2636_3816# v0_c1 0.04798f
C2576 Xd0/m1_3342_4048# el 0.0193f
C2577 Xvi/m1_7102_850# Xr/vglp 0.05753f
C2578 Xg/m1_6282_1450# Xm/in_n 0.00271f
C2579 vdd Xm/a_2240_11218# -0.07117f
C2580 Xr/vglp r2_b1 0.25384f
C2581 Xr/vgln r0_b4 0.043f
C2582 i4_b1 vbn_ax 0.2211f
C2583 Xd2/m1_3982_4048# vth_cmp 0.0027f
C2584 Xi4/a_3078_4510# r2_b4 0.00653f
C2585 i2_b4 i3_b3 0
C2586 Xd1/m1_2910_2650# r2_b3 0.00391f
C2587 Xr/vglp vbp_st 0.29198f
C2588 Xd0/m1_942_4048# vbn_prb 0.0464f
C2589 ua0_stim_out r2_b4 0.04225f
C2590 i2_b4 r1_b0 0.03977f
C2591 Xi1/a_2432_4572# vbp_st 0.0046f
C2592 Xi2/a_2228_4510# ua0_stim_out 0.14405f
C2593 i3_b3 i1_b0 0.03124f
C2594 vbp_w i4_b1 0.05658f
C2595 Xd3/m1_2702_4448# Xd3/m1_3342_4448# -0.00216f
C2596 Xd3/a_2044_3816# vdd 0.08072f
C2597 Xd3/m1_3600_4920# Xd3/m1_1822_4448# -0.00802f
C2598 i4_b1 Xi4/a_1582_4510# 0
C2599 Xr/en_b Xd3/m1_1822_4448# 0
C2600 r1_b3 r2_b4 0.1291f
C2601 i0_b3 Xm/iint 0.12567f
C2602 i4_b4 i3_b1 0.04463f
C2603 Xm/a_736_5516# ua0_s0 0.36586f
C2604 i4_b0 Xg/m1_4760_1320# 0
C2605 v0_c3 ua0_stim 0.0422f
C2606 Xvi/m1_4894_1238# vbn_prb -0.00182f
C2607 Xvi/a_2102_5152# el 0.00507f
C2608 Xr/vgln bias_en 0.16009f
C2609 i4_b3 el 0.06948f
C2610 Xr/vsp Xi1/g 0.74486f
C2611 i2_b4 Xg/m1_4906_9490# 0.00107f
C2612 i4_b4 Xi0/m1_650_4492# 0.07312f
C2613 el Xd1/m1_2318_2410# 0.04333f
C2614 Xm/a_2240_11218# Xm/iint 0
C2615 i3_b1 i3_b0 0.61411f
C2616 ua0_s0 Xd3/a_3228_3816# 0.1138f
C2617 v0_c3 bias_en 0.03742f
C2618 i2_b4 r2_b1 0.58339f
C2619 bias_en Xvi/a_5712_1328# 0.08485f
C2620 Xvi/a_4976_1528# vreset_src 0.04861f
C2621 r1_b4 r1_b0 0.82347f
C2622 i4_b0 Xm/in_n 0
C2623 v0_c4 ua0_int 0.02393f
C2624 i2_b2 Xi3/g 0.04614f
C2625 Xd3/a_2044_3816# Xm/iint 0
C2626 Xi0/g Xi0/m1_650_4492# 0.03832f
C2627 Xg/m1_5516_1920# Xm/in_n 0.00418f
C2628 Xi3/g Xg/a_4580_5314# -0.11011f
C2629 vreset_src i4_b1 0.03349f
C2630 Xd1/a_4168_3416# r2_b3 0
C2631 Xm/a_420_700# Xm/in_p -0
C2632 i1_b0 vbp_st 0
C2633 Xi3/a_3078_4572# i4_b3 0
C2634 Xi3/a_3928_4572# i3_b1 0
C2635 Xi1/g Xi1/m1_1460_4102# -0.01211f
C2636 Xi3/a_4132_4572# i0_b1 0.00128f
C2637 i0_b3 Xm/in_n 0.04012f
C2638 v0_c4 v0_c2 0.13177f
C2639 r0_b4 r2_b3 0.05402f
C2640 i4_b4 Xi0/a_3078_4572# 0.01851f
C2641 r2_b2 i4_b1 0.04546f
C2642 i2_b2 i4_b2 0.02867f
C2643 Xd1/m1_3662_2290# r2_b3 0.08939f
C2644 i4_b0 i2_b3 0.03361f
C2645 Xr/vgln Xi4/m1_988_2984# 0
C2646 Xi1/a_2228_4572# vbp_st 0.00695f
C2647 Xr/vsp Xi3/m1_988_1168# 0.0411f
C2648 Xi2/a_2432_4510# ua0_stim_out 0.04507f
C2649 r1_b4 vbp_st 0.09954f
C2650 v0_c3 v0_c1 1.35645f
C2651 v0_c5 ua0_int 0.11078f
C2652 vbn_ref i4_b1 0.88446f
C2653 Xg/a_4580_5314# i4_b2 0.03399f
C2654 Xd3/a_3820_3816# ua0_s1 0.05197f
C2655 r2_b0 r0_b4 0.37778f
C2656 ib_x2 Xvi/a_2102_5152# 0.04665f
C2657 Xd3/m1_1970_3610# ua0_stim_out 0.00245f
C2658 Xi2/a_528_4510# vbp_syn 0.12272f
C2659 i2_b2 r1_b2 0.03751f
C2660 Xd2/m1_2900_3120# r2_b1 0.03766f
C2661 bias_en vth_ref 0.35623f
C2662 i4_b4 i0_b1 0.06608f
C2663 Xvi/a_2102_5152# Xvi/m1_4546_7560# -0
C2664 Xd0/a_2392_3416# r2_b3 0.08273f
C2665 r1_b2 Xg/a_4580_5314# 0.16733f
C2666 Xi3/g i4_b2 0.29965f
C2667 Xg/m1_6020_10200# r2_b3 0.05368f
C2668 ib_x2 i1_b3 0
C2669 Xr/vsn i4_b4 0.08851f
C2670 bias_en Xi0/a_528_4572# 0
C2671 el Xd1/m1_1716_2640# 0.11745f
C2672 Xi1/m1_988_1168# vbp_st 0.0351f
C2673 ua0_stim_out Xg/a_1580_5314# 0
C2674 Xi2/a_528_4510# r0_b3 0
C2675 i3_b0 i0_b1 0.0134f
C2676 i4_b4 i0_b2 0.07335f
C2677 v0_c2 v0_c5 0.35969f
C2678 r0_b3 Xg/m1_3898_9610# 0.00129f
C2679 bias_en Xd3/m1_4648_4446# 0.00409f
C2680 Xm/iint Xvi/m1_7440_2050# 0
C2681 r1_b3 Xg/a_1580_5314# 0.0558f
C2682 Xi4/a_3078_4510# vbn_leak 0
C2683 vdd Xi0/a_1582_4572# 0.03332f
C2684 Xi2/m1_988_2984# r2_b1 0.03933f
C2685 Xm/a_420_700# Xr/en_b -0.00115f
C2686 r1_b2 Xi3/g 0.18948f
C2687 Xi1/a_528_4572# Xi1/g 0
C2688 Xr/vsn Xi0/g 0.21687f
C2689 Xi2/g r0_b4 0.34198f
C2690 r2_b0 Xg/m1_6020_10200# 0.07517f
C2691 vth_ref Xi0/a_2432_4572# 0.0415f
C2692 r1_b3 vbn_leak 0.18363f
C2693 Xr/vglp Xg/m1_3898_9610# -0
C2694 ua0 Xm/a_420_700# -0.01192f
C2695 Xd0/m1_502_4048# vbn_ref 0
C2696 Xg/a_4580_5314# Xg/a_5188_4156# -0.00336f
C2697 Xr/vsp i4_b1 0.04049f
C2698 Xi4/g bias_en 0.10257f
C2699 vth_ref Xd3/m1_5542_4448# 0.00156f
C2700 vdd ua0_int 1.07278f
C2701 Xi3/a_3928_4572# i0_b1 0
C2702 vth_cmp Xd1/m1_3492_2640# 0.01898f
C2703 ua0_stim ua0_s1 0.26774f
C2704 Xi2/m1_640_4420# vbp_syn 0.01583f
C2705 i4_b1 Xi3/a_528_4572# 0.00192f
C2706 Xi3/g Xg/a_5188_4156# -0.0026f
C2707 Xi3/m1_988_2984# Xm/in_p 0.09748f
C2708 r1_b2 i4_b2 1.06493f
C2709 Xr/vgln vbn_ax 0.1829f
C2710 i2_b1 i4_b1 0.10768f
C2711 Xi2/m1_640_4420# r0_b3 0.16099f
C2712 bias_en ua0_s1 0.60945f
C2713 Xr/vgln Xi3/m1_988_3644# 0.00879f
C2714 i1_b1 i1_b2 0.3251f
C2715 Xg/m1_5022_10210# r2_b3 0.0671f
C2716 v0_c2 vdd 0.53606f
C2717 Xi2/a_3282_4510# Xr/vgln 0.08912f
C2718 vth_cmp i4_b2 0.07558f
C2719 ua0_s0 ua0_stim_out 0.01789f
C2720 i3_b4 i1_b1 0.02995f
C2721 Xr/vgln vbp_w 0.05349f
C2722 Xi4/a_732_4510# r2_b4 0.00716f
C2723 Xr/vgln Xi4/a_1582_4510# 0
C2724 Xvi/a_4976_1528# el 0.047f
C2725 Xm/a_420_700# vbp_st 0.03532f
C2726 Xi2/a_1582_4510# r2_b1 0.0033f
C2727 Xr/vgln Xvi/m1_942_738# 0
C2728 Xi4/m1_988_1168# vbn_prb 0.4067f
C2729 vth_ref Xi0/a_3928_4572# 0.04407f
C2730 Xd3/m1_1970_3610# Xd3/m1_2702_4448# -0.00261f
C2731 r1_b2 vth_cmp 0.04413f
C2732 Xr/vgln Xi1/m1_988_2984# 0
C2733 Xg/a_5188_4156# i4_b2 0.07278f
C2734 i3_b2 i1_b2 0.13778f
C2735 i4_b1 el 0.04755f
C2736 ua0_s0 Xd3/m1_3342_4448# 0.04886f
C2737 r2_b0 Xg/m1_5022_10210# 0.00132f
C2738 Xi2/a_2432_4510# Xi2/a_2228_4510# -0.0099f
C2739 i2_b2 vdd 0.74995f
C2740 i3_b4 i3_b2 0.60813f
C2741 Xi4/g Xi4/m1_988_2984# -0.0411f
C2742 vdd Xd0/m1_2760_3412# -0.00225f
C2743 vdd Xg/a_4580_5314# -0.07948f
C2744 v0_c2 Xm/iint 0.00505f
C2745 ua0_s1 Xd3/m1_5542_4448# 0
C2746 r0_b2 Xi1/g 0.11974f
C2747 ua0_s0 Xm/a_1744_9182# 0.15823f
C2748 Xi1/m1_988_1168# i0_b4 0.02667f
C2749 r1_b2 Xg/a_5188_4156# 0.05703f
C2750 Xi4/m1_988_3644# Xi4/g -0.01554f
C2751 Xg/a_4580_5314# Xg/a_3036_4156# -0.00207f
C2752 v0_c1 ua0_s1 0.04694f
C2753 v0_c4 v0_c5 0.08825f
C2754 vbp_syn ua0_stim_out 0.03095f
C2755 Xr/vgln vreset_src 0.66759f
C2756 Xi2/m1_1500_4102# ua0_stim_out 0
C2757 i2_b2 r1_b1 0.20215f
C2758 Xd2/a_2392_3416# vbn_prb 0.03228f
C2759 vdd Xi3/g 0.47204f
C2760 r1_b3 vbp_syn 0.04529f
C2761 Xi3/g Xi3/m1_650_4492# -0.03609f
C2762 Xr/vgln Xi4/m1_1500_4102# 0
C2763 vbn_leak r2_b4 0.14113f
C2764 vdd Xd1/m1_3492_2640# -0
C2765 Xi3/g Xg/a_3036_4156# 0
C2766 r0_b3 ua0_stim_out 0.19532f
C2767 vbn_ax r2_b3 1.2257f
C2768 vdd Xd2/a_2984_3416# -0.00313f
C2769 Xr/en_b Xr/m1_342_438# 0
C2770 i1_b1 Xm/in_p 0.04199f
C2771 Xr/vgln r2_b2 0.43588f
C2772 ua0_int Xm/a_1764_11418# -0.11837f
C2773 vbp_w r2_b3 0.03774f
C2774 r1_b1 Xi3/g 0
C2775 Xvi/m1_7102_850# Xvi/a_864_6450# -0.00182f
C2776 ib_x2 Xvi/a_4976_1528# 0.06414f
C2777 Xd0/m1_502_4048# el 0.05412f
C2778 Xr/vgln vbn_ref 0.76478f
C2779 r2_b0 vbn_ax 0.57399f
C2780 Xr/vglp ua0_stim_out 0.3902f
C2781 Xm/a_2240_11218# ua0_stim 0
C2782 Xi1/a_1582_4572# vbp_st 0.01029f
C2783 Xr/vglp r1_b3 0.04108f
C2784 Xr/vsn r0_b1 0.16694f
C2785 vdd i4_b2 0.61544f
C2786 i0_b3 bias_en 0.69962f
C2787 r2_b0 vbp_w 0.33348f
C2788 Xr/vsn vbn_prb 0.21976f
C2789 Xi3/m1_650_4492# i4_b2 0.3072f
C2790 bias_en Xm/a_2240_11218# 0.08678f
C2791 Xg/a_3036_4156# i4_b2 0.10884f
C2792 v0_c4 vdd 0.55283f
C2793 Xvi/a_2102_5152# i4_b4 0.08167f
C2794 i4_b3 i4_b4 0.00481f
C2795 ua0_s0 Xd3/m1_2702_4448# 0.05357f
C2796 vdd r1_b2 0.4019f
C2797 vbn_ax i0_b0 0.00205f
C2798 Xd3/a_2044_3816# ua0_stim 0.00206f
C2799 i4_b3 i3_b0 0.19539f
C2800 r1_b1 i4_b2 0.18282f
C2801 r0_b2 Xi2/a_3928_4510# 0.00586f
C2802 Xg/a_4580_5314# Xm/in_n 0
C2803 Xi2/a_732_4510# vbp_syn 0.07945f
C2804 i1_b3 i4_b4 0.8189f
C2805 vreset_src r2_b3 0.06865f
C2806 r1_b2 Xg/a_3036_4156# 0.18939f
C2807 Xi4/g vbp_w -0.01912f
C2808 i0_b3 Xi0/a_2432_4572# 0
C2809 bias_en Xd3/a_2044_3816# 0.05079f
C2810 vbn_ax Xi2/g 0.7428f
C2811 vdd vth_cmp 0.32749f
C2812 i3_b1 i1_b2 0
C2813 vbn_prb Xd2/a_3576_3416# 0.02384f
C2814 Xr/vgln Xvi/m1_5388_6960# 0.00151f
C2815 vth_ref vreset_src 0.64334f
C2816 Xi0/g i4_b3 0.34708f
C2817 Xg/a_7580_5314# vbn_ax 0.10728f
C2818 vreset_src Xd1/m1_942_4048# 0.00718f
C2819 r1_b2 r1_b1 1.26868f
C2820 vbp_st Xr/m1_342_438# 0.04282f
C2821 r2_b1 Xd0/m1_942_4048# 0.04629f
C2822 i2_b4 ua0_stim_out 0.0359f
C2823 i3_b4 i3_b1 0.00134f
C2824 Xi4/g Xvi/m1_942_738# 0.09557f
C2825 vbp_w Xi2/g 0.25943f
C2826 Xr/vgln Xr/vsp 0.53019f
C2827 i2_b4 r1_b3 0.03915f
C2828 Xi1/m1_988_2984# i0_b0 0.00318f
C2829 Xd3/m1_4488_3600# ua0_stim_out 0.03409f
C2830 r2_b2 r2_b3 0.41712f
C2831 v0_c4 Xm/iint 0.11212f
C2832 r2_b0 vreset_src 0.11049f
C2833 i1_b0 ua0_stim_out 0.08246f
C2834 vdd Xg/a_5188_4156# -0.04354f
C2835 vth_ref Xi0/a_4132_4572# 0.0415f
C2836 r1_b1 vth_cmp 1.73683f
C2837 Xi2/m1_640_4420# Xi2/m1_988_2984# -0.01117f
C2838 Xr/vgln Xi3/a_3282_4572# 0.00703f
C2839 i3_b3 i1_b1 0.0372f
C2840 Xd3/a_2636_3816# v0_c0 0.09867f
C2841 vdd v0_c5 0.349f
C2842 Xi1/a_3282_4572# i1_b2 0
C2843 vbn_ref r2_b3 0.17539f
C2844 Xg/a_3036_4156# Xg/a_5188_4156# -0.00129f
C2845 i2_b2 i2_b3 0.28377f
C2846 vdd Xg/m1_3530_1930# -0.00819f
C2847 Xi1/m1_988_3644# Xi1/m1_988_2984# -0.00382f
C2848 Xd3/m1_1822_4448# ua0_stim_out 0.14662f
C2849 Xd0/a_4168_3416# vbn_prb 0.00656f
C2850 Xr/vgln Xi1/a_732_4572# 0.06136f
C2851 Xd0/m1_4094_3010# vbn_prb 0.05916f
C2852 Xi2/a_2228_4510# vbp_syn 0.0026f
C2853 i2_b1 Xr/vgln 0.01263f
C2854 Xi4/a_3928_4510# r2_b4 0.01459f
C2855 vreset_src i0_b0 0.4018f
C2856 r2_b0 r2_b2 0.63654f
C2857 Xi4/g vreset_src 0.19289f
C2858 r1_b4 ua0_stim_out 0.04681f
C2859 Xi1/a_1378_4572# vbp_st 0.01057f
C2860 Xr/vgln Xi1/m1_1460_4102# 0
C2861 r1_b4 r1_b3 0.82482f
C2862 Xd3/a_2044_3816# v0_c1 0.00493f
C2863 i3_b3 i3_b2 0.1514f
C2864 vth_ref Xi0/m1_988_3644# 0
C2865 r2_b0 vbn_ref 0.15568f
C2866 Xi3/g i2_b3 0
C2867 Xi4/g Xi4/m1_1500_4102# -0.00181f
C2868 i0_b3 Xi0/a_3928_4572# 0.0429f
C2869 vreset_src Xi2/g 0.03734f
C2870 Xd3/a_3820_3816# ua0_int 0.00113f
C2871 Xi1/a_3928_4572# i1_b2 0
C2872 Xi0/g Xi1/g 0.87085f
C2873 Xi4/g r2_b2 0.64064f
C2874 bias_en Xvi/m1_7440_2050# 0.01706f
C2875 r1_b2 Xm/in_n 0
C2876 Xr/vgln el 0.68735f
C2877 Xr/vglp r2_b4 0.39193f
C2878 r2_b2 Xi2/g 0.04227f
C2879 i1_b1 vbp_st 0.00252f
C2880 Xm/a_736_7228# Xr/en_b -0.00166f
C2881 Xvi/a_5712_1328# el 0.00106f
C2882 vth_ref Xvi/m1_5388_6960# 0.00874f
C2883 Xvi/m1_8332_7080# vreset_src 0.00186f
C2884 Xi4/g vbn_ref 0.0397f
C2885 Xi4/m1_640_4420# Xi4/m1_988_2984# -0
C2886 vth_cmp Xm/in_n 0.10172f
C2887 ua0_s0 Xd3/m1_1970_3610# 0.03262f
C2888 Xr/vsp r2_b3 0.19279f
C2889 i4_b0 vbn_ax 0.23875f
C2890 ib_r1 Xr/vglp 0.37631f
C2891 vth_cmp Xd1/m1_3782_4048# 0
C2892 Xr/vsp vth_ref 0.20342f
C2893 Xd3/a_3820_3816# v0_c2 0.1204f
C2894 i1_b2 i0_b1 0.03271f
C2895 vbn_ref Xi2/g 0.71781f
C2896 vdd Xi3/m1_650_4492# -0.02561f
C2897 Xi2/m1_988_2984# ua0_stim_out 0
C2898 i3_b4 i0_b1 0.07136f
C2899 i4_b2 i2_b3 0.14883f
C2900 Xi4/a_3282_4510# vreset_src 0
C2901 vbn_ref Xg/a_7580_5314# 0.03731f
C2902 Xr/vsn i1_b2 0
C2903 vdd Xg/a_3036_4156# -0.03278f
C2904 Xi3/g Xi3/m1_1460_4102# -0.01625f
C2905 Xr/vgln r0_b0 0.04636f
C2906 i1_b2 i0_b2 0.05077f
C2907 Xm/a_736_7228# ua0 -0.00246f
C2908 vbp_w i4_b0 0.29479f
C2909 i3_b4 i0_b2 0.03539f
C2910 Xr/vgln Xi3/a_3078_4572# 0.02418f
C2911 i2_b1 r2_b3 0.06299f
C2912 Xi1/a_3078_4572# i1_b2 0.00181f
C2913 Xd0/m1_3342_4048# vbn_prb 0.04888f
C2914 r2_b0 Xr/vsp 0.28239f
C2915 r1_b2 i2_b3 0.03845f
C2916 vdd r1_b1 0.13986f
C2917 vreset_src Xvi/m1_8042_6360# 0.00617f
C2918 Xi2/a_2432_4510# vbp_syn 0.00289f
C2919 Xr/vgln v0_c0 0
C2920 Xr/vgln Xi1/a_528_4572# 0.07997f
C2921 Xr/m1_342_438# i0_b4 0.05f
C2922 i2_b4 r2_b4 0.03926f
C2923 Xm/in_n Xg/m1_3530_1930# 0.0043f
C2924 ua0_int ua0_stim 1.2304f
C2925 Xi4/g Xvi/m1_5388_6960# 0.13377f
C2926 vbn_ref Xg/m1_6282_1450# 0.0081f
C2927 vdd Xm/iint 0.23569f
C2928 v0_c3 v0_c0 0.02752f
C2929 i1_b4 Xr/m1_342_438# 0.02562f
C2930 Xr/vsp i0_b0 0.39454f
C2931 i2_b1 r2_b0 0.02841f
C2932 Xr/vgln Xi0/a_2228_4572# 0
C2933 Xd3/m1_2702_4448# Xd3/m1_1822_4448# -0.00181f
C2934 Xi3/m1_1460_4102# i4_b2 0.01099f
C2935 Xr/vgln ib_x2 0.35175f
C2936 bias_en ua0_int 1.32489f
C2937 Xm/a_420_700# ua0_stim_out -0.0055f
C2938 Xd2/a_4168_3416# Xd2/a_3576_3416# -0.00306f
C2939 Xvi/a_4976_1528# i4_b4 0.40315f
C2940 i4_b0 vreset_src 0.02999f
C2941 el r2_b3 0.54223f
C2942 Xi3/a_3282_4572# i0_b0 0
C2943 v0_c3 ib_x2 0.07095f
C2944 Xvi/a_2102_5152# vbn_prb -0.05042f
C2945 ib_x2 Xvi/a_5712_1328# 0.04442f
C2946 Xm/a_736_7228# vbp_st -0
C2947 vth_ref el 0.40508f
C2948 Xr/vsp Xi2/g 0
C2949 Xd3/m1_1382_4448# Xm/in_p 0.05444f
C2950 Xr/vsp Xg/a_7580_5314# 0.16109f
C2951 vdd Xi3/a_2432_4572# 0
C2952 Xr/vgln Xvi/m1_4546_7560# 0.16606f
C2953 el Xd1/m1_942_4048# 0.01694f
C2954 vbn_prb Xd1/m1_2318_2410# 0.03487f
C2955 Xr/vglp Xg/m1_3298_2050# 0.00218f
C2956 v0_c2 ua0_stim 0.0237f
C2957 r0_b3 Xg/a_1580_5314# 0
C2958 i3_b3 i3_b1 0.00315f
C2959 Xi1/g i2_b0 0
C2960 Xd0/a_1800_3416# r2_b3 0.1471f
C2961 r1_b4 r2_b4 0.03801f
C2962 Xi2/a_1582_4510# ua0_stim_out 0.00953f
C2963 i2_b2 r0_b4 0.05867f
C2964 i0_b1 Xm/in_p 0.04025f
C2965 Xi4/a_3928_4510# vbn_leak 0.00103f
C2966 Xvi/a_5712_1328# Xvi/m1_4546_7560# -0
C2967 r2_b0 el 0.12759f
C2968 r2_b2 i4_b0 0.0359f
C2969 v0_c2 bias_en 1.24989f
C2970 i4_b1 i3_b0 0.03877f
C2971 i0_b3 vreset_src 0.04398f
C2972 i0_b2 Xm/in_p 0.04217f
C2973 vdd Xm/in_n 0.39546f
C2974 r0_b0 r2_b3 0.20462f
C2975 Xvi/m1_8042_6360# vss -0.34565f
C2976 vbn_prb vss 2.55082f
C2977 el vss 4.07419f
C2978 Xvi/m1_4546_7560# vss -0.34405f
C2979 ib_x2 vss 0.09822f
C2980 Xm/iint vss 3.9752f
C2981 vth_cmp vss 3.45215f
C2982 Xvi/m1_1382_738# vss -0.27142f
C2983 Xvi/m1_942_738# vss -0.31019f
C2984 Xvi/m1_502_738# vss -0.25754f
C2985 Xvi/m1_7440_2050# vss -0.41505f
C2986 vth_ref vss 3.91467f
C2987 Xvi/m1_8332_7080# vss -0.29823f
C2988 Xvi/a_2102_5152# vss -0.51887f
C2989 Xvi/a_4976_1528# vss -0.8535f
C2990 Xvi/a_864_6450# vss -2.92321f
C2991 Xvi/m1_4894_1238# vss -0.72832f
C2992 Xr/vglp vss -0.55222f
C2993 vreset_src vss 5.25476f
C2994 Xvi/m1_5388_6960# vss -0.33944f
C2995 Xvi/a_5712_1328# vss -1.7213f
C2996 Xvi/m1_8646_1098# vss -0.08042f
C2997 bias_en vss 1.79443f
C2998 Xvi/m1_7102_850# vss -0.71052f
C2999 Xvi/m1_1276_6360# vss -0.32612f
C3000 ib_r1 vss 2.00935f
C3001 vdd vss -0.29872p
C3002 Xd3/m1_4488_3600# vss -0.7582f
C3003 Xd3/m1_4328_3000# vss -0.74404f
C3004 Xd3/m1_1382_4448# vss -0.30779f
C3005 Xd3/m1_1822_4448# vss -0.25218f
C3006 Xd3/m1_3342_4448# vss -0.57255f
C3007 Xd3/m1_2702_4448# vss -0.86529f
C3008 Xd3/m1_3600_4920# vss -0.70618f
C3009 Xd3/m1_942_4448# vss -0.30146f
C3010 Xd3/m1_1970_3610# vss -0.57238f
C3011 Xd3/m1_502_4448# vss -0.25711f
C3012 Xd3/m1_5982_4448# vss -0.18036f
C3013 Xd3/m1_5542_4448# vss -0.21393f
C3014 Xd3/a_2044_3816# vss -0.1382f
C3015 v0_c0 vss 1.50939f
C3016 Xd3/a_2636_3816# vss -0.2389f
C3017 v0_c1 vss 0.08132f
C3018 Xd3/a_3228_3816# vss -0.45988f
C3019 v0_c2 vss 1.13803f
C3020 Xd3/a_3820_3816# vss -0.37573f
C3021 v0_c3 vss 0.57056f
C3022 v0_c5 vss 3.13386f
C3023 Xd3/a_4412_3816# vss -0.4533f
C3024 v0_c4 vss 2.14522f
C3025 Xd3/a_5004_3816# vss -0.29225f
C3026 Xd3/m1_4648_4446# vss -0.18427f
C3027 Xd2/m1_3982_4048# vss -0.60741f
C3028 Xd2/m1_1382_4048# vss -0.28667f
C3029 Xd2/m1_2900_3120# vss -0.81256f
C3030 Xd2/m1_3542_4048# vss -0.75074f
C3031 Xd2/m1_942_4048# vss -0.3059f
C3032 Xd2/m1_2156_3240# vss -0.84458f
C3033 Xd2/m1_1822_4048# vss -0.61258f
C3034 Xd2/m1_502_4048# vss -0.23977f
C3035 Xd2/a_1800_3416# vss -0.2846f
C3036 r2_b0 vss 1.47219f
C3037 Xd2/a_2392_3416# vss -0.34013f
C3038 r2_b1 vss 0.41551f
C3039 Xd2/a_2984_3416# vss -0.32362f
C3040 r2_b2 vss 1.66661f
C3041 r2_b4 vss 0.90241f
C3042 Xd2/a_3576_3416# vss -0.40354f
C3043 r2_b3 vss 1.07876f
C3044 Xd2/a_4168_3416# vss -0.26024f
C3045 Xr/m1_3862_3522# vss -0.25117f
C3046 Xr/m1_3422_438# vss -0.23682f
C3047 Xr/m1_2542_438# vss -0.23682f
C3048 Xr/m1_1662_438# vss -0.23682f
C3049 Xr/m1_1222_3522# vss -0.25114f
C3050 Xr/m1_782_438# vss -0.23682f
C3051 Xr/m1_342_438# vss -0.8284f
C3052 Xd1/m1_3662_2290# vss -0.70839f
C3053 Xd1/m1_2910_2650# vss -0.74367f
C3054 Xd1/m1_3492_2640# vss -0.75377f
C3055 Xd1/m1_942_4048# vss -0.30356f
C3056 Xd1/m1_2318_2410# vss -0.86529f
C3057 Xd1/m1_1716_2640# vss -0.62551f
C3058 Xd1/m1_502_4048# vss -0.29545f
C3059 Xd1/a_1800_3416# vss -0.25854f
C3060 r1_b0 vss 1.08387f
C3061 Xd1/a_2392_3416# vss -0.31907f
C3062 r1_b1 vss 0.2616f
C3063 Xd1/a_2984_3416# vss -0.36305f
C3064 r1_b2 vss 0.75161f
C3065 r1_b4 vss 0.95989f
C3066 Xd1/a_3576_3416# vss -0.3715f
C3067 r1_b3 vss 0.79731f
C3068 Xd1/a_4168_3416# vss -0.24483f
C3069 Xd1/m1_3782_4048# vss -0.26394f
C3070 Xd0/m1_4094_3010# vss -0.71788f
C3071 Xd0/m1_1382_4048# vss -0.28874f
C3072 Xd0/m1_2760_3412# vss -0.66789f
C3073 Xd0/m1_3342_4048# vss -0.75904f
C3074 Xd0/m1_942_4048# vss -0.30153f
C3075 Xd0/m1_2262_4048# vss -0.80692f
C3076 Xd0/m1_1822_4048# vss -0.63866f
C3077 Xd0/m1_502_4048# vss -0.24401f
C3078 Xd0/a_1800_3416# vss -0.26045f
C3079 r0_b0 vss 0.47631f
C3080 Xd0/a_2392_3416# vss -0.3486f
C3081 r0_b1 vss 0.55561f
C3082 Xd0/a_2984_3416# vss -0.36764f
C3083 r0_b2 vss 0.37281f
C3084 r0_b4 vss 0.22715f
C3085 Xd0/a_3576_3416# vss -0.34676f
C3086 r0_b3 vss 0.65236f
C3087 Xd0/a_4168_3416# vss -0.27354f
C3088 Xd0/m1_4222_4048# vss -0.2797f
C3089 Xi4/m1_988_1168# vss -1.42584f
C3090 Xr/vsn vss -9.67805f
C3091 Xi4/g vss -12.87245f
C3092 Xi4/a_3928_4510# vss -0.18392f
C3093 Xi4/a_3078_4510# vss -0.17856f
C3094 Xi4/a_1378_4510# vss -0.1807f
C3095 Xi4/a_2432_4510# vss -0.26748f
C3096 Xi4/a_2228_4510# vss -0.18318f
C3097 vbp_w vss 1.05534f
C3098 Xi4/a_528_4510# vss -0.17734f
C3099 Xi4/m1_640_4420# vss -0.52003f
C3100 Xi4/m1_1500_4102# vss -0.13305f
C3101 Xi4/m1_988_3644# vss -0.36806f
C3102 Xi4/a_4132_4510# vss -0.26888f
C3103 i4_b4 vss 0.70218f
C3104 i4_b2 vss 2.14483f
C3105 Xi4/a_3282_4510# vss -0.27427f
C3106 i4_b3 vss 1.96583f
C3107 Xi4/a_1582_4510# vss -0.27141f
C3108 i4_b1 vss 2.10555f
C3109 Xi4/a_732_4510# vss -0.26886f
C3110 i4_b0 vss 1.32547f
C3111 Xr/vgln vss -9.13461f
C3112 Xi4/m1_988_2984# vss -0.73496f
C3113 vbp_st vss 3.31005f
C3114 Xi3/m1_988_1168# vss 0.28659f
C3115 Xi3/g vss -5.07893f
C3116 Xi3/a_4132_4572# vss -0.12742f
C3117 Xi3/a_3928_4572# vss -0.21055f
C3118 Xi3/a_3282_4572# vss -0.12264f
C3119 Xi3/a_3078_4572# vss -0.20943f
C3120 Xi3/a_1582_4572# vss -0.04669f
C3121 Xi3/a_1378_4572# vss -0.18299f
C3122 Xi3/a_2432_4572# vss -0.12308f
C3123 Xi3/a_2228_4572# vss -0.20904f
C3124 vbn_ax vss 0.91916f
C3125 Xi3/a_732_4572# vss -0.12468f
C3126 Xi3/a_528_4572# vss -0.21122f
C3127 Xi3/m1_650_4492# vss -0.09243f
C3128 Xi3/m1_1460_4102# vss -0.01996f
C3129 Xi3/m1_988_3644# vss -0.01434f
C3130 i3_b4 vss 0.34705f
C3131 i3_b3 vss 0.45913f
C3132 i3_b2 vss 0.23808f
C3133 i3_b1 vss 0.53812f
C3134 i3_b0 vss 0.47685f
C3135 Xi3/m1_988_2984# vss 0.00347f
C3136 Xi2/m1_988_1168# vss -1.37916f
C3137 Xi2/g vss -13.38668f
C3138 Xi2/a_3928_4510# vss -0.18392f
C3139 Xi2/a_3078_4510# vss -0.17856f
C3140 Xi2/a_1378_4510# vss -0.1807f
C3141 Xi2/a_2432_4510# vss -0.26776f
C3142 Xi2/a_2228_4510# vss -0.18405f
C3143 vbp_syn vss 0.52805f
C3144 Xi2/a_528_4510# vss -0.19449f
C3145 Xi2/m1_640_4420# vss -0.5255f
C3146 Xi2/m1_1500_4102# vss -0.13305f
C3147 Xi2/m1_988_3644# vss -0.36806f
C3148 Xi2/a_4132_4510# vss -0.26912f
C3149 i2_b4 vss 0.64675f
C3150 i2_b2 vss 0.19211f
C3151 Xi2/a_3282_4510# vss -0.27431f
C3152 i2_b3 vss 0.10666f
C3153 Xi2/a_1582_4510# vss -0.27145f
C3154 i2_b1 vss 0.50125f
C3155 Xi2/a_732_4510# vss -0.27834f
C3156 i2_b0 vss 0.30455f
C3157 Xi2/m1_988_2984# vss -0.73496f
C3158 Xm/a_2240_11218# vss -0.36282f
C3159 ua0_int vss 0.34374f
C3160 Xm/a_736_7228# vss -7.34055f
C3161 Xr/en_b vss 0.37353f
C3162 ua0_stim_out vss 0.64123f
C3163 ua0_stim vss 0.86488f
C3164 Xm/a_1764_11418# vss -0.5466f
C3165 Xm/a_1744_9182# vss -0.51234f
C3166 Xm/a_736_5516# vss -6.47913f
C3167 Xm/a_420_700# vss -1.35678f
C3168 ua0_s0 vss 2.74205f
C3169 ua0_s1 vss 0.73594f
C3170 ua0 vss 0.69474f
C3171 Xm/a_1744_10100# vss -0.56343f
C3172 Xi1/m1_988_1168# vss -0.09647f
C3173 Xi1/g vss -4.47964f
C3174 Xi1/a_4132_4572# vss -0.12487f
C3175 Xi1/a_3928_4572# vss -0.21044f
C3176 Xi1/a_3282_4572# vss -0.12264f
C3177 Xi1/a_3078_4572# vss -0.21169f
C3178 Xi1/a_1582_4572# vss -0.1249f
C3179 Xi1/a_1378_4572# vss -0.20883f
C3180 Xi1/a_2432_4572# vss -0.12308f
C3181 Xi1/a_2228_4572# vss -0.20931f
C3182 vbn_ref vss 1.70901f
C3183 Xi1/a_732_4572# vss -0.1247f
C3184 Xi1/a_528_4572# vss -0.21152f
C3185 Xi1/m1_650_4492# vss -0.10434f
C3186 Xi1/m1_1460_4102# vss -0.03065f
C3187 Xi1/m1_988_3644# vss -0.04532f
C3188 i1_b4 vss 0.94084f
C3189 i1_b3 vss 1.06362f
C3190 i1_b2 vss 1.07671f
C3191 i1_b1 vss 0.53495f
C3192 i1_b0 vss 1.23891f
C3193 Xi1/m1_988_2984# vss -0.08637f
C3194 Xi0/m1_988_1168# vss -0.13328f
C3195 Xr/vsp vss -16.34142f
C3196 Xi0/g vss -4.92196f
C3197 Xi0/a_4132_4572# vss -0.12759f
C3198 Xi0/a_3928_4572# vss -0.21031f
C3199 Xi0/a_3282_4572# vss -0.12268f
C3200 Xi0/a_3078_4572# vss -0.20936f
C3201 Xi0/a_1582_4572# vss -0.1249f
C3202 Xi0/a_1378_4572# vss -0.20889f
C3203 Xi0/a_2432_4572# vss -0.12308f
C3204 Xi0/a_2228_4572# vss -0.20929f
C3205 vbn_leak vss 0.1568f
C3206 Xi0/a_732_4572# vss -0.1247f
C3207 Xi0/a_528_4572# vss -0.21103f
C3208 Xi0/m1_650_4492# vss -0.10387f
C3209 Xi0/m1_1460_4102# vss -0.02889f
C3210 Xi0/m1_988_3644# vss -0.04434f
C3211 i0_b4 vss 1.81541f
C3212 i0_b3 vss 0.96241f
C3213 i0_b2 vss 0.38135f
C3214 i0_b1 vss 0.99181f
C3215 i0_b0 vss 1.74765f
C3216 Xi0/m1_988_2984# vss -0.07617f
C3217 Xg/a_1580_5314# vss -0.48657f
C3218 Xg/m1_4906_9490# vss -0.1016f
C3219 Xg/m1_3898_9610# vss -0.0928f
C3220 Xg/m1_3666_9610# vss -0.09723f
C3221 Xm/in_p vss 0.24109f
C3222 Xg/m1_4538_1930# vss -0.22289f
C3223 Xg/m1_3530_1930# vss -0.41751f
C3224 Xg/m1_3298_2050# vss -0.25676f
C3225 Xm/in_n vss 0.31023f
C3226 Xg/a_5188_4156# vss -0.90784f
C3227 Xg/a_7580_5314# vss -0.09321f
C3228 Xg/a_3036_4156# vss -0.89946f
C3229 Xg/a_4580_5314# vss -0.15743f
C3230 Xg/m1_6282_1450# vss -0.11967f
C3231 Xg/m1_5516_1920# vss -0.25092f
C3232 Xg/m1_4760_1320# vss -0.18804f
C3233 Xg/m1_6020_10200# vss -0.14819f
C3234 Xg/m1_5022_10210# vss -0.09562f
.ends
