* NGSPICE file created from bias_b1.ext - technology: gf180mcuD

.subckt n_w2_l4_f4 a_n52_n200# a_852_n200# a_n852_n244# a_n956_n200# a_52_n244# a_n1756_n244#
+ a_1756_n200# a_n1844_n200# a_956_n244# VSUBS
X0 a_852_n200# a_52_n244# a_n52_n200# VSUBS nfet_03v3 ad=0.52p pd=2.52u as=0.52p ps=2.52u w=2u l=4u
X1 a_1756_n200# a_956_n244# a_852_n200# VSUBS nfet_03v3 ad=0.88p pd=4.88u as=0.52p ps=2.52u w=2u l=4u
X2 a_n956_n200# a_n1756_n244# a_n1844_n200# VSUBS nfet_03v3 ad=0.52p pd=2.52u as=0.88p ps=4.88u w=2u l=4u
X3 a_n52_n200# a_n852_n244# a_n956_n200# VSUBS nfet_03v3 ad=0.52p pd=2.52u as=0.52p ps=2.52u w=2u l=4u
C0 a_1756_n200# a_956_n244# 0.07019f
C1 a_852_n200# a_956_n244# 0.07019f
C2 a_n52_n200# a_n956_n200# 0.01073f
C3 a_52_n244# a_852_n200# 0.07019f
C4 a_n52_n200# a_52_n244# 0.07019f
C5 a_n852_n244# a_n1756_n244# 0.00519f
C6 a_n1844_n200# a_n1756_n244# 0.07019f
C7 a_52_n244# a_956_n244# 0.00519f
C8 a_n52_n200# a_n852_n244# 0.07019f
C9 a_n956_n200# a_n852_n244# 0.07019f
C10 a_n956_n200# a_n1844_n200# 0.01073f
C11 a_52_n244# a_n852_n244# 0.00519f
C12 a_852_n200# a_1756_n200# 0.01073f
C13 a_n956_n200# a_n1756_n244# 0.07019f
C14 a_n52_n200# a_852_n200# 0.01073f
C15 a_1756_n200# VSUBS 0.41176f
C16 a_852_n200# VSUBS 0.648f
C17 a_n52_n200# VSUBS 0.64292f
C18 a_n956_n200# VSUBS 0.648f
C19 a_n1844_n200# VSUBS 0.41176f
.ends

.subckt rx_n4 vdd vss line
XD vss line line line line line vss vss line vss n_w2_l4_f4
C0 vdd vss 0.06604f
C1 line vss 2.16208f
.ends

.subckt n_w2_l4_f2 a_n52_n200# a_852_n200# a_n852_n244# a_n940_n200# a_52_n244# VSUBS
X0 a_852_n200# a_52_n244# a_n52_n200# VSUBS nfet_03v3 ad=0.88p pd=4.88u as=0.52p ps=2.52u w=2u l=4u
X1 a_n52_n200# a_n852_n244# a_n940_n200# VSUBS nfet_03v3 ad=0.52p pd=2.52u as=0.88p ps=4.88u w=2u l=4u
C0 a_52_n244# a_852_n200# 0.07019f
C1 a_n940_n200# a_n52_n200# 0.01073f
C2 a_52_n244# a_n52_n200# 0.07019f
C3 a_n940_n200# a_n852_n244# 0.07019f
C4 a_n52_n200# a_852_n200# 0.01073f
C5 a_52_n244# a_n852_n244# 0.00519f
C6 a_n52_n200# a_n852_n244# 0.07019f
C7 a_852_n200# VSUBS 0.41176f
C8 a_n52_n200# VSUBS 0.65308f
C9 a_n940_n200# VSUBS 0.41176f
.ends

.subckt rx_n2 line vdd vss
XD line vss line vss line vss n_w2_l4_f2
C0 vdd line 0.00181f
C1 vdd vss 0.06098f
C2 line vss 1.08247f
.ends

.subckt p_w2_l4 a_400_n200# a_n400_n244# w_n574_n330# a_n488_n200# VSUBS
X0 a_400_n200# a_n400_n244# a_n488_n200# w_n574_n330# pfet_03v3 ad=0.88p pd=4.88u as=0.88p ps=4.88u w=2u l=4u
C0 a_400_n200# a_n400_n244# 0.07019f
C1 a_n488_n200# w_n574_n330# 0.07409f
C2 a_n488_n200# a_n400_n244# 0.07019f
C3 a_n400_n244# w_n574_n330# 0.42229f
C4 a_n488_n200# a_400_n200# 0.01073f
C5 a_400_n200# w_n574_n330# 0.07409f
C6 a_400_n200# VSUBS 0.18936f
C7 a_n488_n200# VSUBS 0.18936f
C8 w_n574_n330# VSUBS 2.27304f
.ends

.subckt rx_p24 line vss vdd
XD line line vdd vdd vss p_w2_l4
C0 line vdd 0.78494f
C1 line vss -0.06364f
C2 vdd vss 5.17939f
.ends

.subckt n_w2_l4 a_400_n200# a_n400_n244# a_n488_n200# VSUBS
X0 a_400_n200# a_n400_n244# a_n488_n200# VSUBS nfet_03v3 ad=0.88p pd=4.88u as=0.88p ps=4.88u w=2u l=4u
C0 a_n488_n200# a_n400_n244# 0.07019f
C1 a_n488_n200# a_400_n200# 0.01073f
C2 a_n400_n244# a_400_n200# 0.07019f
C3 a_400_n200# VSUBS 0.41684f
C4 a_n488_n200# VSUBS 0.41684f
.ends

.subckt rx_n1 vdd vss line
XD line line vss vss n_w2_l4
C0 line vdd 0.00323f
C1 vdd vss 0.05846f
C2 line vss 0.60968f
.ends

.subckt p_w1_l4 a_n488_n100# a_400_n100# a_n400_n144# w_n574_n230# VSUBS
X0 a_400_n100# a_n400_n144# a_n488_n100# w_n574_n230# pfet_03v3 ad=0.44p pd=2.88u as=0.44p ps=2.88u w=1u l=4u
C0 a_400_n100# a_n488_n100# 0.00531f
C1 a_n400_n144# a_n488_n100# 0.03474f
C2 w_n574_n230# a_n488_n100# 0.03707f
C3 a_n400_n144# a_400_n100# 0.03474f
C4 w_n574_n230# a_400_n100# 0.03707f
C5 w_n574_n230# a_n400_n144# 0.42229f
C6 a_400_n100# VSUBS 0.15701f
C7 a_n488_n100# VSUBS 0.15701f
C8 w_n574_n230# VSUBS 1.58424f
.ends

.subckt rx_p05 line vdd vss
XD vdd line line vdd vss p_w1_l4
C0 vdd line 0.81576f
C1 line vss 0.00304f
C2 vdd vss 5.0752f
.ends

.subckt p_w4_l2_f5 a_n304_n400# a_704_n400# a_n704_n444# a_n808_n400# a_304_n444#
+ a_n1208_n444# a_n1296_n400# a_1208_n400# w_n1382_n530# a_200_n400# a_808_n444# a_n200_n444#
+ VSUBS
X0 a_1208_n400# a_808_n444# a_704_n400# w_n1382_n530# pfet_03v3 ad=1.76p pd=8.88u as=1.04p ps=4.52u w=4u l=2u
X1 a_704_n400# a_304_n444# a_200_n400# w_n1382_n530# pfet_03v3 ad=1.04p pd=4.52u as=1.04p ps=4.52u w=4u l=2u
X2 a_n808_n400# a_n1208_n444# a_n1296_n400# w_n1382_n530# pfet_03v3 ad=1.04p pd=4.52u as=1.76p ps=8.88u w=4u l=2u
X3 a_n304_n400# a_n704_n444# a_n808_n400# w_n1382_n530# pfet_03v3 ad=1.04p pd=4.52u as=1.04p ps=4.52u w=4u l=2u
X4 a_200_n400# a_n200_n444# a_n304_n400# w_n1382_n530# pfet_03v3 ad=1.04p pd=4.52u as=1.04p ps=4.52u w=4u l=2u
C0 w_n1382_n530# a_200_n400# 0.18497f
C1 w_n1382_n530# a_304_n444# 0.21994f
C2 a_n808_n400# a_n1296_n400# 0.04287f
C3 a_n200_n444# a_200_n400# 0.11799f
C4 a_n200_n444# a_304_n444# 0.00519f
C5 w_n1382_n530# a_n304_n400# 0.18497f
C6 w_n1382_n530# a_1208_n400# 0.12268f
C7 a_n200_n444# a_n304_n400# 0.11799f
C8 w_n1382_n530# a_n1208_n444# 0.2233f
C9 a_704_n400# a_808_n444# 0.11799f
C10 w_n1382_n530# a_n200_n444# 0.21994f
C11 a_n704_n444# a_n304_n400# 0.11799f
C12 a_n808_n400# a_n304_n400# 0.04287f
C13 a_304_n444# a_808_n444# 0.00519f
C14 w_n1382_n530# a_n704_n444# 0.21994f
C15 a_704_n400# a_200_n400# 0.04287f
C16 a_n704_n444# a_n1208_n444# 0.00519f
C17 a_704_n400# a_304_n444# 0.11799f
C18 a_n200_n444# a_n704_n444# 0.00519f
C19 a_n808_n400# w_n1382_n530# 0.18497f
C20 a_1208_n400# a_808_n444# 0.11799f
C21 a_n808_n400# a_n1208_n444# 0.11799f
C22 a_n1296_n400# w_n1382_n530# 0.12268f
C23 a_n1296_n400# a_n1208_n444# 0.11799f
C24 a_304_n444# a_200_n400# 0.11799f
C25 a_704_n400# a_1208_n400# 0.04287f
C26 w_n1382_n530# a_808_n444# 0.2233f
C27 a_704_n400# w_n1382_n530# 0.18497f
C28 a_200_n400# a_n304_n400# 0.04287f
C29 a_n808_n400# a_n704_n444# 0.11799f
C30 a_1208_n400# VSUBS 0.19832f
C31 a_704_n400# VSUBS 0.12191f
C32 a_200_n400# VSUBS 0.11851f
C33 a_n304_n400# VSUBS 0.11851f
C34 a_n808_n400# VSUBS 0.12191f
C35 a_n1296_n400# VSUBS 0.19832f
C36 w_n1382_n530# VSUBS 8.78952f
.ends

.subckt p_w2_l1 a_100_n200# a_n100_n244# w_n274_n330# a_n188_n200# VSUBS
X0 a_100_n200# a_n100_n244# a_n188_n200# w_n274_n330# pfet_03v3 ad=0.88p pd=4.88u as=0.88p ps=4.88u w=2u l=1u
C0 a_n100_n244# w_n274_n330# 0.12884f
C1 a_n100_n244# a_100_n200# 0.04231f
C2 w_n274_n330# a_100_n200# 0.04851f
C3 a_n100_n244# a_n188_n200# 0.04231f
C4 w_n274_n330# a_n188_n200# 0.04851f
C5 a_100_n200# a_n188_n200# 0.03858f
C6 a_100_n200# VSUBS 0.11088f
C7 a_n188_n200# VSUBS 0.11088f
C8 w_n274_n330# VSUBS 1.08504f
.ends

.subckt n_w4_l2_f6 a_n956_n444# a_1060_n444# a_556_n444# a_n52_n400# a_n1548_n400#
+ a_n1060_n400# a_452_n400# a_n452_n444# a_n556_n400# a_n1460_n444# a_1460_n400# a_52_n444#
+ a_956_n400# VSUBS
X0 a_n556_n400# a_n956_n444# a_n1060_n400# VSUBS nfet_03v3 ad=1.04p pd=4.52u as=1.04p ps=4.52u w=4u l=2u
X1 a_n52_n400# a_n452_n444# a_n556_n400# VSUBS nfet_03v3 ad=1.04p pd=4.52u as=1.04p ps=4.52u w=4u l=2u
X2 a_452_n400# a_52_n444# a_n52_n400# VSUBS nfet_03v3 ad=1.04p pd=4.52u as=1.04p ps=4.52u w=4u l=2u
X3 a_n1060_n400# a_n1460_n444# a_n1548_n400# VSUBS nfet_03v3 ad=1.04p pd=4.52u as=1.76p ps=8.88u w=4u l=2u
X4 a_956_n400# a_556_n444# a_452_n400# VSUBS nfet_03v3 ad=1.04p pd=4.52u as=1.04p ps=4.52u w=4u l=2u
X5 a_1460_n400# a_1060_n444# a_956_n400# VSUBS nfet_03v3 ad=1.76p pd=8.88u as=1.04p ps=4.52u w=4u l=2u
C0 a_52_n444# a_n52_n400# 0.11799f
C1 a_n1060_n400# a_n1548_n400# 0.04287f
C2 a_956_n400# a_1460_n400# 0.04287f
C3 a_n956_n444# a_n1460_n444# 0.00519f
C4 a_556_n444# a_452_n400# 0.11799f
C5 a_n452_n444# a_n52_n400# 0.11799f
C6 a_52_n444# a_452_n400# 0.11799f
C7 a_956_n400# a_1060_n444# 0.11799f
C8 a_n1460_n444# a_n1548_n400# 0.11799f
C9 a_n556_n400# a_n452_n444# 0.11799f
C10 a_n956_n444# a_n452_n444# 0.00519f
C11 a_556_n444# a_52_n444# 0.00519f
C12 a_452_n400# a_n52_n400# 0.04287f
C13 a_n1060_n400# a_n556_n400# 0.04287f
C14 a_956_n400# a_452_n400# 0.04287f
C15 a_n556_n400# a_n52_n400# 0.04287f
C16 a_n956_n444# a_n1060_n400# 0.11799f
C17 a_n1460_n444# a_n1060_n400# 0.11799f
C18 a_556_n444# a_1060_n444# 0.00519f
C19 a_52_n444# a_n452_n444# 0.00519f
C20 a_1060_n444# a_1460_n400# 0.11799f
C21 a_556_n444# a_956_n400# 0.11799f
C22 a_n956_n444# a_n556_n400# 0.11799f
C23 a_1460_n400# VSUBS 0.33857f
C24 a_956_n400# VSUBS 0.34773f
C25 a_452_n400# VSUBS 0.34265f
C26 a_n52_n400# VSUBS 0.34265f
C27 a_n556_n400# VSUBS 0.34265f
C28 a_n1060_n400# VSUBS 0.34773f
C29 a_n1548_n400# VSUBS 0.33857f
.ends

.subckt n_w2_l2_f2 a_n52_n200# a_452_n200# a_n452_n244# a_n540_n200# a_52_n244# VSUBS
X0 a_452_n200# a_52_n244# a_n52_n200# VSUBS nfet_03v3 ad=0.88p pd=4.88u as=0.52p ps=2.52u w=2u l=2u
X1 a_n52_n200# a_n452_n244# a_n540_n200# VSUBS nfet_03v3 ad=0.52p pd=2.52u as=0.88p ps=4.88u w=2u l=2u
C0 a_n452_n244# a_n540_n200# 0.0587f
C1 a_n452_n244# a_n52_n200# 0.0587f
C2 a_n52_n200# a_n540_n200# 0.02133f
C3 a_n452_n244# a_52_n244# 0.00519f
C4 a_452_n200# a_n52_n200# 0.02133f
C5 a_52_n244# a_452_n200# 0.0587f
C6 a_52_n244# a_n52_n200# 0.0587f
C7 a_452_n200# VSUBS 0.26162f
C8 a_n52_n200# VSUBS 0.35281f
C9 a_n540_n200# VSUBS 0.26162f
.ends

.subckt n_w2_l1 a_100_n200# a_n100_n244# a_n188_n200# VSUBS
X0 a_100_n200# a_n100_n244# a_n188_n200# VSUBS nfet_03v3 ad=0.88p pd=4.88u as=0.88p ps=4.88u w=2u l=1u
C0 a_n100_n244# a_100_n200# 0.04231f
C1 a_n100_n244# a_n188_n200# 0.04231f
C2 a_n188_n200# a_100_n200# 0.03858f
C3 a_100_n200# VSUBS 0.19164f
C4 a_n188_n200# VSUBS 0.19164f
.ends

.subckt p_w2_l2_f8 a_n52_n200# a_n1060_n200# a_452_n200# a_1564_n244# a_n452_n244#
+ w_n2138_n330# a_n556_n200# a_n1460_n244# a_1460_n200# a_52_n244# a_n1564_n200# a_956_n200#
+ a_n2052_n200# a_n956_n244# a_1060_n244# a_n1964_n244# a_556_n244# a_1964_n200# VSUBS
X0 a_1964_n200# a_1564_n244# a_1460_n200# w_n2138_n330# pfet_03v3 ad=0.88p pd=4.88u as=0.52p ps=2.52u w=2u l=2u
X1 a_452_n200# a_52_n244# a_n52_n200# w_n2138_n330# pfet_03v3 ad=0.52p pd=2.52u as=0.52p ps=2.52u w=2u l=2u
X2 a_956_n200# a_556_n244# a_452_n200# w_n2138_n330# pfet_03v3 ad=0.52p pd=2.52u as=0.52p ps=2.52u w=2u l=2u
X3 a_1460_n200# a_1060_n244# a_956_n200# w_n2138_n330# pfet_03v3 ad=0.52p pd=2.52u as=0.52p ps=2.52u w=2u l=2u
X4 a_n1564_n200# a_n1964_n244# a_n2052_n200# w_n2138_n330# pfet_03v3 ad=0.52p pd=2.52u as=0.88p ps=4.88u w=2u l=2u
X5 a_n1060_n200# a_n1460_n244# a_n1564_n200# w_n2138_n330# pfet_03v3 ad=0.52p pd=2.52u as=0.52p ps=2.52u w=2u l=2u
X6 a_n556_n200# a_n956_n244# a_n1060_n200# w_n2138_n330# pfet_03v3 ad=0.52p pd=2.52u as=0.52p ps=2.52u w=2u l=2u
X7 a_n52_n200# a_n452_n244# a_n556_n200# w_n2138_n330# pfet_03v3 ad=0.52p pd=2.52u as=0.52p ps=2.52u w=2u l=2u
C0 w_n2138_n330# a_n556_n200# 0.09155f
C1 a_556_n244# a_956_n200# 0.0587f
C2 a_n452_n244# a_52_n244# 0.00519f
C3 a_n452_n244# a_n52_n200# 0.0587f
C4 w_n2138_n330# a_452_n200# 0.09155f
C5 a_1060_n244# a_1564_n244# 0.00519f
C6 a_n452_n244# a_n556_n200# 0.0587f
C7 a_1564_n244# a_1964_n200# 0.0587f
C8 a_956_n200# a_1460_n200# 0.02133f
C9 a_n1964_n244# a_n1564_n200# 0.0587f
C10 w_n2138_n330# a_n1060_n200# 0.09155f
C11 w_n2138_n330# a_956_n200# 0.09155f
C12 a_n2052_n200# a_n1964_n244# 0.0587f
C13 a_n1060_n200# a_n1460_n244# 0.0587f
C14 w_n2138_n330# a_556_n244# 0.21994f
C15 w_n2138_n330# a_1460_n200# 0.09155f
C16 a_n556_n200# a_n956_n244# 0.0587f
C17 w_n2138_n330# a_n1460_n244# 0.21994f
C18 a_n2052_n200# a_n1564_n200# 0.02133f
C19 w_n2138_n330# a_n452_n244# 0.21994f
C20 a_n956_n244# a_n1060_n200# 0.0587f
C21 a_1060_n244# a_956_n200# 0.0587f
C22 w_n2138_n330# a_n956_n244# 0.21994f
C23 a_1060_n244# a_556_n244# 0.00519f
C24 a_n956_n244# a_n1460_n244# 0.00519f
C25 a_1060_n244# a_1460_n200# 0.0587f
C26 w_n2138_n330# a_n1964_n244# 0.2233f
C27 a_n452_n244# a_n956_n244# 0.00519f
C28 a_1964_n200# a_1460_n200# 0.02133f
C29 a_n1060_n200# a_n1564_n200# 0.02133f
C30 a_n1964_n244# a_n1460_n244# 0.00519f
C31 a_52_n244# a_n52_n200# 0.0587f
C32 a_1060_n244# w_n2138_n330# 0.21994f
C33 a_1564_n244# a_1460_n200# 0.0587f
C34 a_n556_n200# a_n52_n200# 0.02133f
C35 a_1964_n200# w_n2138_n330# 0.0618f
C36 a_1564_n244# w_n2138_n330# 0.2233f
C37 a_n52_n200# a_452_n200# 0.02133f
C38 a_52_n244# a_452_n200# 0.0587f
C39 w_n2138_n330# a_n1564_n200# 0.09155f
C40 a_n1564_n200# a_n1460_n244# 0.0587f
C41 a_n2052_n200# w_n2138_n330# 0.0618f
C42 a_n556_n200# a_n1060_n200# 0.02133f
C43 a_556_n244# a_52_n244# 0.00519f
C44 a_452_n200# a_956_n200# 0.02133f
C45 a_556_n244# a_452_n200# 0.0587f
C46 w_n2138_n330# a_n52_n200# 0.09155f
C47 w_n2138_n330# a_52_n244# 0.21994f
C48 a_1964_n200# VSUBS 0.13364f
C49 a_1460_n200# VSUBS 0.12191f
C50 a_956_n200# VSUBS 0.11851f
C51 a_452_n200# VSUBS 0.11851f
C52 a_n52_n200# VSUBS 0.11851f
C53 a_n556_n200# VSUBS 0.11851f
C54 a_n1060_n200# VSUBS 0.11851f
C55 a_n1564_n200# VSUBS 0.12191f
C56 a_n2052_n200# VSUBS 0.13364f
C57 w_n2138_n330# VSUBS 8.46648f
.ends

.subckt n_w2_l2_f8 a_n52_n200# a_n1060_n200# a_452_n200# a_1564_n244# a_n452_n244#
+ a_n556_n200# a_n1460_n244# a_1460_n200# a_52_n244# a_n1564_n200# a_956_n200# a_n2052_n200#
+ a_n956_n244# a_1060_n244# a_n1964_n244# a_556_n244# a_1964_n200# VSUBS
X0 a_1964_n200# a_1564_n244# a_1460_n200# VSUBS nfet_03v3 ad=0.88p pd=4.88u as=0.52p ps=2.52u w=2u l=2u
X1 a_452_n200# a_52_n244# a_n52_n200# VSUBS nfet_03v3 ad=0.52p pd=2.52u as=0.52p ps=2.52u w=2u l=2u
X2 a_956_n200# a_556_n244# a_452_n200# VSUBS nfet_03v3 ad=0.52p pd=2.52u as=0.52p ps=2.52u w=2u l=2u
X3 a_1460_n200# a_1060_n244# a_956_n200# VSUBS nfet_03v3 ad=0.52p pd=2.52u as=0.52p ps=2.52u w=2u l=2u
X4 a_n1564_n200# a_n1964_n244# a_n2052_n200# VSUBS nfet_03v3 ad=0.52p pd=2.52u as=0.88p ps=4.88u w=2u l=2u
X5 a_n1060_n200# a_n1460_n244# a_n1564_n200# VSUBS nfet_03v3 ad=0.52p pd=2.52u as=0.52p ps=2.52u w=2u l=2u
X6 a_n556_n200# a_n956_n244# a_n1060_n200# VSUBS nfet_03v3 ad=0.52p pd=2.52u as=0.52p ps=2.52u w=2u l=2u
X7 a_n52_n200# a_n452_n244# a_n556_n200# VSUBS nfet_03v3 ad=0.52p pd=2.52u as=0.52p ps=2.52u w=2u l=2u
C0 a_n1564_n200# a_n1460_n244# 0.0587f
C1 a_n1964_n244# a_n1564_n200# 0.0587f
C2 a_1964_n200# a_1564_n244# 0.0587f
C3 a_956_n200# a_556_n244# 0.0587f
C4 a_n556_n200# a_n52_n200# 0.02133f
C5 a_956_n200# a_1460_n200# 0.02133f
C6 a_n452_n244# a_52_n244# 0.00519f
C7 a_452_n200# a_52_n244# 0.0587f
C8 a_n556_n200# a_n956_n244# 0.0587f
C9 a_956_n200# a_1060_n244# 0.0587f
C10 a_556_n244# a_1060_n244# 0.00519f
C11 a_1460_n200# a_1060_n244# 0.0587f
C12 a_n1060_n200# a_n1460_n244# 0.0587f
C13 a_n556_n200# a_n452_n244# 0.0587f
C14 a_n1060_n200# a_n956_n244# 0.0587f
C15 a_n2052_n200# a_n1964_n244# 0.0587f
C16 a_1460_n200# a_1564_n244# 0.0587f
C17 a_1564_n244# a_1060_n244# 0.00519f
C18 a_956_n200# a_452_n200# 0.02133f
C19 a_n1060_n200# a_n1564_n200# 0.02133f
C20 a_556_n244# a_452_n200# 0.0587f
C21 a_n556_n200# a_n1060_n200# 0.02133f
C22 a_556_n244# a_52_n244# 0.00519f
C23 a_n2052_n200# a_n1564_n200# 0.02133f
C24 a_n1964_n244# a_n1460_n244# 0.00519f
C25 a_1460_n200# a_1964_n200# 0.02133f
C26 a_n1460_n244# a_n956_n244# 0.00519f
C27 a_n52_n200# a_n452_n244# 0.0587f
C28 a_452_n200# a_n52_n200# 0.02133f
C29 a_n956_n244# a_n452_n244# 0.00519f
C30 a_n52_n200# a_52_n244# 0.0587f
C31 a_1964_n200# VSUBS 0.26162f
C32 a_1460_n200# VSUBS 0.34773f
C33 a_956_n200# VSUBS 0.34265f
C34 a_452_n200# VSUBS 0.34265f
C35 a_n52_n200# VSUBS 0.34265f
C36 a_n556_n200# VSUBS 0.34265f
C37 a_n1060_n200# VSUBS 0.34265f
C38 a_n1564_n200# VSUBS 0.34773f
C39 a_n2052_n200# VSUBS 0.26162f
.ends

.subckt p_w2_l2 a_n288_n200# a_200_n200# a_n200_n244# w_n374_n330# VSUBS
X0 a_200_n200# a_n200_n244# a_n288_n200# w_n374_n330# pfet_03v3 ad=0.88p pd=4.88u as=0.88p ps=4.88u w=2u l=2u
C0 a_n288_n200# a_200_n200# 0.02133f
C1 a_n288_n200# w_n374_n330# 0.0618f
C2 a_200_n200# w_n374_n330# 0.0618f
C3 a_n288_n200# a_n200_n244# 0.0587f
C4 a_200_n200# a_n200_n244# 0.0587f
C5 a_n200_n244# w_n374_n330# 0.22666f
C6 a_200_n200# VSUBS 0.13704f
C7 a_n288_n200# VSUBS 0.13704f
C8 w_n374_n330# VSUBS 1.48104f
.ends

.subckt n_w2_l2 a_n288_n200# a_200_n200# a_n200_n244# VSUBS
X0 a_200_n200# a_n200_n244# a_n288_n200# VSUBS nfet_03v3 ad=0.88p pd=4.88u as=0.88p ps=4.88u w=2u l=2u
C0 a_200_n200# a_n200_n244# 0.0587f
C1 a_200_n200# a_n288_n200# 0.02133f
C2 a_n288_n200# a_n200_n244# 0.0587f
C3 a_200_n200# VSUBS 0.2667f
C4 a_n288_n200# VSUBS 0.2667f
.ends

.subckt p_w2_l2_f2 a_n52_n200# a_452_n200# a_n452_n244# a_n540_n200# w_n626_n330#
+ a_52_n244# VSUBS
X0 a_452_n200# a_52_n244# a_n52_n200# w_n626_n330# pfet_03v3 ad=0.88p pd=4.88u as=0.52p ps=2.52u w=2u l=2u
X1 a_n52_n200# a_n452_n244# a_n540_n200# w_n626_n330# pfet_03v3 ad=0.52p pd=2.52u as=0.88p ps=4.88u w=2u l=2u
C0 a_n52_n200# a_n452_n244# 0.0587f
C1 a_52_n244# a_452_n200# 0.0587f
C2 a_52_n244# w_n626_n330# 0.2233f
C3 a_n540_n200# w_n626_n330# 0.0618f
C4 a_452_n200# w_n626_n330# 0.0618f
C5 a_52_n244# a_n452_n244# 0.00519f
C6 a_n540_n200# a_n452_n244# 0.0587f
C7 a_52_n244# a_n52_n200# 0.0587f
C8 a_n540_n200# a_n52_n200# 0.02133f
C9 a_452_n200# a_n52_n200# 0.02133f
C10 a_n452_n244# w_n626_n330# 0.2233f
C11 a_n52_n200# w_n626_n330# 0.09155f
C12 a_452_n200# VSUBS 0.13364f
C13 a_n52_n200# VSUBS 0.12532f
C14 a_n540_n200# VSUBS 0.13364f
C15 w_n626_n330# VSUBS 2.47896f
.ends

.subckt bias_ladder in_n vgp3 m1_6020_10200# m1_3298_2050# m1_4760_1320# m1_5022_10210#
+ m1_3530_1930# m1_3898_9610# a_7580_5314# vss vgp5 m1_4906_9490# vdd m1_6282_1450#
+ a_1580_5314# m1_3666_9610# m1_5516_1920# a_4580_5314# m1_4538_1930# vgn3 vsn a_5188_4156#
+ vgn5 vsp vglp vgp6 a_3036_4156# vgln in_p
XnpSE m1_3898_9610# m1_4906_9490# vglp m1_3666_9610# vglp vglp in_p m1_6020_10200#
+ vdd m1_5022_10210# vglp vglp vss p_w4_l2_f5
XFP3 vgp3 a_1580_5314# vgp3 vss vss p_w2_l1
XnnSE vgln vgln vgln m1_4760_1320# in_n m1_3298_2050# m1_4538_1930# vgln m1_3530_1930#
+ vgln m1_6282_1450# vgln m1_5516_1920# vss n_w4_l2_f6
XnnSH6T m1_6282_1450# vdd vgln a_7580_5314# vgln vss n_w2_l2_f2
XFP5 vgp5 a_4580_5314# vgp5 vss vss p_w2_l1
XFN3 vgn3 a_3036_4156# vdd vss n_w2_l1
XDP3 vsp vsp a_1580_5314# vgp3 vgp3 vdd a_1580_5314# vgp3 a_1580_5314# vgp3 a_1580_5314#
+ vsp vsp vgp3 vgp3 vgp3 vgp3 vsp vss p_w2_l2_f8
XFP6 vgp6 a_7580_5314# vgp6 vss vss p_w2_l1
XFN5 vgn5 a_5188_4156# vdd vss n_w2_l1
XDP5 vsp vsp a_4580_5314# vgp5 vgp5 vdd a_4580_5314# vgp5 a_4580_5314# vgp5 a_4580_5314#
+ vsp vsp vgp5 vgp5 vgp5 vgp5 vsp vss p_w2_l2_f8
XDN3 vsn vsn a_3036_4156# vgn3 vgn3 a_3036_4156# vgn3 a_3036_4156# vgn3 a_3036_4156#
+ vsn vsn vgn3 vgn3 vgn3 vgn3 vsn vss n_w2_l2_f8
XDP6 vsp vsp a_7580_5314# vgp6 vgp6 vdd a_7580_5314# vgp6 a_7580_5314# vgp6 a_7580_5314#
+ vsp vsp vgp6 vgp6 vgp6 vgp6 vsp vss p_w2_l2_f8
XBP3 vsp vgp3 vgp6 vdd vss p_w2_l2
XDN5 vsn vsn a_5188_4156# vgn5 vgn5 a_5188_4156# vgn5 a_5188_4156# vgn5 a_5188_4156#
+ vsn vsn vgn5 vgn5 vgn5 vgn5 vsn vss n_w2_l2_f8
XBP5 vsp vgp5 vgp6 vdd vss p_w2_l2
XBN3 vgn3 vsn vgn5 vss n_w2_l2
XnnSH01 vdd m1_3298_2050# vgln in_n vgln vss n_w2_l2_f2
XBP6 vsp vgp6 vgp6 vdd vss p_w2_l2
XnnSH24 vdd m1_4538_1930# vgln m1_3530_1930# vgln vss n_w2_l2_f2
XBN5 vgn5 vsn vgn5 vss n_w2_l2
XnpSH3 m1_5022_10210# a_3036_4156# vglp vdd vss p_w2_l2
XnpSH5T m1_6020_10200# vss vglp a_5188_4156# vdd vglp vss p_w2_l2_f2
XnpSH01 vss m1_3666_9610# vglp in_p vdd vglp vss p_w2_l2_f2
XnpSH24 vss m1_4906_9490# vglp m1_3898_9610# vdd vglp vss p_w2_l2_f2
XnnSH3 m1_4760_1320# a_1580_5314# vgln vss n_w2_l2
XnnSH5 m1_5516_1920# a_4580_5314# vgln vss n_w2_l2
C0 vdd m1_3530_1930# 0.05235f
C1 vsp a_3036_4156# 0.0883f
C2 a_1580_5314# m1_5516_1920# 0.05179f
C3 vgn3 vgp3 0.00714f
C4 m1_6282_1450# a_7580_5314# 0.00102f
C5 in_n m1_3530_1930# 0.00742f
C6 vgln m1_4538_1930# 0.37308f
C7 a_5188_4156# a_4580_5314# 0.4945f
C8 m1_3666_9610# vgp6 0.00881f
C9 vdd a_3036_4156# 1.03471f
C10 a_5188_4156# vgp6 0.14378f
C11 m1_5516_1920# a_7580_5314# 0
C12 m1_4906_9490# m1_6020_10200# 0.00282f
C13 a_1580_5314# m1_4760_1320# -0.02087f
C14 vglp m1_6020_10200# 0.27284f
C15 a_5188_4156# vgp5 0.18257f
C16 vgln m1_3530_1930# 0.4385f
C17 in_p vgp6 0
C18 vdd m1_6282_1450# 0.04143f
C19 vgln a_3036_4156# 0.00497f
C20 m1_4906_9490# vgp6 0.01016f
C21 vdd m1_5516_1920# 0.03975f
C22 vgn5 vgn3 0.06099f
C23 vglp a_4580_5314# 0
C24 vgp6 vgp3 0.38706f
C25 vglp vgp6 0.49335f
C26 m1_3298_2050# m1_4760_1320# -0
C27 a_1580_5314# vgn3 0.04478f
C28 vgp5 vgp3 0.00867f
C29 vglp vgp5 0.1447f
C30 m1_3898_9610# vgp6 0.01466f
C31 vdd m1_4760_1320# 0.02112f
C32 vgln m1_6282_1450# 0.19109f
C33 m1_3530_1930# vsn 0.01898f
C34 vgln m1_5516_1920# 0.29348f
C35 m1_5022_10210# a_3036_4156# 0
C36 a_3036_4156# vsn 0.14439f
C37 m1_3298_2050# vgn3 0.00878f
C38 vgln m1_4760_1320# 0.22369f
C39 vgn5 a_4580_5314# 0.10109f
C40 vgn5 vgp6 0.00421f
C41 in_p m1_3666_9610# 0.0161f
C42 vdd vgn3 0.17852f
C43 a_1580_5314# a_4580_5314# 0.06015f
C44 m1_6020_10200# vsp 0.02019f
C45 vgn5 vgp5 0.0996f
C46 a_1580_5314# vgp6 0.24833f
C47 in_n vgn3 0.00344f
C48 m1_4906_9490# a_5188_4156# 0
C49 a_1580_5314# vgp5 0.16694f
C50 m1_3666_9610# vgp3 0
C51 vglp m1_3666_9610# 0.38355f
C52 a_4580_5314# a_7580_5314# 0.29998f
C53 a_5188_4156# vgp3 0.00485f
C54 vglp a_5188_4156# 0.03121f
C55 vgp6 a_7580_5314# 1.8657f
C56 m1_4538_1930# m1_6282_1450# 0
C57 vdd m1_6020_10200# 0.18314f
C58 vgp5 a_7580_5314# 0.32553f
C59 m1_4538_1930# m1_5516_1920# 0.04505f
C60 vgln vgn3 0.47992f
C61 m1_3666_9610# m1_3898_9610# 0.08953f
C62 a_4580_5314# vsp 0.80414f
C63 m1_4760_1320# vsn 0
C64 vgp6 vsp 1.5758f
C65 in_p vgp3 0.0017f
C66 vglp in_p 0.7203f
C67 vgp5 vsp 0.78845f
C68 m1_4538_1930# m1_4760_1320# 0.16397f
C69 vdd a_4580_5314# 1.73154f
C70 m1_4906_9490# vgp3 0.0279f
C71 vglp m1_4906_9490# 0.38823f
C72 vdd vgp6 5.47456f
C73 vglp vgp3 0.48996f
C74 vdd vgp5 3.48321f
C75 m1_3898_9610# m1_4906_9490# 0.00256f
C76 a_5188_4156# vgn5 1.16612f
C77 m1_3530_1930# m1_4760_1320# 0
C78 m1_3898_9610# vgp3 0.04635f
C79 vglp m1_3898_9610# 0.4412f
C80 vgn3 vsn 1.08253f
C81 a_1580_5314# a_5188_4156# 0.12061f
C82 vgln a_4580_5314# 0.49007f
C83 m1_4538_1930# vgn3 0.08119f
C84 m1_5022_10210# m1_6020_10200# 0.0182f
C85 a_5188_4156# a_7580_5314# 0.41188f
C86 m1_5516_1920# m1_6282_1450# 0.00546f
C87 m1_3666_9610# vsp 0.00336f
C88 a_5188_4156# vsp 0.36532f
C89 m1_3530_1930# vgn3 0.04819f
C90 m1_4760_1320# m1_6282_1450# 0
C91 a_1580_5314# vgp3 1.41665f
C92 vglp a_1580_5314# 0
C93 m1_5022_10210# vgp6 0.00778f
C94 m1_3666_9610# vdd 0.05802f
C95 vdd a_5188_4156# 0.39619f
C96 a_4580_5314# vsn 0.36645f
C97 vgn3 a_3036_4156# 0.80773f
C98 vgp6 vsn 0.03394f
C99 in_p vsp 0.13384f
C100 vglp a_7580_5314# 0
C101 a_7580_5314# vgp3 0.20875f
C102 vgp5 vsn 0.17915f
C103 m1_4538_1930# a_4580_5314# 0.00211f
C104 m1_4906_9490# vsp 0.00394f
C105 in_p vdd 1.4091f
C106 m1_6020_10200# a_3036_4156# 0.00106f
C107 vsp vgp3 1.5721f
C108 vglp vsp 0.34417f
C109 vgln a_5188_4156# 0.06289f
C110 m1_4906_9490# vdd 0.08697f
C111 m1_3898_9610# vsp 0.00217f
C112 m1_5516_1920# vgn3 0.00897f
C113 vglp vdd 5.16392f
C114 vdd vgp3 3.78758f
C115 a_1580_5314# vgn5 0.21481f
C116 m1_3898_9610# vdd 0.15129f
C117 a_4580_5314# a_3036_4156# 0.1705f
C118 vgn5 a_7580_5314# 0.26387f
C119 vgp6 a_3036_4156# 0.42099f
C120 m1_4760_1320# vgn3 0.12142f
C121 vgp5 a_3036_4156# 0.72992f
C122 a_1580_5314# a_7580_5314# 0.02594f
C123 m1_5022_10210# a_5188_4156# 0
C124 a_5188_4156# vsn 0.39706f
C125 m1_6282_1450# a_4580_5314# 0.21332f
C126 a_1580_5314# vsp 0.66577f
C127 m1_5516_1920# a_4580_5314# -0.00812f
C128 vdd vgn5 0.10294f
C129 vsp a_7580_5314# 0.4942f
C130 a_1580_5314# vdd 1.62506f
C131 m1_5022_10210# m1_4906_9490# 0.22756f
C132 m1_5022_10210# vgp3 0.00919f
C133 m1_5022_10210# vglp 0.22247f
C134 m1_4760_1320# a_4580_5314# 0
C135 vdd a_7580_5314# 0.83515f
C136 vgln vgn5 0.02641f
C137 m1_5022_10210# m1_3898_9610# 0
C138 a_5188_4156# a_3036_4156# 0.27107f
C139 a_1580_5314# vgln 0.07765f
C140 vdd vsp 3.61245f
C141 vdd m1_3298_2050# 0.05664f
C142 vgln a_7580_5314# 0.10386f
C143 in_n m1_3298_2050# 0.02053f
C144 a_4580_5314# vgn3 0
C145 a_5188_4156# m1_6282_1450# 0.00163f
C146 in_n vdd 0.07179f
C147 vgp5 vgn3 0
C148 m1_4906_9490# a_3036_4156# 0.00404f
C149 a_5188_4156# m1_5516_1920# 0
C150 vgn5 vsn 1.27598f
C151 vgln m1_3298_2050# 0.28259f
C152 a_3036_4156# vgp3 0.03477f
C153 vglp a_3036_4156# 0.03135f
C154 vgp6 m1_6020_10200# 0.04538f
C155 a_1580_5314# vsn 0.16559f
C156 vgln vdd 2.28298f
C157 m1_4538_1930# vgn5 0.00106f
C158 vgp5 m1_6020_10200# 0.01029f
C159 m1_3898_9610# a_3036_4156# 0
C160 vgln in_n 0.47579f
C161 a_1580_5314# m1_4538_1930# 0.00316f
C162 vsn a_7580_5314# 0.31213f
C163 m1_5022_10210# vsp 0.00393f
C164 vgp6 a_4580_5314# 0.58598f
C165 m1_3298_2050# vsn 0.01482f
C166 vgp5 a_4580_5314# 1.87678f
C167 vgp6 vgp5 0.35193f
C168 m1_5022_10210# vdd 0.0596f
C169 vgn5 a_3036_4156# 0.11976f
C170 vdd vsn 0.58029f
C171 a_1580_5314# a_3036_4156# 0.14234f
C172 in_n vsn 0.17665f
C173 vdd m1_4538_1930# 0.27134f
C174 a_3036_4156# a_7580_5314# 0.0745f
C175 vgn5 m1_6282_1450# 0
C176 a_5188_4156# m1_6020_10200# 0.00728f
C177 m1_3298_2050# m1_3530_1930# 0.33404f
C178 vgn5 m1_5516_1920# 0.00187f
C179 vgln vsn 0.48987f
C180 a_1580_5314# vss 1.70876f
C181 m1_4906_9490# vss -0.04028f
C182 m1_3898_9610# vss 0.09303f
C183 m1_3666_9610# vss -0.03204f
C184 in_p vss -0
C185 vglp vss -0.37909f
C186 m1_4538_1930# vss 0.07674f
C187 m1_3530_1930# vss 0.05197f
C188 m1_3298_2050# vss 0.04402f
C189 vdd vss 86.64923f
C190 in_n vss 1.35999f
C191 vgln vss 3.3753f
C192 vgn5 vss 4.03953f
C193 a_5188_4156# vss 1.44532f
C194 vsp vss -0.14973f
C195 a_7580_5314# vss 1.40837f
C196 vsn vss 4.2523f
C197 a_3036_4156# vss 1.80989f
C198 vgn3 vss 3.02208f
C199 vgp6 vss 2.43502f
C200 a_4580_5314# vss 3.24613f
C201 vgp5 vss 1.91603f
C202 m1_6282_1450# vss 0.17092f
C203 m1_5516_1920# vss -0.01345f
C204 m1_4760_1320# vss -0.06206f
C205 vgp3 vss 2.7134f
C206 m1_6020_10200# vss -0.16436f
C207 m1_5022_10210# vss -0.09509f
.ends

.subckt p_w1_l0p28_f2 a_n196_n100# a_n52_n100# w_n282_n230# a_108_n100# a_52_n144#
+ a_n108_n144# VSUBS
X0 a_n52_n100# a_n108_n144# a_n196_n100# w_n282_n230# pfet_03v3 ad=0.26p pd=1.52u as=0.44p ps=2.88u w=1u l=0.28u
X1 a_108_n100# a_52_n144# a_n52_n100# w_n282_n230# pfet_03v3 ad=0.44p pd=2.88u as=0.26p ps=1.52u w=1u l=0.28u
C0 a_n52_n100# a_52_n144# 0.00769f
C1 w_n282_n230# a_52_n144# 0.05505f
C2 a_n108_n144# a_52_n144# 0.00519f
C3 a_108_n100# a_52_n144# 0.00769f
C4 a_n52_n100# a_n196_n100# 0.04256f
C5 w_n282_n230# a_n196_n100# 0.01808f
C6 a_n52_n100# w_n282_n230# 0.01828f
C7 a_n108_n144# a_n196_n100# 0.00769f
C8 a_n52_n100# a_n108_n144# 0.00769f
C9 a_n52_n100# a_108_n100# 0.04256f
C10 w_n282_n230# a_n108_n144# 0.05505f
C11 w_n282_n230# a_108_n100# 0.01808f
C12 a_108_n100# VSUBS 0.0563f
C13 a_n52_n100# VSUBS 0.03533f
C14 a_n196_n100# VSUBS 0.0563f
C15 w_n282_n230# VSUBS 0.77832f
.ends

.subckt n_w0p5_l0p28_f2 a_n52_n50# a_n196_n50# a_52_n94# a_108_n50# a_n108_n94# VSUBS
X0 a_108_n50# a_52_n94# a_n52_n50# VSUBS nfet_03v3 ad=0.22p pd=1.88u as=0.13p ps=1.02u w=0.5u l=0.28u
X1 a_n52_n50# a_n108_n94# a_n196_n50# VSUBS nfet_03v3 ad=0.13p pd=1.02u as=0.22p ps=1.88u w=0.5u l=0.28u
C0 a_n196_n50# a_n52_n50# 0.02085f
C1 a_n108_n94# a_n196_n50# 0.00377f
C2 a_108_n50# a_n52_n50# 0.02085f
C3 a_n108_n94# a_n52_n50# 0.00377f
C4 a_52_n94# a_n52_n50# 0.00377f
C5 a_108_n50# a_52_n94# 0.00377f
C6 a_n108_n94# a_52_n94# 0.00519f
C7 a_108_n50# VSUBS 0.07479f
C8 a_n52_n50# VSUBS 0.09458f
C9 a_n196_n50# VSUBS 0.07479f
.ends

.subckt p_w2_l2_f7 a_n704_n244# a_n808_n200# a_304_n244# a_n1712_n244# a_1712_n200#
+ a_n1800_n200# a_n1208_n244# a_1208_n200# a_200_n200# a_1312_n244# a_808_n244# a_n200_n244#
+ a_n304_n200# w_n1886_n330# a_n1312_n200# a_704_n200# VSUBS
X0 a_n1312_n200# a_n1712_n244# a_n1800_n200# w_n1886_n330# pfet_03v3 ad=0.52p pd=2.52u as=0.88p ps=4.88u w=2u l=2u
X1 a_n304_n200# a_n704_n244# a_n808_n200# w_n1886_n330# pfet_03v3 ad=0.52p pd=2.52u as=0.52p ps=2.52u w=2u l=2u
X2 a_200_n200# a_n200_n244# a_n304_n200# w_n1886_n330# pfet_03v3 ad=0.52p pd=2.52u as=0.52p ps=2.52u w=2u l=2u
X3 a_1712_n200# a_1312_n244# a_1208_n200# w_n1886_n330# pfet_03v3 ad=0.88p pd=4.88u as=0.52p ps=2.52u w=2u l=2u
X4 a_1208_n200# a_808_n244# a_704_n200# w_n1886_n330# pfet_03v3 ad=0.52p pd=2.52u as=0.52p ps=2.52u w=2u l=2u
X5 a_n808_n200# a_n1208_n244# a_n1312_n200# w_n1886_n330# pfet_03v3 ad=0.52p pd=2.52u as=0.52p ps=2.52u w=2u l=2u
X6 a_704_n200# a_304_n244# a_200_n200# w_n1886_n330# pfet_03v3 ad=0.52p pd=2.52u as=0.52p ps=2.52u w=2u l=2u
C0 a_304_n244# a_808_n244# 0.00519f
C1 a_n1208_n244# a_n704_n244# 0.00519f
C2 a_1208_n200# a_704_n200# 0.02133f
C3 w_n1886_n330# a_n1208_n244# 0.21994f
C4 a_n1712_n244# a_n1208_n244# 0.00519f
C5 a_1712_n200# a_1312_n244# 0.0587f
C6 a_n1312_n200# a_n808_n200# 0.02133f
C7 a_1208_n200# a_1312_n244# 0.0587f
C8 a_n200_n244# a_200_n200# 0.0587f
C9 w_n1886_n330# a_704_n200# 0.09155f
C10 w_n1886_n330# a_200_n200# 0.09155f
C11 a_304_n244# a_704_n200# 0.0587f
C12 a_304_n244# a_200_n200# 0.0587f
C13 a_n304_n200# a_200_n200# 0.02133f
C14 a_1208_n200# a_1712_n200# 0.02133f
C15 a_n704_n244# a_n808_n200# 0.0587f
C16 w_n1886_n330# a_1312_n244# 0.2233f
C17 a_n1312_n200# a_n1800_n200# 0.02133f
C18 w_n1886_n330# a_n808_n200# 0.09155f
C19 w_n1886_n330# a_n1312_n200# 0.09155f
C20 w_n1886_n330# a_1712_n200# 0.0618f
C21 a_n304_n200# a_n808_n200# 0.02133f
C22 a_n1312_n200# a_n1712_n244# 0.0587f
C23 a_1208_n200# w_n1886_n330# 0.09155f
C24 a_808_n244# a_704_n200# 0.0587f
C25 w_n1886_n330# a_n1800_n200# 0.0618f
C26 a_n200_n244# a_n704_n244# 0.00519f
C27 w_n1886_n330# a_n704_n244# 0.21994f
C28 a_n1712_n244# a_n1800_n200# 0.0587f
C29 a_n200_n244# w_n1886_n330# 0.21994f
C30 a_1312_n244# a_808_n244# 0.00519f
C31 a_n304_n200# a_n704_n244# 0.0587f
C32 a_n200_n244# a_304_n244# 0.00519f
C33 w_n1886_n330# a_n1712_n244# 0.2233f
C34 a_n200_n244# a_n304_n200# 0.0587f
C35 w_n1886_n330# a_304_n244# 0.21994f
C36 w_n1886_n330# a_n304_n200# 0.09155f
C37 a_200_n200# a_704_n200# 0.02133f
C38 a_1208_n200# a_808_n244# 0.0587f
C39 a_n1208_n244# a_n808_n200# 0.0587f
C40 a_n1312_n200# a_n1208_n244# 0.0587f
C41 w_n1886_n330# a_808_n244# 0.21994f
C42 a_1712_n200# VSUBS 0.13364f
C43 a_1208_n200# VSUBS 0.12191f
C44 a_704_n200# VSUBS 0.11851f
C45 a_200_n200# VSUBS 0.11851f
C46 a_n304_n200# VSUBS 0.11851f
C47 a_n808_n200# VSUBS 0.11851f
C48 a_n1312_n200# VSUBS 0.12191f
C49 a_n1800_n200# VSUBS 0.13364f
C50 w_n1886_n330# VSUBS 7.46856f
.ends

.subckt p_w0p5_l0p5_f2 a_n52_n50# w_n326_n180# a_52_n94# a_152_n50# a_n240_n50# a_n152_n94#
+ VSUBS
X0 a_152_n50# a_52_n94# a_n52_n50# w_n326_n180# pfet_03v3 ad=0.22p pd=1.88u as=0.13p ps=1.02u w=0.5u l=0.5u
X1 a_n52_n50# a_n152_n94# a_n240_n50# w_n326_n180# pfet_03v3 ad=0.13p pd=1.02u as=0.22p ps=1.88u w=0.5u l=0.5u
C0 w_n326_n180# a_52_n94# 0.07657f
C1 a_52_n94# a_152_n50# 0.00625f
C2 a_n52_n50# w_n326_n180# 0.01225f
C3 a_n52_n50# a_152_n50# 0.01511f
C4 a_n52_n50# a_n240_n50# 0.01511f
C5 a_n152_n94# a_52_n94# 0.00519f
C6 w_n326_n180# a_152_n50# 0.01152f
C7 a_n52_n50# a_n152_n94# 0.00625f
C8 w_n326_n180# a_n240_n50# 0.01152f
C9 a_n52_n50# a_52_n94# 0.00625f
C10 w_n326_n180# a_n152_n94# 0.07657f
C11 a_n152_n94# a_n240_n50# 0.00625f
C12 a_152_n50# VSUBS 0.04588f
C13 a_n52_n50# VSUBS 0.04684f
C14 a_n240_n50# VSUBS 0.04588f
C15 w_n326_n180# VSUBS 0.70416f
.ends

.subckt idac_p b0 b1 b3 b4 out vcas vss m1_988_3464# m1_988_2804# vdd a_1378_4392#
+ a_3078_4392# b2 m1_988_888# a_2228_4392# m1_240_3480# a_3928_4392# dump a_528_4392#
+ a_1582_4392# a_4132_4392# a_2432_4392# m1_1500_4312# a_732_4392# vsp a_3282_4392#
+ g
XU4b vsp vsp m1_988_888# g g vdd m1_988_888# g m1_988_888# g m1_988_888# vsp vsp g
+ g g g vsp vss p_w2_l2_f8
XU3 vsp vsp m1_988_2804# g g vdd m1_988_2804# g m1_988_2804# g m1_988_2804# vsp vsp
+ g g g g vsp vss p_w2_l2_f8
XIP0 a_528_4392# vdd vdd a_732_4392# a_528_4392# b0 vss p_w1_l0p28_f2
XIP1 a_1378_4392# vdd vdd a_1582_4392# a_1378_4392# b1 vss p_w1_l0p28_f2
XIN0 vcas a_528_4392# a_528_4392# a_732_4392# b0 vss n_w0p5_l0p28_f2
XIP2 a_2228_4392# vdd vdd a_2432_4392# a_2228_4392# b2 vss p_w1_l0p28_f2
XIN1 vcas a_1378_4392# a_1378_4392# a_1582_4392# b1 vss n_w0p5_l0p28_f2
XIP3 a_3078_4392# vdd vdd a_3282_4392# a_3078_4392# b3 vss p_w1_l0p28_f2
XIN3 vcas a_3078_4392# a_3078_4392# a_3282_4392# b3 vss n_w0p5_l0p28_f2
XIN2 vcas a_2228_4392# a_2228_4392# a_2432_4392# b2 vss n_w0p5_l0p28_f2
XIP4 a_3928_4392# vdd vdd a_4132_4392# a_3928_4392# b4 vss p_w1_l0p28_f2
XIN4 vcas a_3928_4392# a_3928_4392# a_4132_4392# b4 vss n_w0p5_l0p28_f2
XU210 g vsp g g m1_240_3480# vsp g vsp vsp g g g m1_988_3464# vdd m1_988_3464# m1_1500_4312#
+ vss p_w2_l2_f7
XSW0 m1_240_3480# vdd a_732_4392# dump out a_528_4392# vss p_w0p5_l0p5_f2
XSW2 m1_988_3464# vdd a_2432_4392# dump out a_2228_4392# vss p_w0p5_l0p5_f2
XSW1 m1_1500_4312# vdd a_1582_4392# dump out a_1378_4392# vss p_w0p5_l0p5_f2
XSW3 m1_988_2804# vdd a_3282_4392# dump out a_3078_4392# vss p_w0p5_l0p5_f2
XSW4 m1_988_888# vdd a_4132_4392# dump out a_3928_4392# vss p_w0p5_l0p5_f2
XU4a vsp vsp m1_988_888# g g vdd m1_988_888# g m1_988_888# g m1_988_888# vsp vsp g
+ g g g vsp vss p_w2_l2_f8
C0 g a_1582_4392# 0.00236f
C1 a_2432_4392# m1_1500_4312# 0.0018f
C2 m1_1500_4312# b1 0
C3 m1_988_2804# m1_1500_4312# 0.11128f
C4 a_3078_4392# vcas 0.04594f
C5 m1_240_3480# b4 0
C6 g m1_1500_4312# 0.40807f
C7 a_4132_4392# b4 0.14194f
C8 a_3078_4392# dump 0.11788f
C9 m1_240_3480# a_3928_4392# 0.00167f
C10 b3 a_3078_4392# 0.27358f
C11 a_2228_4392# b2 0.1815f
C12 a_4132_4392# a_3928_4392# 0.1229f
C13 a_3282_4392# a_3078_4392# 0.17009f
C14 a_2432_4392# a_2228_4392# 0.18456f
C15 a_2228_4392# b1 0
C16 b4 m1_988_888# 0
C17 a_2228_4392# m1_988_2804# 0
C18 g a_2228_4392# 0.00218f
C19 m1_988_2804# m1_240_3480# 0.46309f
C20 a_1582_4392# m1_1500_4312# 0.0222f
C21 a_3928_4392# m1_988_888# 0.01013f
C22 g m1_240_3480# 1.39137f
C23 a_4132_4392# m1_988_2804# 0
C24 g a_4132_4392# 0
C25 b4 vcas 0.21592f
C26 m1_240_3480# a_528_4392# 0.0165f
C27 b4 dump 0
C28 a_3928_4392# vcas 0.02838f
C29 b3 b4 0.00351f
C30 b4 vsp 0
C31 a_3282_4392# b4 0
C32 m1_988_3464# b2 0
C33 m1_988_2804# m1_988_888# 0.20776f
C34 b2 vcas 0.29794f
C35 a_3928_4392# dump 0.02728f
C36 b3 a_3928_4392# 0.00713f
C37 g m1_988_888# 2.54331f
C38 a_2228_4392# a_1582_4392# 0.06282f
C39 a_2432_4392# m1_988_3464# 0.0039f
C40 a_2432_4392# vcas 0.00805f
C41 a_3928_4392# vsp 0
C42 a_3282_4392# a_3928_4392# 0.05112f
C43 dump b2 0.03612f
C44 b3 b2 0.09189f
C45 b1 vcas 0.16455f
C46 a_1378_4392# out 0.01469f
C47 m1_988_2804# m1_988_3464# 0.03356f
C48 a_2432_4392# dump 0.12878f
C49 a_3282_4392# b2 0
C50 b3 a_2432_4392# 0
C51 g m1_988_3464# 0.69646f
C52 a_2228_4392# m1_1500_4312# 0
C53 dump b1 0.03413f
C54 a_3282_4392# a_2432_4392# 0
C55 m1_988_2804# dump 0.02557f
C56 b3 m1_988_2804# 0.0024f
C57 m1_240_3480# m1_1500_4312# 0.0068f
C58 vdd out 1.27153f
C59 g dump 0.05176f
C60 b3 g 0
C61 m1_988_2804# vsp 0.24604f
C62 a_528_4392# vcas 0.05572f
C63 a_3282_4392# m1_988_2804# 0.00333f
C64 out b0 0.34956f
C65 g vsp 4.05384f
C66 a_1378_4392# vdd 0.49318f
C67 g a_3282_4392# 0.00215f
C68 a_528_4392# dump 0.01755f
C69 a_1378_4392# b0 0.01025f
C70 a_732_4392# b1 0.0505f
C71 a_528_4392# vsp 0
C72 a_1582_4392# vcas 0.01431f
C73 g a_732_4392# 0.00258f
C74 vdd b0 0.15292f
C75 m1_1500_4312# m1_988_888# 0
C76 a_1582_4392# dump 0.29887f
C77 a_732_4392# a_528_4392# 0.11371f
C78 a_4132_4392# m1_240_3480# 0
C79 m1_1500_4312# m1_988_3464# 0.46191f
C80 m1_1500_4312# dump 0.07029f
C81 m1_1500_4312# vsp 0.21814f
C82 a_732_4392# a_1582_4392# 0
C83 m1_240_3480# m1_988_888# 0.04999f
C84 a_4132_4392# m1_988_888# 0.03507f
C85 a_3078_4392# out 0.01364f
C86 a_2228_4392# m1_988_3464# 0.01383f
C87 a_2228_4392# vcas 0.02559f
C88 a_732_4392# m1_1500_4312# 0
C89 m1_240_3480# m1_988_3464# 0.00676f
C90 a_2228_4392# dump 0.22128f
C91 a_4132_4392# vcas 0.00535f
C92 b3 a_2228_4392# 0.00173f
C93 m1_240_3480# dump 0.01325f
C94 a_3078_4392# vdd 0.51762f
C95 a_3282_4392# a_2228_4392# 0
C96 a_4132_4392# dump 0.04726f
C97 m1_240_3480# vsp 0.29136f
C98 a_4132_4392# vsp 0
C99 m1_240_3480# a_732_4392# 0.00483f
C100 dump m1_988_888# 0.05324f
C101 m1_988_888# vsp 0.84877f
C102 a_3928_4392# out 0.0039f
C103 dump m1_988_3464# 0.03151f
C104 dump vcas 0.09162f
C105 b2 out 0
C106 b3 vcas 0.13187f
C107 b4 vdd 0.36351f
C108 m1_988_3464# vsp 0.09235f
C109 b2 a_1378_4392# 0.00157f
C110 a_2432_4392# out 0.03176f
C111 a_3282_4392# vcas 0.02198f
C112 b3 dump 0
C113 a_3928_4392# vdd 0.65032f
C114 b1 out 0.01042f
C115 dump vsp 0.00712f
C116 m1_988_2804# out 0.06468f
C117 a_3282_4392# dump 0.08877f
C118 b3 a_3282_4392# 0.02628f
C119 g out 0.69731f
C120 b2 vdd 0.206f
C121 b1 a_1378_4392# 0.276f
C122 a_732_4392# m1_988_3464# 0.00112f
C123 a_732_4392# vcas 0.07256f
C124 g a_1378_4392# 0.00206f
C125 a_2432_4392# vdd 0.43511f
C126 a_528_4392# out 0.16739f
C127 b1 vdd 0.16268f
C128 a_732_4392# dump 0.11406f
C129 m1_988_2804# vdd 0.36066f
C130 b1 b0 0.00796f
C131 g vdd 8.74367f
C132 a_528_4392# a_1378_4392# 0.00968f
C133 g b0 0
C134 a_528_4392# vdd 0.44354f
C135 a_1582_4392# out 0.01339f
C136 a_528_4392# b0 0.35816f
C137 a_1582_4392# a_1378_4392# 0.20351f
C138 a_3078_4392# b4 0.00186f
C139 m1_1500_4312# out 0.15763f
C140 a_1582_4392# vdd 0.31851f
C141 m1_1500_4312# a_1378_4392# 0.01574f
C142 a_1582_4392# b0 0
C143 a_3078_4392# a_3928_4392# 0.01001f
C144 a_3078_4392# b2 0.00848f
C145 m1_1500_4312# vdd 0.16576f
C146 a_2432_4392# a_3078_4392# 0.16749f
C147 a_2228_4392# out 0.01362f
C148 m1_988_2804# a_3078_4392# 0.00631f
C149 m1_240_3480# out 0.20558f
C150 a_2228_4392# a_1378_4392# 0.0019f
C151 g a_3078_4392# 0.00203f
C152 m1_240_3480# a_1378_4392# 0
C153 a_2228_4392# vdd 0.45461f
C154 a_3928_4392# b4 0.20796f
C155 m1_240_3480# vdd 1.54226f
C156 a_4132_4392# vdd 0.5253f
C157 b4 b2 0
C158 m1_240_3480# b0 0.0015f
C159 out m1_988_888# 0.03269f
C160 m1_988_3464# out 0.21869f
C161 out vcas 0.13451f
C162 vdd m1_988_888# 1.79894f
C163 m1_988_3464# a_1378_4392# 0.00387f
C164 a_1378_4392# vcas 0.02974f
C165 a_2432_4392# b2 0.25812f
C166 m1_988_2804# a_3928_4392# 0
C167 a_3078_4392# m1_1500_4312# 0
C168 dump out 0.14997f
C169 b3 out 0
C170 g a_3928_4392# 0.00474f
C171 b2 b1 0.00341f
C172 out vsp 0
C173 dump a_1378_4392# 0.12224f
C174 a_3282_4392# out 0.01304f
C175 m1_988_3464# vdd 0.12699f
C176 vdd vcas 0.12325f
C177 g b2 0
C178 a_2432_4392# m1_988_2804# 0
C179 b0 vcas 0.06096f
C180 g a_2432_4392# 0.00264f
C181 dump vdd 1.00627f
C182 b3 vdd 0.18861f
C183 g b1 0
C184 a_732_4392# out 0.05477f
C185 dump b0 0
C186 vdd vsp 1.94491f
C187 g m1_988_2804# 1.11336f
C188 a_3282_4392# vdd 0.51129f
C189 a_2228_4392# a_3078_4392# 0.00233f
C190 a_732_4392# a_1378_4392# 0.07957f
C191 a_528_4392# b1 0.00327f
C192 a_4132_4392# a_3078_4392# 0
C193 g a_528_4392# 0.0015f
C194 a_732_4392# vdd 0.42048f
C195 a_1582_4392# b2 0
C196 a_732_4392# b0 0.02072f
C197 a_1582_4392# b1 0.02085f
C198 m1_988_2804# a_1582_4392# 0
C199 m1_988_888# vss 1.02294f
C200 vsp vss 0.2353f
C201 g vss -2.45698f
C202 vdd vss 23.98689f
C203 a_4132_4392# vss 0.12907f
C204 a_3928_4392# vss 0.16119f
C205 a_3282_4392# vss 0.00178f
C206 a_3078_4392# vss 0.11146f
C207 m1_1500_4312# vss -0.02333f
C208 a_1582_4392# vss 0.0096f
C209 a_1378_4392# vss 0.1291f
C210 a_2432_4392# vss 0.06008f
C211 a_2228_4392# vss 0.1444f
C212 dump vss 0.07406f
C213 m1_240_3480# vss 0.32442f
C214 out vss 0.5531f
C215 a_732_4392# vss -0.00313f
C216 a_528_4392# vss 0.1515f
C217 m1_988_3464# vss -0.03952f
C218 b4 vss 0.44872f
C219 b3 vss 0.20878f
C220 b2 vss 0.37183f
C221 vcas vss 1.54593f
C222 b1 vss 0.2684f
C223 b0 vss 0.41869f
C224 m1_988_2804# vss -0.01016f
.ends

.subckt r_w4_l3p97 a_n400_n519# a_n400_397# VSUBS
X0 a_n400_397# a_n400_n519# VSUBS ppolyf_u_1k r_width=4u r_length=3.97u
C0 a_n400_397# a_n400_n519# 0.02123f
C1 a_n400_n519# VSUBS 0.80683f
C2 a_n400_397# VSUBS 0.80683f
.ends

.subckt n_w8_l0p5 a_50_n800# a_n50_n844# a_n138_n800# VSUBS
X0 a_50_n800# a_n50_n844# a_n138_n800# VSUBS nfet_03v3 ad=3.52p pd=16.88u as=3.52p ps=16.88u w=8u l=0.5u
C0 a_n50_n844# a_50_n800# 0.10385f
C1 a_50_n800# a_n138_n800# 0.25117f
C2 a_n50_n844# a_n138_n800# 0.10385f
C3 a_50_n800# VSUBS 0.38495f
C4 a_n138_n800# VSUBS 0.38495f
.ends

.subckt n_w4_l0p5 a_n138_n400# a_50_n400# a_n50_n444# VSUBS
X0 a_50_n400# a_n50_n444# a_n138_n400# VSUBS nfet_03v3 ad=1.76p pd=8.88u as=1.76p ps=8.88u w=4u l=0.5u
C0 a_n50_n444# a_50_n400# 0.05179f
C1 a_50_n400# a_n138_n400# 0.12527f
C2 a_n50_n444# a_n138_n400# 0.05179f
C3 a_50_n400# VSUBS 0.23105f
C4 a_n138_n400# VSUBS 0.23105f
.ends

.subckt n_w0p5_l0p28 a_n28_n94# a_n116_n50# a_28_n50# VSUBS
X0 a_28_n50# a_n28_n94# a_n116_n50# VSUBS nfet_03v3 ad=0.22p pd=1.88u as=0.22p ps=1.88u w=0.5u l=0.28u
C0 a_n28_n94# a_28_n50# 0.00377f
C1 a_28_n50# a_n116_n50# 0.02085f
C2 a_n28_n94# a_n116_n50# 0.00377f
C3 a_28_n50# VSUBS 0.07987f
C4 a_n116_n50# VSUBS 0.07987f
.ends

.subckt p_w1_l0p28 w_n202_n230# a_28_n100# a_n28_n144# a_n116_n100# VSUBS
X0 a_28_n100# a_n28_n144# a_n116_n100# w_n202_n230# pfet_03v3 ad=0.44p pd=2.88u as=0.44p ps=2.88u w=1u l=0.28u
C0 w_n202_n230# a_n116_n100# 0.01808f
C1 a_n116_n100# a_28_n100# 0.04256f
C2 w_n202_n230# a_28_n100# 0.01808f
C3 a_n116_n100# a_n28_n144# 0.00769f
C4 w_n202_n230# a_n28_n144# 0.05841f
C5 a_n28_n144# a_28_n100# 0.00769f
C6 a_28_n100# VSUBS 0.0597f
C7 a_n116_n100# VSUBS 0.0597f
C8 w_n202_n230# VSUBS 0.55752f
.ends

.subckt p_w2_l2_f4 a_n52_n200# a_452_n200# a_n452_n244# a_n556_n200# a_52_n244# a_956_n200#
+ a_n1044_n200# w_n1130_n330# a_n956_n244# a_556_n244# VSUBS
X0 a_452_n200# a_52_n244# a_n52_n200# w_n1130_n330# pfet_03v3 ad=0.52p pd=2.52u as=0.52p ps=2.52u w=2u l=2u
X1 a_956_n200# a_556_n244# a_452_n200# w_n1130_n330# pfet_03v3 ad=0.88p pd=4.88u as=0.52p ps=2.52u w=2u l=2u
X2 a_n556_n200# a_n956_n244# a_n1044_n200# w_n1130_n330# pfet_03v3 ad=0.52p pd=2.52u as=0.88p ps=4.88u w=2u l=2u
X3 a_n52_n200# a_n452_n244# a_n556_n200# w_n1130_n330# pfet_03v3 ad=0.52p pd=2.52u as=0.52p ps=2.52u w=2u l=2u
C0 w_n1130_n330# a_n452_n244# 0.21994f
C1 a_n452_n244# a_52_n244# 0.00519f
C2 a_956_n200# w_n1130_n330# 0.0618f
C3 w_n1130_n330# a_52_n244# 0.21994f
C4 a_n452_n244# a_n956_n244# 0.00519f
C5 a_n452_n244# a_n52_n200# 0.0587f
C6 w_n1130_n330# a_n956_n244# 0.2233f
C7 w_n1130_n330# a_n1044_n200# 0.0618f
C8 a_452_n200# w_n1130_n330# 0.09155f
C9 w_n1130_n330# a_n52_n200# 0.09155f
C10 w_n1130_n330# a_556_n244# 0.2233f
C11 a_452_n200# a_52_n244# 0.0587f
C12 a_956_n200# a_452_n200# 0.02133f
C13 a_52_n244# a_n52_n200# 0.0587f
C14 a_556_n244# a_52_n244# 0.00519f
C15 a_956_n200# a_556_n244# 0.0587f
C16 a_n556_n200# a_n452_n244# 0.0587f
C17 a_n956_n244# a_n1044_n200# 0.0587f
C18 a_n556_n200# w_n1130_n330# 0.09155f
C19 a_452_n200# a_n52_n200# 0.02133f
C20 a_452_n200# a_556_n244# 0.0587f
C21 a_n556_n200# a_n956_n244# 0.0587f
C22 a_n556_n200# a_n1044_n200# 0.02133f
C23 a_n556_n200# a_n52_n200# 0.02133f
C24 a_956_n200# VSUBS 0.13364f
C25 a_452_n200# VSUBS 0.12191f
C26 a_n52_n200# VSUBS 0.11851f
C27 a_n556_n200# VSUBS 0.12191f
C28 a_n1044_n200# VSUBS 0.13364f
C29 w_n1130_n330# VSUBS 4.4748f
.ends

.subckt p_w2_l0p5 a_50_n200# a_n50_n244# w_n224_n330# a_n138_n200# VSUBS
X0 a_50_n200# a_n50_n244# a_n138_n200# w_n224_n330# pfet_03v3 ad=0.88p pd=4.88u as=0.88p ps=4.88u w=2u l=0.5u
C0 a_n50_n244# a_50_n200# 0.02577f
C1 a_n138_n200# a_50_n200# 0.06232f
C2 a_n138_n200# a_n50_n244# 0.02577f
C3 w_n224_n330# a_50_n200# 0.03848f
C4 a_n50_n244# w_n224_n330# 0.07993f
C5 a_n138_n200# w_n224_n330# 0.03848f
C6 a_50_n200# VSUBS 0.0978f
C7 a_n138_n200# VSUBS 0.0978f
C8 w_n224_n330# VSUBS 0.88704f
.ends

.subckt n_w2_l0p5 a_50_n200# a_n50_n244# a_n138_n200# VSUBS
X0 a_50_n200# a_n50_n244# a_n138_n200# VSUBS nfet_03v3 ad=0.88p pd=4.88u as=0.88p ps=4.88u w=2u l=0.5u
C0 a_50_n200# a_n138_n200# 0.06232f
C1 a_n138_n200# a_n50_n244# 0.02577f
C2 a_50_n200# a_n50_n244# 0.02577f
C3 a_50_n200# VSUBS 0.1541f
C4 a_n138_n200# VSUBS 0.1541f
.ends

.subckt p_w4_l0p5 a_n138_n400# a_50_n400# a_n50_n444# w_n224_n530# VSUBS
X0 a_50_n400# a_n50_n444# a_n138_n400# w_n224_n530# pfet_03v3 ad=1.76p pd=8.88u as=1.76p ps=8.88u w=4u l=0.5u
C0 a_n50_n444# a_50_n400# 0.05179f
C1 a_n138_n400# a_50_n400# 0.12527f
C2 a_n138_n400# a_n50_n444# 0.05179f
C3 w_n224_n530# a_50_n400# 0.07442f
C4 a_n50_n444# w_n224_n530# 0.07993f
C5 a_n138_n400# w_n224_n530# 0.07442f
C6 a_50_n400# VSUBS 0.16249f
C7 a_n138_n400# VSUBS 0.16249f
C8 w_n224_n530# VSUBS 1.42464f
.ends

.subckt bias_master pad s0 s1 stim intref en in_n in_p iint en_b vbp_st ua0_stim a_1744_9182#
+ vss a_1764_11418# vdd a_1744_10100# a_2240_11218# a_420_700# a_736_7228# a_736_5516#
XOP vss a_1744_10100# a_736_7228# vss n_w2_l2
XRS pad a_420_700# vss r_w4_l3p97
XS1 a_736_5516# s1 a_420_700# vss n_w8_l0p5
XS0 a_420_700# a_736_7228# s0 vss n_w4_l0p5
XOS vss vbp_st a_736_7228# vss n_w2_l2
XIENn en vss en_b vss n_w0p5_l0p28
XIENp vdd en_b en vdd vss p_w1_l0p28
XQX a_1744_9182# vdd a_1744_9182# vdd a_1744_9182# a_736_7228# a_736_7228# vdd a_1744_9182#
+ a_1744_9182# vss p_w2_l2_f4
XDXa vss vss a_736_5516# a_736_5516# a_736_5516# a_736_5516# a_736_5516# a_736_5516#
+ a_736_5516# a_736_5516# vss vss a_736_5516# a_736_5516# a_736_5516# a_736_5516#
+ vss vss n_w2_l2_f8
XOX vss a_1744_9182# a_736_5516# vss n_w2_l2
XDXb vss vss a_736_5516# a_736_5516# a_736_5516# a_736_5516# a_736_5516# a_736_5516#
+ a_736_5516# a_736_5516# vss vss a_736_5516# a_736_5516# a_736_5516# a_736_5516#
+ vss vss n_w2_l2_f8
XISTn stim vss a_1764_11418# vss n_w0p5_l0p28
XISTp vdd a_1764_11418# stim vdd vss p_w1_l0p28
XSWI a_736_7228# a_2240_11218# vdd iint vss p_w2_l0p5
XPD vdd a_1744_10100# a_1744_10100# in_p a_1744_10100# vdd vdd vdd a_1744_10100# a_1744_10100#
+ vss p_w2_l2_f4
XSTN ua0_stim stim a_420_700# vss n_w2_l0p5
XSTP a_420_700# ua0_stim a_1764_11418# vdd vss p_w4_l0p5
XPDN a_736_7228# vss en_b vss n_w4_l0p5
XDa vss vss a_736_7228# a_736_7228# a_736_7228# a_736_7228# a_736_7228# a_736_7228#
+ a_736_7228# a_736_7228# vss vss a_736_7228# a_736_7228# a_736_7228# a_736_7228#
+ vss vss n_w2_l2_f8
XDb vss vss a_736_7228# a_736_7228# a_736_7228# a_736_7228# a_736_7228# a_736_7228#
+ a_736_7228# a_736_7228# vss vss a_736_7228# a_736_7228# a_736_7228# a_736_7228#
+ vss vss n_w2_l2_f8
XIIRn intref vss a_2240_11218# vss n_w0p5_l0p28
XIIRp vdd a_2240_11218# intref vdd vss p_w1_l0p28
XON vss in_n a_736_7228# vss n_w2_l2
D0 vss a_420_700# diode_nd2ps_03v3 pj=22u area=10p
D1 a_420_700# vdd diode_pd2nw_03v3 pj=22u area=10p
C0 a_1744_10100# a_2240_11218# 0.00646f
C1 en vdd 1.40435f
C2 en a_1744_9182# 0
C3 a_2240_11218# intref 0.51277f
C4 pad intref 0.04537f
C5 a_1744_10100# a_736_7228# 0.21495f
C6 a_1744_10100# vbp_st 0.06941f
C7 ua0_stim in_n 0.13986f
C8 a_736_7228# intref 1.05564f
C9 a_1744_10100# a_420_700# 0
C10 en a_736_5516# 0.1206f
C11 vbp_st intref 0.10375f
C12 stim in_n 0
C13 a_1764_11418# en_b 0.04298f
C14 a_420_700# intref 0.08048f
C15 a_1744_10100# vdd 2.14231f
C16 a_1744_10100# a_1744_9182# 0.21634f
C17 vdd intref 1.1637f
C18 a_2240_11218# en_b 0.55285f
C19 a_1744_9182# intref 0.06003f
C20 pad en_b 0.00118f
C21 ua0_stim a_1764_11418# 0.39761f
C22 a_736_7228# en_b 0.01852f
C23 vbp_st en_b 0.22396f
C24 a_1764_11418# stim 0.89967f
C25 pad s0 0.04859f
C26 in_p en 0.1023f
C27 a_736_5516# intref 0.42454f
C28 a_420_700# en_b 0.00238f
C29 ua0_stim a_2240_11218# 0.01891f
C30 stim a_2240_11218# 0.02672f
C31 vdd en_b 1.53555f
C32 pad stim 0.03728f
C33 s0 a_736_7228# 0.08339f
C34 pad s1 0.04303f
C35 ua0_stim a_736_7228# 0.65944f
C36 a_1764_11418# iint 0.04831f
C37 ua0_stim vbp_st 0.28759f
C38 s0 a_420_700# 0.23128f
C39 stim a_736_7228# 0.67831f
C40 ua0_stim a_420_700# 0.27553f
C41 stim vbp_st 0.03538f
C42 in_p a_1744_10100# 0.1228f
C43 a_2240_11218# iint 0.04705f
C44 s1 a_736_7228# 0.26174f
C45 a_736_5516# en_b 0.10641f
C46 stim a_420_700# 0.39449f
C47 ua0_stim vdd 0.7438f
C48 ua0_stim a_1744_9182# 0
C49 s1 a_420_700# 0.34537f
C50 vdd stim 0.43645f
C51 a_1744_9182# stim 0.09507f
C52 a_736_7228# iint 0.07137f
C53 s1 vdd 0
C54 vbp_st iint 0.03426f
C55 s0 a_736_5516# 0.00164f
C56 ua0_stim a_736_5516# 0.76166f
C57 a_1744_10100# en 0
C58 vdd iint 0.20167f
C59 stim a_736_5516# 0.46322f
C60 en intref 0.18747f
C61 s1 a_736_5516# 0.04485f
C62 in_p ua0_stim 0.13299f
C63 a_1744_10100# intref 0.00123f
C64 en en_b 0.16284f
C65 in_p stim 0
C66 a_1764_11418# in_n 0
C67 s0 en 0.08622f
C68 en ua0_stim 0.04932f
C69 in_p iint 0
C70 a_1744_10100# en_b 0
C71 en stim 0.16867f
C72 in_n a_736_7228# 0.22106f
C73 in_n vbp_st 0
C74 en_b intref 0.13348f
C75 en s1 0.05296f
C76 in_n a_420_700# 0.06513f
C77 vdd in_n 0.93129f
C78 a_1744_9182# in_n 0.05554f
C79 a_1764_11418# a_2240_11218# 0.0155f
C80 en iint 0.04364f
C81 a_1744_10100# ua0_stim 0.0495f
C82 s0 intref 0
C83 a_1744_10100# stim 0.5686f
C84 ua0_stim intref 0.38842f
C85 a_1764_11418# a_736_7228# 0.58069f
C86 a_1764_11418# vbp_st 0.24107f
C87 stim intref 0.10135f
C88 a_1764_11418# a_420_700# 0.01871f
C89 s1 intref 0.00169f
C90 a_736_7228# a_2240_11218# 0.1092f
C91 pad a_736_7228# 0.00246f
C92 a_2240_11218# vbp_st 0.09119f
C93 a_1764_11418# vdd 0.9203f
C94 a_1744_10100# iint 0.0038f
C95 a_1744_9182# a_1764_11418# 0.08433f
C96 a_2240_11218# a_420_700# 0
C97 pad a_420_700# 0.54069f
C98 s0 en_b 0
C99 ua0_stim en_b 0.11556f
C100 vdd a_2240_11218# 1.56335f
C101 pad vdd 0.30131f
C102 a_1744_9182# a_2240_11218# 0.04423f
C103 a_736_7228# vbp_st 0.19283f
C104 stim en_b 0.09516f
C105 a_736_7228# a_420_700# 0.60616f
C106 vbp_st a_420_700# 0.00221f
C107 a_1764_11418# a_736_5516# 0.29581f
C108 s1 en_b 0.04984f
C109 vdd a_736_7228# 1.34623f
C110 a_1744_9182# a_736_7228# 0.40049f
C111 in_p in_n 0.00893f
C112 a_1744_9182# vbp_st 0.27778f
C113 vdd vbp_st 1.24211f
C114 s0 ua0_stim 0
C115 a_736_5516# a_2240_11218# 0.20875f
C116 vdd a_420_700# 1.39245f
C117 a_1744_9182# a_420_700# 0
C118 iint en_b 0.00566f
C119 s0 stim 0
C120 ua0_stim stim 0.17275f
C121 a_1744_9182# vdd 1.89441f
C122 s0 s1 0.37932f
C123 ua0_stim s1 0
C124 a_736_5516# a_736_7228# 0.94834f
C125 a_736_5516# vbp_st 0.01681f
C126 en in_n 0.22085f
C127 s1 stim 0.05023f
C128 a_736_5516# a_420_700# 0.22588f
C129 in_p a_1764_11418# 0.10845f
C130 ua0_stim iint 0.22215f
C131 vdd a_736_5516# 0.03946f
C132 a_1744_9182# a_736_5516# 0.06682f
C133 stim iint 0
C134 in_p a_2240_11218# 0
C135 a_1744_10100# in_n 0
C136 in_p a_736_7228# 0.13123f
C137 en a_1764_11418# 0.00964f
C138 in_p vbp_st 0.01109f
C139 in_p a_420_700# 0.14384f
C140 en a_2240_11218# 0.0689f
C141 pad en 0.07917f
C142 in_p vdd 0.3992f
C143 in_p a_1744_9182# 0.0074f
C144 en a_736_7228# 0.06595f
C145 en vbp_st 0.4389f
C146 a_1744_10100# a_1764_11418# 0.20361f
C147 en a_420_700# 1.35379f
C148 a_1764_11418# intref 0.13911f
C149 in_n vss 0.4171f
C150 a_2240_11218# vss 1.12079f
C151 intref vss 1.56078f
C152 a_736_7228# vss 7.21627f
C153 en_b vss 2.84339f
C154 ua0_stim vss 1.3904f
C155 stim vss 1.68124f
C156 in_p vss 0.10852f
C157 iint vss -0.02046f
C158 a_1764_11418# vss 0.23987f
C159 a_736_5516# vss 5.14983f
C160 a_1744_9182# vss -0.31499f
C161 vdd vss 48.57603f
C162 en vss 2.99933f
C163 vbp_st vss 0.13312f
C164 a_420_700# vss 2.09001f
C165 s0 vss 0.69974f
C166 s1 vss 0.67954f
C167 pad vss 1.41208f
C168 a_1744_10100# vss -0.2385f
.ends

.subckt n_w2_l2_f7 a_n704_n244# a_n808_n200# a_304_n244# a_n1712_n244# a_1712_n200#
+ a_n1800_n200# a_n1208_n244# a_1208_n200# a_200_n200# a_1312_n244# a_808_n244# a_n200_n244#
+ a_n304_n200# a_n1312_n200# a_704_n200# VSUBS
X0 a_n304_n200# a_n704_n244# a_n808_n200# VSUBS nfet_03v3 ad=0.52p pd=2.52u as=0.52p ps=2.52u w=2u l=2u
X1 a_200_n200# a_n200_n244# a_n304_n200# VSUBS nfet_03v3 ad=0.52p pd=2.52u as=0.52p ps=2.52u w=2u l=2u
X2 a_1712_n200# a_1312_n244# a_1208_n200# VSUBS nfet_03v3 ad=0.88p pd=4.88u as=0.52p ps=2.52u w=2u l=2u
X3 a_1208_n200# a_808_n244# a_704_n200# VSUBS nfet_03v3 ad=0.52p pd=2.52u as=0.52p ps=2.52u w=2u l=2u
X4 a_704_n200# a_304_n244# a_200_n200# VSUBS nfet_03v3 ad=0.52p pd=2.52u as=0.52p ps=2.52u w=2u l=2u
X5 a_n1312_n200# a_n1712_n244# a_n1800_n200# VSUBS nfet_03v3 ad=0.52p pd=2.52u as=0.88p ps=4.88u w=2u l=2u
X6 a_n808_n200# a_n1208_n244# a_n1312_n200# VSUBS nfet_03v3 ad=0.52p pd=2.52u as=0.52p ps=2.52u w=2u l=2u
C0 a_n704_n244# a_n1208_n244# 0.00519f
C1 a_1208_n200# a_704_n200# 0.02133f
C2 a_n1312_n200# a_n808_n200# 0.02133f
C3 a_n1712_n244# a_n1208_n244# 0.00519f
C4 a_304_n244# a_200_n200# 0.0587f
C5 a_n304_n200# a_n808_n200# 0.02133f
C6 a_n200_n244# a_n704_n244# 0.00519f
C7 a_1208_n200# a_1712_n200# 0.02133f
C8 a_808_n244# a_1312_n244# 0.00519f
C9 a_n304_n200# a_200_n200# 0.02133f
C10 a_n1312_n200# a_n1800_n200# 0.02133f
C11 a_808_n244# a_704_n200# 0.0587f
C12 a_304_n244# a_704_n200# 0.0587f
C13 a_n704_n244# a_n808_n200# 0.0587f
C14 a_n1312_n200# a_n1712_n244# 0.0587f
C15 a_1208_n200# a_808_n244# 0.0587f
C16 a_n304_n200# a_n704_n244# 0.0587f
C17 a_704_n200# a_200_n200# 0.02133f
C18 a_n1312_n200# a_n1208_n244# 0.0587f
C19 a_n808_n200# a_n1208_n244# 0.0587f
C20 a_304_n244# a_n200_n244# 0.00519f
C21 a_n1712_n244# a_n1800_n200# 0.0587f
C22 a_304_n244# a_808_n244# 0.00519f
C23 a_n304_n200# a_n200_n244# 0.0587f
C24 a_1208_n200# a_1312_n244# 0.0587f
C25 a_n200_n244# a_200_n200# 0.0587f
C26 a_1312_n244# a_1712_n200# 0.0587f
C27 a_1712_n200# VSUBS 0.26162f
C28 a_1208_n200# VSUBS 0.34773f
C29 a_704_n200# VSUBS 0.34265f
C30 a_200_n200# VSUBS 0.34265f
C31 a_n304_n200# VSUBS 0.34265f
C32 a_n808_n200# VSUBS 0.34265f
C33 a_n1312_n200# VSUBS 0.34773f
C34 a_n1800_n200# VSUBS 0.26162f
.ends

.subckt n_w0p5_l0p5_f2 a_n52_n50# a_52_n94# a_152_n50# a_n240_n50# a_n152_n94# VSUBS
X0 a_152_n50# a_52_n94# a_n52_n50# VSUBS nfet_03v3 ad=0.22p pd=1.88u as=0.13p ps=1.02u w=0.5u l=0.5u
X1 a_n52_n50# a_n152_n94# a_n240_n50# VSUBS nfet_03v3 ad=0.13p pd=1.02u as=0.22p ps=1.88u w=0.5u l=0.5u
C0 a_n52_n50# a_n152_n94# 0.00625f
C1 a_52_n94# a_n152_n94# 0.00519f
C2 a_52_n94# a_n52_n50# 0.00625f
C3 a_n52_n50# a_152_n50# 0.01511f
C4 a_52_n94# a_152_n50# 0.00625f
C5 a_n240_n50# a_n152_n94# 0.00625f
C6 a_n240_n50# a_n52_n50# 0.01511f
C7 a_152_n50# VSUBS 0.09131f
C8 a_n52_n50# VSUBS 0.12761f
C9 a_n240_n50# VSUBS 0.09131f
.ends

.subckt idac_n b0 b1 b2 b3 b4 out vcas vdd m1_988_3304# a_1378_4170# a_528_4170# a_2228_4170#
+ a_3928_4170# m1_988_2644# a_2432_4170# g a_3282_4170# a_1582_4170# m1_988_888# m1_260_2080#
+ dump m1_1500_3762# a_4132_4170# vsn vss a_3078_4170# a_732_4170#
XU4b vsn vsn m1_988_888# g g m1_988_888# g m1_988_888# g m1_988_888# vsn vsn g g g
+ g vsn vss n_w2_l2_f8
XU3 vsn vsn m1_988_2644# g g m1_988_2644# g m1_988_2644# g m1_988_2644# vsn vsn g
+ g g g vsn vss n_w2_l2_f8
XIP0 a_732_4170# vcas vcas a_528_4170# a_732_4170# b0 vss p_w1_l0p28_f2
XIP1 a_1582_4170# vcas vcas a_1378_4170# a_1582_4170# b1 vss p_w1_l0p28_f2
XIP2 a_2432_4170# vcas vcas a_2228_4170# a_2432_4170# b2 vss p_w1_l0p28_f2
XIN0 vss a_732_4170# a_732_4170# a_528_4170# b0 vss n_w0p5_l0p28_f2
XIP3 a_3282_4170# vcas vcas a_3078_4170# a_3282_4170# b3 vss p_w1_l0p28_f2
XIN1 vss a_1582_4170# a_1582_4170# a_1378_4170# b1 vss n_w0p5_l0p28_f2
XIP4 a_4132_4170# vcas vcas a_3928_4170# a_4132_4170# b4 vss p_w1_l0p28_f2
XIN3 vss a_3282_4170# a_3282_4170# a_3078_4170# b3 vss n_w0p5_l0p28_f2
XIN2 vss a_2432_4170# a_2432_4170# a_2228_4170# b2 vss n_w0p5_l0p28_f2
XIN4 vss a_4132_4170# a_4132_4170# a_3928_4170# b4 vss n_w0p5_l0p28_f2
XU210 g vsn g g m1_260_2080# vsn g vsn vsn g g g m1_988_3304# m1_988_3304# m1_1500_3762#
+ vss n_w2_l2_f7
XSW0 m1_260_2080# a_732_4170# dump out a_528_4170# vss n_w0p5_l0p5_f2
XSW2 m1_988_3304# a_2432_4170# dump out a_2228_4170# vss n_w0p5_l0p5_f2
XSW1 m1_1500_3762# a_1582_4170# dump out a_1378_4170# vss n_w0p5_l0p5_f2
XSW3 m1_988_2644# a_3282_4170# dump out a_3078_4170# vss n_w0p5_l0p5_f2
XSW4 m1_988_888# a_4132_4170# dump out a_3928_4170# vss n_w0p5_l0p5_f2
XU4a vsn vsn m1_988_888# g g m1_988_888# g m1_988_888# g m1_988_888# vsn vsn g g g
+ g vsn vss n_w2_l2_f8
C0 m1_988_2644# m1_988_3304# 0.00259f
C1 out dump 0.4373f
C2 vcas b4 0.34586f
C3 out a_2432_4170# 0.02507f
C4 m1_988_3304# a_1582_4170# 0
C5 m1_988_3304# m1_1500_3762# 0.11176f
C6 vcas b3 0.48197f
C7 b0 a_1582_4170# 0.00914f
C8 b0 a_732_4170# 0.2484f
C9 m1_988_3304# g 0.39585f
C10 b3 b4 0.0097f
C11 vdd vcas 0.00626f
C12 vsn b4 0
C13 m1_988_888# b4 0
C14 m1_988_3304# b2 0
C15 b0 a_528_4170# 0.02165f
C16 b0 g 0
C17 a_1582_4170# vcas 0.27006f
C18 vdd b4 0.0055f
C19 a_3078_4170# vcas 0.73187f
C20 a_4132_4170# out 0.00472f
C21 m1_988_3304# a_1378_4170# 0
C22 a_2228_4170# a_3282_4170# 0.01488f
C23 b0 m1_260_2080# 0
C24 m1_1500_3762# vcas 0.00146f
C25 a_732_4170# vcas 0.26007f
C26 vsn m1_988_888# 0.75155f
C27 m1_988_3304# dump 0.34162f
C28 m1_988_2644# b3 0
C29 vdd b3 0.00415f
C30 a_3078_4170# b4 0.14552f
C31 b0 b1 0.02437f
C32 a_528_4170# vcas 0.09144f
C33 m1_988_2644# m1_988_888# 0.44143f
C34 m1_988_2644# vsn 0.25449f
C35 g vcas 0.00531f
C36 m1_988_3304# a_2432_4170# 0.00578f
C37 vcas a_3928_4170# 0.08407f
C38 out a_3282_4170# 0.02704f
C39 vcas b2 0.3849f
C40 a_3078_4170# b3 0.09671f
C41 m1_988_888# a_3078_4170# 0.08147f
C42 vsn a_3078_4170# 0.01097f
C43 m1_1500_3762# b3 0
C44 g b4 0
C45 a_3928_4170# b4 0.02632f
C46 a_1378_4170# vcas 0.15514f
C47 vcas b1 0.89272f
C48 vsn m1_1500_3762# 0.02504f
C49 b4 m1_260_2080# 0
C50 m1_988_2644# a_3078_4170# 0.08059f
C51 a_3078_4170# vdd 0
C52 dump vcas 1.35686f
C53 m1_988_2644# m1_1500_3762# 0.09258f
C54 g b3 0
C55 a_528_4170# vsn 0
C56 a_3928_4170# b3 0
C57 m1_988_888# g 2.42837f
C58 vsn g 4.12488f
C59 b3 b2 0.01263f
C60 m1_988_888# a_3928_4170# 0.0651f
C61 vsn a_3928_4170# 0
C62 a_2432_4170# vcas 0.31499f
C63 m1_988_888# m1_260_2080# 0.55941f
C64 vsn m1_260_2080# 0.30933f
C65 a_732_4170# a_1582_4170# 0.00288f
C66 m1_1500_3762# a_1582_4170# 0.02077f
C67 dump b4 0.05108f
C68 m1_988_2644# g 1.19317f
C69 m1_1500_3762# a_3078_4170# 0.00387f
C70 m1_988_2644# a_3928_4170# 0
C71 a_1378_4170# b3 0.00218f
C72 m1_988_2644# m1_260_2080# 0.24844f
C73 a_2228_4170# out 0.02717f
C74 a_528_4170# a_1582_4170# 0.0056f
C75 g a_1582_4170# 0.0036f
C76 dump b3 0.14989f
C77 a_3078_4170# g 0.13262f
C78 a_528_4170# a_732_4170# 0.1853f
C79 a_3078_4170# a_3928_4170# 0.27629f
C80 m1_988_888# dump 0.1173f
C81 vsn dump 0.45688f
C82 a_3078_4170# m1_260_2080# 0.20065f
C83 a_1582_4170# b2 0.00172f
C84 g a_732_4170# 0.00276f
C85 m1_1500_3762# g 0.51943f
C86 a_3078_4170# b2 0
C87 a_2432_4170# b3 0.00238f
C88 m1_1500_3762# m1_260_2080# 0
C89 a_732_4170# m1_260_2080# 0.00987f
C90 m1_988_2644# dump 0.07098f
C91 m1_1500_3762# b2 0
C92 vdd dump 0.01049f
C93 a_1378_4170# a_1582_4170# 0.12904f
C94 a_1582_4170# b1 0.27926f
C95 a_528_4170# g 0.00771f
C96 a_1378_4170# a_3078_4170# 0
C97 a_4132_4170# vcas 0.27886f
C98 a_528_4170# m1_260_2080# 0.05346f
C99 a_1378_4170# a_732_4170# 0.00239f
C100 m1_1500_3762# a_1378_4170# 0.00998f
C101 a_732_4170# b1 0.00568f
C102 m1_1500_3762# b1 0
C103 g a_3928_4170# 0.00223f
C104 g m1_260_2080# 1.12515f
C105 dump a_1582_4170# 0.01837f
C106 g b2 0
C107 a_3928_4170# m1_260_2080# 0
C108 a_3078_4170# dump 0.52465f
C109 m1_1500_3762# dump 0.09882f
C110 dump a_732_4170# 0.02697f
C111 a_528_4170# a_1378_4170# 0.00677f
C112 a_528_4170# b1 0.04801f
C113 a_2432_4170# a_1582_4170# 0.01867f
C114 a_4132_4170# b4 0.25674f
C115 a_1378_4170# g 0.00374f
C116 a_2432_4170# a_3078_4170# 0.0066f
C117 g b1 0
C118 a_2432_4170# m1_1500_3762# 0
C119 a_528_4170# dump 0.07429f
C120 a_1378_4170# b2 0.00837f
C121 b1 b2 0.0021f
C122 a_3282_4170# vcas 0.29204f
C123 dump g 0.62788f
C124 dump a_3928_4170# 0.03528f
C125 a_4132_4170# b3 0.00478f
C126 a_2228_4170# m1_988_3304# 0.06446f
C127 dump m1_260_2080# 0.05465f
C128 a_1378_4170# b1 0.03605f
C129 dump b2 0.07018f
C130 a_4132_4170# m1_988_888# 0.02826f
C131 a_4132_4170# vsn 0
C132 a_2432_4170# g 0.00286f
C133 a_3282_4170# b4 0.0031f
C134 a_2432_4170# b2 0.24144f
C135 a_1378_4170# dump 0.07506f
C136 dump b1 0.0143f
C137 a_2432_4170# a_1378_4170# 0.06027f
C138 a_2432_4170# b1 0
C139 a_3282_4170# b3 0.14389f
C140 out m1_988_3304# 0.25145f
C141 a_4132_4170# a_3078_4170# 0.06615f
C142 a_2432_4170# dump 0.04021f
C143 m1_988_2644# a_3282_4170# 0.00988f
C144 a_2228_4170# vcas 0.08842f
C145 a_3282_4170# vdd 0
C146 b0 out 0.01654f
C147 a_4132_4170# g 0.00123f
C148 a_4132_4170# a_3928_4170# 0.12544f
C149 a_3282_4170# a_1582_4170# 0
C150 a_4132_4170# m1_260_2080# 0
C151 a_3282_4170# a_3078_4170# 0.27925f
C152 out vcas 0.27597f
C153 a_2228_4170# b3 0.00226f
C154 vsn a_2228_4170# 0
C155 a_3282_4170# g 0.00339f
C156 a_3282_4170# a_3928_4170# 0.0068f
C157 a_4132_4170# dump 0.04826f
C158 a_3282_4170# b2 0
C159 a_3282_4170# a_1378_4170# 0
C160 a_3282_4170# b1 0
C161 out b3 0
C162 a_2228_4170# a_1582_4170# 0.00492f
C163 out m1_988_888# 0.00355f
C164 a_2228_4170# a_3078_4170# 0.00113f
C165 vsn out 0.01026f
C166 a_3282_4170# dump 0.04973f
C167 a_2228_4170# m1_1500_3762# 0.00184f
C168 m1_988_2644# out 0.06032f
C169 a_2432_4170# a_3282_4170# 0.01327f
C170 a_2228_4170# g 0.00553f
C171 out a_1582_4170# 0.17521f
C172 out a_3078_4170# 0.08761f
C173 a_2228_4170# b2 0.04686f
C174 out m1_1500_3762# 0.38998f
C175 out a_732_4170# 0.01797f
C176 a_2228_4170# a_1378_4170# 0.00673f
C177 a_2228_4170# b1 0
C178 a_528_4170# out 0.25397f
C179 b0 vcas 0.36918f
C180 out g 0.30711f
C181 out a_3928_4170# 0.00435f
C182 a_2228_4170# dump 0.15915f
C183 out m1_260_2080# 0.07116f
C184 out b2 0.01329f
C185 a_2228_4170# a_2432_4170# 0.14213f
C186 a_4132_4170# a_3282_4170# 0.128f
C187 out a_1378_4170# 0.04703f
C188 out b1 0.39281f
C189 vsn m1_988_3304# 0.0562f
C190 vdd vss 0.03123f
C191 m1_988_888# vss 1.06123f
C192 vsn vss 1.84736f
C193 g vss 5.72892f
C194 a_4132_4170# vss 0.41879f
C195 a_3928_4170# vss 0.33427f
C196 a_3282_4170# vss 0.41623f
C197 a_3078_4170# vss 0.59741f
C198 m1_1500_3762# vss 0.27797f
C199 a_1582_4170# vss 0.4013f
C200 a_1378_4170# vss 0.34562f
C201 a_2432_4170# vss 0.40441f
C202 a_2228_4170# vss 0.17252f
C203 dump vss 1.82894f
C204 m1_260_2080# vss 2.17739f
C205 out vss 1.05553f
C206 a_732_4170# vss 0.39599f
C207 a_528_4170# vss 0.28429f
C208 m1_988_3304# vss 0.09089f
C209 b4 vss 0.21281f
C210 b2 vss 0.19167f
C211 b3 vss 0.18821f
C212 b1 vss 0.38616f
C213 b0 vss 0.34676f
C214 vcas vss 10.83517f
C215 m1_988_2644# vss 0.29815f
.ends

.subckt r_w1_l7p765 a_n100_n899# a_n100_777# VSUBS
X0 a_n100_777# a_n100_n899# VSUBS ppolyf_u_1k r_width=1u r_length=7.77u
C0 a_n100_n899# VSUBS 0.27003f
C1 a_n100_777# VSUBS 0.27003f
.ends

.subckt r_w2_l1p97 a_n200_n319# a_n200_197# VSUBS
X0 a_n200_197# a_n200_n319# VSUBS ppolyf_u_1k r_width=2u r_length=1.97u
C0 a_n200_n319# a_n200_197# 0.02096f
C1 a_n200_n319# VSUBS 0.42971f
C2 a_n200_197# VSUBS 0.42971f
.ends

.subckt r_w1_l1p94 a_n100_n316# a_n100_194# VSUBS
X0 a_n100_194# a_n100_n316# VSUBS ppolyf_u_1k r_width=1u r_length=1.94u
C0 a_n100_n316# a_n100_194# 0.01052f
C1 a_n100_n316# VSUBS 0.2541f
C2 a_n100_194# VSUBS 0.2541f
.ends

.subckt r_w1_l3p88 a_n100_n510# a_n100_388# VSUBS
X0 a_n100_388# a_n100_n510# VSUBS ppolyf_u_1k r_width=1u r_length=3.88u
C0 a_n100_n510# a_n100_388# 0.00535f
C1 a_n100_n510# VSUBS 0.26053f
C2 a_n100_388# VSUBS 0.26053f
.ends

.subckt n_w0p5_l1 a_100_n50# a_n100_n94# a_n188_n50# VSUBS
X0 a_100_n50# a_n100_n94# a_n188_n50# VSUBS nfet_03v3 ad=0.22p pd=1.88u as=0.22p ps=1.88u w=0.5u l=1u
C0 a_100_n50# a_n100_n94# 0.01026f
C1 a_100_n50# a_n188_n50# 0.00935f
C2 a_n100_n94# a_n188_n50# 0.01026f
C3 a_100_n50# VSUBS 0.13392f
C4 a_n188_n50# VSUBS 0.13392f
.ends

.subckt p_w1_l1 a_n188_n100# a_100_n100# a_n100_n144# w_n274_n230# VSUBS
X0 a_100_n100# a_n100_n144# a_n188_n100# w_n274_n230# pfet_03v3 ad=0.44p pd=2.88u as=0.44p ps=2.88u w=1u l=1u
C0 a_n100_n144# a_100_n100# 0.02094f
C1 a_n188_n100# w_n274_n230# 0.02517f
C2 a_n188_n100# a_n100_n144# 0.02094f
C3 w_n274_n230# a_n100_n144# 0.12884f
C4 a_n188_n100# a_100_n100# 0.0191f
C5 w_n274_n230# a_100_n100# 0.02517f
C6 a_100_n100# VSUBS 0.07854f
C7 a_n188_n100# VSUBS 0.07854f
C8 w_n274_n230# VSUBS 0.75624f
.ends

.subckt r_w1_l11p645 a_n100_1165# a_n100_n1287# VSUBS
X0 a_n100_1165# a_n100_n1287# VSUBS ppolyf_u_1k r_width=1u r_length=11.65u
C0 a_n100_n1287# VSUBS 0.27003f
C1 a_n100_1165# VSUBS 0.27003f
.ends

.subckt n_w4_l0p28_f2 a_n52_n400# a_52_n444# a_108_n400# a_n108_n444# a_n196_n400#
+ VSUBS
X0 a_108_n400# a_52_n444# a_n52_n400# VSUBS nfet_03v3 ad=1.76p pd=8.88u as=1.04p ps=4.52u w=4u l=0.28u
X1 a_n52_n400# a_n108_n444# a_n196_n400# VSUBS nfet_03v3 ad=1.04p pd=4.52u as=1.76p ps=8.88u w=4u l=0.28u
C0 a_108_n400# a_52_n444# 0.03125f
C1 a_52_n444# a_n52_n400# 0.03125f
C2 a_108_n400# a_n52_n400# 0.17284f
C3 a_n196_n400# a_n108_n444# 0.03125f
C4 a_n108_n444# a_52_n444# 0.00519f
C5 a_n196_n400# a_n52_n400# 0.17284f
C6 a_n108_n444# a_n52_n400# 0.03125f
C7 a_108_n400# VSUBS 0.20946f
C8 a_n52_n400# VSUBS 0.09458f
C9 a_n196_n400# VSUBS 0.20946f
.ends

.subckt vdacr_el b0 b1 b2 b3 b4 vdd out m1_3662_4048# m1_2742_3250# a_2224_3416# a_3408_3416#
+ m1_822_4048# a_1632_3416# m1_3310_2880# m1_1262_4048# a_1040_3416# vss a_2816_3416#
+ m1_617_3840# m1_2242_4966# m1_956_3000# m1_382_4048#
XXRS4_0 m1_3662_4048# m1_3310_2880# vss r_w1_l7p765
XXRS4_1 vss m1_3662_4048# vss r_w1_l7p765
XXRS0 m1_617_3840# m1_956_3000# vss r_w2_l1p97
XXRS1 m1_2242_4966# m1_617_3840# vss r_w1_l1p94
XXRS3 m1_3310_2880# m1_2742_3250# vss r_w1_l7p765
XXRS2 m1_2742_3250# m1_2242_4966# vss r_w1_l3p88
XIB4n a_3408_3416# b4 vss vss n_w0p5_l1
XIB3n a_2816_3416# b3 vss vss n_w0p5_l1
XIB4p vdd a_3408_3416# b4 vdd vss p_w1_l1
XIB2n a_2224_3416# b2 vss vss n_w0p5_l1
XIB3p vdd a_2816_3416# b3 vdd vss p_w1_l1
XIB2p vdd a_2224_3416# b2 vdd vss p_w1_l1
XIB1n a_1632_3416# b1 vss vss n_w0p5_l1
XIB0n a_1040_3416# b0 vss vss n_w0p5_l1
XIB1p vdd a_1632_3416# b1 vdd vss p_w1_l1
XIB0p vdd a_1040_3416# b0 vdd vss p_w1_l1
XXRB0 out m1_382_4048# vss r_w1_l11p645
XSW0 m1_617_3840# a_1040_3416# m1_956_3000# a_1040_3416# m1_956_3000# vss n_w4_l0p28_f2
XXRB1 m1_382_4048# m1_822_4048# vss r_w1_l11p645
XSW2 m1_2742_3250# a_2224_3416# m1_2242_4966# a_2224_3416# m1_2242_4966# vss n_w4_l0p28_f2
XSW1 m1_2242_4966# a_1632_3416# m1_617_3840# a_1632_3416# m1_617_3840# vss n_w4_l0p28_f2
XXRB3 m1_1262_4048# m1_956_3000# vss r_w1_l11p645
XXRB2 m1_822_4048# m1_1262_4048# vss r_w1_l11p645
XSW3 m1_3310_2880# a_2816_3416# m1_2742_3250# a_2816_3416# m1_2742_3250# vss n_w4_l0p28_f2
XSW4 vss a_3408_3416# m1_3310_2880# a_3408_3416# m1_3310_2880# vss n_w4_l0p28_f2
C0 m1_617_3840# m1_3662_4048# 0
C1 a_2224_3416# b2 0.22771f
C2 m1_956_3000# b2 0
C3 a_1632_3416# a_1040_3416# 0.0443f
C4 a_2224_3416# m1_2242_4966# 0.17274f
C5 m1_956_3000# m1_2242_4966# 0.15942f
C6 b4 b1 0.00115f
C7 a_1632_3416# m1_956_3000# 0.03269f
C8 a_2224_3416# a_1632_3416# 0.03245f
C9 m1_3662_4048# a_3408_3416# 0
C10 b1 b2 0.04707f
C11 b1 m1_2242_4966# 0.00209f
C12 a_1632_3416# b1 0.35929f
C13 a_2816_3416# m1_617_3840# 0
C14 a_2224_3416# a_1040_3416# 0
C15 m1_956_3000# a_1040_3416# 0.11081f
C16 m1_617_3840# m1_2742_3250# 0.01845f
C17 a_2224_3416# m1_956_3000# 0
C18 a_2816_3416# a_3408_3416# 0.03415f
C19 m1_617_3840# m1_382_4048# 0.32274f
C20 b1 a_1040_3416# 0.03315f
C21 a_3408_3416# m1_2742_3250# 0.01258f
C22 a_2224_3416# b1 0
C23 b1 m1_956_3000# 0
C24 m1_617_3840# b0 0
C25 m1_617_3840# m1_1262_4048# 0.13358f
C26 m1_617_3840# vdd 0
C27 m1_3662_4048# m1_2742_3250# 0.03614f
C28 m1_382_4048# out 0.02694f
C29 a_3408_3416# vdd 0.22664f
C30 out m1_1262_4048# 0.01147f
C31 a_2816_3416# m1_2742_3250# 0.2733f
C32 m1_617_3840# m1_822_4048# 0.123f
C33 m1_2742_3250# m1_1262_4048# 0.009f
C34 a_2816_3416# vdd 0.1469f
C35 m1_2742_3250# vdd 0.00512f
C36 a_3408_3416# b3 0
C37 m1_617_3840# m1_3310_2880# 0.00278f
C38 out m1_822_4048# 0.02257f
C39 a_3408_3416# m1_3310_2880# 0.07699f
C40 b0 vdd 0.49326f
C41 m1_617_3840# m1_2242_4966# 0.32683f
C42 b4 a_3408_3416# 0.21422f
C43 m1_617_3840# a_1632_3416# 0.15378f
C44 m1_3662_4048# m1_3310_2880# 0.3114f
C45 a_2816_3416# b3 0.2249f
C46 m1_617_3840# a_1040_3416# 0.2193f
C47 m1_2742_3250# b3 0.00105f
C48 a_2224_3416# m1_617_3840# 0.03861f
C49 m1_617_3840# m1_956_3000# 0.75011f
C50 m1_3662_4048# m1_2242_4966# 0
C51 m1_382_4048# m1_822_4048# 0.39941f
C52 a_2816_3416# m1_3310_2880# 0.20114f
C53 m1_2742_3250# m1_3310_2880# 0.31172f
C54 a_2224_3416# a_3408_3416# 0
C55 m1_617_3840# b1 0.00533f
C56 m1_1262_4048# m1_822_4048# 0.18781f
C57 a_2816_3416# b4 0.05297f
C58 m1_2742_3250# b2 0.01093f
C59 b3 vdd 0.44294f
C60 a_2816_3416# m1_2242_4966# 0
C61 a_2816_3416# a_1632_3416# 0.00123f
C62 m1_3662_4048# m1_956_3000# 0
C63 m1_2742_3250# m1_2242_4966# 0.46801f
C64 m1_2742_3250# a_1632_3416# 0.00921f
C65 m1_3310_2880# vdd 0.00483f
C66 m1_382_4048# m1_2242_4966# 0
C67 b2 b0 0.00416f
C68 b4 vdd 0.59499f
C69 b2 vdd 0.46487f
C70 m1_1262_4048# m1_2242_4966# 0.01042f
C71 a_2224_3416# a_2816_3416# 0.17309f
C72 a_1632_3416# m1_1262_4048# 0.00132f
C73 a_1632_3416# b0 0.00371f
C74 m1_2242_4966# vdd 0.0033f
C75 a_2224_3416# m1_2742_3250# 0.23293f
C76 m1_2742_3250# m1_956_3000# 0.00197f
C77 a_1632_3416# vdd 0.17222f
C78 m1_382_4048# a_1040_3416# 0
C79 a_2816_3416# b1 0
C80 m1_382_4048# m1_956_3000# 0.00423f
C81 m1_1262_4048# a_1040_3416# 0
C82 a_1040_3416# b0 0.2598f
C83 a_1040_3416# vdd 0.27317f
C84 m1_956_3000# b0 0.00622f
C85 m1_1262_4048# m1_956_3000# 0.07066f
C86 m1_3310_2880# b3 0.02434f
C87 a_2224_3416# vdd 0.20102f
C88 m1_956_3000# vdd 0.00146f
C89 b1 b0 0.02882f
C90 b4 b3 0.04052f
C91 b2 b3 0.04135f
C92 b1 vdd 0.48179f
C93 m1_2242_4966# m1_822_4048# 0
C94 a_1632_3416# b3 0.00127f
C95 b4 m1_3310_2880# 0.01127f
C96 m1_2242_4966# m1_3310_2880# 0
C97 a_1632_3416# m1_3310_2880# 0
C98 a_1040_3416# m1_822_4048# 0
C99 b4 b2 0
C100 m1_956_3000# m1_822_4048# 0.03636f
C101 a_2224_3416# b3 0.05038f
C102 m1_2242_4966# b2 0.00331f
C103 a_1632_3416# b2 0.02431f
C104 a_1632_3416# m1_2242_4966# 0.15001f
C105 b1 b3 0
C106 a_2224_3416# m1_3310_2880# 0.05997f
C107 m1_956_3000# m1_3310_2880# 0
C108 a_1040_3416# b2 0.00223f
C109 m1_617_3840# out 0.00314f
C110 a_2224_3416# b4 0
C111 m1_3310_2880# vss 1.09895f
C112 m1_1262_4048# vss 0.55221f
C113 m1_2242_4966# vss 0.19454f
C114 m1_2742_3250# vss 0.65139f
C115 m1_822_4048# vss 0.24942f
C116 m1_617_3840# vss 2.00651f
C117 m1_956_3000# vss 0.55486f
C118 m1_382_4048# vss 0.33796f
C119 out vss 0.8541f
C120 vdd vss 10.07211f
C121 a_1040_3416# vss 1.07104f
C122 b0 vss 0.4933f
C123 a_1632_3416# vss 0.5138f
C124 b1 vss 0.49625f
C125 a_2224_3416# vss 0.54715f
C126 b2 vss 0.3102f
C127 a_2816_3416# vss 0.43096f
C128 b3 vss 0.35598f
C129 a_3408_3416# vss 1.10802f
C130 b4 vss 0.34471f
C131 m1_3662_4048# vss 0.38401f
.ends

.subckt r_w1_l13p91 a_n100_n1513# a_n100_1391# VSUBS
X0 a_n100_1391# a_n100_n1513# VSUBS ppolyf_u_1k r_width=1u r_length=13.91u
C0 a_n100_n1513# VSUBS 0.27003f
C1 a_n100_1391# VSUBS 0.27003f
.ends

.subckt vdacr_vr b0 b1 b2 b3 b4 out vss m1_2862_4048# a_680_3416# a_2456_3416# vdd
+ m1_860_4046# m1_462_4048# m1_2974_2650# a_1864_3416# a_3048_3416# m1_2372_2520#
+ m1_756_3120# a_1272_3416# m1_606_2410# m1_1780_5040#
XXRS4_0 m1_2862_4048# m1_2974_2650# vss r_w1_l7p765
XXRS4_1 vss m1_2862_4048# vss r_w1_l7p765
XXRS0 m1_756_3120# m1_606_2410# vss r_w2_l1p97
XXRS1 m1_1780_5040# m1_756_3120# vss r_w1_l1p94
XXRS3 m1_2974_2650# m1_2372_2520# vss r_w1_l7p765
XXRS2 m1_2372_2520# m1_1780_5040# vss r_w1_l3p88
XIB4n a_3048_3416# b4 vss vss n_w0p5_l1
XIB3n a_2456_3416# b3 vss vss n_w0p5_l1
XIB4p vdd a_3048_3416# b4 vdd vss p_w1_l1
XIB2n a_1864_3416# b2 vss vss n_w0p5_l1
XIB3p vdd a_2456_3416# b3 vdd vss p_w1_l1
XIB2p vdd a_1864_3416# b2 vdd vss p_w1_l1
XIB1n a_1272_3416# b1 vss vss n_w0p5_l1
XIB0n a_680_3416# b0 vss vss n_w0p5_l1
XIB1p vdd a_1272_3416# b1 vdd vss p_w1_l1
XIB0p vdd a_680_3416# b0 vdd vss p_w1_l1
XXRB0 m1_462_4048# out vss r_w1_l13p91
XSW0 m1_756_3120# a_680_3416# m1_606_2410# a_680_3416# m1_606_2410# vss n_w4_l0p28_f2
XXRB1 m1_860_4046# m1_462_4048# vss r_w1_l13p91
XSW2 m1_2372_2520# a_1864_3416# m1_1780_5040# a_1864_3416# m1_1780_5040# vss n_w4_l0p28_f2
XSW1 m1_1780_5040# a_1272_3416# m1_756_3120# a_1272_3416# m1_756_3120# vss n_w4_l0p28_f2
XXRB2 m1_606_2410# m1_860_4046# vss r_w1_l13p91
XSW3 m1_2974_2650# a_2456_3416# m1_2372_2520# a_2456_3416# m1_2372_2520# vss n_w4_l0p28_f2
XSW4 vss a_3048_3416# m1_2974_2650# a_3048_3416# m1_2974_2650# vss n_w4_l0p28_f2
C0 b1 b0 0.0391f
C1 b2 a_1272_3416# 0.04419f
C2 b2 a_2456_3416# 0
C3 m1_2372_2520# a_1864_3416# 0.27866f
C4 b1 vdd 0.41268f
C5 b1 a_680_3416# 0.03391f
C6 b1 m1_756_3120# 0.00539f
C7 b3 a_1272_3416# 0
C8 b3 a_2456_3416# 0.21262f
C9 m1_1780_5040# b1 0.00216f
C10 b3 b2 0.03777f
C11 m1_2372_2520# vdd 0.00451f
C12 m1_2862_4048# m1_756_3120# 0
C13 m1_2372_2520# m1_756_3120# 0.13736f
C14 m1_1780_5040# m1_2862_4048# 0.00262f
C15 a_1864_3416# a_3048_3416# 0
C16 b1 m1_606_2410# 0
C17 m1_2372_2520# m1_1780_5040# 0.17871f
C18 m1_2372_2520# out 0
C19 a_1864_3416# a_1272_3416# 0.02555f
C20 a_1864_3416# a_2456_3416# 0.02335f
C21 m1_2862_4048# m1_606_2410# 0
C22 b2 a_1864_3416# 0.16397f
C23 m1_2372_2520# m1_606_2410# 0
C24 a_3048_3416# vdd 0.14688f
C25 m1_2862_4048# m1_2974_2650# 0.17897f
C26 b2 b0 0
C27 m1_2372_2520# m1_2974_2650# 0.5557f
C28 a_1272_3416# vdd 0.13505f
C29 vdd a_2456_3416# 0.20273f
C30 b3 a_1864_3416# 0.04632f
C31 b2 vdd 0.57544f
C32 a_1272_3416# a_680_3416# 0.04759f
C33 a_1272_3416# m1_756_3120# 0.2354f
C34 m1_756_3120# a_2456_3416# 0
C35 b2 m1_756_3120# 0
C36 b2 a_680_3416# 0
C37 m1_2372_2520# m1_860_4046# 0
C38 m1_1780_5040# a_1272_3416# 0.152f
C39 m1_1780_5040# a_2456_3416# 0.00741f
C40 b2 m1_1780_5040# 0
C41 b3 vdd 0.45194f
C42 a_1272_3416# m1_606_2410# 0.01865f
C43 a_3048_3416# m1_2974_2650# 0.1083f
C44 a_1272_3416# m1_2974_2650# 0
C45 m1_2974_2650# a_2456_3416# 0.30479f
C46 a_3048_3416# b4 0.26257f
C47 a_1864_3416# vdd 0.23259f
C48 m1_860_4046# a_1272_3416# 0
C49 a_1864_3416# a_680_3416# 0
C50 a_1864_3416# m1_756_3120# 0.0068f
C51 a_2456_3416# b4 0.09406f
C52 b0 vdd 0.43014f
C53 b3 m1_2974_2650# 0.00379f
C54 b2 b4 0
C55 a_1864_3416# m1_1780_5040# 0.42554f
C56 b0 m1_756_3120# 0
C57 b0 a_680_3416# 0.24565f
C58 m1_462_4048# m1_2372_2520# 0
C59 vdd m1_756_3120# 0.00214f
C60 a_680_3416# vdd 0.1904f
C61 b3 b4 0.04752f
C62 a_1864_3416# m1_606_2410# 0.0027f
C63 a_680_3416# m1_756_3120# 0.10755f
C64 m1_1780_5040# vdd 0.0026f
C65 m1_1780_5040# m1_756_3120# 0.43379f
C66 b0 m1_606_2410# 0.01272f
C67 a_1864_3416# m1_2974_2650# 0.00495f
C68 a_680_3416# m1_606_2410# 0.28826f
C69 m1_756_3120# m1_606_2410# 0.30895f
C70 m1_1780_5040# out 0.00646f
C71 m1_2974_2650# vdd 0.01155f
C72 m1_1780_5040# m1_606_2410# 0.12918f
C73 m1_2974_2650# m1_756_3120# 0.0665f
C74 m1_1780_5040# m1_2974_2650# 0.08507f
C75 vdd b4 0.55146f
C76 m1_860_4046# a_680_3416# 0
C77 m1_860_4046# m1_756_3120# 0.01696f
C78 m1_2974_2650# m1_606_2410# 0
C79 m1_860_4046# m1_1780_5040# 0.08602f
C80 m1_860_4046# out 0.01202f
C81 m1_860_4046# m1_606_2410# 0.08949f
C82 m1_2974_2650# b4 0.03331f
C83 m1_462_4048# a_680_3416# 0.00361f
C84 m1_462_4048# m1_756_3120# 0
C85 m1_462_4048# m1_1780_5040# 0
C86 m1_462_4048# out 0.08166f
C87 m1_462_4048# m1_606_2410# 0.01332f
C88 m1_462_4048# m1_860_4046# 0.19198f
C89 m1_2372_2520# m1_2862_4048# 0.02957f
C90 a_1272_3416# b1 0.24882f
C91 a_3048_3416# m1_2862_4048# 0.00491f
C92 b2 b1 0.05461f
C93 m1_2372_2520# a_3048_3416# 0
C94 m1_2862_4048# a_2456_3416# 0.00561f
C95 m1_2372_2520# a_1272_3416# 0.01394f
C96 m1_2372_2520# a_2456_3416# 0.13462f
C97 b3 b1 0.00301f
C98 m1_2372_2520# b2 0.00692f
C99 m1_2372_2520# b3 0.02027f
C100 a_3048_3416# a_2456_3416# 0.11912f
C101 a_1864_3416# b1 0
C102 b2 a_3048_3416# 0
C103 a_1272_3416# a_2456_3416# 0.00297f
C104 m1_2974_2650# vss 0.65248f
C105 m1_2372_2520# vss 0.45945f
C106 m1_1780_5040# vss 0.79973f
C107 m1_860_4046# vss 0.58374f
C108 m1_756_3120# vss 0.79001f
C109 m1_606_2410# vss 0.54107f
C110 m1_462_4048# vss 0.74869f
C111 out vss 0.66703f
C112 vdd vss 7.78061f
C113 a_680_3416# vss 0.76469f
C114 b0 vss 0.46453f
C115 a_1272_3416# vss 0.41953f
C116 b1 vss 0.31842f
C117 a_1864_3416# vss 0.56004f
C118 b2 vss 0.2832f
C119 b4 vss 0.38639f
C120 a_2456_3416# vss 0.64752f
C121 b3 vss 0.32156f
C122 a_3048_3416# vss 1.09158f
C123 m1_2862_4048# vss 0.49249f
.ends

.subckt r_w1_l14p555 a_n100_1456# a_n100_n1578# VSUBS
X0 a_n100_1456# a_n100_n1578# VSUBS ppolyf_u_1k r_width=1u r_length=14.56u
C0 a_n100_n1578# VSUBS 0.27003f
C1 a_n100_1456# VSUBS 0.27003f
.ends

.subckt p_w10_l10 w_n1174_n1130# a_n1000_n1044# a_1000_n1000# a_n1088_n1000# VSUBS
X0 a_1000_n1000# a_n1000_n1044# a_n1088_n1000# w_n1174_n1130# pfet_03v3 ad=4.4p pd=20.88u as=4.4p ps=20.88u w=10u l=10u
C0 a_1000_n1000# w_n1174_n1130# 0.41194f
C1 w_n1174_n1130# a_n1088_n1000# 0.41194f
C2 w_n1174_n1130# a_n1000_n1044# 1.0092f
C3 a_1000_n1000# a_n1000_n1044# 0.38624f
C4 a_n1000_n1044# a_n1088_n1000# 0.38624f
C5 a_1000_n1000# VSUBS 0.65771f
C6 a_n1088_n1000# VSUBS 0.65771f
C7 w_n1174_n1130# VSUBS 15.9194f
.ends

.subckt bias_rails vsp vgln en_b vdd m1_782_438# m1_3422_438# m1_3862_3522# m1_2542_438#
+ vss m1_1222_3522# m1_342_438# vsn m1_1662_438# vglp
XR0 vsp m1_342_438# vss r_w1_l14p555
XR1 vsp m1_782_438# vss r_w1_l14p555
XR2 m1_1222_3522# m1_782_438# vss r_w1_l14p555
XR3 m1_1222_3522# m1_1662_438# vss r_w1_l14p555
XR4 vgln m1_1662_438# vss r_w1_l14p555
XHDR vdd m1_342_438# en_b vdd vss p_w4_l0p5
XR5 vgln m1_2542_438# vss r_w1_l14p555
XR6 vglp m1_2542_438# vss r_w1_l14p555
XR7 vglp m1_3422_438# vss r_w1_l14p555
XR9 m1_3862_3522# vsn vss r_w1_l14p555
XR8 m1_3862_3522# m1_3422_438# vss r_w1_l14p555
XR10 vss vsn vss r_w1_l14p555
XC2 vsp vdd vsp vsp vss p_w10_l10
XC1 vss vsn vss vss vss p_w10_l10
C0 m1_342_438# en_b 0.02808f
C1 m1_1662_438# m1_782_438# 0.00961f
C2 m1_3862_3522# vsp 0.02981f
C3 vsn vgln 0.59161f
C4 vglp en_b 0.00265f
C5 vsn vsp 0.81189f
C6 vgln vglp 0.17255f
C7 vsn m1_2542_438# 0
C8 m1_3862_3522# vglp 0.01054f
C9 vsn m1_342_438# 0.18087f
C10 m1_2542_438# m1_342_438# 0.02465f
C11 vsp vglp 0.16572f
C12 vsn m1_3422_438# 0.03433f
C13 m1_3422_438# m1_2542_438# 0.00961f
C14 vdd en_b 1.36198f
C15 m1_782_438# m1_342_438# 0.0401f
C16 vsn vglp 0.14758f
C17 m1_3422_438# m1_342_438# 0.0285f
C18 m1_3862_3522# vdd 0.01537f
C19 vgln m1_1222_3522# 0.01049f
C20 vdd vsp 1.60715f
C21 vsn vdd 0.00661f
C22 m1_1222_3522# vsp 0.09037f
C23 vdd m1_342_438# 0.17301f
C24 vsn m1_1222_3522# 0.063f
C25 m1_3862_3522# en_b 0.00238f
C26 vsp en_b 0.24632f
C27 vdd vglp 0.06028f
C28 m1_1662_438# m1_2542_438# 0.00961f
C29 vsn en_b 0.00115f
C30 vgln vsp 0.07625f
C31 m1_1662_438# m1_342_438# 0.02539f
C32 m1_3862_3522# vss 0.01668f
C33 vsn vss 2.43428f
C34 m1_3422_438# vss 0.00649f
C35 vglp vss 0.71006f
C36 m1_2542_438# vss 0.04057f
C37 en_b vss 0.77429f
C38 vdd vss 2.40243f
C39 vgln vss 0.3466f
C40 m1_1662_438# vss 0.04061f
C41 m1_1222_3522# vss 0.03291f
C42 m1_782_438# vss 0.04119f
C43 m1_342_438# vss 1.80172f
C44 vsp vss 7.7207f
.ends

.subckt r_w2_l1p315 a_n200_n254# a_n200_132# VSUBS
X0 a_n200_132# a_n200_n254# VSUBS ppolyf_u_1k r_width=2u r_length=1.32u
C0 a_n200_132# a_n200_n254# 0.02982f
C1 a_n200_n254# VSUBS 0.42149f
C2 a_n200_132# VSUBS 0.42149f
.ends

.subckt r_w2_l2p625 a_n200_n385# a_n200_263# VSUBS
X0 a_n200_263# a_n200_n385# VSUBS ppolyf_u_1k r_width=2u r_length=2.63u
C0 a_n200_263# a_n200_n385# 0.01591f
C1 a_n200_n385# VSUBS 0.43549f
C2 a_n200_263# VSUBS 0.43549f
.ends

.subckt r_w1_l5p175 a_n100_518# a_n100_n640# VSUBS
X0 a_n100_518# a_n100_n640# VSUBS ppolyf_u_1k r_width=1u r_length=5.18u
C0 a_n100_518# a_n100_n640# 0.00399f
C1 a_n100_n640# VSUBS 0.26263f
C2 a_n100_518# VSUBS 0.26263f
.ends

.subckt r_w1_l2p59 a_n100_n381# a_n100_259# VSUBS
X0 a_n100_259# a_n100_n381# VSUBS ppolyf_u_1k r_width=1u r_length=2.59u
C0 a_n100_259# a_n100_n381# 0.00799f
C1 a_n100_n381# VSUBS 0.25697f
C2 a_n100_259# VSUBS 0.25697f
.ends

.subckt r_w1_l10p35 a_n100_n1157# a_n100_1035# VSUBS
X0 a_n100_1035# a_n100_n1157# VSUBS ppolyf_u_1k r_width=1u r_length=10.35u
C0 a_n100_n1157# VSUBS 0.27003f
C1 a_n100_1035# VSUBS 0.27003f
.ends

.subckt vdacr_vc b0 b1 b2 b3 b4 vdd out vss a_680_3416# a_2456_3416# m1_596_2880#
+ a_1864_3416# m1_1342_4048# a_3048_3416# m1_1780_2760# m1_2382_2650# a_1272_3416#
+ m1_902_4048# m1_756_3240# m1_2964_2640#
XXRS0 m1_756_3240# m1_596_2880# vss r_w2_l1p315
XXRS1 m1_1780_2760# m1_756_3240# vss r_w2_l2p625
XXRS3 m1_2382_2650# m1_2964_2640# vss r_w1_l5p175
XXRS2 m1_2382_2650# m1_1780_2760# vss r_w1_l2p59
XXRS4 vss m1_2964_2640# vss r_w1_l10p35
XIB4n a_3048_3416# b4 vss vss n_w0p5_l1
XIB3n a_2456_3416# b3 vss vss n_w0p5_l1
XIB4p vdd a_3048_3416# b4 vdd vss p_w1_l1
XIB2n a_1864_3416# b2 vss vss n_w0p5_l1
XIB3p vdd a_2456_3416# b3 vdd vss p_w1_l1
XIB2p vdd a_1864_3416# b2 vdd vss p_w1_l1
XIB1n a_1272_3416# b1 vss vss n_w0p5_l1
XIB0n a_680_3416# b0 vss vss n_w0p5_l1
XIB1p vdd a_1272_3416# b1 vdd vss p_w1_l1
XIB0p vdd a_680_3416# b0 vdd vss p_w1_l1
XXRB0 out m1_462_4048# vss r_w1_l14p555
XSW0 m1_756_3240# a_680_3416# m1_596_2880# a_680_3416# m1_596_2880# vss n_w4_l0p28_f2
XXRB1 m1_462_4048# m1_902_4048# vss r_w1_l14p555
XSW2 m1_2382_2650# a_1864_3416# m1_1780_2760# a_1864_3416# m1_1780_2760# vss n_w4_l0p28_f2
XSW1 m1_1780_2760# a_1272_3416# m1_756_3240# a_1272_3416# m1_756_3240# vss n_w4_l0p28_f2
XXRB3 m1_1342_4048# m1_596_2880# vss r_w1_l14p555
XXRB2 m1_902_4048# m1_1342_4048# vss r_w1_l14p555
XSW3 m1_2964_2640# a_2456_3416# m1_2382_2650# a_2456_3416# m1_2382_2650# vss n_w4_l0p28_f2
XSW4 vss a_3048_3416# m1_2964_2640# a_3048_3416# m1_2964_2640# vss n_w4_l0p28_f2
C0 vdd a_3048_3416# 0.1443f
C1 m1_2964_2640# a_2456_3416# 0.19022f
C2 b3 a_1272_3416# 0
C3 out m1_1780_2760# 0.00408f
C4 a_2456_3416# m1_1780_2760# 0.02311f
C5 m1_2964_2640# m1_2382_2650# 0.25078f
C6 vdd a_1272_3416# 0.16599f
C7 b3 b4 0.05196f
C8 b3 b2 0.05389f
C9 b1 a_1864_3416# 0.01341f
C10 m1_756_3240# a_1272_3416# 0.25178f
C11 m1_2964_2640# m1_596_2880# 0
C12 m1_2382_2650# m1_1780_2760# 0.57773f
C13 vdd b0 0.4728f
C14 vdd b4 0.64298f
C15 vdd b2 0.48541f
C16 m1_902_4048# a_1272_3416# 0.00535f
C17 m1_1780_2760# a_680_3416# 0
C18 m1_756_3240# b0 0
C19 m1_596_2880# m1_1780_2760# 0.13932f
C20 a_2456_3416# m1_2382_2650# 0.29833f
C21 m1_2964_2640# a_3048_3416# 0.09007f
C22 m1_756_3240# m1_1342_4048# 0.02959f
C23 a_2456_3416# m1_596_2880# 0
C24 m1_902_4048# m1_1342_4048# 0.59267f
C25 m1_2382_2650# a_680_3416# 0
C26 m1_2964_2640# a_1272_3416# 0
C27 m1_2382_2650# m1_596_2880# 0.12127f
C28 a_2456_3416# a_3048_3416# 0.03483f
C29 m1_596_2880# a_680_3416# 0.18443f
C30 m1_1780_2760# a_1272_3416# 0.20372f
C31 m1_2964_2640# b4 0.01478f
C32 b3 a_1864_3416# 0.03231f
C33 m1_2382_2650# a_3048_3416# 0.00307f
C34 a_2456_3416# a_1272_3416# 0.01817f
C35 m1_2964_2640# m1_1342_4048# 0
C36 vdd a_1864_3416# 0.25499f
C37 m1_1780_2760# b2 0.01235f
C38 m1_756_3240# a_1864_3416# 0.21894f
C39 m1_1780_2760# m1_1342_4048# 0.36407f
C40 a_2456_3416# b4 0.08415f
C41 m1_2382_2650# a_1272_3416# 0.00845f
C42 a_2456_3416# b2 0.00423f
C43 vdd b1 0.42955f
C44 out m1_1342_4048# 0.02845f
C45 a_680_3416# a_1272_3416# 0.0323f
C46 m1_596_2880# a_1272_3416# 0.01859f
C47 m1_756_3240# b1 0.02481f
C48 m1_2382_2650# b2 0.00779f
C49 b0 a_680_3416# 0.36752f
C50 m1_596_2880# b0 0.00542f
C51 m1_2382_2650# m1_1342_4048# 0.00106f
C52 m1_596_2880# m1_1342_4048# 0.05175f
C53 m1_2964_2640# a_1864_3416# 0
C54 a_3048_3416# b4 0.28941f
C55 m1_1780_2760# a_1864_3416# 0.45815f
C56 a_2456_3416# a_1864_3416# 0.02091f
C57 b0 a_1272_3416# 0
C58 vdd b3 0.45495f
C59 b2 a_1272_3416# 0.04376f
C60 b1 m1_1780_2760# 0
C61 m1_1342_4048# a_1272_3416# 0.00125f
C62 m1_2382_2650# a_1864_3416# 0.08407f
C63 vdd m1_756_3240# 0.00935f
C64 a_1864_3416# a_680_3416# 0.00213f
C65 m1_596_2880# a_1864_3416# 0.00298f
C66 m1_756_3240# m1_462_4048# 0.07243f
C67 m1_756_3240# m1_902_4048# 0.15859f
C68 b1 a_680_3416# 0.0311f
C69 m1_902_4048# m1_462_4048# 0.1067f
C70 a_3048_3416# a_1864_3416# 0
C71 m1_2964_2640# b3 0
C72 m1_2964_2640# vdd 0.00309f
C73 a_1864_3416# a_1272_3416# 0.13668f
C74 m1_2964_2640# m1_756_3240# 0.03724f
C75 vdd m1_1780_2760# 0.0024f
C76 a_2456_3416# b3 0.20171f
C77 a_1864_3416# b4 0
C78 m1_2964_2640# m1_902_4048# 0
C79 a_1864_3416# b2 0.30281f
C80 b1 a_1272_3416# 0.24461f
C81 m1_756_3240# m1_1780_2760# 0.31426f
C82 vdd a_2456_3416# 0.22632f
C83 m1_462_4048# m1_1780_2760# 0
C84 m1_2382_2650# b3 0.02078f
C85 m1_902_4048# m1_1780_2760# 0.0028f
C86 b1 b0 0.03223f
C87 a_2456_3416# m1_756_3240# 0.00946f
C88 b1 b2 0.03672f
C89 m1_462_4048# out 0.08186f
C90 vdd m1_2382_2650# 0.00156f
C91 m1_902_4048# out 0.00898f
C92 vdd a_680_3416# 0.29783f
C93 m1_2382_2650# m1_756_3240# 0.18929f
C94 vdd m1_596_2880# 0
C95 m1_2382_2650# m1_462_4048# 0
C96 m1_756_3240# a_680_3416# 0.09138f
C97 m1_2382_2650# m1_902_4048# 0
C98 m1_596_2880# m1_756_3240# 0.63405f
C99 m1_2964_2640# m1_1780_2760# 0.00209f
C100 b3 a_3048_3416# 0
C101 m1_462_4048# a_680_3416# 0.00344f
C102 m1_596_2880# m1_462_4048# 0.10991f
C103 m1_902_4048# a_680_3416# 0
C104 m1_596_2880# m1_902_4048# 0.04254f
C105 m1_2964_2640# vss 1.71738f
C106 m1_1342_4048# vss 0.20629f
C107 m1_2382_2650# vss 0.88559f
C108 m1_1780_2760# vss 0.55176f
C109 m1_902_4048# vss 0.29458f
C110 m1_756_3240# vss 0.82268f
C111 m1_596_2880# vss 0.7575f
C112 m1_462_4048# vss 0.72606f
C113 out vss 0.62102f
C114 vdd vss 7.67233f
C115 a_680_3416# vss 1.18414f
C116 b0 vss 0.36638f
C117 a_1272_3416# vss 0.4405f
C118 b1 vss 0.28315f
C119 a_1864_3416# vss 0.73889f
C120 b2 vss 0.31706f
C121 b4 vss 0.35606f
C122 a_2456_3416# vss 0.60405f
C123 b3 vss 0.35144f
C124 a_3048_3416# vss 1.11524f
.ends

.subckt r_w1_l9p86 a_n100_n1108# a_n100_986# VSUBS
X0 a_n100_986# a_n100_n1108# VSUBS ppolyf_u_1k r_width=1u r_length=9.86u
C0 a_n100_n1108# VSUBS 0.27003f
C1 a_n100_986# VSUBS 0.27003f
.ends

.subckt r_w2_l2p5 a_n200_250# a_n200_n372# VSUBS
X0 a_n200_250# a_n200_n372# VSUBS ppolyf_u_1k r_width=2u r_length=2.5u
C0 a_n200_n372# a_n200_250# 0.01672f
C1 a_n200_n372# VSUBS 0.4345f
C2 a_n200_250# VSUBS 0.4345f
.ends

.subckt r_w1_l2p465 a_n100_n369# a_n100_247# VSUBS
X0 a_n100_247# a_n100_n369# VSUBS ppolyf_u_1k r_width=1u r_length=2.47u
C0 a_n100_n369# a_n100_247# 0.00837f
C1 a_n100_n369# VSUBS 0.25651f
C2 a_n100_247# VSUBS 0.25651f
.ends

.subckt r_w1_l4p93 a_n100_n615# a_n100_493# VSUBS
X0 a_n100_493# a_n100_n615# VSUBS ppolyf_u_1k r_width=1u r_length=4.93u
C0 a_n100_n615# a_n100_493# 0.0042f
C1 a_n100_n615# VSUBS 0.2623f
C2 a_n100_493# VSUBS 0.2623f
.ends

.subckt r_w1_l13p145 a_n100_1315# a_n100_n1437# VSUBS
X0 a_n100_1315# a_n100_n1437# VSUBS ppolyf_u_1k r_width=1u r_length=13.15u
C0 a_n100_n1437# VSUBS 0.27003f
C1 a_n100_1315# VSUBS 0.27003f
.ends

.subckt r_w1_l13p39 a_n100_n1461# a_n100_1339# VSUBS
X0 a_n100_1339# a_n100_n1461# VSUBS ppolyf_u_1k r_width=1u r_length=13.39u
C0 a_n100_n1461# VSUBS 0.27003f
C1 a_n100_1339# VSUBS 0.27003f
.ends

.subckt n_w6_l0p28_f2 a_52_n644# a_108_n600# a_n108_n644# a_n196_n600# a_n52_n600#
+ VSUBS
X0 a_108_n600# a_52_n644# a_n52_n600# VSUBS nfet_03v3 ad=2.64p pd=12.88u as=1.56p ps=6.52u w=6u l=0.28u
X1 a_n52_n600# a_n108_n644# a_n196_n600# VSUBS nfet_03v3 ad=1.56p pd=6.52u as=2.64p ps=12.88u w=6u l=0.28u
C0 a_n52_n600# a_108_n600# 0.2597f
C1 a_108_n600# a_52_n644# 0.04695f
C2 a_n52_n600# a_n196_n600# 0.2597f
C3 a_n52_n600# a_n108_n644# 0.04695f
C4 a_52_n644# a_n108_n644# 0.00519f
C5 a_n196_n600# a_n108_n644# 0.04695f
C6 a_n52_n600# a_52_n644# 0.04695f
C7 a_108_n600# VSUBS 0.28641f
C8 a_n52_n600# VSUBS 0.09458f
C9 a_n196_n600# VSUBS 0.28641f
.ends

.subckt vdacr_vt b0 b1 b2 b3 b4 b5 vdd m1_2720_2760# a_4584_3816# m1_5422_4448# vss
+ m1_382_4448# m1_822_4448# a_1624_3816# a_3992_3816# m1_1523_3480# out a_3400_3816#
+ a_2808_3816# m1_1702_4448# m1_2408_3600# m1_3908_2760# m1_4078_3250# m1_4102_4448#
+ m1_3222_4448# a_2216_3816# m1_4982_4448# m1_1262_4448#
XXRS4_0 m1_4102_4448# m1_3908_2760# vss r_w1_l9p86
XXRS4_1 m1_4078_3250# m1_4102_4448# vss r_w1_l9p86
XXRS0 m1_1523_3480# m1_2408_3600# vss r_w2_l2p5
XXRS1 m1_2720_2760# m1_2408_3600# vss r_w1_l2p465
XXRS3 m1_3908_2760# m1_3222_4448# vss r_w1_l9p86
XXRS2 m1_3222_4448# m1_2720_2760# vss r_w1_l4p93
XIB5n a_4584_3816# b5 vss vss n_w0p5_l1
XIB4n a_3992_3816# b4 vss vss n_w0p5_l1
XIB5p vdd a_4584_3816# b5 vdd vss p_w1_l1
XIB3n a_3400_3816# b3 vss vss n_w0p5_l1
XIB4p vdd a_3992_3816# b4 vdd vss p_w1_l1
XIB2n a_2808_3816# b2 vss vss n_w0p5_l1
XIB3p vdd a_3400_3816# b3 vdd vss p_w1_l1
XIB2p vdd a_2808_3816# b2 vdd vss p_w1_l1
XIB1n a_2216_3816# b1 vss vss n_w0p5_l1
XIB0n a_1624_3816# b0 vss vss n_w0p5_l1
XIB1p vdd a_2216_3816# b1 vdd vss p_w1_l1
XIB0p vdd a_1624_3816# b0 vdd vss p_w1_l1
XXRS5_0 m1_4078_3250# m1_4982_4448# vss r_w1_l13p145
XXRS5_1 m1_4982_4448# m1_5422_4448# vss r_w1_l13p145
XXRB0 m1_382_4448# out vss r_w1_l13p39
XSW0 a_1624_3816# m1_1523_3480# a_1624_3816# m1_1523_3480# m1_2408_3600# vss n_w6_l0p28_f2
XXRS5_2 m1_5422_4448# vss vss r_w1_l13p145
XXRB1 m1_822_4448# m1_382_4448# vss r_w1_l13p39
XSW2 a_2808_3816# m1_2720_2760# a_2808_3816# m1_2720_2760# m1_3222_4448# vss n_w6_l0p28_f2
XSW1 a_2216_3816# m1_2408_3600# a_2216_3816# m1_2408_3600# m1_2720_2760# vss n_w6_l0p28_f2
XXRB3 m1_1702_4448# m1_1262_4448# vss r_w1_l13p39
XXRB2 m1_1262_4448# m1_822_4448# vss r_w1_l13p39
XSW3 a_3400_3816# m1_3222_4448# a_3400_3816# m1_3222_4448# m1_3908_2760# vss n_w6_l0p28_f2
XXRB4 m1_1523_3480# m1_1702_4448# vss r_w1_l13p39
XSW4 a_3992_3816# m1_3908_2760# a_3992_3816# m1_3908_2760# m1_4078_3250# vss n_w6_l0p28_f2
XSW5 a_4584_3816# m1_4078_3250# a_4584_3816# m1_4078_3250# vss vss n_w6_l0p28_f2
C0 m1_1702_4448# m1_3222_4448# 0.01015f
C1 b0 m1_1523_3480# 0.00106f
C2 m1_2408_3600# m1_1702_4448# 0.06983f
C3 m1_1702_4448# out 0.0205f
C4 m1_382_4448# m1_1262_4448# 0
C5 m1_1523_3480# m1_1262_4448# 0
C6 b0 b2 0
C7 m1_2720_2760# m1_1702_4448# 0
C8 b0 a_1624_3816# 0.15697f
C9 b0 b1 0.07045f
C10 m1_382_4448# m1_1523_3480# 0
C11 b0 a_2808_3816# 0
C12 a_4584_3816# b5 0.25028f
C13 a_1624_3816# m1_1262_4448# 0.01883f
C14 m1_4982_4448# a_4584_3816# 0.00404f
C15 b4 b5 0.04472f
C16 b0 m1_2408_3600# 0
C17 b2 b4 0
C18 a_4584_3816# m1_3222_4448# 0
C19 m1_1702_4448# m1_3908_2760# 0
C20 m1_2408_3600# m1_1262_4448# 0
C21 out m1_1262_4448# 0.01815f
C22 a_1624_3816# m1_1523_3480# 0.24354f
C23 m1_2720_2760# m1_1262_4448# 0
C24 m1_3222_4448# m1_1523_3480# 0.00589f
C25 a_4584_3816# a_3400_3816# 0.00726f
C26 b4 a_3400_3816# 0.05013f
C27 a_2808_3816# m1_1523_3480# 0
C28 b4 b3 0.0464f
C29 b0 vdd 0.93369f
C30 m1_382_4448# out 0.05592f
C31 b2 m1_3222_4448# 0.02027f
C32 m1_2408_3600# m1_1523_3480# 0.469f
C33 b2 b1 0.03795f
C34 a_4584_3816# a_3992_3816# 0.07047f
C35 m1_2720_2760# m1_1523_3480# 0.1053f
C36 b4 a_3992_3816# 0.14825f
C37 a_1624_3816# b1 0.07746f
C38 b2 a_2808_3816# 0.15545f
C39 m1_4102_4448# m1_1523_3480# 0
C40 a_1624_3816# a_2808_3816# 0
C41 b2 a_3400_3816# 0.0044f
C42 b2 b3 0.04625f
C43 a_2808_3816# m1_3222_4448# 0.33661f
C44 m1_2720_2760# b2 0.00703f
C45 a_2808_3816# b1 0
C46 a_1624_3816# m1_2408_3600# 0.06776f
C47 m1_2408_3600# m1_3222_4448# 0.04242f
C48 vdd a_4584_3816# 0.20323f
C49 a_3992_3816# b5 0.04355f
C50 a_1624_3816# m1_2720_2760# 0
C51 a_3400_3816# m1_3222_4448# 0.21689f
C52 m1_2408_3600# b1 0.03027f
C53 m1_3222_4448# b3 0.02397f
C54 m1_4102_4448# m1_4982_4448# 0
C55 vdd b4 0.42881f
C56 m1_2720_2760# m1_3222_4448# 0.29322f
C57 b1 b3 0
C58 m1_2720_2760# b1 0
C59 b0 a_2216_3816# 0
C60 m1_3908_2760# a_4584_3816# 0.00224f
C61 m1_2408_3600# a_2808_3816# 0.00831f
C62 vdd m1_1523_3480# 0.00181f
C63 b4 m1_3908_2760# 0.01955f
C64 a_2808_3816# a_3400_3816# 0.12718f
C65 a_2808_3816# b3 0.06713f
C66 a_3992_3816# m1_3222_4448# 0.00131f
C67 m1_4102_4448# m1_3222_4448# 0.00515f
C68 m1_2720_2760# a_2808_3816# 0.18059f
C69 m1_2408_3600# out 0.00379f
C70 m1_3908_2760# m1_1523_3480# 0
C71 m1_2720_2760# m1_2408_3600# 0.46666f
C72 a_3400_3816# b3 0.22216f
C73 m1_4982_4448# m1_5422_4448# 0.22446f
C74 m1_2720_2760# a_3400_3816# 0.00201f
C75 vdd b5 0.43768f
C76 a_2808_3816# a_3992_3816# 0
C77 vdd b2 0.50217f
C78 m1_4102_4448# m1_2408_3600# 0
C79 a_3400_3816# a_3992_3816# 0.06572f
C80 m1_4982_4448# m1_3908_2760# 0
C81 a_1624_3816# vdd 0.18717f
C82 m1_2720_2760# a_3992_3816# 0
C83 m1_4102_4448# m1_2720_2760# 0
C84 vdd m1_3222_4448# 0
C85 m1_822_4448# m1_1262_4448# 0.1481f
C86 vdd b1 0.57997f
C87 a_4584_3816# m1_4078_3250# 0.111f
C88 m1_3908_2760# m1_3222_4448# 0.79372f
C89 a_2216_3816# m1_1523_3480# 0.06767f
C90 m1_4102_4448# a_3992_3816# 0.00406f
C91 b4 m1_4078_3250# 0.00389f
C92 vdd a_2808_3816# 0.27798f
C93 vdd m1_2408_3600# 0.00431f
C94 vdd a_3400_3816# 0.23735f
C95 a_2808_3816# m1_3908_2760# 0.05146f
C96 vdd b3 0.48325f
C97 m1_2720_2760# vdd 0.00518f
C98 m1_822_4448# m1_382_4448# 0.24532f
C99 m1_822_4448# m1_1523_3480# 0
C100 m1_2408_3600# m1_3908_2760# 0.00121f
C101 b2 a_2216_3816# 0.05886f
C102 m1_3908_2760# a_3400_3816# 0.22332f
C103 m1_4102_4448# m1_5422_4448# 0
C104 m1_3908_2760# b3 0.00485f
C105 b5 m1_4078_3250# 0.00647f
C106 m1_2720_2760# m1_3908_2760# 0.00425f
C107 vdd a_3992_3816# 0.2529f
C108 a_1624_3816# a_2216_3816# 0.04096f
C109 m1_4982_4448# m1_4078_3250# 0.28435f
C110 a_2216_3816# m1_3222_4448# 0.00993f
C111 a_2216_3816# b1 0.2531f
C112 m1_3908_2760# a_3992_3816# 0.28733f
C113 m1_4102_4448# m1_3908_2760# 0.13034f
C114 m1_3222_4448# m1_4078_3250# 0.00268f
C115 a_2808_3816# a_2216_3816# 0.04827f
C116 m1_2408_3600# a_2216_3816# 0.39348f
C117 a_2216_3816# a_3400_3816# 0
C118 a_2216_3816# b3 0
C119 m1_2720_2760# a_2216_3816# 0.18569f
C120 m1_5422_4448# m1_3908_2760# 0
C121 a_3400_3816# m1_4078_3250# 0.02137f
C122 vdd m1_3908_2760# 0.00273f
C123 m1_1702_4448# m1_1262_4448# 0.26271f
C124 m1_2720_2760# m1_4078_3250# 0
C125 m1_2408_3600# m1_822_4448# 0
C126 m1_822_4448# out 0.03993f
C127 a_3992_3816# m1_4078_3250# 0.46129f
C128 m1_4102_4448# m1_4078_3250# 0.24673f
C129 m1_1702_4448# m1_382_4448# 0
C130 m1_1702_4448# m1_1523_3480# 0.11064f
C131 vdd a_2216_3816# 0.16862f
C132 m1_5422_4448# m1_4078_3250# 0.00347f
C133 vdd m1_4078_3250# 0
C134 m1_3908_2760# m1_4078_3250# 0.30336f
C135 a_1624_3816# m1_1702_4448# 0.00126f
C136 m1_4078_3250# vss 1.0193f
C137 m1_3908_2760# vss 0.6176f
C138 m1_1262_4448# vss 0.46622f
C139 m1_1702_4448# vss 0.50469f
C140 m1_3222_4448# vss 0.36281f
C141 m1_2720_2760# vss 0.22391f
C142 m1_822_4448# vss 0.40669f
C143 m1_2408_3600# vss 0.34795f
C144 m1_1523_3480# vss 0.30041f
C145 m1_382_4448# vss 0.76813f
C146 out vss 0.89235f
C147 m1_5422_4448# vss 0.76804f
C148 m1_4982_4448# vss 0.40392f
C149 vdd vss 15.03409f
C150 a_1624_3816# vss 1.18395f
C151 b0 vss 0.66386f
C152 a_2216_3816# vss 0.49587f
C153 b1 vss 0.50743f
C154 b2 vss 0.53627f
C155 a_2808_3816# vss 0.53292f
C156 a_3400_3816# vss 0.52169f
C157 b3 vss 0.32078f
C158 a_3992_3816# vss 0.54027f
C159 b4 vss 0.29907f
C160 a_4584_3816# vss 0.98136f
C161 b5 vss 0.41509f
C162 m1_4102_4448# vss 0.36138f
.ends

.subckt p_w0p8_l2 w_n374_n210# a_n288_n80# a_200_n80# a_n200_n124# VSUBS
X0 a_200_n80# a_n200_n124# a_n288_n80# w_n374_n210# pfet_03v3 ad=0.352p pd=2.48u as=0.352p ps=2.48u w=0.8u l=2u
C0 a_n288_n80# a_200_n80# 0.0084f
C1 w_n374_n210# a_n288_n80# 0.02527f
C2 a_n288_n80# a_n200_n124# 0.02312f
C3 w_n374_n210# a_200_n80# 0.02527f
C4 a_200_n80# a_n200_n124# 0.02312f
C5 w_n374_n210# a_n200_n124# 0.22666f
C6 a_200_n80# VSUBS 0.09823f
C7 a_n288_n80# VSUBS 0.09823f
C8 w_n374_n210# VSUBS 0.94248f
.ends

.subckt p_w4_l2_f4 w_n1130_n530# a_n956_n444# a_556_n444# a_n52_n400# a_452_n400#
+ a_n452_n444# a_n556_n400# a_52_n444# a_956_n400# a_n1044_n400# VSUBS
X0 a_n556_n400# a_n956_n444# a_n1044_n400# w_n1130_n530# pfet_03v3 ad=1.04p pd=4.52u as=1.76p ps=8.88u w=4u l=2u
X1 a_n52_n400# a_n452_n444# a_n556_n400# w_n1130_n530# pfet_03v3 ad=1.04p pd=4.52u as=1.04p ps=4.52u w=4u l=2u
X2 a_452_n400# a_52_n444# a_n52_n400# w_n1130_n530# pfet_03v3 ad=1.04p pd=4.52u as=1.04p ps=4.52u w=4u l=2u
X3 a_956_n400# a_556_n444# a_452_n400# w_n1130_n530# pfet_03v3 ad=1.76p pd=8.88u as=1.04p ps=4.52u w=4u l=2u
C0 a_n556_n400# a_n956_n444# 0.11799f
C1 a_n52_n400# a_n452_n444# 0.11799f
C2 a_452_n400# a_n52_n400# 0.04287f
C3 w_n1130_n530# a_n1044_n400# 0.12268f
C4 a_n52_n400# a_52_n444# 0.11799f
C5 w_n1130_n530# a_n52_n400# 0.18497f
C6 a_n556_n400# a_n1044_n400# 0.04287f
C7 a_n52_n400# a_n556_n400# 0.04287f
C8 a_n956_n444# a_n1044_n400# 0.11799f
C9 a_n452_n444# a_52_n444# 0.00519f
C10 a_556_n444# a_956_n400# 0.11799f
C11 w_n1130_n530# a_n452_n444# 0.21994f
C12 a_452_n400# a_956_n400# 0.04287f
C13 w_n1130_n530# a_956_n400# 0.12268f
C14 a_n452_n444# a_n556_n400# 0.11799f
C15 a_452_n400# a_556_n444# 0.11799f
C16 a_556_n444# a_52_n444# 0.00519f
C17 w_n1130_n530# a_556_n444# 0.2233f
C18 a_n452_n444# a_n956_n444# 0.00519f
C19 a_452_n400# a_52_n444# 0.11799f
C20 w_n1130_n530# a_452_n400# 0.18497f
C21 w_n1130_n530# a_52_n444# 0.21994f
C22 w_n1130_n530# a_n556_n400# 0.18497f
C23 w_n1130_n530# a_n956_n444# 0.2233f
C24 a_956_n400# VSUBS 0.19832f
C25 a_452_n400# VSUBS 0.12191f
C26 a_n52_n400# VSUBS 0.11851f
C27 a_n556_n400# VSUBS 0.12191f
C28 a_n1044_n400# VSUBS 0.19832f
C29 w_n1130_n530# VSUBS 7.1868f
.ends

.subckt p_w0p5_l10 a_n1088_n50# a_1000_n50# w_n1174_n180# a_n1000_n94# VSUBS
X0 a_1000_n50# a_n1000_n94# a_n1088_n50# w_n1174_n180# pfet_03v3 ad=0.22p pd=1.88u as=0.22p ps=1.88u w=0.5u l=10u
C0 a_n1000_n94# a_n1088_n50# 0.01858f
C1 w_n1174_n180# a_n1088_n50# 0.02013f
C2 a_1000_n50# a_n1000_n94# 0.01858f
C3 w_n1174_n180# a_n1000_n94# 1.0092f
C4 w_n1174_n180# a_1000_n50# 0.02013f
C5 a_1000_n50# VSUBS 0.30033f
C6 a_n1088_n50# VSUBS 0.30033f
C7 w_n1174_n180# VSUBS 2.53584f
.ends

.subckt n_w2_l2_f4 a_n52_n200# a_452_n200# a_n452_n244# a_n556_n200# a_52_n244# a_956_n200#
+ a_n1044_n200# a_n956_n244# a_556_n244# VSUBS
X0 a_452_n200# a_52_n244# a_n52_n200# VSUBS nfet_03v3 ad=0.52p pd=2.52u as=0.52p ps=2.52u w=2u l=2u
X1 a_956_n200# a_556_n244# a_452_n200# VSUBS nfet_03v3 ad=0.88p pd=4.88u as=0.52p ps=2.52u w=2u l=2u
X2 a_n556_n200# a_n956_n244# a_n1044_n200# VSUBS nfet_03v3 ad=0.52p pd=2.52u as=0.88p ps=4.88u w=2u l=2u
X3 a_n52_n200# a_n452_n244# a_n556_n200# VSUBS nfet_03v3 ad=0.52p pd=2.52u as=0.52p ps=2.52u w=2u l=2u
C0 a_n52_n200# a_n452_n244# 0.0587f
C1 a_956_n200# a_452_n200# 0.02133f
C2 a_n956_n244# a_n556_n200# 0.0587f
C3 a_n1044_n200# a_n556_n200# 0.02133f
C4 a_452_n200# a_52_n244# 0.0587f
C5 a_452_n200# a_556_n244# 0.0587f
C6 a_n52_n200# a_n556_n200# 0.02133f
C7 a_956_n200# a_556_n244# 0.0587f
C8 a_n452_n244# a_52_n244# 0.00519f
C9 a_556_n244# a_52_n244# 0.00519f
C10 a_n956_n244# a_n452_n244# 0.00519f
C11 a_452_n200# a_n52_n200# 0.02133f
C12 a_n956_n244# a_n1044_n200# 0.0587f
C13 a_n452_n244# a_n556_n200# 0.0587f
C14 a_n52_n200# a_52_n244# 0.0587f
C15 a_956_n200# VSUBS 0.26162f
C16 a_452_n200# VSUBS 0.34773f
C17 a_n52_n200# VSUBS 0.34265f
C18 a_n556_n200# VSUBS 0.34773f
C19 a_n1044_n200# VSUBS 0.26162f
.ends

.subckt p_w4_l1_f4 a_252_n400# a_n556_n444# a_n644_n400# a_n252_n444# a_n356_n400#
+ a_n52_n400# a_356_n444# w_n730_n530# a_52_n444# a_556_n400# VSUBS
X0 a_n356_n400# a_n556_n444# a_n644_n400# w_n730_n530# pfet_03v3 ad=1.04p pd=4.52u as=1.76p ps=8.88u w=4u l=1u
X1 a_556_n400# a_356_n444# a_252_n400# w_n730_n530# pfet_03v3 ad=1.76p pd=8.88u as=1.04p ps=4.52u w=4u l=1u
X2 a_n52_n400# a_n252_n444# a_n356_n400# w_n730_n530# pfet_03v3 ad=1.04p pd=4.52u as=1.04p ps=4.52u w=4u l=1u
X3 a_252_n400# a_52_n444# a_n52_n400# w_n730_n530# pfet_03v3 ad=1.04p pd=4.52u as=1.04p ps=4.52u w=4u l=1u
C0 a_556_n400# a_252_n400# 0.07756f
C1 a_n356_n400# a_n52_n400# 0.07756f
C2 w_n730_n530# a_n644_n400# 0.09518f
C3 a_n356_n400# a_n556_n444# 0.08505f
C4 a_356_n444# w_n730_n530# 0.12548f
C5 a_252_n400# a_n52_n400# 0.07756f
C6 a_356_n444# a_556_n400# 0.08505f
C7 w_n730_n530# a_556_n400# 0.09518f
C8 a_n644_n400# a_n556_n444# 0.08505f
C9 w_n730_n530# a_n52_n400# 0.12997f
C10 a_252_n400# a_52_n444# 0.08505f
C11 w_n730_n530# a_n556_n444# 0.12548f
C12 a_356_n444# a_52_n444# 0.00519f
C13 w_n730_n530# a_52_n444# 0.12212f
C14 a_n356_n400# a_n252_n444# 0.08505f
C15 a_n52_n400# a_52_n444# 0.08505f
C16 w_n730_n530# a_n252_n444# 0.12212f
C17 a_n252_n444# a_n52_n400# 0.08505f
C18 a_n252_n444# a_n556_n444# 0.00519f
C19 a_n356_n400# a_n644_n400# 0.07756f
C20 a_n356_n400# w_n730_n530# 0.12997f
C21 a_n252_n444# a_52_n444# 0.00519f
C22 a_356_n444# a_252_n400# 0.08505f
C23 w_n730_n530# a_252_n400# 0.12997f
C24 a_556_n400# VSUBS 0.17216f
C25 a_252_n400# VSUBS 0.0696f
C26 a_n52_n400# VSUBS 0.06619f
C27 a_n356_n400# VSUBS 0.0696f
C28 a_n644_n400# VSUBS 0.17216f
C29 w_n730_n530# VSUBS 4.6428f
.ends

.subckt n_w4_l2_f2 a_n52_n400# a_452_n400# a_n452_n444# a_n540_n400# a_52_n444# VSUBS
X0 a_n52_n400# a_n452_n444# a_n540_n400# VSUBS nfet_03v3 ad=1.04p pd=4.52u as=1.76p ps=8.88u w=4u l=2u
X1 a_452_n400# a_52_n444# a_n52_n400# VSUBS nfet_03v3 ad=1.76p pd=8.88u as=1.04p ps=4.52u w=4u l=2u
C0 a_52_n444# a_n452_n444# 0.00519f
C1 a_n452_n444# a_n540_n400# 0.11799f
C2 a_52_n444# a_452_n400# 0.11799f
C3 a_n52_n400# a_n452_n444# 0.11799f
C4 a_n52_n400# a_52_n444# 0.11799f
C5 a_n52_n400# a_452_n400# 0.04287f
C6 a_n52_n400# a_n540_n400# 0.04287f
C7 a_452_n400# VSUBS 0.33857f
C8 a_n52_n400# VSUBS 0.35281f
C9 a_n540_n400# VSUBS 0.33857f
.ends

.subckt p_w1_l0p5 a_n138_n100# a_50_n100# a_n50_n144# w_n224_n230# VSUBS
X0 a_50_n100# a_n50_n144# a_n138_n100# w_n224_n230# pfet_03v3 ad=0.44p pd=2.88u as=0.44p ps=2.88u w=1u l=0.5u
C0 a_n50_n144# w_n224_n230# 0.07993f
C1 w_n224_n230# a_n138_n100# 0.0205f
C2 a_n50_n144# a_n138_n100# 0.01275f
C3 a_50_n100# w_n224_n230# 0.0205f
C4 a_50_n100# a_n50_n144# 0.01275f
C5 a_50_n100# a_n138_n100# 0.03085f
C6 a_50_n100# VSUBS 0.06546f
C7 a_n138_n100# VSUBS 0.06546f
C8 w_n224_n230# VSUBS 0.61824f
.ends

.subckt p_w4_l2 w_n374_n530# a_n288_n400# a_200_n400# a_n200_n444# VSUBS
X0 a_200_n400# a_n200_n444# a_n288_n400# w_n374_n530# pfet_03v3 ad=1.76p pd=8.88u as=1.76p ps=8.88u w=4u l=2u
C0 a_n200_n444# w_n374_n530# 0.22666f
C1 w_n374_n530# a_n288_n400# 0.12268f
C2 a_n200_n444# a_n288_n400# 0.11799f
C3 a_200_n400# w_n374_n530# 0.12268f
C4 a_200_n400# a_n200_n444# 0.11799f
C5 a_200_n400# a_n288_n400# 0.04287f
C6 a_200_n400# VSUBS 0.20173f
C7 a_n288_n400# VSUBS 0.20173f
C8 w_n374_n530# VSUBS 2.37864f
.ends

.subckt n_w4_l2 a_n288_n400# a_200_n400# a_n200_n444# VSUBS
X0 a_200_n400# a_n200_n444# a_n288_n400# VSUBS nfet_03v3 ad=1.76p pd=8.88u as=1.76p ps=8.88u w=4u l=2u
C0 a_n288_n400# a_n200_n444# 0.11799f
C1 a_n200_n444# a_200_n400# 0.11799f
C2 a_n288_n400# a_200_n400# 0.04287f
C3 a_200_n400# VSUBS 0.34365f
C4 a_n288_n400# VSUBS 0.34365f
.ends

.subckt p_w4_l1 a_n188_n400# a_100_n400# a_n100_n444# w_n274_n530# VSUBS
X0 a_100_n400# a_n100_n444# a_n188_n400# w_n274_n530# pfet_03v3 ad=1.76p pd=8.88u as=1.76p ps=8.88u w=4u l=1u
C0 a_n100_n444# w_n274_n530# 0.12884f
C1 w_n274_n530# a_n188_n400# 0.09518f
C2 a_n100_n444# a_n188_n400# 0.08505f
C3 a_100_n400# w_n274_n530# 0.09518f
C4 a_100_n400# a_n100_n444# 0.08505f
C5 a_100_n400# a_n188_n400# 0.07756f
C6 a_100_n400# VSUBS 0.17557f
C7 a_n188_n400# VSUBS 0.17557f
C8 w_n274_n530# VSUBS 1.74264f
.ends

.subckt r_w1_l14p19 a_n100_1419# a_n100_n1541# VSUBS
X0 a_n100_1419# a_n100_n1541# VSUBS ppolyf_u_1k r_width=1u r_length=14.19u
C0 a_n100_n1541# VSUBS 0.27003f
C1 a_n100_1419# VSUBS 0.27003f
.ends

.subckt p_w0p5_l4 a_n488_n50# a_400_n50# a_n400_n94# w_n574_n180# VSUBS
X0 a_400_n50# a_n400_n94# a_n488_n50# w_n574_n180# pfet_03v3 ad=0.22p pd=1.88u as=0.22p ps=1.88u w=0.5u l=4u
C0 a_n400_n94# w_n574_n180# 0.42229f
C1 w_n574_n180# a_n488_n50# 0.01856f
C2 a_n400_n94# a_n488_n50# 0.01702f
C3 a_400_n50# w_n574_n180# 0.01856f
C4 a_400_n50# a_n400_n94# 0.01702f
C5 a_400_n50# a_n488_n50# 0.0026f
C6 a_400_n50# VSUBS 0.14084f
C7 a_n488_n50# VSUBS 0.14084f
C8 w_n574_n180# VSUBS 1.23984f
.ends

.subckt bias_vi en vglp vgln vth_cmp vth_ref m1_8646_1098# m1_942_738# vreset_src
+ iint m1_8042_6360# m1_7102_850# ib_x2 m1_7440_2050# m1_5388_6960# m1_4894_1238#
+ a_5712_1328# a_2102_5152# m1_4546_7560# m1_502_738# m1_1276_6360# m1_1382_738# vbn_prb
+ vdd a_4976_1528# m1_8332_7080# el a_864_6450# vss ib_r1
XPP vdd vdd vbn_prb a_864_6450# vss p_w0p8_l2
XMO vdd a_864_6450# a_864_6450# vdd m1_1276_6360# a_864_6450# m1_1276_6360# a_864_6450#
+ vdd vdd vss p_w4_l2_f4
XPS vdd m1_7102_850# vdd vgln vss p_w0p5_l10
XOR vss ib_r1 vbn_prb ib_r1 vbn_prb vss vss vbn_prb vbn_prb vss n_w2_l2_f4
XKO a_4976_1528# vglp m1_1276_6360# vglp a_4976_1528# m1_1276_6360# vglp vdd vglp
+ m1_1276_6360# vss p_w4_l1_f4
XMR vdd a_864_6450# a_864_6450# vdd m1_5388_6960# a_864_6450# m1_5388_6960# a_864_6450#
+ vdd vdd vss p_w4_l2_f4
XP1 vdd a_2102_5152# a_2102_5152# vdd vss p_w2_l2
XNS vss m1_7102_850# a_5712_1328# m1_7102_850# a_5712_1328# vss n_w4_l2_f2
XPOFF vdd a_864_6450# en vdd vss p_w1_l0p5
XP2 vdd a_864_6450# a_2102_5152# vdd vss p_w2_l2
XMS2 vss en m1_8646_1098# vss n_w0p5_l1
XMS1 m1_8646_1098# m1_7102_850# a_864_6450# vss n_w0p5_l1
XNT vss m1_4894_1238# a_5712_1328# vss n_w2_l2
XMT vdd vdd m1_8332_7080# a_864_6450# vss p_w4_l2
XKR vreset_src vglp m1_5388_6960# vglp vreset_src m1_5388_6960# vglp vdd vglp m1_5388_6960#
+ vss p_w4_l1_f4
XN1 m1_4894_1238# a_864_6450# vglp vss n_w4_l2
XN2 m1_4894_1238# a_2102_5152# a_4976_1528# vss n_w4_l2
XKT m1_8332_7080# vth_ref vglp vdd vss p_w4_l1
XOX vss m1_7440_2050# vbn_prb m1_7440_2050# vbn_prb vss vss vbn_prb vbn_prb vss n_w2_l2_f4
XXR00 a_4976_1528# m1_502_738# vss r_w1_l14p19
XXR01 m1_502_738# m1_942_738# vss r_w1_l14p19
XXR03 m1_1382_738# vss vss r_w1_l14p19
XXR02 m1_942_738# m1_1382_738# vss r_w1_l14p19
XPB vdd a_5712_1328# a_864_6450# vdd vss p_w0p5_l4
XNB vss a_5712_1328# a_5712_1328# vss n_w2_l2
XMC vdd a_864_6450# a_864_6450# vdd m1_8042_6360# a_864_6450# m1_8042_6360# a_864_6450#
+ vdd vdd vss p_w4_l2_f4
XKC vth_cmp vglp m1_8042_6360# vglp vth_cmp m1_8042_6360# vglp vdd vglp m1_8042_6360#
+ vss p_w4_l1_f4
XME vdd a_864_6450# a_864_6450# vdd m1_4546_7560# a_864_6450# m1_4546_7560# a_864_6450#
+ vdd vdd vss p_w4_l2_f4
XPI vdd vdd iint a_864_6450# vss p_w0p8_l2
XSX2 m1_7440_2050# ib_r1 ib_x2 vss n_w4_l0p5
XKE el vglp m1_4546_7560# vglp el m1_4546_7560# vglp vdd vglp m1_4546_7560# vss p_w4_l1_f4
XDB vss vbn_prb vbn_prb vss n_w2_l2
C0 vbn_prb m1_4894_1238# 0.02997f
C1 iint a_864_6450# 0.13343f
C2 m1_7102_850# vdd 0.12129f
C3 vdd a_2102_5152# 1.73077f
C4 m1_7102_850# a_864_6450# 0.14649f
C5 a_5712_1328# vglp 0.16841f
C6 a_864_6450# m1_8646_1098# 0.03779f
C7 a_864_6450# a_2102_5152# 0.40639f
C8 vreset_src m1_5388_6960# 0.26696f
C9 a_864_6450# m1_7440_2050# 0.06786f
C10 m1_8042_6360# vreset_src 0.26401f
C11 vreset_src vdd 0.46224f
C12 m1_1276_6360# a_2102_5152# 0.00961f
C13 en ib_r1 0.13773f
C14 m1_4894_1238# a_5712_1328# 0.16211f
C15 m1_4894_1238# vglp 0.286f
C16 vreset_src a_864_6450# 0.08448f
C17 el m1_5388_6960# 0
C18 vdd a_4976_1528# 1.4633f
C19 en vgln 0.06792f
C20 en m1_502_738# 0.01007f
C21 ib_x2 vdd 0
C22 m1_4546_7560# m1_5388_6960# 0.09335f
C23 el vdd 0.94055f
C24 a_864_6450# a_4976_1528# 0.73462f
C25 iint en 0.17194f
C26 m1_8042_6360# m1_8332_7080# 0.13476f
C27 vdd m1_1382_738# 0.0035f
C28 m1_942_738# vdd 0.00344f
C29 vgln ib_r1 0.04275f
C30 m1_4546_7560# vdd 0.40586f
C31 vdd m1_8332_7080# 0.82484f
C32 ib_x2 a_864_6450# 0.02181f
C33 el a_864_6450# 0.02982f
C34 iint ib_r1 0.10242f
C35 en m1_7102_850# 0.14198f
C36 m1_4546_7560# a_864_6450# 0.73f
C37 a_864_6450# m1_8332_7080# 0.09337f
C38 m1_1276_6360# a_4976_1528# 0.30906f
C39 en m1_8646_1098# 0.001f
C40 m1_8042_6360# vbn_prb 0
C41 en a_2102_5152# 0.04646f
C42 iint vgln 0.12915f
C43 vbn_prb vdd 0.24855f
C44 vth_cmp vreset_src 0.14964f
C45 el m1_1276_6360# 0.00217f
C46 m1_7102_850# ib_r1 0.03826f
C47 m1_5388_6960# vth_ref 0
C48 en m1_7440_2050# 0.05869f
C49 m1_8042_6360# vth_ref 0.00285f
C50 ib_r1 a_2102_5152# 0.11035f
C51 vbn_prb a_864_6450# 0.59172f
C52 m1_4546_7560# m1_1276_6360# 0.14038f
C53 vdd vth_ref 0.31053f
C54 m1_7102_850# vgln 0.08937f
C55 ib_r1 m1_7440_2050# 0.00546f
C56 vgln a_2102_5152# 0.08399f
C57 a_864_6450# vth_ref 0.00723f
C58 vth_cmp el 0.048f
C59 iint m1_7102_850# 0.3658f
C60 vgln m1_7440_2050# 0
C61 iint a_2102_5152# 0
C62 vth_cmp m1_8332_7080# 0.00111f
C63 en a_4976_1528# 0.05046f
C64 iint m1_7440_2050# 0
C65 m1_5388_6960# a_5712_1328# 0.00317f
C66 ib_x2 en 0.14421f
C67 m1_7102_850# m1_8646_1098# -0.00509f
C68 m1_5388_6960# vglp 0.15331f
C69 vreset_src vgln 0
C70 a_5712_1328# vdd 0.56694f
C71 en m1_1382_738# 0.14813f
C72 ib_r1 a_4976_1528# 0.24273f
C73 m1_8042_6360# vglp 0.2232f
C74 en m1_942_738# 0.00966f
C75 m1_7102_850# m1_7440_2050# 0.02863f
C76 vdd vglp 5.25107f
C77 ib_x2 ib_r1 0.20298f
C78 m1_8646_1098# m1_7440_2050# 0.00687f
C79 a_864_6450# a_5712_1328# 0.04659f
C80 vgln a_4976_1528# 0
C81 m1_502_738# a_4976_1528# 0.04144f
C82 vth_cmp vth_ref 0.05697f
C83 a_864_6450# vglp 0.83998f
C84 ib_x2 vgln 0.26925f
C85 iint a_4976_1528# 0
C86 vbn_prb en 0.26578f
C87 m1_502_738# m1_1382_738# 0
C88 iint ib_x2 0.04728f
C89 m1_502_738# m1_942_738# 0.42104f
C90 m1_1276_6360# vglp 0.16358f
C91 vbn_prb ib_r1 0.81062f
C92 ib_x2 m1_7102_850# 0.07339f
C93 a_4976_1528# a_2102_5152# 0.4055f
C94 a_864_6450# m1_4894_1238# 0.3222f
C95 ib_x2 m1_8646_1098# 0.01147f
C96 vbn_prb vgln 0.23038f
C97 ib_x2 a_2102_5152# 0.01217f
C98 a_2102_5152# m1_1382_738# 0
C99 ib_x2 m1_7440_2050# 0.08935f
C100 vth_cmp vglp 0.28484f
C101 iint vbn_prb 0.08998f
C102 m1_4546_7560# a_2102_5152# 0.0186f
C103 vbn_prb m1_7102_850# 0.11192f
C104 en a_5712_1328# 0.05214f
C105 vbn_prb m1_8646_1098# 0
C106 el vreset_src 0.03609f
C107 en vglp 0.59159f
C108 vbn_prb a_2102_5152# 0.11077f
C109 m1_4546_7560# vreset_src 0.00447f
C110 vreset_src m1_8332_7080# 0.01543f
C111 vbn_prb m1_7440_2050# 0.36218f
C112 a_5712_1328# ib_r1 0.15887f
C113 ib_x2 a_4976_1528# 0.04795f
C114 el a_4976_1528# 0.00185f
C115 vglp ib_r1 0.44719f
C116 a_4976_1528# m1_1382_738# 0.00776f
C117 vgln a_5712_1328# 0.3298f
C118 m1_942_738# a_4976_1528# 0.00922f
C119 m1_4546_7560# a_4976_1528# 0.00278f
C120 ib_x2 m1_1382_738# 0
C121 vgln vglp 0
C122 en m1_4894_1238# 0
C123 el m1_8332_7080# 0.00199f
C124 m1_4546_7560# el 0.12283f
C125 iint a_5712_1328# 0.29607f
C126 m1_942_738# m1_1382_738# 0.08765f
C127 iint vglp 0.04831f
C128 m1_8042_6360# m1_5388_6960# 0.11312f
C129 m1_5388_6960# vdd 0.62183f
C130 vreset_src vth_ref 0.1174f
C131 m1_4894_1238# ib_r1 0.16682f
C132 vbn_prb a_4976_1528# 0.11005f
C133 m1_7102_850# a_5712_1328# 0.54324f
C134 m1_8042_6360# vdd 0.53891f
C135 ib_x2 vbn_prb 0.06125f
C136 m1_7102_850# vglp 0.18545f
C137 a_5712_1328# a_2102_5152# 0.15699f
C138 m1_5388_6960# a_864_6450# 0.32262f
C139 vbn_prb m1_1382_738# 0
C140 vglp m1_8646_1098# 0
C141 vglp a_2102_5152# 0.09855f
C142 m1_8042_6360# a_864_6450# 0.5698f
C143 a_5712_1328# m1_7440_2050# 0.03242f
C144 a_864_6450# vdd 10.38485f
C145 el vth_ref 0.71135f
C146 iint m1_4894_1238# 0.00172f
C147 vglp m1_7440_2050# 0.05819f
C148 vth_ref m1_8332_7080# 0.06042f
C149 m1_7102_850# m1_4894_1238# 0
C150 m1_1276_6360# vdd 0.61385f
C151 vreset_src vglp 0.54612f
C152 m1_4894_1238# a_2102_5152# 0.06382f
C153 m1_1276_6360# a_864_6450# 0.39666f
C154 a_5712_1328# a_4976_1528# 0.0106f
C155 vth_cmp m1_5388_6960# 0.00607f
C156 vglp a_4976_1528# 0.38892f
C157 m1_8042_6360# vth_cmp 0.21651f
C158 ib_x2 a_5712_1328# 0.10242f
C159 vth_cmp vdd 0.17797f
C160 ib_x2 vglp 0.10572f
C161 el vglp 0.41693f
C162 m1_4546_7560# a_5712_1328# 0
C163 vglp m1_1382_738# 0.00131f
C164 vth_cmp a_864_6450# 0.02777f
C165 m1_4546_7560# vglp 0.73349f
C166 vglp m1_8332_7080# 0.0652f
C167 m1_8042_6360# en 0
C168 en vdd 0.32674f
C169 m1_4894_1238# a_4976_1528# 0.17878f
C170 vbn_prb a_5712_1328# 0.18056f
C171 ib_x2 m1_4894_1238# 0.06226f
C172 vbn_prb vglp 0.48983f
C173 en a_864_6450# 0.33221f
C174 vdd ib_r1 0
C175 vgln m1_5388_6960# 0.00536f
C176 vglp vth_ref 0.06719f
C177 vgln vdd 2.2258f
C178 a_864_6450# ib_r1 0.24976f
C179 m1_502_738# vdd 0.00342f
C180 m1_8042_6360# iint 0
C181 iint vdd 0.18374f
C182 vgln a_864_6450# 0.12647f
C183 m1_8042_6360# vss -0.29705f
C184 vbn_prb vss 3.71278f
C185 el vss 0.65712f
C186 m1_4546_7560# vss -0.26802f
C187 ib_x2 vss 3.37258f
C188 iint vss 1.91268f
C189 vth_cmp vss 0.07828f
C190 m1_1382_738# vss 1.13003f
C191 m1_942_738# vss 0.5126f
C192 m1_502_738# vss 0.71186f
C193 m1_7440_2050# vss 0.52223f
C194 vth_ref vss 0.57598f
C195 m1_8332_7080# vss -0.04322f
C196 a_2102_5152# vss 0.19991f
C197 a_4976_1528# vss 1.61618f
C198 a_864_6450# vss -0.98223f
C199 m1_4894_1238# vss 0.33472f
C200 vglp vss 1.49743f
C201 vreset_src vss 0.10863f
C202 m1_5388_6960# vss -0.271f
C203 a_5712_1328# vss 1.81802f
C204 m1_8646_1098# vss 0.01901f
C205 en vss 2.7871f
C206 m1_7102_850# vss 0.68137f
C207 m1_1276_6360# vss -0.17835f
C208 ib_r1 vss 1.6597f
C209 vgln vss 0.40803f
C210 vdd vss 64.84496f
.ends

.subckt bias_b1 vth_ref vreset_src ib_r1 ua0 vbn_leak vbn_ref vbp_syn vbp_st vbn_prb
+ el vth_cmp vbn_ax vbp_w ua0_stim_out r0_b0 r0_b1 r0_b2 r0_b3 r0_b4 r2_b0 r2_b1 r2_b2
+ r2_b3 r2_b4 r1_b0 r1_b1 r1_b2 r1_b3 r1_b4 i2_b0 i4_b0 i2_b1 i4_b1 i2_b2 i4_b2 i2_b3
+ i4_b3 i2_b4 i4_b4 i0_b0 i1_b0 i3_b0 i0_b1 i1_b1 i3_b1 i0_b2 i1_b2 i3_b2 i0_b3 i1_b3
+ i3_b3 i0_b4 i1_b4 i3_b4 v0_c0 v0_c1 v0_c2 v0_c3 v0_c4 v0_c5 bias_en ib_x2 ua0_s0
+ ua0_s1 ua0_stim ua0_int vdd vss
XXx0 vdd vss vbn_leak rx_n4
XXx1 vbn_ref vdd vss rx_n2
XXx2 vbp_syn vss vdd rx_p24
XXx3 vdd vss vbn_ax rx_n1
XXx4 vbp_w vdd vss rx_p05
XXg Xm/in_n Xi1/g Xg/m1_6020_10200# Xg/m1_3298_2050# Xg/m1_4760_1320# Xg/m1_5022_10210#
+ Xg/m1_3530_1930# Xg/m1_3898_9610# Xg/a_7580_5314# vss Xi0/g Xg/m1_4906_9490# vdd
+ Xg/m1_6282_1450# Xg/a_1580_5314# Xg/m1_3666_9610# Xg/m1_5516_1920# Xg/a_4580_5314#
+ Xg/m1_4538_1930# Xi4/g Xr/vsn Xg/a_5188_4156# Xi2/g Xr/vsp Xr/vglp Xi3/g Xg/a_3036_4156#
+ Xr/vgln Xm/in_p bias_ladder
XXi1 i1_b0 i1_b1 i1_b3 i1_b4 vbn_ref Xr/vgln vss Xi1/m1_988_3464# Xi1/m1_988_2804#
+ vdd Xi1/a_1378_4392# Xi1/a_3078_4392# i1_b2 Xi1/m1_988_888# Xi1/a_2228_4392# Xi1/m1_240_3480#
+ Xi1/a_3928_4392# vss Xi1/a_528_4392# Xi1/a_1582_4392# Xi1/a_4132_4392# Xi1/a_2432_4392#
+ Xi1/m1_1500_4312# Xi1/a_732_4392# Xr/vsp Xi1/a_3282_4392# Xi1/g idac_p
XXi0 i0_b0 i0_b1 i0_b3 i0_b4 vbn_leak Xr/vgln vss Xi0/m1_988_3464# Xi0/m1_988_2804#
+ vdd Xi0/a_1378_4392# Xi0/a_3078_4392# i0_b2 Xi0/m1_988_888# Xi0/a_2228_4392# Xi0/m1_240_3480#
+ Xi0/a_3928_4392# vss Xi0/a_528_4392# Xi0/a_1582_4392# Xi0/a_4132_4392# Xi0/a_2432_4392#
+ Xi0/m1_1500_4312# Xi0/a_732_4392# Xr/vsp Xi0/a_3282_4392# Xi0/g idac_p
XXm ua0 ua0_s0 ua0_s1 ua0_stim ua0_int bias_en Xm/in_n Xm/in_p Xm/iint Xr/en_b vbp_st
+ ua0_stim_out Xm/a_1744_9182# vss Xm/a_1764_11418# vdd Xm/a_1744_10100# Xm/a_2240_11218#
+ Xm/a_420_700# Xm/a_736_7228# Xm/a_736_5516# bias_master
XXi2 i2_b0 i2_b1 i2_b2 i2_b3 i2_b4 vbp_syn Xr/vgln vdd Xi2/m1_988_3304# Xi2/a_1378_4170#
+ Xi2/a_528_4170# Xi2/a_2228_4170# Xi2/a_3928_4170# Xi2/m1_988_2644# Xi2/a_2432_4170#
+ Xi2/g Xi2/a_3282_4170# Xi2/a_1582_4170# Xi2/m1_988_888# Xi2/m1_260_2080# vdd Xi2/m1_1500_3762#
+ Xi2/a_4132_4170# Xr/vsn vss Xi2/a_3078_4170# Xi2/a_732_4170# idac_n
XXxst vbp_st vdd vss rx_p05
XXi3 i3_b0 i3_b1 i3_b3 i3_b4 vbn_ax Xr/vgln vss Xi3/m1_988_3464# Xi3/m1_988_2804#
+ vdd Xi3/a_1378_4392# Xi3/a_3078_4392# i3_b2 Xi3/m1_988_888# Xi3/a_2228_4392# Xi3/m1_240_3480#
+ Xi3/a_3928_4392# vss Xi3/a_528_4392# Xi3/a_1582_4392# Xi3/a_4132_4392# Xi3/a_2432_4392#
+ Xi3/m1_1500_4312# Xi3/a_732_4392# Xr/vsp Xi3/a_3282_4392# Xi3/g idac_p
XXi4 i4_b0 i4_b1 i4_b2 i4_b3 i4_b4 vbp_w Xr/vgln vdd Xi4/m1_988_3304# Xi4/a_1378_4170#
+ Xi4/a_528_4170# Xi4/a_2228_4170# Xi4/a_3928_4170# Xi4/m1_988_2644# Xi4/a_2432_4170#
+ Xi4/g Xi4/a_3282_4170# Xi4/a_1582_4170# Xi4/m1_988_888# Xi4/m1_260_2080# vdd Xi4/m1_1500_3762#
+ Xi4/a_4132_4170# Xr/vsn vss Xi4/a_3078_4170# Xi4/a_732_4170# idac_n
XXd0 r0_b0 r0_b1 r0_b2 r0_b3 r0_b4 vdd el Xd0/m1_3662_4048# Xd0/m1_2742_3250# Xd0/a_2224_3416#
+ Xd0/a_3408_3416# Xd0/m1_822_4048# Xd0/a_1632_3416# Xd0/m1_3310_2880# Xd0/m1_1262_4048#
+ Xd0/a_1040_3416# vss Xd0/a_2816_3416# Xd0/m1_617_3840# Xd0/m1_2242_4966# Xd0/m1_956_3000#
+ Xd0/m1_382_4048# vdacr_el
XXd1 r1_b0 r1_b1 r1_b2 r1_b3 r1_b4 vreset_src vss Xd1/m1_2862_4048# Xd1/a_680_3416#
+ Xd1/a_2456_3416# vdd Xd1/m1_860_4046# Xd1/m1_462_4048# Xd1/m1_2974_2650# Xd1/a_1864_3416#
+ Xd1/a_3048_3416# Xd1/m1_2372_2520# Xd1/m1_756_3120# Xd1/a_1272_3416# Xd1/m1_606_2410#
+ Xd1/m1_1780_5040# vdacr_vr
XXr Xr/vsp Xr/vgln Xr/en_b vdd Xr/m1_782_438# Xr/m1_3422_438# Xr/m1_3862_3522# Xr/m1_2542_438#
+ vss Xr/m1_1222_3522# Xr/m1_342_438# Xr/vsn Xr/m1_1662_438# Xr/vglp bias_rails
XXd2 r2_b0 r2_b1 r2_b2 r2_b3 r2_b4 vdd vth_cmp vss Xd2/a_680_3416# Xd2/a_2456_3416#
+ Xd2/m1_596_2880# Xd2/a_1864_3416# Xd2/m1_1342_4048# Xd2/a_3048_3416# Xd2/m1_1780_2760#
+ Xd2/m1_2382_2650# Xd2/a_1272_3416# Xd2/m1_902_4048# Xd2/m1_756_3240# Xd2/m1_2964_2640#
+ vdacr_vc
XXd3 v0_c0 v0_c1 v0_c2 v0_c3 v0_c4 v0_c5 vdd Xd3/m1_2720_2760# Xd3/a_4584_3816# Xd3/m1_5422_4448#
+ vss Xd3/m1_382_4448# Xd3/m1_822_4448# Xd3/a_1624_3816# Xd3/a_3992_3816# Xd3/m1_1523_3480#
+ vth_ref Xd3/a_3400_3816# Xd3/a_2808_3816# Xd3/m1_1702_4448# Xd3/m1_2408_3600# Xd3/m1_3908_2760#
+ Xd3/m1_4078_3250# Xd3/m1_4102_4448# Xd3/m1_3222_4448# Xd3/a_2216_3816# Xd3/m1_4982_4448#
+ Xd3/m1_1262_4448# vdacr_vt
XXvi bias_en Xr/vglp Xr/vgln vth_cmp vth_ref Xvi/m1_8646_1098# Xvi/m1_942_738# vreset_src
+ Xm/iint Xvi/m1_8042_6360# Xvi/m1_7102_850# ib_x2 Xvi/m1_7440_2050# Xvi/m1_5388_6960#
+ Xvi/m1_4894_1238# Xvi/a_5712_1328# Xvi/a_2102_5152# Xvi/m1_4546_7560# Xvi/m1_502_738#
+ Xvi/m1_1276_6360# Xvi/m1_1382_738# vbn_prb vdd Xvi/a_4976_1528# Xvi/m1_8332_7080#
+ el Xvi/a_864_6450# vss ib_r1 bias_vi
C0 r0_b4 vbp_w 0.15451f
C1 Xg/a_3036_4156# vdd -0.10778f
C2 Xi0/g Xr/vsp 0.72745f
C3 i0_b4 i3_b3 0.1533f
C4 Xd2/m1_1342_4048# vbn_prb 0
C5 bias_en Xd3/m1_2720_2760# 0.00653f
C6 Xi0/a_528_4392# vbn_prb 0.01623f
C7 r2_b4 Xi2/m1_988_888# 0.28692f
C8 Xd3/m1_4982_4448# ua0_s1 0
C9 i3_b1 Xi0/g 0.31901f
C10 r2_b0 vbp_syn 0.03621f
C11 Xi1/g Xm/in_p 0.29151f
C12 r2_b3 Xr/vgln 0.25948f
C13 i4_b2 i3_b0 0.03321f
C14 Xi1/g i2_b4 0
C15 r1_b1 Xr/vsp 0.03782f
C16 Xm/iint Xm/in_p 1.26605f
C17 vdd Xi3/a_3928_4392# 0.0018f
C18 r0_b0 vbp_w 0.22368f
C19 Xd3/m1_3908_2760# ua0_s0 0.00203f
C20 Xd1/a_3048_3416# r1_b2 0
C21 Xi0/m1_240_3480# vbp_syn 0
C22 ua0_stim_out vbp_syn 0.28887f
C23 r2_b4 Xi2/m1_988_2644# 0.2535f
C24 i3_b1 r1_b1 0.03463f
C25 r2_b3 Xr/vsp 0.03758f
C26 r2_b2 vbn_prb 0.38621f
C27 Xm/in_n vth_ref 0.0486f
C28 Xi0/a_1582_4392# i0_b1 0.01842f
C29 r2_b2 i0_b3 0.03023f
C30 Xd0/m1_3310_2880# Xr/vsp 0.08504f
C31 r2_b0 r0_b3 1.16204f
C32 i3_b1 r2_b3 0.01216f
C33 i3_b4 Xi0/g 0.21833f
C34 i4_b2 i0_b4 0.04707f
C35 i1_b3 i3_b3 0.13225f
C36 ua0_stim_out r0_b3 0.0607f
C37 r2_b4 Xi4/m1_1500_3762# 0
C38 vdd Xi2/m1_988_2644# -0.03361f
C39 i2_b3 i2_b0 0
C40 i2_b3 Xr/vglp 0.18472f
C41 i3_b4 r1_b1 0.05784f
C42 Xi2/a_1378_4170# i0_b1 0.01588f
C43 Xg/a_5188_4156# Xi0/g -0.05636f
C44 Xd0/a_1040_3416# vth_cmp 0.01697f
C45 r2_b4 r0_b2 0
C46 Xi4/a_732_4170# vreset_src 0.00136f
C47 Xg/m1_6020_10200# i0_b3 0
C48 r0_b4 r2_b2 0.00582f
C49 Xi4/m1_1500_3762# vdd 0
C50 Xi4/a_4132_4170# i4_b3 0
C51 Xr/vsn vbn_ax 0.023f
C52 Xi4/a_4132_4170# i4_b0 0
C53 Xr/m1_342_438# vth_ref 0.16257f
C54 Xr/vgln Xi1/a_1378_4392# 0.02413f
C55 i2_b1 r1_b1 0.0281f
C56 Xd0/a_3408_3416# r0_b2 0.00348f
C57 Xi2/g Xi2/m1_988_3304# -0.00417f
C58 v0_c1 Xr/vsp 0.04591f
C59 Xd2/m1_902_4048# vbn_prb 0.00109f
C60 vdd r0_b2 0.71237f
C61 r1_b4 i0_b3 0.02035f
C62 ua0_stim_out Xi2/m1_260_2080# 0.10252f
C63 bias_en Xvi/a_2102_5152# 0.04789f
C64 Xi1/a_1378_4392# Xr/vsp 0.02204f
C65 vbn_leak vbp_syn 0.2476f
C66 r2_b1 i0_b1 0.02873f
C67 r1_b3 r1_b0 0.1225f
C68 Xi4/g Xvi/m1_502_738# 0.0529f
C69 r2_b3 i2_b1 0.04191f
C70 ua0_s1 ua0_s0 0.06073f
C71 Xi3/a_3078_4392# Xi3/a_3282_4392# -0
C72 r2_b4 r1_b0 0.71447f
C73 Xr/vgln vbn_prb 0.04014f
C74 Xi0/a_1378_4392# i0_b1 0.01681f
C75 vbn_ax vbp_syn 0.14599f
C76 v0_c1 Xd3/a_4584_3816# 0.0202f
C77 Xr/vgln i0_b3 1.17009f
C78 Xi1/m1_988_2804# Xi1/m1_1500_4312# -0.01223f
C79 Xi4/g Xi4/m1_988_888# 0.28086f
C80 v0_c0 Xd3/m1_3908_2760# 0.01041f
C81 Xi1/a_1582_4392# Xi1/m1_988_2804# -0
C82 Xvi/m1_5388_6960# vreset_src 0.14283f
C83 vdd ua0_stim 1.91775f
C84 Xr/vgln Xi2/a_1582_4170# 0
C85 r1_b0 Xvi/a_4976_1528# 0
C86 Xi2/g Xm/iint 0.00622f
C87 vbn_prb Xr/vsp 0.41985f
C88 Xi0/g vbn_ref 0.29455f
C89 Xi1/a_1582_4392# Xi1/m1_1500_4312# -0
C90 Xi0/g i0_b2 0
C91 Xi2/a_4132_4170# i0_b4 0.03841f
C92 i3_b4 v0_c1 0.00112f
C93 r1_b0 vdd 0.57282f
C94 Xr/vglp i2_b4 0.07845f
C95 r0_b1 vbn_ref 0.24643f
C96 Xr/vglp Xm/in_p 0.1679f
C97 i0_b3 Xr/vsp 0.1121f
C98 i4_b4 i0_b1 0.33255f
C99 Xr/m1_1222_3522# Xm/in_p 0.00606f
C100 r0_b1 i0_b2 0.03473f
C101 Xi0/a_3282_4392# i0_b0 0
C102 r1_b1 i0_b2 0.11981f
C103 i3_b1 i0_b3 0.11403f
C104 r1_b1 vbn_ref 0.03399f
C105 ua0_stim Xm/a_420_700# 0.16525f
C106 Xd3/a_2216_3816# ua0_int 0.00195f
C107 i3_b4 Xi1/a_1378_4392# 0
C108 r0_b3 vbn_ax 0.22979f
C109 r0_b0 r1_b4 0.00187f
C110 r0_b4 Xr/vgln 0.2338f
C111 r2_b2 Xvi/m1_502_738# 0
C112 Xg/a_4580_5314# ua0_stim_out 0.1136f
C113 r2_b3 vbn_ref 0.02716f
C114 r2_b3 i0_b2 0.03632f
C115 el r0_b2 0.00102f
C116 Xg/a_7580_5314# Xi0/g 0.03101f
C117 Xi4/a_3928_4170# i4_b0 0
C118 vdd Xd3/m1_2408_3600# -0.00404f
C119 r0_b0 Xr/vgln 0.03129f
C120 Xi4/m1_988_888# r2_b2 0.35905f
C121 r1_b3 Xi3/g 0.04753f
C122 i4_b3 i4_b0 0.11686f
C123 r2_b4 Xi3/g 0.01953f
C124 r1_b3 i3_b3 0.04125f
C125 Xr/vsn vbp_w 0.01328f
C126 Xi1/g Xi1/a_3282_4392# 0.02078f
C127 Xg/m1_4906_9490# i0_b0 0.00134f
C128 i0_b1 i0_b0 0.00697f
C129 Xm/a_2240_11218# Xm/a_736_7228# -0.05653f
C130 Xd0/a_2224_3416# r0_b1 0.02243f
C131 Xi3/a_2432_4392# i3_b2 -0.01077f
C132 Xg/a_3036_4156# vbp_st 0.04942f
C133 Xm/a_420_700# Xm/a_736_5516# -0.00332f
C134 i4_b1 Xr/vsn 0.27182f
C135 vbn_ax Xi2/m1_260_2080# 0.19077f
C136 Xi4/g Xr/vsn 1.36004f
C137 vdd Xi3/g 1.03221f
C138 r1_b0 el 0.03036f
C139 vdd Xm/a_1764_11418# 0.00116f
C140 v0_c1 Xd3/m1_4078_3250# 0.08306f
C141 r2_b4 Xi4/a_1582_4170# 0.00447f
C142 ua0_s1 Xm/a_1744_9182# 0.05933f
C143 vdd i3_b3 1.20005f
C144 v0_c0 ua0_s1 0.18234f
C145 vbp_w vbp_syn 0.13899f
C146 i2_b1 i0_b3 0.06328f
C147 Xi0/a_3078_4392# i0_b0 0
C148 i2_b1 Xi2/a_1582_4170# 0.00373f
C149 Xi3/m1_1500_4312# Xi3/m1_988_2804# -0.00915f
C150 Xi0/m1_988_888# vth_cmp 0.00365f
C151 Xi2/m1_988_888# vbp_st 0.55341f
C152 i0_b4 Xi2/a_528_4170# 0.02494f
C153 i4_b2 r1_b3 0.22581f
C154 Xi2/m1_988_2644# vbp_st 0.14547f
C155 v0_c2 ua0_stim 0.08364f
C156 r1_b0 i2_b2 0.04493f
C157 r2_b0 Xd2/a_680_3416# 0.00512f
C158 Xi4/a_1582_4170# vdd 0.02671f
C159 v0_c1 ua0_int 0.0659f
C160 r2_b0 Xi4/a_528_4170# 0
C161 Xi1/a_2228_4392# Xi1/m1_988_2804# -0
C162 vbp_w r0_b3 0.04554f
C163 Xd3/a_2808_3816# Xd3/a_2216_3816# -0.00314f
C164 Xr/vsn r2_b2 1.29508f
C165 Xi0/m1_988_3464# Xi0/g -0.06901f
C166 Xi1/a_2228_4392# Xi1/m1_1500_4312# -0
C167 r0_b4 i2_b1 0.00153f
C168 vbn_ref vbn_prb 0.01164f
C169 i4_b4 Xvi/a_864_6450# 0.1962f
C170 Xr/m1_1662_438# ib_r1 0
C171 r1_b2 r0_b2 0.48927f
C172 i0_b2 vbn_prb 0
C173 Xg/m1_3898_9610# Xr/vsp 0.00664f
C174 i4_b2 vdd 1.20344f
C175 i0_b3 i0_b2 0.33835f
C176 bias_en Xvi/a_4976_1528# 0.06908f
C177 vbn_ref i0_b3 1.6425f
C178 el Xi3/g 0.44183f
C179 Xi3/a_2228_4392# i3_b2 -0.00373f
C180 vbn_ref Xi2/a_1582_4170# 0.0385f
C181 Xi4/a_2432_4170# r1_b1 0.00226f
C182 bias_en vdd 0.52857f
C183 v0_c1 v0_c4 0.11926f
C184 vbp_st r0_b2 0.11447f
C185 i0_b4 Xg/m1_3666_9610# 0.0056f
C186 r2_b0 i4_b0 0
C187 vbn_prb Xd1/m1_2862_4048# 0.00706f
C188 i4_b3 ua0_stim_out 0.069f
C189 r2_b4 Xi4/a_1378_4170# 0.00188f
C190 bias_en Xm/a_420_700# 0.18478f
C191 ua0_stim_out i4_b0 0.03819f
C192 Xi2/a_3282_4170# i2_b3 0.00174f
C193 Xi1/g i4_b4 0.23619f
C194 r1_b0 r1_b2 0.0333f
C195 vbp_w Xi2/m1_260_2080# 0
C196 r0_b4 i0_b2 0.0534f
C197 Xi0/a_3282_4392# i0_b1 0.04191f
C198 r0_b4 vbn_ref 0.02958f
C199 Xvi/m1_1382_738# ib_x2 0.00831f
C200 bias_en ib_x2 0.57715f
C201 i1_b0 Xi3/g 0.04586f
C202 r0_b3 Xi3/a_528_4392# 0
C203 Xr/vsn r1_b4 0.03917f
C204 vreset_src Xvi/a_864_6450# 0.45712f
C205 r2_b4 Xi2/a_4132_4170# 0.00276f
C206 r0_b0 i0_b2 0.03001f
C207 v0_c1 v0_c5 0.14328f
C208 r1_b1 Xi3/a_4132_4392# 0
C209 Xr/vgln Xi1/m1_240_3480# 0.10181f
C210 i1_b0 i3_b3 0.1106f
C211 r0_b0 vbn_ref 0.057f
C212 Xvi/m1_1276_6360# vth_cmp 0.00964f
C213 r1_b0 vbp_st 0.03019f
C214 Xi4/a_1378_4170# vdd 0.055f
C215 i2_b3 i3_b0 0.09925f
C216 i4_b2 el 0.0358f
C217 Xi1/a_2432_4392# Xi1/m1_988_2804# -0
C218 Xr/vsn Xr/vgln 1.00173f
C219 Xi1/g i1_b2 0.03893f
C220 Xi1/a_2432_4392# Xi1/m1_1500_4312# -0
C221 Xr/m1_782_438# Xr/vgln 0.00128f
C222 Xr/m1_3422_438# Xm/in_n 0
C223 Xd3/a_2808_3816# v0_c1 0.13669f
C224 Xi0/a_3078_4392# Xi0/a_3282_4392# -0
C225 Xi1/m1_240_3480# Xr/vsp 0.01399f
C226 Xi1/g i0_b0 0.08467f
C227 bias_en el 0
C228 Xd3/a_3400_3816# v0_c4 0
C229 ua0_stim_out Xi2/a_2228_4170# 0
C230 Xi2/a_4132_4170# vdd 0.00206f
C231 Xg/m1_4906_9490# i0_b1 0.0073f
C232 ua0_int Xm/a_736_7228# 0.1538f
C233 Xr/vsn Xr/vsp 0.73278f
C234 Xm/iint vreset_src 0.03931f
C235 Xi4/a_2228_4170# r1_b1 0.0015f
C236 Xi2/m1_1500_3762# i0_b1 0.02586f
C237 r1_b2 Xi3/g 0
C238 Xr/vsn Xg/m1_3530_1930# 0
C239 Xd0/a_2224_3416# r0_b0 0.04145f
C240 i3_b1 Xr/vsn 0.49655f
C241 Xi2/a_3928_4170# Xi0/g 0
C242 i2_b3 i0_b4 0.0143f
C243 i4_b2 i2_b2 0.25407f
C244 Xr/vgln Xi1/a_3078_4392# 0.01583f
C245 Xvi/m1_8042_6360# vdd -0.00131f
C246 vdd Xi0/m1_988_2804# -0.00877f
C247 Xg/a_1580_5314# Xm/in_p 0.09677f
C248 Xg/a_3036_4156# Xi0/g 0.00924f
C249 Xr/vgln vbp_syn 0.56967f
C250 Xi2/a_3078_4170# i2_b3 0.03375f
C251 Xi0/m1_988_3464# vbn_prb 0.11428f
C252 i1_b2 i1_b1 0.41867f
C253 v0_c2 bias_en 0.04453f
C254 Xi0/a_3078_4392# i0_b1 0.0182f
C255 Xi4/a_2432_4170# vbn_prb 0
C256 vbp_syn Xr/vsp 0
C257 vbp_st Xi3/g 0.19934f
C258 r2_b1 i2_b0 0.07666f
C259 vbp_st Xm/a_1764_11418# 0
C260 i3_b2 Xm/in_p 0.09995f
C261 r2_b3 Xi2/a_3928_4170# 0.00456f
C262 Xvi/m1_5388_6960# Xvi/a_864_6450# -0.03764f
C263 i3_b3 vbp_st 0.13114f
C264 Xr/vsn i3_b4 0.31316f
C265 Xi1/g Xi1/a_4132_4392# 0
C266 Xr/vgln r0_b3 0.23407f
C267 r1_b1 Xi3/a_3928_4392# 0
C268 Xvi/m1_8042_6360# ib_x2 0.03053f
C269 Xr/en_b Xd3/m1_822_4448# 0.00164f
C270 Xd0/m1_3662_4048# vth_cmp 0
C271 Xr/vsn Xg/a_5188_4156# 0.03777f
C272 r2_b0 ua0_stim_out 0.03582f
C273 Xi2/m1_988_888# Xi0/g 0.04948f
C274 v0_c2 Xd3/a_3992_3816# 0.0562f
C275 i2_b4 i3_b0 0.62753f
C276 i3_b0 Xm/in_p 0.20583f
C277 i4_b1 Xi4/a_4132_4170# 0
C278 Xd1/a_1864_3416# r1_b3 0.00176f
C279 ua0_stim_out Xi0/m1_240_3480# 0.0586f
C280 i4_b4 Xr/vglp 0.34639f
C281 r0_b0 Xd1/a_3048_3416# 0
C282 Xi0/g Xi2/m1_988_2644# 0.25629f
C283 v0_c0 Xr/vgln 0.05467f
C284 Xm/a_2240_11218# Xm/a_1744_9182# -0.04415f
C285 vth_ref Xd3/m1_2408_3600# -0.00352f
C286 i3_b4 Xi1/a_3078_4392# 0
C287 Xvi/m1_8042_6360# el 0
C288 Xi2/g Xi3/m1_988_2804# 0
C289 Xi0/m1_988_2804# el 0.04359f
C290 Xd0/a_1632_3416# Xd0/a_1040_3416# -0.00457f
C291 Xd3/m1_382_4448# ua0_s0 0.00121f
C292 r2_b3 Xi2/m1_988_888# 0.39961f
C293 v0_c0 Xr/vsp 0.52762f
C294 i4_b2 vbp_st 0.2537f
C295 Xi4/a_528_4170# vbp_w 0
C296 Xr/vgln Xi2/m1_260_2080# 0.38833f
C297 i0_b4 i2_b4 0.02707f
C298 i0_b4 Xm/in_p 0.16233f
C299 Xd1/a_1864_3416# vdd -0
C300 r2_b3 Xi2/m1_988_2644# 0.16194f
C301 Xd3/m1_4078_3250# ua0_s0 0.00628f
C302 Xi3/a_2432_4392# vdd 0.02946f
C303 i1_b2 Xr/vglp 0
C304 bias_en vbp_st 0.03816f
C305 i2_b0 i0_b0 0.0491f
C306 Xi2/a_3078_4170# i2_b4 0.00228f
C307 Xi1/m1_240_3480# vbn_ref -0.00132f
C308 Xr/vglp i0_b0 0.71959f
C309 Xi0/g r0_b2 0.04684f
C310 i0_b1 Xi2/m1_988_3304# 0.08399f
C311 i2_b1 vbp_syn 0.05134f
C312 Xi4/a_2228_4170# vbn_prb 0
C313 Xi4/a_4132_4170# r2_b2 0
C314 r1_b3 vth_cmp 0.0581f
C315 vreset_src Xr/vglp 0.21983f
C316 r0_b1 r0_b2 0.46726f
C317 Xm/in_n ua0_s0 0.05062f
C318 r2_b4 vth_cmp 0.04107f
C319 Xd0/m1_1262_4048# vth_cmp 0.00271f
C320 Xr/vsn vbn_ref 0.00275f
C321 Xi1/g Xi1/a_3928_4392# 0.01245f
C322 Xi2/g Xg/a_1580_5314# 0.0139f
C323 i3_b4 v0_c0 0.0514f
C324 ua0_int ua0_s0 0.00377f
C325 v0_c3 Xi1/a_3282_4392# 0.03352f
C326 ib_r1 Xvi/m1_7102_850# 0.01071f
C327 vbp_w i4_b0 0.07702f
C328 v0_c1 Xd3/m1_4102_4448# 0.01067f
C329 r2_b3 r0_b2 0
C330 Xvi/a_4976_1528# vth_cmp 0.00941f
C331 Xr/vsn Xm/in_n 0.17246f
C332 Xi2/a_3928_4170# i0_b3 0.00584f
C333 i4_b1 Xi4/a_3928_4170# 0
C334 Xr/m1_782_438# Xm/in_n 0
C335 vbn_leak Xi0/m1_240_3480# -0
C336 ua0_stim_out vbn_leak 0.33686f
C337 Xi1/g Xg/m1_4906_9490# -0
C338 Xi1/g i0_b1 0.14756f
C339 Xi2/g i3_b2 0.5394f
C340 vdd vth_cmp 0.61911f
C341 i4_b1 i4_b3 0.27114f
C342 r1_b0 Xi0/g 0.03112f
C343 Xi4/g i4_b3 0.19261f
C344 r2_b0 vbn_ax 0.0296f
C345 Xr/vsn Xg/a_7580_5314# 0.09681f
C346 i3_b4 Xi2/m1_260_2080# 0.00127f
C347 ua0_stim_out vbn_ax 0.03332f
C348 i4_b1 i4_b0 0.11981f
C349 Xi4/g i4_b0 0
C350 i0_b2 vbp_syn 0.15807f
C351 vbn_ref vbp_syn 0.37953f
C352 r2_b0 Xd2/a_1864_3416# 0.0027f
C353 Xd3/m1_5422_4448# ua0_s1 0.0022f
C354 v0_c4 ua0_s0 0.04666f
C355 r1_b0 r1_b1 0.39834f
C356 Xi2/g i3_b0 0.43609f
C357 Xd2/m1_2382_2650# vbn_prb 0.07626f
C358 vth_cmp Xd0/m1_617_3840# 0.02723f
C359 Xg/a_4580_5314# Xr/vsp 0.07336f
C360 Xi1/m1_240_3480# v0_c4 0.01648f
C361 Xd0/m1_956_3000# Xr/vsp 0.016f
C362 Xi3/a_2228_4392# vdd 0.06213f
C363 bias_en vth_ref 0.84852f
C364 Xd3/a_2216_3816# Xd3/m1_2408_3600# -0.00107f
C365 i3_b1 Xg/a_4580_5314# 0.13565f
C366 r1_b3 i2_b3 0.03618f
C367 Xd1/m1_756_3120# vbn_prb 0.0289f
C368 ib_x2 vth_cmp 0.10088f
C369 r2_b3 r1_b0 0.16768f
C370 r2_b4 i2_b3 0.03203f
C371 r0_b3 vbn_ref 0.03577f
C372 r0_b3 i0_b2 0.02956f
C373 Xr/vsn Xg/m1_3298_2050# 0
C374 i1_b1 i0_b1 0.05318f
C375 Xr/m1_782_438# Xr/m1_342_438# -0.00568f
C376 Xvi/m1_5388_6960# Xr/vglp -0
C377 Xd1/a_2456_3416# vth_cmp 0.00559f
C378 v0_c0 Xd3/m1_4078_3250# 0
C379 v0_c5 ua0_s0 0.11045f
C380 r1_b3 Xi4/a_3282_4170# 0
C381 i4_b3 r2_b2 0.07996f
C382 Xi3/m1_1500_4312# vdd 0.04534f
C383 ua0_stim_out ua0_s1 0.00797f
C384 Xi2/g i0_b4 0
C385 r2_b2 i4_b0 0.70962f
C386 v0_c0 vbn_ref 0.00786f
C387 vth_cmp el 2.27855f
C388 i3_b4 Xg/a_4580_5314# 0.10296f
C389 i2_b3 vdd 0.51135f
C390 Xi0/g Xi3/g 0.48289f
C391 Xi4/m1_1500_3762# vbn_prb 0.00379f
C392 Xi2/g Xi2/a_3078_4170# -0.01711f
C393 v0_c4 Xi1/a_3078_4392# 0
C394 ua0_stim_out Xi0/a_732_4392# 0.03853f
C395 Xi3/m1_988_888# i4_b0 0
C396 Xg/a_5188_4156# Xg/a_4580_5314# -0.00321f
C397 v0_c1 ua0_stim 0.10177f
C398 Xi0/g i3_b3 0.1559f
C399 ua0_int Xm/a_1744_9182# -0
C400 r1_b1 Xi3/g 0.06256f
C401 Xi4/a_3282_4170# vdd 0
C402 Xd1/m1_2974_2650# vbn_prb 0.00982f
C403 v0_c0 ua0_int 0.04626f
C404 vbn_leak vbn_ax 0.38542f
C405 r1_b1 i3_b3 0.03432f
C406 Xi1/g Xr/en_b 0
C407 i0_b3 r0_b2 0.02898f
C408 Xvi/a_5712_1328# vreset_src 0.0027f
C409 r2_b3 Xi3/g 0
C410 Xr/en_b Xm/iint 0.48997f
C411 Xd2/m1_1780_2760# vbn_prb 0.03279f
C412 Xd1/a_1864_3416# r1_b2 0.0013f
C413 r2_b0 vbp_w 0.04351f
C414 Xd3/m1_3908_2760# ua0_s1 0.08154f
C415 vbp_w ua0_stim_out 0.20647f
C416 Xr/vgln Xi1/m1_988_2804# 0.00491f
C417 bias_en Xvi/m1_8332_7080# 0.05531f
C418 vbp_w Xi0/m1_240_3480# 0.11634f
C419 Xi2/a_528_4170# vbp_st 0
C420 Xi4/g Xvi/m1_942_738# 0
C421 Xd1/m1_606_2410# vbn_prb 0.05078f
C422 Xm/iint Xvi/a_864_6450# 0.04778f
C423 Xr/vgln Xi1/m1_1500_4312# 0.14837f
C424 Xi4/a_1582_4170# r1_b1 0.00182f
C425 Xr/vgln Xi1/a_1582_4392# 0.02413f
C426 Xg/m1_4906_9490# Xr/vglp 0.04629f
C427 r1_b4 i4_b0 0.02698f
C428 r1_b3 Xm/in_p 0
C429 r1_b3 i2_b4 0.04401f
C430 r2_b0 Xi4/g 0
C431 Xvi/m1_8042_6360# vth_ref 0.0282f
C432 v0_c1 Xd3/m1_2408_3600# 0.01559f
C433 i2_b0 i0_b1 0
C434 Xr/vglp i0_b1 0.44804f
C435 v0_c0 v0_c4 0.17186f
C436 i4_b2 Xi0/g 0.06494f
C437 vbp_w Xi3/m1_240_3480# 0.02581f
C438 i4_b1 ua0_stim_out 0.03853f
C439 r2_b4 i2_b4 0.03362f
C440 Xi1/m1_988_2804# Xr/vsp 0.04654f
C441 bias_en Xvi/m1_7440_2050# 0.0273f
C442 r1_b3 Xi4/a_3078_4170# 0
C443 r0_b4 r0_b2 0.44505f
C444 i4_b3 Xr/vgln 0.38091f
C445 Xi1/m1_1500_4312# Xr/vsp 0.00179f
C446 r1_b0 i0_b3 0.02087f
C447 r2_b3 Xi4/a_1582_4170# 0
C448 i4_b2 r1_b1 0.07423f
C449 Xi1/a_1582_4392# Xr/vsp 0.00819f
C450 Xg/m1_6020_10200# Xg/m1_5022_10210# -0.00223f
C451 Xr/vgln i4_b0 0.14044f
C452 i4_b4 Xg/a_1580_5314# 0.28689f
C453 ua0_stim Xd3/a_3400_3816# 0.00167f
C454 i0_b4 Xi2/a_1378_4170# 0.03793f
C455 vth_cmp Xvi/m1_4546_7560# 0.01325f
C456 r0_b0 r0_b2 1.0951f
C457 Xg/a_4580_5314# vbn_ref 0.0116f
C458 Xg/a_4580_5314# Xg/m1_6282_1450# 0
C459 r2_b1 i3_b0 0
C460 vdd i2_b4 0.89944f
C461 i4_b3 Xr/vsp 0.39555f
C462 ua0_stim_out Xi0/a_528_4392# 0.12258f
C463 Xi0/a_732_4392# vbn_leak 0
C464 i1_b3 Xi1/a_3282_4392# 0
C465 i1_b4 Xr/vgln 0.00894f
C466 vdd Xm/in_p 1.34255f
C467 r1_b2 vth_cmp 0.03104f
C468 i3_b1 i4_b3 0.04272f
C469 Xr/vsp i4_b0 0.06972f
C470 Xi3/m1_988_3464# vbn_ax -0
C471 Xg/a_4580_5314# Xm/in_n 0.0045f
C472 r2_b0 Xi3/a_528_4392# 0
C473 r2_b2 Xvi/m1_942_738# 0
C474 Xi4/a_3078_4170# vdd 0
C475 Xd1/m1_2372_2520# vbn_prb 0.0313f
C476 i4_b4 i3_b2 0.0496f
C477 i3_b1 i4_b0 0.03633f
C478 vdd Xi0/m1_1500_4312# -0.00303f
C479 i2_b3 i2_b2 0.047f
C480 r2_b0 r2_b2 0.06878f
C481 r2_b2 ua0_stim_out 0.12534f
C482 Xd3/a_2808_3816# v0_c0 0.01476f
C483 Xg/a_7580_5314# Xg/a_4580_5314# -0.01509f
C484 ib_x2 Xm/in_p 0.03715f
C485 ua0_stim Xm/a_736_7228# 0
C486 i4_b4 i3_b0 0.07977f
C487 r2_b1 i0_b4 0.03896f
C488 Xr/vgln Xi2/a_2228_4170# 0
C489 vbp_w vbn_leak 0.11992f
C490 v0_c3 Xi1/a_4132_4392# 0.05822f
C491 Xm/iint Xvi/m1_4894_1238# 0.00235f
C492 i4_b3 i3_b4 0.0468f
C493 Xi4/a_1378_4170# r1_b1 0
C494 i3_b4 i4_b0 0.04079f
C495 bias_en Xd3/m1_1702_4448# 0.05834f
C496 v0_c1 Xd3/m1_1523_3480# 0.00669f
C497 Xg/m1_5022_10210# Xr/vsp 0
C498 i0_b3 Xi3/g 0.00156f
C499 Xi2/a_3282_4170# i0_b0 0
C500 Xi1/g i1_b1 0.0388f
C501 i1_b2 i3_b2 0.09734f
C502 Xvi/m1_8042_6360# Xvi/m1_8332_7080# -0.00233f
C503 vbp_w vbn_ax 0.19277f
C504 i3_b3 i0_b3 0.0014f
C505 Xi3/m1_240_3480# Xi3/m1_988_888# -0.00978f
C506 Xr/vgln ib_r1 0.5417f
C507 Xi3/a_1582_4392# vdd 0.02683f
C508 Xi3/a_3282_4392# i3_b2 0
C509 Xr/vsn Xg/a_3036_4156# 0.03006f
C510 Xr/en_b Xr/vglp 0.13604f
C511 i3_b4 i1_b4 0.13021f
C512 Xi2/a_4132_4170# r1_b1 0
C513 i4_b4 i0_b4 0.04215f
C514 r1_b0 Xi4/m1_988_3304# 0.00286f
C515 Xm/a_736_7228# Xm/a_736_5516# -0.02717f
C516 bias_en v0_c1 0.23772f
C517 i4_b3 i2_b1 0
C518 Xr/vsn Xi3/a_3928_4392# 0
C519 Xd3/m1_4102_4448# ua0_s0 0.00804f
C520 i0_b0 i3_b0 0.54504f
C521 Xi4/a_1582_4170# vbn_prb 0
C522 r2_b0 r1_b4 0.02766f
C523 Xi2/g r1_b3 0.04859f
C524 Xi0/g Xi0/m1_988_2804# 0.05841f
C525 Xr/vglp Xvi/a_864_6450# 0.64885f
C526 r2_b4 Xi2/g 0.63834f
C527 Xi0/a_528_4392# vbn_leak 0
C528 r2_b3 Xi2/a_4132_4170# 0.00258f
C529 i2_b1 i4_b0 0.13608f
C530 r1_b4 ua0_stim_out 0.03516f
C531 Xi3/m1_988_3464# Xi3/a_732_4392# -0.00109f
C532 Xr/vgln Xi1/a_2228_4392# 0.07162f
C533 Xi4/g Xi4/m1_260_2080# 0
C534 Xd1/m1_1780_5040# Xr/vsp 0.05015f
C535 i4_b4 Xvi/m1_1276_6360# 0.19996f
C536 r2_b0 Xr/vgln 0.06357f
C537 r2_b4 Xd1/a_680_3416# 0
C538 Xd0/m1_382_4048# Xr/vsp 0.05362f
C539 Xr/vsn Xi2/m1_988_888# -0.02397f
C540 v0_c1 Xd3/a_3992_3816# 0.02305f
C541 vbn_ref Xi1/m1_988_2804# -0.00243f
C542 i1_b0 Xm/in_p 0
C543 i2_b4 i2_b2 0.00567f
C544 vth_ref vth_cmp 0.20595f
C545 r1_b4 Xi3/m1_240_3480# 0.00956f
C546 Xm/in_p i2_b2 0.00132f
C547 Xi1/a_2228_4392# Xr/vsp 0.00364f
C548 ua0_stim_out Xr/vgln 0.33744f
C549 i4_b2 i0_b3 0.03653f
C550 vbn_ref Xi1/m1_1500_4312# -0.00582f
C551 i1_b2 i0_b4 0.12224f
C552 Xvi/m1_1382_738# vbn_prb 0.0102f
C553 vbp_w Xi3/m1_988_3464# 0.11797f
C554 ua0_stim_out Xm/a_2240_11218# 0.01402f
C555 Xr/vsn Xi2/m1_988_2644# -0.0579f
C556 bias_en vbn_prb 0.51744f
C557 Xi3/a_528_4392# vbn_ax 0.00193f
C558 Xi2/g vdd 0.57758f
C559 i0_b4 i0_b0 0.0208f
C560 r2_b0 Xr/vsp 0.03557f
C561 Xi4/m1_988_888# r1_b0 0.00145f
C562 vbp_w Xi0/a_732_4392# 0
C563 Xr/vgln Xi3/m1_240_3480# 0.17357f
C564 Xi1/g Xr/vglp 0.09948f
C565 v0_c3 Xi1/a_3928_4392# 0.08503f
C566 i4_b3 vbn_ref 0.06506f
C567 i4_b3 i0_b2 0.044f
C568 Xr/m1_1222_3522# Xm/iint 0.01514f
C569 Xm/iint Xr/vglp 0.39089f
C570 Xi0/m1_240_3480# Xr/vsp -0.00988f
C571 ua0_stim_out Xr/vsp 0.28183f
C572 Xi2/a_3078_4170# i0_b0 0.00101f
C573 vbn_ref i4_b0 0.03181f
C574 i0_b2 i4_b0 0.08162f
C575 r2_b2 Xd2/a_1864_3416# 0
C576 vbp_w Xi3/a_732_4392# 0.1426f
C577 i3_b1 ua0_stim_out 0.04579f
C578 Xi3/m1_240_3480# Xr/vsp -0.00921f
C579 i4_b3 Xm/in_n 0.25323f
C580 r2_b2 Xi4/m1_260_2080# 0.09177f
C581 Xi2/g ib_x2 0.04432f
C582 Xi3/a_1378_4392# vdd 0.03879f
C583 Xi3/a_3078_4392# i3_b2 0
C584 Xi0/g Xi2/a_528_4170# 0
C585 Xvi/m1_1276_6360# vreset_src 0.0045f
C586 i3_b4 Xi1/a_2228_4392# 0
C587 Xr/m1_1662_438# Xm/in_n 0
C588 i4_b3 Xg/a_7580_5314# 0
C589 i1_b2 i1_b3 0.02617f
C590 Xi4/a_1378_4170# vbn_prb 0
C591 v0_c4 Xi1/m1_988_2804# 0.23567f
C592 ua0_stim ua0_s0 0.00321f
C593 vreset_src Xvi/a_2102_5152# 0.02215f
C594 i3_b4 ua0_stim_out 0.79413f
C595 v0_c4 Xi1/m1_1500_4312# 0.02049f
C596 vdd Xi1/a_3282_4392# 0.14661f
C597 i4_b1 vbp_w 0.04447f
C598 i1_b1 Xr/vglp 0.04745f
C599 Xr/vgln Xi1/a_2432_4392# 0.06313f
C600 vbn_ref Xg/m1_5022_10210# 0
C601 Xr/m1_3422_438# bias_en 0.0105f
C602 Xi2/g el 0.01123f
C603 Xg/a_5188_4156# ua0_stim_out 0.04275f
C604 vdd Xi0/a_1582_4392# -0
C605 bias_en Xm/a_736_7228# 0.00109f
C606 v0_c0 Xd3/m1_4102_4448# 0.00127f
C607 vbn_ref Xi2/a_2228_4170# 0.03261f
C608 r1_b4 vbn_ax 0.07903f
C609 vbp_st Xm/in_p 0.03853f
C610 i0_b0 Xi2/a_2432_4170# 0
C611 Xi2/a_4132_4170# i0_b3 0.00463f
C612 i4_b1 Xi4/g 0.23436f
C613 Xi1/a_2432_4392# Xr/vsp 0
C614 Xr/vgln vbn_leak 0.00761f
C615 vbp_syn r0_b2 0.12646f
C616 r2_b0 i2_b1 0
C617 Xr/vsn r1_b0 0.03922f
C618 vbp_w Xi0/a_528_4392# 0
C619 vdd Xi2/a_1378_4170# 0.00177f
C620 Xi0/m1_988_2804# vbn_prb 0.09788f
C621 Xi0/m1_988_888# i0_b1 0
C622 Xr/vgln vbn_ax 0.33729f
C623 Xd2/m1_2964_2640# vbn_prb 0.11614f
C624 Xr/m1_1662_438# Xr/m1_342_438# -0
C625 Xi0/g Xg/m1_3666_9610# 0.00249f
C626 i1_b4 v0_c4 0
C627 Xd3/m1_2408_3600# ua0_s0 0
C628 Xi2/a_3282_4170# i0_b1 0.03095f
C629 r1_b3 r2_b1 0.03482f
C630 vbp_w Xi3/a_528_4392# 0.01487f
C631 Xi0/g vth_cmp 0.05724f
C632 bias_en Xd3/m1_4982_4448# 0.04802f
C633 i1_b3 Xi1/a_4132_4392# 0
C634 r2_b4 r2_b1 0.39052f
C635 Xd0/m1_2742_3250# Xd0/m1_1262_4048# -0.00438f
C636 r0_b3 r0_b2 0.4172f
C637 Xd0/a_1632_3416# vdd 0.00272f
C638 Xi2/m1_988_2644# Xi2/m1_260_2080# -0.00848f
C639 r1_b1 vth_cmp 0.02675f
C640 Xr/vgln Xvi/m1_7102_850# 0.01373f
C641 i3_b1 vbn_ax -0.00588f
C642 ua0_stim_out Xd3/m1_382_4448# 0
C643 i0_b4 Xi0/a_3282_4392# 0
C644 i0_b1 i3_b0 0.32763f
C645 i4_b1 r2_b2 0.09723f
C646 bias_en Xvi/m1_502_738# 0.18622f
C647 vbp_w Xi3/m1_988_888# 0.03306f
C648 r1_b4 Xi3/m1_988_3464# 0.2116f
C649 r2_b3 vth_cmp 0.03773f
C650 Xi4/g r2_b2 0.56348f
C651 r2_b0 vbn_ref 0.03457f
C652 r2_b1 vdd 0.30313f
C653 r2_b0 i0_b2 0.03068f
C654 r1_b3 i4_b4 0.0022f
C655 Xd0/a_1632_3416# Xd0/m1_617_3840# -0
C656 Xvi/a_5712_1328# Xm/iint 0.22273f
C657 vdd Xd2/a_3048_3416# 0.01839f
C658 vth_cmp Xd0/m1_3310_2880# 0
C659 ua0_stim_out i0_b2 0
C660 Xm/a_2240_11218# ua0_s1 1.0366f
C661 vth_ref Xm/in_p 0.03672f
C662 vdd Xi0/a_1378_4392# -0.00125f
C663 Xd0/m1_382_4048# Xd1/m1_2862_4048# 0.0019f
C664 Xr/vgln Xi3/m1_988_3464# 0
C665 Xr/vsn Xi3/g 0.62874f
C666 Xi4/a_2432_4170# i4_b0 0
C667 ua0_stim_out Xm/in_n 0.09981f
C668 i4_b4 Xvi/a_4976_1528# 0.10484f
C669 ib_r1 Xr/m1_342_438# 0.0078f
C670 Xr/vsn i3_b3 1.20936f
C671 v0_c0 ua0_stim 0.14326f
C672 Xd3/m1_5422_4448# v0_c4 0.00226f
C673 ua0_stim_out ua0_int 0.01641f
C674 Xg/m1_4906_9490# i0_b4 0.00742f
C675 Xi3/m1_988_3464# Xr/vsp -0.00356f
C676 i0_b4 i0_b1 0.83503f
C677 i0_b3 Xi2/a_528_4170# 0.00127f
C678 i4_b4 vdd 1.5305f
C679 Xg/a_7580_5314# ua0_stim_out 0.03964f
C680 r1_b4 vbp_w 0.43357f
C681 Xvi/a_5712_1328# Xvi/m1_4894_1238# -0
C682 Xd0/a_1632_3416# el 0.15601f
C683 Xi2/m1_1500_3762# i0_b4 0
C684 Xi2/a_3078_4170# i0_b1 0.13339f
C685 i2_b3 r1_b1 0.03276f
C686 r1_b3 i0_b0 0.04204f
C687 ua0_s1 Xd3/a_4584_3816# 0.07604f
C688 r2_b4 i0_b0 0.03031f
C689 Xi2/g vbp_st 0.58925f
C690 i2_b1 vbn_ax 0
C691 i1_b3 Xi1/a_3928_4392# 0.00179f
C692 i4_b1 r1_b4 0.00441f
C693 r1_b3 vreset_src 0.00123f
C694 vbp_w Xr/vgln 0.28453f
C695 Xi1/g v0_c3 0.92538f
C696 Xd1/m1_860_4046# vbn_prb 0.10179f
C697 r2_b4 vreset_src 0.02665f
C698 r2_b1 el 0.04983f
C699 Xi4/a_3282_4170# r1_b1 0.00108f
C700 Xd0/m1_2742_3250# el 0.0271f
C701 i3_b1 Xi3/a_732_4392# -0.04794f
C702 r2_b3 i2_b3 0.03135f
C703 r1_b0 Xi2/m1_260_2080# 0.00303f
C704 v0_c0 Xd3/m1_2408_3600# 0.18484f
C705 i0_b4 Xi0/a_3078_4392# 0
C706 r0_b4 Xi2/a_528_4170# 0
C707 i1_b2 vdd 0.43345f
C708 i4_b1 Xr/vgln 0.31617f
C709 Xr/vsn i4_b2 0.04106f
C710 bias_en ua0_s0 0.54293f
C711 Xi4/g Xr/vgln 0.07346f
C712 vbp_w Xr/vsp 0.43805f
C713 vdd i0_b0 0.9402f
C714 vreset_src Xvi/a_4976_1528# 0.03328f
C715 Xi3/a_3282_4392# vdd 0.03457f
C716 r2_b4 Xi4/a_732_4170# 0.03526f
C717 i3_b1 vbp_w 0.19085f
C718 Xr/vsn bias_en 0.01854f
C719 vbn_leak i0_b2 0.20763f
C720 vbn_ref vbn_leak 0.23782f
C721 vdd vreset_src 1.60313f
C722 i4_b1 Xr/vsp 0.13628f
C723 Xr/m1_782_438# bias_en 0.0105f
C724 Xi4/g Xr/vsp 0.15818f
C725 vth_cmp vbn_prb 0.10379f
C726 i0_b3 Xg/m1_3666_9610# 0.03147f
C727 i4_b4 el 0.03091f
C728 Xd0/m1_1262_4048# Xd0/m1_2242_4966# -0
C729 i3_b1 i4_b1 0.10449f
C730 i0_b1 Xi2/a_2432_4170# 0.0126f
C731 r2_b1 i2_b2 0.00113f
C732 i3_b1 Xi4/g 0.01792f
C733 i0_b2 vbn_ax 0.41231f
C734 vbn_ref vbn_ax 0.20155f
C735 Xi1/g Xg/a_1580_5314# -0.10333f
C736 r1_b4 r2_b2 0.02525f
C737 vdd ua0 -0.00727f
C738 vdd Xi4/a_732_4170# 0.01056f
C739 Xr/vgln Xi3/a_528_4392# 0
C740 i4_b3 Xg/a_3036_4156# 0.22776f
C741 ib_x2 vreset_src 0.37646f
C742 Xi0/g Xm/in_p 0.32607f
C743 Xvi/a_5712_1328# Xr/vglp 0
C744 r1_b4 Xi3/m1_988_888# 0.16181f
C745 r2_b2 Xr/vgln 0.04042f
C746 Xi1/g i3_b2 0.08564f
C747 ua0_stim_out Xi0/m1_988_3464# 0.13246f
C748 vdd Xi1/a_4132_4392# -0.00462f
C749 i1_b0 i4_b4 0
C750 Xm/a_420_700# ua0 0.00255f
C751 Xd0/a_1632_3416# r1_b2 0.00258f
C752 Xi0/g Xi0/m1_1500_4312# 0
C753 i4_b1 i3_b4 0.04366f
C754 Xd3/m1_4078_3250# ua0_s1 0.14731f
C755 r1_b1 i2_b4 0.03329f
C756 Xd1/a_2456_3416# vreset_src 0.00211f
C757 Xr/vgln Xi3/m1_988_888# 0.19735f
C758 i3_b1 Xi3/a_528_4392# -0
C759 i0_b0 el 0.02934f
C760 Xi4/a_3078_4170# r1_b1 0.03595f
C761 r2_b2 Xr/vsp 0.03619f
C762 v0_c0 Xd3/m1_1523_3480# 0.21271f
C763 Xi1/g i3_b0 0.00643f
C764 i0_b4 Xi2/m1_988_3304# 0.00116f
C765 r2_b3 i2_b4 0.05177f
C766 i3_b1 r2_b2 0.03795f
C767 vreset_src el 0.20025f
C768 r0_b0 vth_cmp 0.0018f
C769 r2_b1 r1_b2 0.64455f
C770 Xi0/a_2432_4392# vbn_prb 0.00135f
C771 Xr/vsp Xi3/m1_988_888# 0.16764f
C772 Xi3/a_3078_4392# vdd 0.01665f
C773 Xi4/a_4132_4170# r1_b0 0.05849f
C774 Xvi/m1_1276_6360# Xvi/a_864_6450# -0.01448f
C775 vdd Xvi/m1_5388_6960# -0.04513f
C776 ua0_int ua0_s1 0.4818f
C777 i2_b3 i0_b3 1.30783f
C778 i4_b1 i2_b1 0.18765f
C779 i1_b2 i1_b0 0.08618f
C780 i1_b1 i3_b2 0.05783f
C781 bias_en v0_c0 0.11404f
C782 i1_b0 i0_b0 0.04699f
C783 Xi4/a_3282_4170# vbn_prb 0
C784 i4_b4 Xvi/m1_4546_7560# 0
C785 Xd0/m1_822_4048# el 0.00545f
C786 i0_b0 i2_b2 0.06578f
C787 r2_b1 vbp_st 0.03358f
C788 r2_b1 Xi2/a_732_4170# 0
C789 Xi1/g i0_b4 0.10975f
C790 r1_b4 Xr/vgln 0.15971f
C791 Xg/a_4580_5314# Xi3/g -0.01398f
C792 i3_b1 Xg/m1_6020_10200# 0
C793 i3_b4 r2_b2 0.07114f
C794 Xd0/m1_2242_4966# el 0.09751f
C795 i1_b1 i3_b0 0
C796 Xi3/m1_240_3480# Xi3/a_4132_4392# -0
C797 vdd Xi0/a_3282_4392# 0.00594f
C798 vdd Xd3/m1_822_4448# 0.00329f
C799 Xg/a_4580_5314# i3_b3 0.10823f
C800 ib_x2 Xvi/m1_5388_6960# 0.23992f
C801 vbp_w i0_b2 0.00289f
C802 r1_b3 i0_b1 0.03814f
C803 r1_b4 Xr/vsp 0.73745f
C804 ua0_s1 v0_c4 0.07517f
C805 Xi0/m1_988_3464# vbn_leak -0.00211f
C806 r2_b4 i0_b1 0.17513f
C807 i3_b1 r1_b4 0.03336f
C808 i4_b4 vbp_st 0.04763f
C809 Xi0/m1_988_2804# vbp_syn 0
C810 vdd Xi1/a_3928_4392# -0.00191f
C811 i4_b1 i0_b2 0.0515f
C812 Xi4/a_528_4170# r1_b0 0.01711f
C813 i4_b1 vbn_ref 0.04781f
C814 r2_b4 Xi2/m1_1500_3762# 0.11683f
C815 Xr/vgln Xi1/a_528_4392# 0.00784f
C816 r2_b2 i2_b1 0.48438f
C817 Xm/iint Xvi/a_2102_5152# 0
C818 Xr/vgln Xr/vsp 1.43979f
C819 r1_b2 i0_b0 0.0286f
C820 i4_b1 Xm/in_n 0.08496f
C821 i3_b1 Xr/vgln 0.14655f
C822 ib_x2 Xd3/m1_822_4448# 0
C823 Xi2/g Xi0/g 0.45344f
C824 Xi2/a_3928_4170# ua0_stim_out 0
C825 i1_b1 i0_b4 0.10299f
C826 Xi1/g i1_b3 0.05073f
C827 vreset_src Xvi/m1_4546_7560# 0.00993f
C828 Xvi/m1_5388_6960# el -0
C829 Xi4/g Xm/in_n 0.05294f
C830 vdd Xg/m1_4906_9490# -0.00553f
C831 Xi0/a_2228_4392# vbn_prb 0.00223f
C832 Xi1/a_528_4392# Xr/vsp 0.0985f
C833 v0_c2 Xi1/a_4132_4392# 0
C834 vdd i0_b1 1.52891f
C835 Xd0/a_2816_3416# vdd 0
C836 Xg/a_3036_4156# ua0_stim_out 0.05218f
C837 v0_c5 ua0_s1 0.10417f
C838 Xi2/a_3282_4170# i2_b0 0
C839 r1_b2 vreset_src 0.01986f
C840 Xi2/g r1_b1 0.04426f
C841 Xi4/a_3928_4170# r1_b0 0.05008f
C842 i3_b4 r1_b4 0.0608f
C843 i3_b2 Xr/vglp 0.04617f
C844 Xi2/m1_1500_3762# vdd -0.02469f
C845 i3_b1 Xr/vsp 0.26804f
C846 i4_b3 r1_b0 0.08822f
C847 Xg/m1_3530_1930# Xr/vsp 0.01443f
C848 i2_b4 i0_b3 0.03805f
C849 i0_b3 Xm/in_p 0.11102f
C850 i0_b0 vbp_st 0.03765f
C851 Xi4/a_3078_4170# vbn_prb 0.0019f
C852 r1_b0 i4_b0 0.53425f
C853 Xi0/m1_1500_4312# vbn_prb 0.00971f
C854 r2_b3 Xi2/g 0.6358f
C855 i0_b0 Xi2/a_732_4170# 0
C856 Xi4/g Xg/m1_4538_1930# 0
C857 Xd3/a_2808_3816# ua0_s1 0.12918f
C858 i3_b4 Xr/vgln 0.00962f
C859 Xr/vglp i3_b0 0.07949f
C860 r2_b2 vbn_ref 0.03706f
C861 r2_b2 i0_b2 0.33691f
C862 Xi3/m1_240_3480# Xi3/a_3928_4392# -0
C863 vdd Xi0/a_3078_4392# -0.00266f
C864 Xi2/m1_988_888# ua0_stim_out 0.06113f
C865 Xi2/a_528_4170# vbp_syn 0.00317f
C866 i1_b1 i1_b3 0
C867 r1_b4 i2_b1 0.02482f
C868 i3_b4 Xi1/a_528_4392# 0
C869 Xg/m1_5516_1920# Xr/vsp 0.00582f
C870 i3_b4 Xr/vsp 0.56306f
C871 Xi4/a_4132_4170# i4_b2 0
C872 Xi0/m1_988_3464# Xi0/a_732_4392# -0.00109f
C873 ua0_stim_out Xi2/m1_988_2644# 0.16941f
C874 i3_b1 i3_b4 0.28814f
C875 Xg/a_5188_4156# Xr/vsp 0.04697f
C876 Xd1/a_1272_3416# vreset_src 0.17188f
C877 i0_b1 el -0
C878 i2_b1 Xr/vgln 0.21077f
C879 vbn_ref Xg/m1_6020_10200# 0
C880 Xi4/g Xg/m1_4760_1320# 0
C881 bias_en Xd3/m1_1262_4448# 0.05056f
C882 i3_b1 Xg/a_5188_4156# 0.22409f
C883 i0_b4 Xr/vglp 0.2095f
C884 Xd0/a_2816_3416# el 0.00194f
C885 r0_b3 Xi2/a_528_4170# 0
C886 i2_b0 i0_b4 0.03485f
C887 Xr/vsn vth_cmp 0.02601f
C888 Xd1/m1_462_4048# Xd2/m1_2964_2640# 0.04825f
C889 Xvi/m1_5388_6960# Xvi/m1_4546_7560# -0.00185f
C890 i4_b3 Xi3/g 0.21275f
C891 v0_c2 Xi1/a_3928_4392# 0
C892 Xi3/g i4_b0 0.04796f
C893 vbp_w Xi0/m1_988_3464# 0.00257f
C894 i4_b3 i3_b3 0.14611f
C895 r2_b4 Xi2/m1_988_3304# 0.00604f
C896 r1_b4 vbn_ref 0.02857f
C897 r1_b4 i0_b2 0.27982f
C898 r2_b0 r0_b2 0.30395f
C899 Xr/en_b vdd 1.03425f
C900 i3_b3 i4_b0 0.03678f
C901 ua0_stim_out r0_b2 0.04081f
C902 i1_b0 i0_b1 0.14485f
C903 i3_b4 Xg/a_5188_4156# 0.05801f
C904 Xi0/a_4132_4392# i0_b1 0.01356f
C905 i0_b1 i2_b2 0
C906 Xr/vglp Xvi/a_2102_5152# -0.00293f
C907 Xvi/a_864_6450# Xvi/a_4976_1528# -0.00802f
C908 vreset_src vth_ref 0.59172f
C909 i4_b1 Xi4/a_2432_4170# 0
C910 i1_b4 i3_b3 0
C911 Xd3/m1_3222_4448# v0_c3 0
C912 Xr/vgln i0_b2 0.05522f
C913 Xr/vgln vbn_ref 0.49114f
C914 vdd Xvi/a_864_6450# -0.08114f
C915 r0_b1 Xd0/a_1632_3416# 0.04294f
C916 Xi4/a_1582_4170# i4_b0 0
C917 r1_b3 Xi1/g 0
C918 r2_b1 Xi0/g 0.0259f
C919 Xr/en_b ib_x2 0.03942f
C920 Xm/in_n Xr/vgln 0.60746f
C921 ua0_stim_out ua0_stim 0.00174f
C922 vbn_ref Xi1/a_528_4392# 0
C923 vbn_ref Xr/vsp 0.74557f
C924 r2_b0 r1_b0 0.03422f
C925 Xi4/a_3928_4170# i4_b2 0.00121f
C926 Xg/m1_6282_1450# Xr/vsp 0.00581f
C927 i0_b2 Xr/vsp 0
C928 Xd1/a_680_3416# vbn_prb 0.00884f
C929 r0_b1 r2_b1 0.01187f
C930 r0_b1 Xd0/m1_2742_3250# 0
C931 Xi2/m1_988_888# vbn_ax 0
C932 Xi0/a_4132_4392# Xi0/a_3078_4392# -0
C933 i4_b2 i4_b3 0.97197f
C934 i3_b1 vbn_ref 0.07613f
C935 i3_b1 i0_b2 0.05909f
C936 r1_b0 ua0_stim_out 0.03557f
C937 r2_b1 r1_b1 0.03223f
C938 ua0_int Xm/a_2240_11218# -0.08795f
C939 i4_b2 i4_b0 0.16715f
C940 Xm/iint Xvi/a_4976_1528# 0
C941 ib_x2 Xvi/a_864_6450# 0.29159f
C942 Xm/in_n Xr/vsp 0.56544f
C943 Xd3/m1_822_4448# vbp_st 0
C944 Xi1/g vdd 2.19334f
C945 r1_b2 i0_b1 0.03837f
C946 r2_b3 r2_b1 0.65331f
C947 Xm/in_n Xg/m1_3530_1930# 0.09255f
C948 vdd Xm/iint 0.44199f
C949 i4_b4 Xi0/g 0.03879f
C950 r2_b3 Xd2/a_3048_3416# 0.00794f
C951 Xi4/m1_988_2644# vbn_prb 0.37728f
C952 r0_b4 Xi2/g 0
C953 Xg/a_7580_5314# Xr/vsp 0.17096f
C954 Xd1/m1_2862_4048# Xr/vsp 0.08402f
C955 Xr/m1_1662_438# bias_en 0.0105f
C956 i4_b4 r1_b1 0.0702f
C957 i3_b1 Xg/a_7580_5314# 0.05691f
C958 Xr/vgln Xr/m1_342_438# 0.00804f
C959 Xd0/a_2224_3416# Xr/vsp 0
C960 Xg/m1_4538_1930# Xr/vsp 0.00557f
C961 i3_b4 vbn_ref 0.10365f
C962 Xi0/a_2432_4392# vbp_syn 0.01302f
C963 ua0_s1 Xd3/m1_4102_4448# 0
C964 Xvi/a_864_6450# el -0.0052f
C965 Xd3/m1_2720_2760# Xd3/m1_3222_4448# -0.0666f
C966 Xi0/a_1582_4392# vbn_prb 0.00566f
C967 i0_b1 vbp_st 0.06319f
C968 Xi0/a_3928_4392# i0_b1 0.01291f
C969 i0_b1 Xi2/a_732_4170# 0.00866f
C970 Xvi/m1_8646_1098# ib_r1 0
C971 Xm/iint ib_x2 0.14429f
C972 vreset_src Xvi/m1_8332_7080# 0.01219f
C973 Xvi/m1_5388_6960# vth_ref 0.01596f
C974 Xg/a_5188_4156# vbn_ref 0.04109f
C975 Xi1/g ib_x2 0.03236f
C976 Xm/in_n Xg/m1_5516_1920# 0.02891f
C977 v0_c4 Xr/vsp 0.35171f
C978 r1_b4 Xd1/a_3048_3416# -0
C979 r2_b0 Xi3/g 0
C980 i1_b2 Xi0/g 0
C981 vbn_ax r0_b2 0.04053f
C982 Xg/m1_3298_2050# Xr/vsp 0.00613f
C983 Xg/a_5188_4156# Xm/in_n 0
C984 Xr/m1_3862_3522# Xm/in_p 0.00717f
C985 i1_b1 vdd 0.71975f
C986 ua0_stim_out Xi3/g 0.20584f
C987 i3_b4 Xg/a_7580_5314# 0.04708f
C988 ua0_stim_out Xm/a_1764_11418# 0.04408f
C989 i2_b1 i0_b2 0.27422f
C990 i2_b1 vbn_ref 0.06544f
C991 ua0_s0 Xm/in_p 0.04297f
C992 r0_b1 i0_b0 0.03323f
C993 r1_b1 i0_b0 0.03059f
C994 ua0_stim_out i3_b3 0.04596f
C995 Xg/m1_4760_1320# Xr/vsp 0.00528f
C996 i4_b1 Xg/a_3036_4156# 0.02626f
C997 vth_ref Xd3/m1_822_4448# 0
C998 Xi2/a_1378_4170# i0_b3 0.00424f
C999 v0_c4 Xd3/a_4584_3816# 0.07689f
C1000 Xi3/m1_240_3480# Xi3/g 0.05764f
C1001 Xi0/a_3928_4392# Xi0/a_3078_4392# -0
C1002 Xi4/g Xg/a_3036_4156# -0.05673f
C1003 Xd2/a_1272_3416# r2_b1 0
C1004 ib_x2 Xvi/m1_4894_1238# 0
C1005 Xm/in_n Xr/m1_2542_438# 0
C1006 Xr/vsn Xm/in_p 0.26222f
C1007 Xvi/a_5712_1328# Xvi/a_2102_5152# -0.02125f
C1008 r1_b1 vreset_src 1.43786f
C1009 bias_en ib_r1 0.46671f
C1010 r2_b3 i0_b0 0.0362f
C1011 Xd1/a_3048_3416# Xr/vsp 0.01962f
C1012 Xg/a_1580_5314# i3_b2 0.0494f
C1013 Xi2/m1_988_888# vbp_w 0.08692f
C1014 bias_en Xd3/m1_5422_4448# 0.06433f
C1015 Xi4/a_2432_4170# Xr/vgln -0.00164f
C1016 r1_b3 i2_b0 0.06739f
C1017 r2_b3 vreset_src 0.03389f
C1018 r2_b4 i2_b0 0.05551f
C1019 r2_b1 vbn_prb 0.05083f
C1020 r1_b1 Xi4/a_732_4170# 0
C1021 Xd0/m1_2742_3250# vbn_prb 0.017f
C1022 Xi0/m1_988_3464# Xr/vsp -0.00318f
C1023 v0_c5 Xd3/a_4584_3816# 0.00284f
C1024 Xd2/a_3048_3416# vbn_prb 0.02066f
C1025 r1_b0 Xi4/m1_260_2080# 0.00262f
C1026 vth_cmp Xd0/m1_956_3000# 0.00849f
C1027 Xi0/a_2228_4392# vbp_syn 0.04274f
C1028 vbn_ref i0_b2 0.15788f
C1029 Xi1/g i1_b0 0.08982f
C1030 r2_b1 i0_b3 0.04096f
C1031 i4_b2 ua0_stim_out 0.23451f
C1032 Xvi/a_864_6450# Xvi/m1_4546_7560# -0.01694f
C1033 r0_b1 Xd0/m1_2242_4966# 0
C1034 bias_en Xvi/m1_942_738# 0.04893f
C1035 Xi4/a_2432_4170# Xr/vsp 0
C1036 Xi0/a_1378_4392# vbn_prb 0.03665f
C1037 v0_c2 Xi1/g 0.05961f
C1038 r1_b4 Xi3/a_4132_4392# 0.02698f
C1039 ua0_stim ua0_s1 0.28546f
C1040 r2_b3 Xi4/a_732_4170# 0
C1041 Xm/in_n Xg/m1_6282_1450# 0.0228f
C1042 bias_en ua0_stim_out 0.13944f
C1043 vdd Xr/vglp 1.60145f
C1044 i4_b2 Xi3/m1_240_3480# 0.00663f
C1045 Xr/m1_1222_3522# vdd 0.00132f
C1046 Xr/en_b vbp_st 0.96592f
C1047 i2_b0 vdd 0.13954f
C1048 i3_b2 i3_b0 0
C1049 Xr/vgln Xi3/a_4132_4392# 0.00665f
C1050 r0_b0 Xd0/a_1632_3416# 0.05171f
C1051 Xg/a_7580_5314# vbn_ref 0.06569f
C1052 i4_b4 i0_b3 0.03328f
C1053 i1_b3 v0_c3 0
C1054 vbp_w r0_b2 0.03922f
C1055 r0_b4 r2_b1 0.63238f
C1056 i0_b4 Xg/a_1580_5314# 0
C1057 Xi1/g Xi1/m1_988_888# 0.14324f
C1058 vbn_ax Xi3/g 0.00742f
C1059 Xi2/m1_988_3304# vbp_st 0.00253f
C1060 i1_b1 i1_b0 0.08826f
C1061 ib_x2 Xr/vglp 0.33099f
C1062 Xd3/m1_4078_3250# v0_c4 0
C1063 Xi2/a_3282_4170# i0_b4 0.04348f
C1064 r0_b0 r2_b1 0
C1065 ua0_s1 Xm/a_736_5516# 0.4059f
C1066 r0_b0 Xd0/m1_2742_3250# 0
C1067 i3_b1 Xi3/a_4132_4392# 0
C1068 Xd3/m1_2408_3600# ua0_s1 0.09138f
C1069 Xm/in_n Xg/m1_4538_1930# 0.02736f
C1070 vbn_ref v0_c4 0.10653f
C1071 i0_b4 i3_b2 0.28725f
C1072 Xi1/g Xi1/m1_988_3464# -0.05088f
C1073 Xvi/m1_8042_6360# ib_r1 0.00504f
C1074 Xd2/m1_596_2880# vbn_prb 0.00881f
C1075 bias_en Xd3/m1_3908_2760# 0.05571f
C1076 i1_b2 i0_b3 0.0852f
C1077 i0_b0 vbn_prb 0.05531f
C1078 Xi1/g vbp_st 0.11135f
C1079 i0_b4 i3_b0 0.22732f
C1080 r1_b0 vbp_w 0.02193f
C1081 Xm/in_n Xr/m1_342_438# 0.03331f
C1082 Xm/iint vbp_st 0.72512f
C1083 Xr/vsn Xi2/g 0.14643f
C1084 ua0_int v0_c4 0.01993f
C1085 i0_b0 i0_b3 0.1434f
C1086 vreset_src vbn_prb 0.25601f
C1087 Xr/vglp el 0.01042f
C1088 Xm/in_n Xg/m1_3298_2050# 0.02616f
C1089 Xi2/a_3928_4170# Xr/vgln 0
C1090 i3_b4 Xi3/a_4132_4392# 0
C1091 r1_b4 Xi3/a_3928_4392# 0.01837f
C1092 i0_b0 Xi2/a_1582_4170# 0
C1093 Xg/a_3036_4156# Xr/vgln -0
C1094 ua0_s1 Xm/a_1764_11418# 0.00125f
C1095 Xr/en_b vth_ref 0.03505f
C1096 Xd3/a_3992_3816# Xd3/m1_3908_2760# -0
C1097 v0_c1 Xi1/a_4132_4392# 0.00479f
C1098 i4_b1 r1_b0 0.07851f
C1099 vdd Xd0/a_1040_3416# -0.00488f
C1100 Xi4/g r1_b0 0.01342f
C1101 Xi3/m1_988_3464# Xi3/g -0.03456f
C1102 Xm/in_n Xg/m1_4760_1320# 0.02278f
C1103 i1_b3 i3_b2 0.0114f
C1104 Xi4/a_732_4170# vbn_prb 0
C1105 Xr/vgln Xi3/a_3928_4392# 0.01014f
C1106 Xi0/g i0_b1 0.00261f
C1107 Xg/m1_4906_9490# Xi0/g 0.05526f
C1108 Xd0/m1_822_4048# vbn_prb 0.04981f
C1109 ua0_stim_out Xi0/m1_988_2804# 0.05505f
C1110 Xvi/a_864_6450# vth_ref 0.00978f
C1111 i4_b3 Xg/m1_3666_9610# 0
C1112 Xg/a_3036_4156# Xr/vsp 0.05177f
C1113 r0_b4 i0_b0 0.03784f
C1114 Xd0/a_1040_3416# Xd0/m1_617_3840# -0.00174f
C1115 Xi2/g vbp_syn 0
C1116 r0_b1 i0_b1 0.04283f
C1117 v0_c5 ua0_int 0.10841f
C1118 Xr/vglp i2_b2 0.03955f
C1119 r1_b1 i0_b1 0.11061f
C1120 i4_b3 vth_cmp 0.04056f
C1121 Xd0/m1_2242_4966# vbn_prb 0.00284f
C1122 r0_b1 Xd0/a_2816_3416# 0.04419f
C1123 i3_b1 Xg/a_3036_4156# 0.09953f
C1124 Xi2/m1_1500_3762# Xi0/g 0.00331f
C1125 i2_b0 i2_b2 0.21581f
C1126 i1_b0 Xr/vglp 0.00298f
C1127 vth_cmp i4_b0 0.02548f
C1128 r0_b0 i0_b0 0.02853f
C1129 Xi2/m1_988_888# Xr/vgln 0.03797f
C1130 Xd3/m1_1523_3480# ua0_s1 0.01837f
C1131 Xi2/a_3078_4170# i0_b4 0.10277f
C1132 Xi4/m1_988_888# r2_b1 0
C1133 i3_b1 Xi3/a_3928_4392# 0
C1134 Xd3/a_1624_3816# vdd 0.00676f
C1135 bias_en Xvi/m1_7102_850# 0.06148f
C1136 Xr/vgln Xi2/m1_988_2644# 0.00107f
C1137 Xd3/a_2808_3816# ua0_int 0
C1138 r2_b3 i0_b1 0.03137f
C1139 Xvi/a_5712_1328# vdd -0.02118f
C1140 vbp_w Xi3/g 0.67851f
C1141 Xg/a_4580_5314# Xm/in_p 0.08983f
C1142 Xi2/g r0_b3 0.00112f
C1143 r2_b2 r1_b0 0.2968f
C1144 Xd1/m1_756_3120# Xr/vsp 0.02906f
C1145 Xm/iint vth_ref 0.07448f
C1146 i3_b4 Xg/a_3036_4156# 0.04632f
C1147 v0_c5 v0_c4 0.07835f
C1148 Xd0/m1_3662_4048# Xi0/m1_988_888# 0.0088f
C1149 i3_b1 Xi2/m1_988_888# 0.00332f
C1150 i4_b1 Xi3/g 0.05104f
C1151 i4_b4 Xg/m1_3898_9610# 0
C1152 bias_en ua0_s1 0.28974f
C1153 Xd0/a_1040_3416# el 0.07738f
C1154 Xi4/g Xi3/g 0.24365f
C1155 i1_b3 i0_b4 0.05605f
C1156 Xr/vglp Xvi/m1_4546_7560# -0.04586f
C1157 Xg/a_3036_4156# Xg/a_5188_4156# -0
C1158 i3_b4 Xi3/a_3928_4392# 0
C1159 i4_b1 i3_b3 0.20915f
C1160 r2_b0 Xi2/a_528_4170# 0
C1161 Xi1/a_3282_4392# Xi1/a_3078_4392# -0
C1162 v0_c1 Xi1/a_3928_4392# 0.00202f
C1163 Xi4/g i3_b3 0.00603f
C1164 r1_b2 i2_b0 0.24337f
C1165 Xvi/a_5712_1328# ib_x2 0.09844f
C1166 ua0_stim_out Xi2/a_528_4170# 0
C1167 Xi0/a_1582_4392# vbp_syn 0
C1168 Xd3/a_3992_3816# ua0_s1 0.05409f
C1169 i4_b3 i2_b3 0.13289f
C1170 Xr/vgln r0_b2 0.15899f
C1171 i0_b4 Xi2/a_2432_4170# 0.06355f
C1172 Xi2/m1_988_888# i3_b4 0.00499f
C1173 i2_b3 i4_b0 0.03147f
C1174 Xvi/a_864_6450# Xvi/m1_8332_7080# -0.02741f
C1175 i4_b1 Xi4/a_1582_4170# 0.00567f
C1176 i4_b2 vbp_w -0.01301f
C1177 Xi2/g Xi2/m1_260_2080# -0.04272f
C1178 Xi0/a_3282_4392# i0_b3 0
C1179 vdd v0_c3 0.57733f
C1180 Xd1/m1_2974_2650# Xr/vsp 0.2559f
C1181 vdd Xi3/m1_988_2804# -0.02172f
C1182 Xr/vglp vbp_st 0.25584f
C1183 Xi2/a_1378_4170# vbp_syn 0
C1184 i2_b0 Xi2/a_732_4170# 0.00113f
C1185 i4_b3 Xi4/a_3282_4170# 0
C1186 r1_b4 r1_b0 1.73065f
C1187 Xr/vsn r2_b1 0.01886f
C1188 Xvi/m1_7440_2050# Xvi/a_864_6450# -0.00251f
C1189 Xvi/m1_502_738# vreset_src 0
C1190 Xd1/m1_1780_5040# vth_cmp 0
C1191 Xi4/a_3282_4170# i4_b0 0
C1192 r2_b2 Xi3/g 0.04446f
C1193 i4_b1 i4_b2 0.38995f
C1194 Xd0/m1_382_4048# vth_cmp 0.013f
C1195 ua0_stim Xm/a_2240_11218# 0
C1196 r2_b2 i3_b3 0.03786f
C1197 v0_c0 Xi1/a_3282_4392# 0
C1198 ib_x2 v0_c3 0.18403f
C1199 r1_b0 Xr/vgln 0.45313f
C1200 Xi0/g Xi2/m1_988_3304# 0.00332f
C1201 Xi2/a_3928_4170# vbn_ref 0.03936f
C1202 Xi4/g Xvi/m1_1382_738# 0
C1203 Xd1/m1_606_2410# Xr/vsp 0.00546f
C1204 Xi3/g Xi3/m1_988_888# 0.21397f
C1205 r2_b4 Xi2/a_3282_4170# 0.00284f
C1206 i0_b1 vbn_prb 0.18103f
C1207 Xi4/g bias_en 0.00161f
C1208 Xd1/m1_462_4048# Xd1/a_680_3416# -0
C1209 r1_b1 Xvi/a_864_6450# 0
C1210 Xm/iint Xvi/m1_8332_7080# 0
C1211 Xg/a_3036_4156# vbn_ref 0.04647f
C1212 r1_b3 i3_b2 0.04352f
C1213 r2_b0 vth_cmp 0.03097f
C1214 Xg/m1_4906_9490# i0_b3 0.07618f
C1215 i0_b1 i0_b3 0.3298f
C1216 r1_b0 Xr/vsp 0.03814f
C1217 Xr/vsn i4_b4 0.26478f
C1218 ua0_stim_out vth_cmp 0.16256f
C1219 vth_cmp Xi0/m1_240_3480# 0.0191f
C1220 vdd Xg/a_1580_5314# -0.25439f
C1221 i0_b1 Xi2/a_1582_4170# 0.00708f
C1222 Xg/m1_6020_10200# Xi3/g 0
C1223 Xi0/m1_988_888# Xd0/a_3408_3416# 0.00198f
C1224 r2_b1 vbp_syn 0.03798f
C1225 Xvi/m1_7440_2050# Xm/iint 0.00117f
C1226 Xi2/g Xg/a_4580_5314# 0.06706f
C1227 Xi2/m1_1500_3762# i0_b3 0
C1228 vdd Xi0/m1_988_888# -0.07466f
C1229 r1_b3 i3_b0 0.09402f
C1230 i3_b1 r1_b0 0.03384f
C1231 ua0_stim Xd3/a_4584_3816# 0.01686f
C1232 Xi2/a_3282_4170# vdd 0.00172f
C1233 vth_cmp Xi3/m1_240_3480# 0
C1234 r2_b4 i3_b0 0.07591f
C1235 Xi0/a_1378_4392# vbp_syn 0
C1236 Xi1/g Xi0/g 0.37254f
C1237 Xm/a_2240_11218# Xm/a_736_5516# -0.15536f
C1238 i4_b2 r2_b2 0.12245f
C1239 Xi3/m1_988_2804# el 0.014f
C1240 Xd3/m1_2720_2760# vdd -0.00518f
C1241 Xg/a_3036_4156# Xg/a_7580_5314# -0.00118f
C1242 vdd i3_b2 0.51597f
C1243 Xr/vglp vth_ref 0.54633f
C1244 r1_b4 Xi3/g 0.95299f
C1245 Xi2/a_528_4170# vbn_ax 0.00412f
C1246 i4_b3 Xm/in_p 0.17721f
C1247 i4_b3 i2_b4 0.24666f
C1248 r0_b4 i0_b1 0.02699f
C1249 i4_b1 Xi4/a_1378_4170# 0
C1250 Xi1/g r1_b1 0
C1251 r2_b3 Xd2/a_2456_3416# 0.00441f
C1252 r2_b1 r0_b3 0.41034f
C1253 Xi0/a_3078_4392# i0_b3 0.00411f
C1254 i2_b4 i4_b0 0.0395f
C1255 Xm/in_p i4_b0 0.52813f
C1256 i4_b3 Xi4/a_3078_4170# 0
C1257 Xd1/m1_2372_2520# Xr/vsp 0.1982f
C1258 r1_b4 i3_b3 0.03322f
C1259 i4_b2 Xi3/m1_988_888# 0.30405f
C1260 vdd i3_b0 0.73268f
C1261 r0_b0 i0_b1 0.14773f
C1262 Xi4/a_3078_4170# i4_b0 0
C1263 i3_b4 r1_b0 0.05996f
C1264 Xr/vgln Xi3/g 0.3172f
C1265 r1_b3 i0_b4 0.03629f
C1266 r0_b0 Xd0/a_2816_3416# 0.04272f
C1267 Xr/vsn Xi3/a_3282_4392# 0
C1268 v0_c2 Xd3/m1_3222_4448# 0.02241f
C1269 r2_b4 i0_b4 0.03748f
C1270 Xr/vsn vreset_src 0.03405f
C1271 Xr/vgln i3_b3 0.0581f
C1272 vbp_w Xi0/m1_988_2804# 0.01079f
C1273 v0_c2 v0_c3 1.03018f
C1274 ua0_stim_out Xi0/a_2432_4392# 0.00704f
C1275 i2_b3 ua0_stim_out 0
C1276 Xi3/g Xr/vsp 0.75515f
C1277 i1_b1 Xi0/g 0.30064f
C1278 ua0 ua0_s0 0.08179f
C1279 r2_b4 Xi2/a_3078_4170# 0.09405f
C1280 Xg/m1_3530_1930# Xi3/g 0
C1281 Xi0/m1_988_888# el 0.03455f
C1282 i3_b3 Xr/vsp 0.19139f
C1283 i3_b1 Xi3/g 0.87842f
C1284 r1_b0 i2_b1 0.0282f
C1285 vdd i0_b4 1.23974f
C1286 i3_b1 i3_b3 0.99459f
C1287 i0_b0 vbp_syn 0.05085f
C1288 vth_cmp vbn_leak 0.0066f
C1289 Xi4/a_1582_4170# Xr/vgln -0.00168f
C1290 i4_b2 r1_b4 0.16431f
C1291 Xi1/m1_240_3480# Xi1/a_4132_4392# -0
C1292 vbn_ref r0_b2 0.0329f
C1293 i0_b2 r0_b2 0.03446f
C1294 Xvi/m1_1276_6360# Xvi/a_4976_1528# -0.01375f
C1295 Xi2/a_3078_4170# vdd -0.15459f
C1296 vth_cmp vbn_ax 0.04184f
C1297 Xi1/m1_988_888# v0_c3 0.09187f
C1298 Xvi/a_864_6450# vbn_prb -0.05235f
C1299 Xi4/a_1582_4170# Xr/vsp 0
C1300 Xvi/m1_1276_6360# vdd -0.07021f
C1301 i4_b2 Xr/vgln 0.44867f
C1302 Xi2/a_4132_4170# r2_b2 0
C1303 v0_c1 Xi1/g 0.0437f
C1304 Xvi/a_4976_1528# Xvi/a_2102_5152# -0
C1305 Xr/vglp Xvi/m1_8332_7080# 0.07925f
C1306 i3_b4 Xi3/g 0.2313f
C1307 i0_b0 r0_b3 0.02778f
C1308 vdd Xvi/a_2102_5152# -0.02853f
C1309 bias_en Xr/vgln 0.30012f
C1310 Xg/a_5188_4156# Xi3/g 0.11923f
C1311 i3_b4 i3_b3 0.19634f
C1312 Xg/m1_3898_9610# i0_b1 0.00924f
C1313 i4_b2 Xr/vsp 0.44958f
C1314 i1_b0 i3_b2 0.81591f
C1315 r1_b0 vbn_ref 0.02909f
C1316 Xvi/m1_7440_2050# Xr/vglp 0.05727f
C1317 Xd0/a_1632_3416# Xd0/m1_956_3000# -0
C1318 i1_b3 vdd 0.10301f
C1319 r1_b0 i0_b2 0.02574f
C1320 Xd2/a_2456_3416# vbn_prb 0.16572f
C1321 Xr/vsn Xi3/a_3078_4392# 0
C1322 Xg/a_5188_4156# i3_b3 0.05356f
C1323 i3_b1 i4_b2 0.06175f
C1324 Xd0/a_2224_3416# r0_b2 0.00304f
C1325 v0_c2 Xd3/m1_2720_2760# -0.00586f
C1326 Xi1/a_4132_4392# Xi1/a_3078_4392# -0
C1327 Xi2/g i4_b3 0.16605f
C1328 ua0_stim ua0_int 0.81176f
C1329 Xr/vglp Xi0/g 0.83469f
C1330 ua0_stim_out Xi0/a_2228_4392# 0.00774f
C1331 i1_b0 i3_b0 0.05675f
C1332 Xi2/g i4_b0 0.04265f
C1333 Xm/iint vbn_prb 0.00107f
C1334 Xi3/a_2432_4392# vbp_w 0
C1335 Xi0/a_2432_4392# vbn_leak 0
C1336 i3_b0 i2_b2 0
C1337 Xr/en_b Xm/a_736_7228# -0
C1338 ib_x2 Xvi/a_2102_5152# 0.11121f
C1339 vdd Xi2/a_2432_4170# 0.00209f
C1340 r0_b1 i2_b0 0
C1341 Xi1/g i0_b3 0.10287f
C1342 i2_b0 r1_b1 0.04795f
C1343 ua0_stim_out Xm/in_p 0.89521f
C1344 Xd3/m1_822_4448# ua0_s0 0.00122f
C1345 Xi4/a_1378_4170# Xr/vgln -0.00581f
C1346 i4_b2 i3_b4 0.16179f
C1347 i1_b1 Xi1/a_1378_4392# 0.00763f
C1348 Xi2/a_4132_4170# r1_b4 0
C1349 Xi0/m1_1500_4312# Xi0/m1_240_3480# -0.00136f
C1350 ua0_stim_out Xi0/m1_1500_4312# 0.15891f
C1351 Xi1/m1_240_3480# Xi1/a_3928_4392# -0
C1352 r2_b3 i2_b0 0.05759f
C1353 Xg/a_4580_5314# i4_b4 0
C1354 ua0_stim v0_c4 0.07875f
C1355 ua0_int Xm/a_736_5516# 0.07202f
C1356 Xg/a_1580_5314# vbp_st 0.14523f
C1357 i1_b0 i0_b4 0.0642f
C1358 i0_b4 Xi0/a_4132_4392# -0.00292f
C1359 i0_b4 i2_b2 0.02132f
C1360 vbn_ref Xi3/g 0.40147f
C1361 v0_c0 Xi1/a_4132_4392# 0.01601f
C1362 Xd0/m1_3662_4048# vdd 0.00193f
C1363 i4_b2 i2_b1 0.01201f
C1364 i1_b1 i0_b3 0.04219f
C1365 Xd1/m1_462_4048# vreset_src 0
C1366 vbp_w vth_cmp 0.08192f
C1367 r1_b2 i3_b0 0
C1368 Xi0/a_3282_4392# vbp_syn 0.04406f
C1369 i3_b3 vbn_ref 0.04332f
C1370 Xi3/m1_1500_4312# Xi3/m1_988_3464# -0
C1371 i3_b2 vbp_st 0.06944f
C1372 Xm/in_n Xi3/g 0.06404f
C1373 Xr/vsn i0_b1 0
C1374 i4_b1 vth_cmp 0.04406f
C1375 Xvi/m1_8042_6360# Xr/vgln 0.01001f
C1376 Xm/in_n Xm/a_1764_11418# 0
C1377 v0_c5 ua0_stim 0.85869f
C1378 ua0_int Xm/a_1764_11418# 0
C1379 bias_en Xr/m1_2542_438# 0.0105f
C1380 Xi4/g vth_cmp 0.04903f
C1381 Xi1/a_3928_4392# Xi1/a_3078_4392# -0
C1382 Xi4/a_4132_4170# i4_b4 0
C1383 r0_b1 Xd0/a_1040_3416# 0.02021f
C1384 i3_b0 vbp_st 0.29299f
C1385 Xg/a_7580_5314# Xi3/g 0.30846f
C1386 i1_b3 i1_b0 0.01285f
C1387 Xi3/a_2228_4392# vbp_w 0.0031f
C1388 Xi0/a_2228_4392# vbn_leak 0
C1389 r2_b4 r1_b3 0.04601f
C1390 Xi0/m1_988_2804# Xr/vsp -0.00318f
C1391 Xi4/a_528_4170# r2_b1 0
C1392 Xg/a_7580_5314# i3_b3 0.12945f
C1393 Xd3/a_2808_3816# ua0_stim 0.00101f
C1394 r1_b2 i0_b4 0.05653f
C1395 bias_en Xd3/m1_382_4448# 0.05633f
C1396 Xd2/m1_1342_4048# vth_cmp 0
C1397 vth_cmp Xi0/a_528_4392# 0
C1398 i0_b1 vbp_syn 0.82047f
C1399 i4_b2 vbn_ref 0.07697f
C1400 i4_b2 i0_b2 0.13848f
C1401 Xvi/m1_1276_6360# Xvi/m1_4546_7560# -0.00679f
C1402 Xi3/m1_1500_4312# vbp_w 0.00758f
C1403 Xi0/m1_1500_4312# vbn_leak -0.00115f
C1404 Xd3/a_1624_3816# Xd3/a_2216_3816# -0
C1405 bias_en Xd3/m1_4078_3250# 0.05671f
C1406 i2_b2 Xi2/a_2432_4170# 0
C1407 Xd0/m1_3662_4048# el 0.00135f
C1408 r2_b0 Xi2/g 0
C1409 r1_b3 vdd 0.56805f
C1410 r1_b0 Xi4/a_2432_4170# 0.06597f
C1411 Xg/m1_3298_2050# Xi3/g 0
C1412 vbp_w Xi0/a_2432_4392# 0.0221f
C1413 i0_b4 Xi0/a_3928_4392# 0.0029f
C1414 r2_b4 vdd 0.75992f
C1415 Xr/vglp vbn_prb 0.18239f
C1416 Xi2/g ua0_stim_out 0.52272f
C1417 i0_b4 Xi2/a_732_4170# 0.02657f
C1418 i0_b4 vbp_st 0.13359f
C1419 r2_b2 vth_cmp 0.03633f
C1420 i2_b0 i0_b3 0.03775f
C1421 Xr/vglp i0_b3 0.71932f
C1422 v0_c0 Xi1/a_3928_4392# 0.05472f
C1423 i0_b1 r0_b3 0.02705f
C1424 Xi4/a_4132_4170# vreset_src 0.00543f
C1425 Xd0/m1_2242_4966# Xd0/m1_956_3000# 0
C1426 Xi3/a_2432_4392# r1_b4 0.00735f
C1427 Xr/en_b Xr/m1_3862_3522# 0.0017f
C1428 Xd3/a_2808_3816# Xd3/m1_2408_3600# -0
C1429 Xr/vgln Xi2/a_528_4170# 0
C1430 i4_b1 i2_b3 0.03156f
C1431 r2_b1 i4_b0 0
C1432 vdd Xvi/a_4976_1528# -0.12986f
C1433 Xd0/a_2816_3416# r0_b3 0.00373f
C1434 bias_en Xm/in_n 0.26699f
C1435 Xi0/a_3078_4392# vbp_syn 0.02132f
C1436 i2_b0 Xi2/a_1582_4170# 0
C1437 Xi2/a_4132_4170# i2_b1 0
C1438 vth_cmp Xi3/m1_988_888# 0.19577f
C1439 vdd Xd0/a_3408_3416# 0.00399f
C1440 Xr/en_b ua0_s0 0.04068f
C1441 bias_en ua0_int 0.05311f
C1442 Xr/en_b Xi1/m1_240_3480# 0.01261f
C1443 Xi3/a_2432_4392# Xr/vgln 0.05482f
C1444 i4_b1 Xi4/a_3282_4170# 0
C1445 Xi4/a_3928_4170# i4_b4 0
C1446 r1_b0 Xi3/a_4132_4392# 0
C1447 Xr/vsn Xr/en_b 0.00249f
C1448 Xd3/a_2216_3816# Xd3/m1_3222_4448# -0
C1449 i4_b3 i4_b4 0.9939f
C1450 vdd Xm/a_420_700# -0.00272f
C1451 Xd1/a_1864_3416# Xr/vsp 0.04672f
C1452 vdd Xm/a_1744_10100# 0
C1453 Xd3/a_3992_3816# ua0_int 0.00219f
C1454 r0_b4 i2_b0 0.27867f
C1455 ib_x2 Xvi/a_4976_1528# 0.08019f
C1456 i4_b4 i4_b0 0.24067f
C1457 Xi2/m1_988_888# Xi2/m1_988_2644# -0.0121f
C1458 vdd ib_x2 0.79424f
C1459 r1_b3 el 0.03388f
C1460 bias_en v0_c4 0.04604f
C1461 Xi4/a_528_4170# vreset_src 0
C1462 i0_b1 Xi2/m1_260_2080# 0.08595f
C1463 r2_b4 el 0.05675f
C1464 r1_b4 vth_cmp 0.05015f
C1465 Xd0/m1_1262_4048# el 0.02521f
C1466 bias_en Xr/m1_342_438# 0.02246f
C1467 ua0_stim_out Xi0/a_1582_4392# 0.00822f
C1468 Xi2/a_4132_4170# vbn_ref 0.04651f
C1469 r2_b2 i2_b3 0.03721f
C1470 Xi0/m1_1500_4312# Xi0/a_732_4392# -0
C1471 Xi2/a_4132_4170# i0_b2 0
C1472 Xm/iint Xr/m1_3862_3522# 0.02789f
C1473 r1_b0 Xi4/a_2228_4170# 0.04345f
C1474 vbp_w Xi0/a_2228_4392# 0.02202f
C1475 Xvi/a_4976_1528# el 0
C1476 Xr/vgln vth_cmp 0.08993f
C1477 Xd3/a_1624_3816# v0_c1 0.01863f
C1478 Xd3/a_3992_3816# v0_c4 0.09662f
C1479 Xm/iint ua0_s0 0.03938f
C1480 i4_b3 i0_b0 0.04108f
C1481 Xi1/g Xi1/m1_240_3480# 0.01644f
C1482 vdd el 0.80937f
C1483 Xi4/a_3928_4170# vreset_src 0.00565f
C1484 Xi3/a_2228_4392# r1_b4 0.0027f
C1485 Xd3/a_2808_3816# Xd3/m1_1523_3480# -0
C1486 Xg/m1_3666_9610# Xr/vsp 0.01796f
C1487 i0_b0 i4_b0 0.04156f
C1488 r1_b3 i2_b2 0.03684f
C1489 bias_en v0_c5 0.04835f
C1490 i4_b3 vreset_src 0.02888f
C1491 Xr/vsn Xi1/g 0.06842f
C1492 Xi2/g vbn_ax 0.0064f
C1493 r2_b4 i2_b2 0.04303f
C1494 i1_b2 i1_b4 0
C1495 Xi3/a_4132_4392# Xi3/g 0
C1496 Xr/vsn Xm/iint 0.08621f
C1497 vth_cmp Xr/vsp 0.49215f
C1498 Xg/a_1580_5314# Xi0/g 0.09609f
C1499 vbp_w Xi0/m1_1500_4312# 0.0014f
C1500 i4_b1 i2_b4 0.12178f
C1501 i4_b1 Xm/in_p 0.22446f
C1502 vreset_src i4_b0 0.03065f
C1503 Xd3/m1_3222_4448# Xd3/m1_1702_4448# -0.0024f
C1504 i4_b1 Xi4/a_3078_4170# 0.00358f
C1505 el Xd0/m1_617_3840# 0.21385f
C1506 Xi3/a_2228_4392# Xr/vgln 0.02912f
C1507 Xi0/g Xi0/m1_988_888# 0.39303f
C1508 i4_b2 Xi4/a_2432_4170# 0
C1509 Xi3/m1_1500_4312# r1_b4 0.08979f
C1510 r1_b0 Xi3/a_3928_4392# 0
C1511 ib_x2 el 0.08979f
C1512 Xd3/a_2216_3816# Xd3/m1_2720_2760# -0
C1513 r2_b0 r2_b1 2.68687f
C1514 Xi4/a_732_4170# i4_b0 0
C1515 Xi3/a_1582_4392# Xi3/a_732_4392# -0
C1516 v0_c0 Xr/en_b 0
C1517 i3_b2 Xi0/g 0.00622f
C1518 vdd Xi0/a_4132_4392# -0.01274f
C1519 vdd i2_b2 0.45671f
C1520 i1_b0 vdd 0.52003f
C1521 r1_b4 i2_b3 0.02733f
C1522 Xd1/m1_606_2410# Xd1/m1_756_3120# -0
C1523 Xg/m1_3898_9610# Xr/vglp 0
C1524 r2_b1 ua0_stim_out 0.03681f
C1525 r2_b0 Xd2/a_3048_3416# 0.00118f
C1526 r0_b0 Xd0/a_1040_3416# 0.02256f
C1527 v0_c1 Xd3/m1_3222_4448# 0.14473f
C1528 Xi1/g Xi1/a_3078_4392# 0.00281f
C1529 i0_b0 Xg/m1_5022_10210# 0.00103f
C1530 v0_c2 vdd 0.32488f
C1531 r1_b1 i3_b2 0.03813f
C1532 i3_b1 Xi3/a_2228_4392# 0
C1533 Xi2/m1_988_888# r1_b0 0.01128f
C1534 v0_c1 v0_c3 0.18281f
C1535 Xi3/a_1582_4392# vbp_w 0.00736f
C1536 Xi0/a_1378_4392# Xi0/m1_240_3480# -0
C1537 Xi0/g i3_b0 0.12449f
C1538 ua0_stim_out Xi0/a_1378_4392# 0.02301f
C1539 r2_b3 Xi2/a_3282_4170# 0
C1540 Xi0/a_1582_4392# vbn_leak 0
C1541 Xr/vgln Xi0/a_2432_4392# 0.00111f
C1542 i2_b3 Xr/vgln 0.21656f
C1543 r1_b3 r1_b2 0.09492f
C1544 Xi0/m1_988_888# Xd0/m1_3310_2880# 0.00134f
C1545 r2_b4 r1_b2 0.0392f
C1546 Xi3/m1_1500_4312# Xr/vsp -0.00195f
C1547 r2_b2 i2_b4 0.03775f
C1548 i4_b2 Xi3/a_4132_4392# 0
C1549 vbn_ref Xi2/a_528_4170# 0.01139f
C1550 r2_b2 Xm/in_p 0
C1551 r1_b1 i3_b0 0.05675f
C1552 Xvi/a_4976_1528# Xvi/m1_4546_7560# -0
C1553 v0_c2 ib_x2 0.07115f
C1554 i1_b4 Xi1/a_4132_4392# -0.00502f
C1555 r2_b2 Xi4/a_3078_4170# 0.00448f
C1556 ua0_stim_out i4_b4 0.04522f
C1557 Xg/a_3036_4156# Xi3/g 0.0958f
C1558 vdd Xi1/m1_988_888# -0.03719f
C1559 i2_b3 Xr/vsp 0.23829f
C1560 vdd Xvi/m1_4546_7560# -0.03843f
C1561 r1_b3 vbp_st 0.03995f
C1562 ib_r1 vreset_src 0.0924f
C1563 r2_b3 i3_b0 0.3955f
C1564 Xg/a_3036_4156# i3_b3 0.10112f
C1565 Xi4/a_2432_4170# Xi4/a_1378_4170# -0.00657f
C1566 r1_b0 Xi4/m1_1500_3762# 0.00249f
C1567 r2_b4 vbp_st 0.14283f
C1568 Xi3/a_3928_4392# Xi3/g 0
C1569 Xi2/a_1378_4170# vbn_ax 0
C1570 i0_b4 Xi0/g 0.31217f
C1571 r1_b2 vdd 1.25921f
C1572 Xi3/a_1378_4392# Xi3/m1_988_3464# -0.00198f
C1573 v0_c0 Xi1/g 1.18317f
C1574 i3_b3 Xi3/a_3928_4392# 0
C1575 r0_b1 i0_b4 0.05109f
C1576 i1_b2 Xi1/a_2228_4392# 0.0033f
C1577 vdd Xi1/m1_988_3464# 0.03297f
C1578 Xd1/m1_1780_5040# vreset_src 0.04637f
C1579 Xi1/a_3928_4392# Xi1/m1_988_2804# -0
C1580 i0_b4 r1_b1 0.03419f
C1581 Xi2/g vbp_w 0.09729f
C1582 Xi2/a_3078_4170# Xi0/g 0
C1583 ib_x2 Xvi/m1_4546_7560# 0.00318f
C1584 r2_b0 i0_b0 0.02567f
C1585 v0_c3 Xd3/a_3400_3816# 0.03873f
C1586 Xvi/m1_942_738# vreset_src 0
C1587 Xi3/a_1378_4392# Xi3/a_732_4392# -0.0029f
C1588 Xr/vglp Xi1/m1_240_3480# 0.00162f
C1589 vdd Xi0/a_3928_4392# 0.00171f
C1590 vdd vbp_st 1.20047f
C1591 i4_b1 Xi2/g 0.08795f
C1592 r2_b3 i0_b4 0.03136f
C1593 ua0_stim_out i0_b0 0.03612f
C1594 Xi4/g Xi2/g 0.08347f
C1595 Xi2/m1_988_888# i3_b3 0
C1596 v0_c1 Xd3/m1_2720_2760# 0.10822f
C1597 Xi0/m1_988_3464# Xi0/m1_988_2804# -0.00121f
C1598 r1_b4 i2_b4 0.02788f
C1599 r2_b0 vreset_src 0.02776f
C1600 Xr/vsn Xr/vglp 0.61425f
C1601 Xi3/a_1378_4392# vbp_w 0.03482f
C1602 Xi0/a_1378_4392# vbn_leak 0
C1603 r2_b3 Xi2/a_3078_4170# 0.35507f
C1604 r2_b1 vbn_ax 0.32312f
C1605 Xd1/a_2456_3416# r1_b2 0
C1606 Xr/vgln Xm/in_p 0.05294f
C1607 Xr/vgln i2_b4 0.04156f
C1608 ib_x2 vbp_st 0.16814f
C1609 Xd1/a_1272_3416# vdd -0
C1610 Xvi/m1_4546_7560# el -0
C1611 i4_b2 Xi3/a_3928_4392# 0
C1612 Xi0/m1_988_888# vbn_prb 0.22558f
C1613 r2_b0 Xi4/a_732_4170# 0
C1614 Xm/in_n vth_cmp 0
C1615 i2_b3 i2_b1 0.01191f
C1616 i1_b4 Xi1/a_3928_4392# 0.00229f
C1617 r1_b2 el 0.04149f
C1618 Xi4/a_3078_4170# Xr/vgln 0
C1619 i4_b3 i0_b1 0.05477f
C1620 r2_b1 Xi4/m1_260_2080# 0.06502f
C1621 Xi2/a_3282_4170# i0_b3 0.00412f
C1622 i0_b1 i4_b0 0.03405f
C1623 Xm/in_p Xr/vsp 1.27323f
C1624 i2_b4 Xr/vsp 0.06918f
C1625 ua0_stim Xm/a_736_5516# 0
C1626 i2_b0 vbp_syn 0.27654f
C1627 i3_b2 i0_b3 0.08061f
C1628 i4_b2 Xi2/m1_988_888# 0
C1629 vbp_w Xi0/a_1582_4392# 0.06038f
C1630 vth_cmp Xd1/m1_2862_4048# 0.00831f
C1631 i3_b1 Xm/in_p 0.25719f
C1632 Xi2/g r2_b2 0.05796f
C1633 i1_b2 Xi1/a_2432_4392# 0.00138f
C1634 vbp_st el 0.00311f
C1635 bias_en Xd3/m1_4102_4448# 0.06509f
C1636 Xg/a_4580_5314# Xm/iint 0
C1637 Xi3/a_1582_4392# r1_b4 0
C1638 vdd vth_ref 0.60712f
C1639 i3_b0 i0_b3 0.02901f
C1640 v0_c2 Xi1/m1_988_888# 0.0194f
C1641 r1_b2 i2_b2 0.27729f
C1642 v0_c3 Xd3/m1_4982_4448# 0.00412f
C1643 Xi2/g Xi3/m1_988_888# 0
C1644 i2_b0 r0_b3 0
C1645 Xi0/a_2432_4392# i0_b2 0
C1646 i2_b3 i0_b2 0.07102f
C1647 Xd0/m1_3662_4048# Xi0/g 0
C1648 i2_b3 vbn_ref 0.0401f
C1649 i0_b1 Xg/m1_5022_10210# 0.00539f
C1650 Xg/m1_4906_9490# Xg/m1_5022_10210# 0
C1651 i0_b0 vbn_leak 0.68642f
C1652 Xi3/a_1582_4392# Xr/vgln 0
C1653 i3_b4 Xm/in_p 0.17521f
C1654 r1_b0 Xi3/g 0.06384f
C1655 i0_b1 Xi2/a_2228_4170# 0.02399f
C1656 Xg/a_5188_4156# Xm/in_p 0.04228f
C1657 Xi0/a_4132_4392# vbp_st 0
C1658 i0_b0 vbn_ax 0.14012f
C1659 r1_b0 i3_b3 0.03342f
C1660 r2_b2 Xi4/m1_988_2644# 0.01966f
C1661 ib_x2 vth_ref 1.93662f
C1662 v0_c1 i1_b3 0.00506f
C1663 i0_b4 i0_b3 0.12736f
C1664 i3_b1 Xi3/a_1582_4392# 0.00525f
C1665 i0_b4 Xi2/a_1582_4170# 0.04551f
C1666 Xi2/g r1_b4 0.16434f
C1667 Xd1/a_3048_3416# vth_cmp 0.02457f
C1668 r2_b1 vbp_w 0.04139f
C1669 ua0_stim_out Xi0/a_3282_4392# 0.00603f
C1670 Xi2/a_3078_4170# i0_b3 0.04792f
C1671 i2_b1 Xm/in_p 0.04697f
C1672 i2_b1 i2_b4 0
C1673 r1_b0 Xi4/a_1582_4170# 0.06289f
C1674 vbp_w Xi0/a_1378_4392# 0.07556f
C1675 vth_ref el 0.17246f
C1676 Xi2/g Xr/vgln 1.10151f
C1677 Xi4/g r2_b1 0.00202f
C1678 Xi0/m1_988_3464# vth_cmp 0.00143f
C1679 r0_b4 i0_b4 0.0404f
C1680 r1_b3 Xi0/g 0.05704f
C1681 bias_en ua0_stim 0.21327f
C1682 i4_b2 r1_b0 0.8636f
C1683 vdd Xvi/m1_8332_7080# -0.06846f
C1684 Xi3/a_1378_4392# r1_b4 0
C1685 i1_b3 i0_b3 0.02597f
C1686 i4_b3 Xvi/a_864_6450# 0.0292f
C1687 Xi2/g Xr/vsp 0.30352f
C1688 r2_b4 Xi0/g 0.19191f
C1689 r1_b2 vbp_st 0.17276f
C1690 r2_b0 i0_b1 0.02809f
C1691 r0_b0 i0_b4 0.10859f
C1692 Xvi/a_864_6450# i4_b0 0
C1693 r1_b3 r1_b1 0.09807f
C1694 ua0_stim_out i0_b1 0.39703f
C1695 Xi0/a_2228_4392# i0_b2 0.00283f
C1696 r2_b4 r1_b1 0.03679f
C1697 Xi2/g Xg/m1_3530_1930# 0.01305f
C1698 Xi3/a_1378_4392# Xr/vgln 0
C1699 i3_b1 Xi2/g 0.13636f
C1700 Xd3/m1_3222_4448# ua0_s0 0.00975f
C1701 Xi1/g Xi1/m1_988_2804# -0.04009f
C1702 i3_b3 Xi3/g 0.45859f
C1703 i4_b1 i4_b4 0.22546f
C1704 i2_b4 vbn_ref 0.03442f
C1705 i2_b4 i0_b2 0.04813f
C1706 vbn_ref Xm/in_p 0.05537f
C1707 Xi4/g i4_b4 0.28602f
C1708 Xi2/m1_1500_3762# ua0_stim_out 0.0465f
C1709 Xi1/g Xi1/m1_1500_4312# -0.02273f
C1710 Xd3/a_3992_3816# ua0_stim 0.00224f
C1711 i0_b2 Xm/in_p 0
C1712 v0_c3 ua0_s0 0.09622f
C1713 Xi0/g Xd0/a_3408_3416# 0.0029f
C1714 i0_b3 Xi2/a_2432_4170# 0.00542f
C1715 v0_c3 Xi1/m1_240_3480# 0.00841f
C1716 ua0 ua0_s1 0.17416f
C1717 r2_b3 r1_b3 0.04714f
C1718 r2_b1 Xi3/a_528_4392# 0
C1719 Xd3/a_2216_3816# vdd -0
C1720 vdd Xi0/g 1.14003f
C1721 r0_b1 Xd0/a_3408_3416# 0.09363f
C1722 Xg/a_4580_5314# Xr/vglp 0.26607f
C1723 r2_b3 r2_b4 1.49054f
C1724 Xm/in_n Xm/in_p 0.10876f
C1725 r2_b2 r2_b1 0.12586f
C1726 bias_en Xd3/m1_2408_3600# 0.03256f
C1727 i4_b3 Xi1/g 0.38372f
C1728 r0_b1 vdd 1.41946f
C1729 Xr/vgln Xi1/a_3282_4392# 0.00379f
C1730 vdd r1_b1 0.15244f
C1731 i3_b1 Xi3/a_1378_4392# 0.01119f
C1732 Xi2/g Xg/m1_5516_1920# 0.04808f
C1733 Xi2/g i3_b4 0.1581f
C1734 Xi1/g i4_b0 0.0327f
C1735 Xr/vgln Xi0/a_1582_4392# -0.00373f
C1736 ua0_stim_out Xi0/a_3078_4392# 0.00515f
C1737 vbp_w i0_b0 0.17488f
C1738 Xvi/m1_7440_2050# ib_x2 -0
C1739 Xg/a_7580_5314# Xm/in_p 0.06136f
C1740 Xi0/a_3282_4392# vbn_leak 0
C1741 vbp_w vreset_src 0.02594f
C1742 Xd0/m1_3662_4048# vbn_prb 0.04315f
C1743 Xi2/g Xg/a_5188_4156# 0.00977f
C1744 r2_b3 vdd 0.96723f
C1745 r1_b0 Xi4/a_1378_4170# 0.04412f
C1746 r0_b1 Xd0/m1_617_3840# 0
C1747 i4_b2 Xi3/g 0.15706f
C1748 i4_b1 i0_b0 0.0418f
C1749 Xi1/g i1_b4 0.24242f
C1750 Xvi/m1_8332_7080# el 0.01112f
C1751 vdd Xd0/m1_3310_2880# 0
C1752 Xd3/a_1624_3816# v0_c0 0.18125f
C1753 i4_b2 i3_b3 0.03933f
C1754 i4_b1 vreset_src 0.20757f
C1755 r2_b2 i4_b4 0.15837f
C1756 Xr/vgln Xi2/a_1378_4170# -0
C1757 i1_b1 Xi1/a_1582_4392# 0.00119f
C1758 v0_c3 Xi1/a_3078_4392# 0.00771f
C1759 Xi4/g vreset_src 0.40665f
C1760 Xg/m1_3898_9610# i0_b4 0.00634f
C1761 vbp_w Xi4/a_732_4170# 0
C1762 ib_r1 Xvi/a_864_6450# 0.18138f
C1763 Xi2/a_4132_4170# r1_b0 0
C1764 Xr/m1_342_438# Xm/in_p 0
C1765 Xr/vsn Xg/a_1580_5314# 0.06986f
C1766 i0_b1 vbn_leak 0.00227f
C1767 Xi0/g el 0.71182f
C1768 r1_b4 r2_b1 0.02476f
C1769 r0_b1 el 0.1751f
C1770 vth_ref vbp_st 0.02883f
C1771 Xvi/m1_8646_1098# bias_en 0.001f
C1772 Xr/en_b ua0_stim_out 0.32815f
C1773 i0_b1 vbn_ax 0.03281f
C1774 r1_b1 el 0.03126f
C1775 Xr/vsn i3_b2 0.40283f
C1776 Xd1/m1_756_3120# Xd1/m1_860_4046# -0.00341f
C1777 Xd0/a_1040_3416# Xd0/m1_956_3000# -0
C1778 Xd0/a_1632_3416# Xr/vsp 0
C1779 r2_b2 i0_b0 0.07321f
C1780 r2_b1 Xr/vgln 0.07863f
C1781 v0_c0 Xd3/m1_3222_4448# 0.18311f
C1782 Xi2/m1_1500_3762# vbn_ax 0
C1783 v0_c1 vdd 0.42982f
C1784 ib_r1 Xm/iint 0.27781f
C1785 Xd3/m1_1702_4448# ib_x2 0
C1786 bias_en Xd3/m1_1523_3480# 0.00235f
C1787 r2_b3 el 0.07461f
C1788 r2_b4 vbn_prb 0.08744f
C1789 r2_b2 vreset_src 0.03327f
C1790 Xd2/a_1272_3416# vdd 0
C1791 Xd0/m1_1262_4048# vbn_prb 0.05668f
C1792 Xd0/m1_3310_2880# el 0.00784f
C1793 Xr/vsn i3_b0 0.26714f
C1794 Xr/vgln Xi0/a_1378_4392# -0
C1795 ua0_stim_out Xi2/m1_988_3304# 0.16481f
C1796 vdd Xi1/a_1378_4392# 0
C1797 Xi0/a_3078_4392# vbn_leak 0
C1798 v0_c0 v0_c3 0.20108f
C1799 r1_b3 i0_b3 0.0292f
C1800 Xi2/g Xg/m1_6282_1450# 0.09942f
C1801 Xi0/m1_988_888# vbp_syn 0.00124f
C1802 i1_b0 Xi0/g 0.03776f
C1803 r2_b1 Xr/vsp 0.0348f
C1804 Xd2/m1_2382_2650# vth_cmp 0.005f
C1805 v0_c2 Xd3/a_2216_3816# 0.00549f
C1806 r2_b4 i0_b3 0.02502f
C1807 Xd0/m1_2742_3250# Xr/vsp 0.07663f
C1808 r1_b1 i2_b2 0.0467f
C1809 bias_en Xvi/m1_1382_738# 0.06021f
C1810 r2_b0 Xd2/a_2456_3416# 0.00248f
C1811 Xi2/g Xm/in_n 0.2847f
C1812 v0_c1 ib_x2 0.05103f
C1813 Xr/vgln i4_b4 0.46377f
C1814 Xi0/m1_988_3464# Xi0/m1_1500_4312# -0
C1815 vdd vbn_prb 0.72422f
C1816 Xi4/g Xvi/m1_5388_6960# 0.05345f
C1817 Xi2/a_3928_4170# i2_b3 0.00221f
C1818 r2_b3 i2_b2 0.04355f
C1819 ib_r1 Xvi/m1_4894_1238# 0.00544f
C1820 Xi2/g Xg/a_7580_5314# 0.00996f
C1821 vbp_w Xi0/a_3282_4392# 0.02381f
C1822 i4_b3 Xr/vglp 0.31025f
C1823 vdd i0_b3 0.83602f
C1824 ua0_stim_out Xm/iint 0.27534f
C1825 Xi1/g ua0_stim_out 0.08632f
C1826 r0_b4 r2_b4 0.00694f
C1827 i2_b0 i4_b0 0.04372f
C1828 Xr/vglp i4_b0 0
C1829 i4_b4 Xr/vsp 0.7284f
C1830 Xi2/g Xg/m1_4538_1930# 0.04267f
C1831 i0_b1 Xi0/a_732_4392# 0
C1832 r1_b4 i0_b0 0.02494f
C1833 vbn_prb Xd0/m1_617_3840# 0.0254f
C1834 i4_b4 Xg/m1_3530_1930# 0.00272f
C1835 i3_b1 i4_b4 0.04776f
C1836 i4_b2 Xi4/a_1378_4170# -0
C1837 Xi3/a_3282_4392# r1_b4 0.00513f
C1838 Xr/vsn Xi2/a_3078_4170# -0.0092f
C1839 r1_b2 Xi0/g 0.08436f
C1840 ib_x2 vbn_prb 0.1989f
C1841 i1_b2 Xr/vgln 0.17521f
C1842 Xd1/m1_606_2410# Xd1/m1_860_4046# -0.00258f
C1843 Xd1/m1_2974_2650# vth_cmp 0.01042f
C1844 r0_b1 r1_b2 0.07935f
C1845 r0_b4 Xd0/a_3408_3416# 0.03281f
C1846 r0_b3 i3_b0 0
C1847 Xr/vgln i0_b0 0.14097f
C1848 r1_b2 r1_b1 0.15764f
C1849 Xi2/g Xg/m1_3298_2050# 0.0126f
C1850 Xi3/a_3282_4392# Xr/vgln 0.02228f
C1851 v0_c0 Xd3/m1_2720_2760# 0.29891f
C1852 r0_b4 vdd 0.70304f
C1853 i0_b4 vbp_syn 0.35032f
C1854 Xr/vgln vreset_src 0.70458f
C1855 i1_b2 Xr/vsp 0
C1856 vbp_w i0_b1 0.50798f
C1857 r0_b0 Xd0/a_3408_3416# 0.06111f
C1858 Xi0/g vbp_st 0.5092f
C1859 Xr/vglp Xg/m1_5022_10210# 0.0069f
C1860 r2_b1 i2_b1 0
C1861 Xd2/m1_1780_2760# vth_cmp 0.00342f
C1862 Xi2/g Xg/m1_4760_1320# 0.02874f
C1863 i3_b4 i4_b4 0.08042f
C1864 r0_b0 vdd 1.5215f
C1865 i0_b0 Xr/vsp 0.05349f
C1866 i3_b1 i1_b2 0.04243f
C1867 r2_b3 r1_b2 0.04347f
C1868 Xi2/a_1378_4170# vbn_ref 0.03621f
C1869 r2_b4 Xi4/m1_988_3304# 0.00597f
C1870 el vbn_prb 0.33449f
C1871 r0_b1 vbp_st 0.4101f
C1872 i4_b1 i0_b1 0.08146f
C1873 vreset_src Xr/vsp 0.11031f
C1874 r1_b1 vbp_st 0.0348f
C1875 vdd Xm/a_736_7228# -0.00928f
C1876 v0_c2 v0_c1 1.20185f
C1877 Xi1/g Xi1/a_2432_4392# 0
C1878 i0_b4 r0_b3 0.03765f
C1879 r0_b0 Xd0/m1_617_3840# -0
C1880 r1_b0 vth_cmp 0.02585f
C1881 ib_r1 Xr/vglp 0.29033f
C1882 Xm/a_420_700# Xm/a_736_7228# -0.02284f
C1883 r2_b3 vbp_st 0.16006f
C1884 vbp_w Xi0/a_3078_4392# 0.07257f
C1885 Xi1/a_3282_4392# v0_c4 0.00589f
C1886 Xvi/a_864_6450# Xvi/m1_7102_850# -0.00375f
C1887 Xi4/a_732_4170# Xr/vsp 0
C1888 Xr/en_b ua0_s1 0.13638f
C1889 i3_b0 Xi2/m1_260_2080# 0.09689f
C1890 Xi2/a_3928_4170# i2_b4 0.0039f
C1891 i1_b3 Xi1/a_3078_4392# 0
C1892 Xr/m1_3422_438# ib_x2 0.00305f
C1893 Xd0/m1_822_4048# Xr/vsp 0.04717f
C1894 i3_b4 i1_b2 0.09403f
C1895 v0_c0 i0_b4 0
C1896 Xd1/a_1272_3416# r1_b1 0.00117f
C1897 Xvi/m1_8332_7080# vth_ref 0.01619f
C1898 Xg/a_3036_4156# Xm/in_p 0.04477f
C1899 Xd0/m1_2242_4966# Xr/vsp 0.06067f
C1900 Xi3/a_3078_4392# r1_b4 0.0061f
C1901 r2_b1 vbn_ref 0.0309f
C1902 v0_c1 Xi1/m1_988_888# 0.10854f
C1903 i1_b0 i0_b3 0.32048f
C1904 r2_b1 i0_b2 0.03168f
C1905 i0_b3 i2_b2 0.03777f
C1906 r2_b2 i0_b1 0.07842f
C1907 Xd1/m1_2372_2520# vth_cmp 0.00328f
C1908 r0_b0 el 0.25602f
C1909 Xi3/a_3078_4392# Xr/vgln 0.0708f
C1910 Xg/a_4580_5314# i3_b2 0.37602f
C1911 i0_b4 Xi2/m1_260_2080# 0.00149f
C1912 r2_b0 i2_b0 0.00211f
C1913 vdd Xg/m1_3898_9610# 0
C1914 Xm/iint Xvi/m1_7102_850# 0.05861f
C1915 Xr/vgln Xvi/m1_5388_6960# 0.00506f
C1916 Xr/m1_1222_3522# ua0_stim_out 0
C1917 ua0_stim_out Xr/vglp 0.23905f
C1918 v0_c2 Xd3/a_3400_3816# 0.10144f
C1919 ib_x2 Xd3/m1_4982_4448# 0
C1920 i2_b1 i0_b0 0.4807f
C1921 i4_b4 i0_b2 0.04856f
C1922 i4_b4 vbn_ref 0.05127f
C1923 vth_cmp Xi3/g 0.27944f
C1924 Xi2/g Xi3/a_4132_4392# 0.02186f
C1925 r0_b4 i2_b2 0.01777f
C1926 v0_c0 i1_b3 0.24008f
C1927 r1_b0 i2_b3 0.02785f
C1928 i3_b1 Xi3/a_3078_4392# 0
C1929 Xg/m1_4906_9490# Xg/m1_6020_10200# -0.00216f
C1930 Xm/in_n i4_b4 0.42351f
C1931 i0_b1 Xg/m1_6020_10200# 0
C1932 v0_c3 Xi1/m1_988_2804# 0.05752f
C1933 r1_b2 i0_b3 0.02581f
C1934 r1_b0 Xi4/a_3282_4170# 0.06329f
C1935 Xg/a_7580_5314# i4_b4 0
C1936 i1_b2 vbn_ref 0.00749f
C1937 r1_b4 i0_b1 0.0337f
C1938 vbp_st vbn_prb 0.12889f
C1939 i1_b2 i0_b2 0.01645f
C1940 i4_b1 Xvi/a_864_6450# 0.07369f
C1941 Xg/a_4580_5314# i0_b4 0
C1942 i0_b0 i0_b2 1.65185f
C1943 i0_b0 vbn_ref 0.12361f
C1944 Xr/vsn r1_b3 0.12438f
C1945 Xi4/g Xvi/a_864_6450# 0.51898f
C1946 Xd3/m1_1702_4448# vth_ref 0
C1947 Xi0/a_3928_4392# i0_b3 0
C1948 i0_b3 vbp_st 0.07728f
C1949 vdd Xr/m1_3862_3522# 0.00694f
C1950 r2_b4 Xr/vsn 0.34309f
C1951 i0_b3 Xi2/a_732_4170# 0
C1952 i4_b2 Xg/m1_3666_9610# 0
C1953 Xr/vgln i0_b1 0.30864f
C1954 r0_b4 r1_b2 0.36991f
C1955 vdd ua0_s0 0.06012f
C1956 Xi3/m1_1500_4312# Xi3/g 0.09629f
C1957 i4_b2 vth_cmp 0.05015f
C1958 vdd Xi1/m1_240_3480# 0.06977f
C1959 i1_b4 v0_c3 0.06699f
C1960 Xvi/a_5712_1328# ib_r1 0.04566f
C1961 i4_b4 Xg/m1_3298_2050# 0.00534f
C1962 Xi2/m1_1500_3762# Xr/vgln 0
C1963 Xd1/a_1272_3416# vbn_prb 0
C1964 Xi2/g Xg/a_3036_4156# -0
C1965 r0_b0 r1_b2 0.84878f
C1966 Xr/vsn vdd 0.43565f
C1967 Xg/m1_4906_9490# Xr/vsp 0
C1968 i0_b1 Xr/vsp 0.05901f
C1969 i4_b1 Xi1/g 0.14098f
C1970 Xm/a_420_700# ua0_s0 0.01355f
C1971 Xd0/a_2816_3416# Xr/vsp 0
C1972 r0_b4 vbp_st 0.03202f
C1973 r0_b4 Xi2/a_732_4170# 0
C1974 r2_b4 vbp_syn 0.01604f
C1975 Xi2/g Xi3/a_3928_4392# 0.02385f
C1976 i2_b0 vbn_ax 0.03142f
C1977 i4_b3 Xg/a_1580_5314# 0.20245f
C1978 ib_x2 ua0_s0 0.13625f
C1979 r1_b0 i2_b4 0.02843f
C1980 i3_b4 Xi1/a_3928_4392# 0
C1981 r2_b2 Xvi/a_864_6450# 0.00313f
C1982 Xi0/m1_988_3464# Xi0/a_1378_4392# -0.00284f
C1983 Xg/a_1580_5314# i4_b0 0.12152f
C1984 r0_b0 vbp_st 0.20495f
C1985 ua0 ua0_int 0.00954f
C1986 r0_b1 Xi0/g 0.17051f
C1987 r1_b0 Xi4/a_3078_4170# 0.05528f
C1988 Xr/vsn ib_x2 0.10208f
C1989 Xi2/g Xi2/m1_988_888# -0.15738f
C1990 r1_b1 Xi0/g 0.04046f
C1991 Xr/vglp Xvi/m1_7102_850# 0.04952f
C1992 vdd vbp_syn 0.61403f
C1993 vdd Xi1/a_3078_4392# 0.10075f
C1994 r2_b4 r0_b3 0.00454f
C1995 Xr/m1_782_438# ib_x2 0.00364f
C1996 i4_b3 i3_b2 0.08966f
C1997 i3_b2 i4_b0 0.04034f
C1998 Xr/m1_342_438# vreset_src 0
C1999 Xi2/g Xi2/m1_988_2644# -0.21519f
C2000 i4_b2 i2_b3 0.11165f
C2001 r2_b3 Xi0/g 0.21446f
C2002 Xi0/g Xd0/m1_3310_2880# 0.00906f
C2003 v0_c3 Xd3/m1_5422_4448# 0.0265f
C2004 i1_b4 i3_b2 0
C2005 Xd0/a_2224_3416# Xd0/m1_2242_4966# -0
C2006 r2_b2 Xi1/g 0
C2007 i4_b3 i3_b0 0.10024f
C2008 r2_b3 r1_b1 0.03752f
C2009 Xr/vsn el 0.03422f
C2010 r0_b1 Xd0/m1_3310_2880# 0
C2011 vdd r0_b3 0.37168f
C2012 i3_b0 i4_b0 0.04196f
C2013 i4_b2 Xi4/a_3282_4170# 0
C2014 Xr/en_b Xr/vgln 0.00267f
C2015 i2_b1 i0_b1 0
C2016 Xm/in_p Xi3/g 0.20329f
C2017 v0_c4 Xi1/a_4132_4392# 0.01929f
C2018 vdd Xm/a_1744_9182# -0.00844f
C2019 Xr/en_b Xm/a_2240_11218# -0.04575f
C2020 r2_b4 Xi2/m1_260_2080# 0.1227f
C2021 v0_c0 vdd 0.93528f
C2022 i3_b3 Xm/in_p 0.0394f
C2023 Xi1/g Xg/m1_6020_10200# 0
C2024 v0_c2 ua0_s0 0.36812f
C2025 i4_b3 i0_b4 0.0556f
C2026 Xd2/m1_2964_2640# vth_cmp 0.00883f
C2027 Xvi/m1_8042_6360# vth_cmp -0
C2028 Xi0/m1_988_2804# vth_cmp 0
C2029 Xr/en_b Xr/vsp 0.46589f
C2030 Xr/vgln Xvi/a_864_6450# 0.5972f
C2031 el vbp_syn 0
C2032 i0_b4 i4_b0 0.03198f
C2033 Xr/m1_3422_438# vth_ref 0.02522f
C2034 Xr/vgln Xi2/m1_988_3304# 0
C2035 Xr/vsn i1_b0 0
C2036 v0_c1 Xd3/a_2216_3816# 0.13585f
C2037 Xi4/a_2432_4170# vreset_src 0.00581f
C2038 i1_b4 i0_b4 0.12647f
C2039 Xvi/a_864_6450# Xr/vsp 0.00657f
C2040 i4_b3 Xvi/m1_1276_6360# 0.01608f
C2041 vdd Xi2/m1_260_2080# -0.0022f
C2042 v0_c0 ib_x2 0.05484f
C2043 i4_b1 i2_b0 0
C2044 i0_b1 vbn_ref 0.16552f
C2045 Xg/m1_4906_9490# vbn_ref 0
C2046 i4_b1 Xr/vglp 0.0367f
C2047 Xi4/g Xr/vglp 0.38348f
C2048 Xi2/g r1_b0 0.05893f
C2049 i0_b1 i0_b2 0.07332f
C2050 Xi2/a_4132_4170# i2_b3 0.00129f
C2051 Xi1/m1_988_888# Xi1/m1_240_3480# -0.00124f
C2052 Xi0/a_4132_4392# vbp_syn 0.06234f
C2053 Xi1/g Xr/vgln 0.21354f
C2054 Xr/vgln Xm/iint 0.54103f
C2055 Xi2/m1_1500_3762# vbn_ref 0
C2056 ua0_stim_out Xg/a_1580_5314# 0.14721f
C2057 vbp_syn i2_b2 -0.01189f
C2058 i4_b2 i2_b4 0.03822f
C2059 i1_b1 Xg/m1_6020_10200# 0.00192f
C2060 i4_b2 Xm/in_p 0.11791f
C2061 v0_c3 Xd3/m1_3908_2760# 0.00446f
C2062 i0_b4 Xg/m1_5022_10210# 0.00533f
C2063 r1_b0 Xd1/a_680_3416# 0.00588f
C2064 Xi0/g vbn_prb 0.67866f
C2065 i4_b2 Xi4/a_3078_4170# 0
C2066 ua0_stim_out Xi0/m1_988_888# 0.02723f
C2067 Xi0/m1_988_888# Xi0/m1_240_3480# -0.01389f
C2068 Xi1/m1_240_3480# Xi1/m1_988_3464# -0
C2069 i0_b4 Xi2/a_2228_4170# 0.0501f
C2070 bias_en Xm/in_p 0.11081f
C2071 Xi0/g i0_b3 0.04594f
C2072 Xi1/g Xr/vsp 0.79995f
C2073 Xm/iint Xr/vsp 0.17447f
C2074 Xg/a_3036_4156# i4_b4 0.30798f
C2075 v0_c3 Xi1/a_2432_4392# 0
C2076 r0_b1 i0_b3 0.26024f
C2077 ua0_stim_out i3_b2 0.11203f
C2078 i3_b1 Xi1/g 0.07344f
C2079 i1_b3 i1_b4 0.13567f
C2080 v0_c4 Xi1/a_3928_4392# 0.00359f
C2081 ua0_s0 vbp_st 0.0342f
C2082 r1_b1 i0_b3 0.02578f
C2083 r0_b3 i2_b2 0.00135f
C2084 r1_b0 Xi4/m1_988_2644# 0
C2085 Xd3/a_1624_3816# ua0_s1 0.09971f
C2086 Xg/a_4580_5314# vdd -0.05188f
C2087 r2_b3 vbn_prb 0.17053f
C2088 r2_b0 i3_b0 0
C2089 r2_b2 i2_b0 0.12262f
C2090 Xd0/m1_3310_2880# vbn_prb 0.01034f
C2091 Xr/vsn vbp_st 2.02432f
C2092 ua0_stim_out i3_b0 0.21615f
C2093 r2_b3 i0_b3 0.01872f
C2094 i1_b1 Xr/vgln 0.03329f
C2095 Xi4/a_4132_4170# r1_b3 0
C2096 r0_b4 Xi0/g 0.21804f
C2097 Xi4/a_2228_4170# vreset_src 0.00314f
C2098 Xi3/m1_988_2804# vbn_ax -0
C2099 Xi2/g Xi3/g 0.69329f
C2100 r1_b2 vbp_syn 0.11022f
C2101 r0_b4 r0_b1 0.04444f
C2102 Xr/en_b Xd3/m1_382_4448# 0.00397f
C2103 v0_c2 v0_c0 0.00292f
C2104 i3_b4 Xi1/g 0.13143f
C2105 Xd0/m1_956_3000# Xd0/m1_617_3840# -0
C2106 Xi2/g i3_b3 0.08422f
C2107 i1_b1 Xr/vsp 0.00518f
C2108 r0_b0 Xi0/g 0.06723f
C2109 i3_b1 i1_b1 0.16106f
C2110 r2_b0 i0_b4 0.03654f
C2111 ib_r1 Xvi/a_2102_5152# 0.00454f
C2112 r0_b1 r0_b0 0.50694f
C2113 Xr/vglp Xg/m1_6020_10200# 0.07515f
C2114 Xi0/a_3928_4392# vbp_syn 0.01958f
C2115 vbp_st vbp_syn 0.62654f
C2116 Xi2/a_4132_4170# i2_b4 0
C2117 r2_b1 r0_b2 0.00723f
C2118 vdd Xd3/m1_1262_4448# 0
C2119 ua0_stim_out i0_b4 0
C2120 vbp_syn Xi2/a_732_4170# 0.0273f
C2121 r0_b4 Xd0/m1_3310_2880# 0
C2122 Xd3/m1_3222_4448# ua0_s1 0.11915f
C2123 r1_b2 r0_b3 0.34466f
C2124 v0_c0 Xi1/m1_988_888# 0.51316f
C2125 r2_b4 Xi4/a_528_4170# 0.01643f
C2126 Xr/en_b Xm/in_n 0.02906f
C2127 v0_c3 ua0_s1 0.05179f
C2128 Xi2/a_3078_4170# ua0_stim_out 0.02803f
C2129 r1_b4 i2_b0 0.13454f
C2130 r0_b0 Xd0/m1_3310_2880# 0
C2131 vth_ref ua0_s0 0.69501f
C2132 el Xd0/m1_956_3000# 0.11374f
C2133 Xr/en_b ua0_int 0.02049f
C2134 Xd2/a_1272_3416# vbn_prb 0.01159f
C2135 i3_b4 i1_b1 0.11216f
C2136 Xi3/m1_988_2804# Xi3/m1_988_3464# -0.00259f
C2137 i4_b2 Xi2/g 0.05561f
C2138 r0_b3 vbp_st 0.07202f
C2139 r0_b3 Xi2/a_732_4170# 0
C2140 Xd1/m1_606_2410# Xd2/a_3048_3416# 0
C2141 Xr/vsn vth_ref 0.10342f
C2142 Xd3/m1_1262_4448# ib_x2 0
C2143 v0_c0 Xi1/m1_988_3464# 0
C2144 Xd1/m1_756_3120# vreset_src 0.07662f
C2145 i3_b2 vbn_ax 0
C2146 Xr/m1_1222_3522# Xr/vgln 0.00235f
C2147 Xr/vgln Xr/vglp 0.88848f
C2148 v0_c1 Xd3/a_3400_3816# 0.03963f
C2149 Xr/vgln i2_b0 0.00219f
C2150 r2_b1 r1_b0 0.03501f
C2151 Xr/m1_782_438# vth_ref 0.04539f
C2152 Xm/iint Xd3/m1_382_4448# 0
C2153 Xi4/a_528_4170# vdd 0.01157f
C2154 r1_b0 Xd2/a_3048_3416# 0.01728f
C2155 Xi4/a_3928_4170# r1_b3 0
C2156 i4_b3 r1_b3 0.28777f
C2157 i1_b0 Xg/a_4580_5314# 0
C2158 Xg/m1_3898_9610# Xi0/g 0.01458f
C2159 Xr/vglp Xr/vsp 0.67254f
C2160 vdd Xi1/m1_988_2804# 0.17838f
C2161 r2_b4 i4_b0 0.22091f
C2162 r1_b3 i4_b0 1.84331f
C2163 i3_b0 vbn_ax 0.08423f
C2164 Xi1/g vbn_ref 0.05701f
C2165 i2_b3 Xg/m1_3666_9610# 0
C2166 i3_b1 Xr/vglp 0.29701f
C2167 vdd Xi1/m1_1500_4312# 0.09138f
C2168 Xi1/g i0_b2 0
C2169 vdd Xi1/a_1582_4392# 0
C2170 vbp_w Xi3/m1_988_2804# 0.13247f
C2171 Xi4/m1_1500_3762# vreset_src 0
C2172 r1_b0 i4_b4 0.08557f
C2173 i4_b3 Xvi/a_4976_1528# 0.03179f
C2174 i0_b3 Xi2/a_1582_4170# 0.00546f
C2175 i0_b0 r0_b2 0.03296f
C2176 Xvi/a_4976_1528# i4_b0 0
C2177 Xm/in_n Xm/iint 0.10447f
C2178 vbp_st Xi2/m1_260_2080# 0.05133f
C2179 i0_b4 vbn_leak 0.00126f
C2180 i4_b3 vdd 1.41701f
C2181 Xd1/m1_2974_2650# vreset_src 0.00113f
C2182 Xd3/m1_2720_2760# ua0_s1 0.10151f
C2183 vdd i4_b0 0.83577f
C2184 Xi1/g Xg/a_7580_5314# -0
C2185 i0_b4 vbn_ax 0.05381f
C2186 r1_b4 Xd0/a_1040_3416# 0
C2187 i3_b4 Xr/vglp 0.2091f
C2188 r2_b1 Xi3/g 0
C2189 r0_b4 i0_b3 0.15492f
C2190 i1_b4 vdd -0.01437f
C2191 i1_b1 vbn_ref 0.06966f
C2192 i1_b1 i0_b2 0.05159f
C2193 Xg/a_5188_4156# Xr/vglp 0.00215f
C2194 v0_c1 Xd3/m1_4982_4448# 0.16607f
C2195 r1_b0 i0_b0 0.02526f
C2196 r0_b0 i0_b3 0.02584f
C2197 Xd1/m1_606_2410# vreset_src 0.03302f
C2198 Xi1/g v0_c4 0.37671f
C2199 v0_c0 vth_ref 0.06639f
C2200 Xm/iint Xr/m1_342_438# 0
C2201 vbp_w Xi0/m1_988_888# 0.27596f
C2202 r1_b0 vreset_src 0.45672f
C2203 Xr/m1_1662_438# ib_x2 0.00364f
C2204 i4_b1 Xg/a_1580_5314# 0.28967f
C2205 Xd0/a_1040_3416# Xr/vsp 0.00229f
C2206 Xg/a_4580_5314# vbp_st 0.18945f
C2207 Xi2/a_3928_4170# i0_b1 0.07576f
C2208 i2_b1 i2_b0 0.01882f
C2209 i2_b1 Xr/vglp 0.0066f
C2210 i3_b0 Xi3/a_732_4392# 0.00499f
C2211 vbp_w i3_b2 0
C2212 i4_b4 Xi3/g 0.15343f
C2213 vdd Xi2/a_2228_4170# 0.00138f
C2214 ua0_stim ua0 0.34907f
C2215 vbn_prb Xi4/m1_988_3304# 0.00556f
C2216 Xr/vsn Xi0/g 0.3178f
C2217 i4_b3 el 0.03655f
C2218 i4_b4 i3_b3 0.04035f
C2219 ib_r1 Xvi/a_4976_1528# 0.01284f
C2220 r0_b4 r0_b0 0.17049f
C2221 el i4_b0 0.07173f
C2222 Xd1/a_680_3416# Xd2/m1_2964_2640# 0
C2223 r1_b0 Xi4/a_732_4170# 0.02492f
C2224 i4_b1 i3_b2 0.05852f
C2225 Xi1/g v0_c5 0
C2226 Xr/vsn r1_b1 1.18266f
C2227 vdd ib_r1 0.47434f
C2228 Xi3/m1_988_2804# Xi3/m1_988_888# -0
C2229 vbp_w i3_b0 0.22607f
C2230 Xi4/g i3_b2 0.28381f
C2231 Xvi/a_5712_1328# Xr/vgln 0.03354f
C2232 Xd1/m1_2372_2520# vreset_src 0.00913f
C2233 r2_b0 r1_b3 0.03072f
C2234 r2_b0 r2_b4 0.09475f
C2235 r2_b3 Xr/vsn 0.35474f
C2236 i4_b1 i3_b0 0.18868f
C2237 i1_b2 Xi3/g 0.41164f
C2238 r1_b3 ua0_stim_out 0.09371f
C2239 Xvi/m1_502_738# vbn_prb 0.06214f
C2240 r2_b4 ua0_stim_out 0.16955f
C2241 Xi0/g vbp_syn 0.10258f
C2242 Xi2/m1_988_888# i0_b1 0.01f
C2243 Xr/vglp vbn_ref 0.09772f
C2244 i2_b0 vbn_ref 0.0365f
C2245 i4_b3 i2_b2 0.02673f
C2246 i2_b0 i0_b2 0.45495f
C2247 Xr/vglp i0_b2 0.01969f
C2248 i1_b2 i3_b3 0.05976f
C2249 Xi4/m1_988_888# vbn_prb 0.09045f
C2250 Xd3/m1_1702_4448# ua0_s0 0.0019f
C2251 r0_b1 vbp_syn 0.24577f
C2252 Xg/m1_3898_9610# i0_b3 0.02479f
C2253 i2_b2 i4_b0 0.08678f
C2254 ib_r1 ib_x2 0.06115f
C2255 i0_b1 Xi2/m1_988_2644# 0.02465f
C2256 vdd Xi1/a_2228_4392# 0.00248f
C2257 r2_b4 Xi3/m1_240_3480# 0.15141f
C2258 Xi3/a_3282_4392# i3_b3 -0
C2259 i4_b2 i4_b4 0.00675f
C2260 vbp_w i0_b4 0
C2261 Xm/in_n Xr/vglp 0.04477f
C2262 r2_b0 vdd 0.23f
C2263 ib_x2 Xd3/m1_5422_4448# 0
C2264 Xi1/m1_988_888# Xi1/m1_988_2804# -0.06084f
C2265 r1_b4 Xi3/m1_988_2804# 0.11952f
C2266 Xi2/m1_1500_3762# Xi2/m1_988_2644# -0
C2267 i1_b0 i1_b4 0
C2268 vdd Xi0/m1_240_3480# -0.0806f
C2269 ua0_stim_out vdd 2.37211f
C2270 Xi0/g r0_b3 0.04758f
C2271 r2_b2 i3_b2 0.0416f
C2272 i4_b1 i0_b4 0.06696f
C2273 v0_c2 i1_b4 0
C2274 v0_c1 ua0_s0 0.18498f
C2275 r0_b1 r0_b3 0.57905f
C2276 i3_b0 Xi3/a_528_4392# 0.01006f
C2277 Xr/vgln v0_c3 0
C2278 v0_c1 Xi1/m1_240_3480# 0.00692f
C2279 vdd Xi3/m1_240_3480# -0.0616f
C2280 Xr/vgln Xi3/m1_988_2804# 0.04779f
C2281 Xi2/g Xi3/a_2432_4392# 0.03941f
C2282 Xi1/m1_988_3464# Xi1/m1_988_2804# -0.02059f
C2283 i2_b3 i2_b4 0.31023f
C2284 i2_b3 Xm/in_p 0.09766f
C2285 r2_b2 i3_b0 0.12136f
C2286 ua0_stim_out Xm/a_1744_10100# 0
C2287 ua0_stim_out Xm/a_420_700# 0.00417f
C2288 v0_c0 Xd3/a_2216_3816# 0.03706f
C2289 Xi1/m1_988_3464# Xi1/m1_1500_4312# -0
C2290 Xi4/a_1582_4170# vreset_src 0.00469f
C2291 i4_b1 Xvi/m1_1276_6360# 0.00435f
C2292 ua0_stim_out ib_x2 0.03713f
C2293 v0_c3 Xr/vsp 0.10361f
C2294 i4_b2 i0_b0 0.03153f
C2295 i0_b1 r0_b2 0.0439f
C2296 r2_b3 r0_b3 0.0132f
C2297 Xi4/g Xvi/m1_1276_6360# 0.03982f
C2298 Xi3/m1_988_2804# Xr/vsp -0.02082f
C2299 Xd0/a_2816_3416# r0_b2 0.00313f
C2300 Xr/m1_342_438# Xr/vglp 0
C2301 Xd0/m1_382_4048# el 0.0036f
C2302 Xi4/g Xvi/a_2102_5152# 0.01013f
C2303 i4_b2 vreset_src 0.0285f
C2304 Xd3/m1_1262_4448# vth_ref 0
C2305 vdd Xd3/m1_3908_2760# -0
C2306 v0_c3 Xd3/a_4584_3816# 0.04456f
C2307 i4_b3 vbp_st 0.04216f
C2308 Xi0/g Xi2/m1_260_2080# 0.08804f
C2309 r2_b2 i0_b4 0.03978f
C2310 r2_b0 el 0.04213f
C2311 Xvi/m1_1382_738# vreset_src 0
C2312 bias_en vreset_src 0.28089f
C2313 vbp_st i4_b0 0.12206f
C2314 Xr/vsn vbn_prb 0.21479f
C2315 r1_b4 i3_b2 0.0828f
C2316 vdd Xi1/a_2432_4392# 0.02293f
C2317 Xd2/m1_2964_2640# Xd2/a_3048_3416# -0.00106f
C2318 r2_b4 vbn_ax 0.46974f
C2319 Xi0/m1_240_3480# el 0.07365f
C2320 ua0_stim_out el 0.33618f
C2321 Xr/vgln Xi1/a_732_4392# 0.00507f
C2322 i3_b4 v0_c3 0
C2323 Xi3/a_3078_4392# i3_b3 -0.0033f
C2324 v0_c2 Xd3/m1_5422_4448# 0.00117f
C2325 r1_b0 i0_b1 0.03363f
C2326 Xi2/a_3078_4170# r2_b2 0
C2327 Xg/a_1580_5314# Xr/vsp -0.06489f
C2328 r1_b4 i3_b0 0.07153f
C2329 r2_b2 Xvi/m1_1276_6360# 0
C2330 el Xi3/m1_240_3480# 0.00833f
C2331 Xr/vgln i3_b2 0.34776f
C2332 vdd vbn_leak 0.09421f
C2333 bias_en ua0 0.06485f
C2334 Xi0/m1_988_888# Xr/vsp 0.01717f
C2335 i3_b1 Xg/a_1580_5314# 0.08981f
C2336 v0_c0 Xd3/m1_1702_4448# 0.0127f
C2337 r2_b3 Xi2/m1_260_2080# 0.20958f
C2338 Xi1/a_732_4392# Xr/vsp 0.07502f
C2339 r2_b4 Xi4/m1_260_2080# 0.13543f
C2340 Xi2/g Xi3/a_2228_4392# 0.10625f
C2341 Xi1/g Xg/a_3036_4156# -0.02139f
C2342 i0_b4 Xg/m1_6020_10200# 0.00961f
C2343 r2_b0 i2_b2 0
C2344 vdd vbn_ax 0.90266f
C2345 vbn_prb vbp_syn 0.26045f
C2346 Xr/vgln i3_b0 0.0575f
C2347 ua0_stim_out Xi0/a_4132_4392# 0.0087f
C2348 i3_b2 Xr/vsp 0.08011f
C2349 Xi2/m1_988_2644# Xi2/m1_988_3304# -0.00253f
C2350 i2_b4 Xm/in_p 0.13181f
C2351 Xd2/a_1864_3416# vdd 0
C2352 Xi4/a_1378_4170# vreset_src 0
C2353 i3_b1 i3_b2 0.60242f
C2354 i0_b3 vbp_syn 0.2459f
C2355 Xg/a_4580_5314# Xi0/g -0.01498f
C2356 vbp_syn Xi2/a_1582_4170# 0.00307f
C2357 Xi2/a_4132_4170# i0_b0 0
C2358 ua0_s0 Xm/a_736_7228# -0.00177f
C2359 Xi4/m1_260_2080# vdd 0.03136f
C2360 v0_c1 v0_c0 0.18358f
C2361 r1_b4 i0_b4 0.03276f
C2362 i3_b4 Xg/a_1580_5314# 0.13318f
C2363 i3_b0 Xr/vsp 0.10496f
C2364 r0_b1 Xd0/m1_956_3000# 0
C2365 r2_b4 Xi3/m1_988_3464# 0.00192f
C2366 i3_b1 i3_b0 0.02024f
C2367 r2_b1 Xi2/a_528_4170# 0
C2368 r0_b3 i0_b3 0.03068f
C2369 Xr/vgln i0_b4 0.17169f
C2370 i3_b2 Xg/m1_5516_1920# 0
C2371 vdd ua0_s1 1.18492f
C2372 i3_b4 i3_b2 0.13576f
C2373 Xr/m1_1662_438# vth_ref 0.02726f
C2374 Xd3/m1_4078_3250# v0_c3 0.00682f
C2375 r0_b4 vbp_syn 0.05045f
C2376 Xi1/a_2228_4392# Xi1/m1_988_3464# -0
C2377 vbn_leak el 0.09409f
C2378 ib_x2 Xvi/m1_7102_850# 0
C2379 r2_b0 r1_b2 1.49256f
C2380 Xvi/m1_8042_6360# vreset_src 0.2216f
C2381 vdd Xi3/m1_988_3464# 0.04178f
C2382 Xg/a_5188_4156# i3_b2 0.10282f
C2383 Xd3/m1_4982_4448# ua0_s0 0.01804f
C2384 Xi2/a_3078_4170# Xr/vgln -0.01227f
C2385 r1_b2 ua0_stim_out 0.03877f
C2386 Xd1/a_3048_3416# Xd0/a_1040_3416# 0.03142f
C2387 Xr/en_b ua0_stim 0.53384f
C2388 i0_b4 Xr/vsp 0.16694f
C2389 v0_c3 vbn_ref 0.01713f
C2390 Xr/vgln Xvi/m1_1276_6360# 0.22288f
C2391 r0_b0 vbp_syn 0.32068f
C2392 v0_c2 Xd3/m1_3908_2760# 0.04151f
C2393 Xm/a_420_700# ua0_s1 0.16451f
C2394 ua0_s1 Xm/a_1744_10100# 0
C2395 i3_b4 i3_b0 0.03918f
C2396 vdd Xi0/a_732_4392# 0
C2397 el vbn_ax 0.03904f
C2398 r1_b3 vbp_w 0.06871f
C2399 r2_b4 vbp_w 0.18382f
C2400 i3_b1 i0_b4 0.03094f
C2401 Xi2/a_3282_4170# i2_b1 0
C2402 Xi4/a_4132_4170# r1_b1 0.00117f
C2403 bias_en Xd3/m1_822_4448# 0.05142f
C2404 Xr/vgln Xvi/a_2102_5152# 0.16035f
C2405 Xd0/a_1632_3416# vth_cmp 0.00119f
C2406 r0_b4 r0_b3 0.1937f
C2407 vdd Xi3/a_732_4392# 0.01908f
C2408 v0_c3 ua0_int 0.06478f
C2409 r2_b0 vbp_st 0.03745f
C2410 r2_b0 Xi2/a_732_4170# 0
C2411 Xvi/m1_1276_6360# Xr/vsp 0.01759f
C2412 i4_b1 r1_b3 0.42506f
C2413 ua0_stim_out Xi0/a_3928_4392# 0.00552f
C2414 ua0_stim_out vbp_st 1.33911f
C2415 i1_b3 Xr/vgln 0.06466f
C2416 i4_b1 r2_b4 0.00131f
C2417 r2_b4 Xi4/g 0.06323f
C2418 r1_b0 Xvi/a_864_6450# 0
C2419 r0_b0 r0_b3 0.05478f
C2420 i4_b2 i0_b1 0.04379f
C2421 r2_b1 vth_cmp 0.03517f
C2422 vbp_w vdd 1.59336f
C2423 i2_b1 i3_b0 0.00139f
C2424 Xd1/m1_462_4048# vbn_prb 0.10275f
C2425 Xd0/m1_2742_3250# vth_cmp 0
C2426 Xg/a_1580_5314# vbn_ref 0
C2427 i3_b4 i0_b4 0.01708f
C2428 Xr/vsn Xi4/m1_988_888# 0.0291f
C2429 i4_b1 Xvi/a_4976_1528# 0.16335f
C2430 Xi4/g Xvi/a_4976_1528# 0.09172f
C2431 ib_r1 vth_ref 0.18101f
C2432 Xr/vgln Xi2/a_2432_4170# 0
C2433 Xi1/a_732_4392# vbn_ref 0
C2434 Xg/a_5188_4156# i0_b4 0.05013f
C2435 i4_b1 vdd 1.84441f
C2436 Xi4/a_528_4170# r1_b1 0
C2437 Xi4/g vdd 0.89821f
C2438 Xi2/a_3282_4170# vbn_ref 0.0273f
C2439 Xg/a_3036_4156# Xr/vglp 0
C2440 v0_c3 v0_c4 1.72119f
C2441 Xm/in_n Xg/a_1580_5314# 0
C2442 Xi2/g Xm/in_p 0.01281f
C2443 r0_b4 Xi2/m1_260_2080# 0.00173f
C2444 i4_b4 Xg/m1_3666_9610# 0.00153f
C2445 i3_b2 i0_b2 0
C2446 i3_b2 Xg/m1_6282_1450# 0
C2447 i3_b2 vbn_ref 0.0869f
C2448 i4_b4 vth_cmp 0.03475f
C2449 Xi3/a_2432_4392# Xi3/a_3282_4392# -0
C2450 Xi0/a_732_4392# el 0.00181f
C2451 r2_b3 Xi4/a_528_4170# 0
C2452 Xd1/a_1864_3416# vreset_src 0.01599f
C2453 Xr/en_b Xm/a_1764_11418# 0
C2454 i2_b1 i0_b4 0.01426f
C2455 r2_b4 r2_b2 0.02841f
C2456 r1_b3 r2_b2 0.42174f
C2457 vbn_prb Xd0/m1_956_3000# 0
C2458 i4_b3 Xi0/g 0.06954f
C2459 i3_b0 i0_b2 0.35819f
C2460 vbn_ref i3_b0 0.03298f
C2461 vdd Xi0/a_528_4392# 0
C2462 i3_b4 i1_b3 0.20214f
C2463 Xi4/a_3928_4170# r1_b1 0.00209f
C2464 Xi4/g ib_x2 0.02766f
C2465 Xi0/g i4_b0 0.07882f
C2466 Xi2/a_3078_4170# i2_b1 0
C2467 i4_b3 r1_b1 0.08559f
C2468 r1_b3 Xi3/m1_988_888# 0.00124f
C2469 v0_c2 ua0_s1 0.2939f
C2470 v0_c5 v0_c3 0.01039f
C2471 r1_b2 vbn_ax 0.11715f
C2472 ua0_stim_out vth_ref 0.03656f
C2473 Xd1/m1_860_4046# vreset_src 0.21729f
C2474 vdd Xi3/a_528_4392# 0.0212f
C2475 Xg/a_7580_5314# i3_b2 0.04164f
C2476 r1_b1 i4_b0 0.54057f
C2477 r2_b2 Xvi/a_4976_1528# 0
C2478 vbp_w el 0.2729f
C2479 Xd3/a_2808_3816# Xd3/m1_3222_4448# -0.00114f
C2480 Xi0/a_3928_4392# vbn_leak 0
C2481 vbn_leak vbp_st 0.03894f
C2482 Xd0/m1_3662_4048# Xr/vsp 0.05436f
C2483 r2_b2 vdd 0.76138f
C2484 i3_b2 Xg/m1_4538_1930# 0
C2485 Xd3/a_2808_3816# v0_c3 -0.00388f
C2486 i0_b0 vth_cmp 0.00441f
C2487 Xi2/a_4132_4170# i0_b1 0.02183f
C2488 i4_b1 el 0.04231f
C2489 r2_b3 i4_b0 0.00218f
C2490 Xi2/g Xi3/a_1582_4392# 0.00889f
C2491 vbn_ax Xi2/a_732_4170# 0.0018f
C2492 vbp_st vbn_ax 0.12301f
C2493 Xi4/a_4132_4170# vbn_prb 0
C2494 Xi4/g el 0.18087f
C2495 i0_b4 vbn_ref 1.44606f
C2496 vreset_src vth_cmp 0.21339f
C2497 vdd Xi3/m1_988_888# 0.05051f
C2498 i0_b4 i0_b2 0.00294f
C2499 ib_r1 Xvi/m1_8332_7080# 0.20707f
C2500 Xi0/g Xg/m1_5022_10210# 0.04771f
C2501 Xi1/g Xi3/g 0.07766f
C2502 i3_b2 Xg/m1_3298_2050# 0
C2503 i2_b3 i4_b4 0.0759f
C2504 r1_b4 r1_b3 0.24315f
C2505 Xm/iint Xm/a_1764_11418# 0
C2506 vbp_w Xi0/a_4132_4392# 0.07384f
C2507 Xi2/a_3078_4170# i0_b2 0
C2508 Xi2/a_3078_4170# vbn_ref 0.0414f
C2509 r2_b4 r1_b4 0.23032f
C2510 i0_b1 Xi0/m1_988_2804# 0
C2511 vdd Xg/m1_6020_10200# 0.0027f
C2512 Xi1/g i3_b3 0.11014f
C2513 bias_en Xr/en_b 0.04516f
C2514 i2_b1 Xi2/a_2432_4170# 0
C2515 Xi3/a_2228_4392# Xi3/a_3282_4392# -0
C2516 i3_b2 Xg/m1_4760_1320# 0
C2517 Xi0/a_528_4392# el 0
C2518 Xd0/m1_822_4048# vth_cmp 0.00544f
C2519 i4_b1 i2_b2 0.07819f
C2520 r1_b3 Xr/vgln 0.17023f
C2521 Xg/a_7580_5314# i0_b4 0.004f
C2522 r2_b4 Xr/vgln 0.12861f
C2523 Xvi/m1_8646_1098# Xm/iint 0.01122f
C2524 bias_en Xvi/a_864_6450# 0.09439f
C2525 Xd0/m1_2242_4966# vth_cmp 0
C2526 ua0_s1 vbp_st 0.0024f
C2527 Xd2/a_680_3416# vbn_prb 0.00237f
C2528 r1_b4 vdd 0.81825f
C2529 Xi4/a_528_4170# vbn_prb 0
C2530 r2_b2 el 0.02879f
C2531 r1_b3 Xr/vsp 0.56013f
C2532 Xr/vgln Xvi/a_4976_1528# 0.05896f
C2533 Xd0/m1_1262_4048# Xr/vsp 0.1194f
C2534 r2_b4 Xr/vsp 0.13406f
C2535 Xi0/a_2432_4392# i0_b0 0
C2536 i1_b1 Xi3/g 0.11394f
C2537 i2_b3 i0_b0 0.05785f
C2538 i3_b1 r1_b3 0.04919f
C2539 Xd3/a_2808_3816# Xd3/m1_2720_2760# -0.00288f
C2540 Xr/vgln vdd 4.23326f
C2541 el Xi3/m1_988_888# 0.41473f
C2542 Xr/vsn r0_b3 0
C2543 i4_b2 Xi1/g 0.07283f
C2544 i1_b1 i3_b3 0.0367f
C2545 r1_b0 i2_b0 0.04574f
C2546 vdd Xm/a_2240_11218# -0.11713f
C2547 vbp_w r1_b2 0.14159f
C2548 vbn_ref Xi2/a_2432_4170# 0.04494f
C2549 i0_b2 Xi2/a_2432_4170# 0
C2550 v0_c1 i1_b4 0.00414f
C2551 Xvi/a_4976_1528# Xr/vsp 0.00895f
C2552 v0_c0 ua0_s0 0.07572f
C2553 v0_c0 Xi1/m1_240_3480# 0.14156f
C2554 r2_b0 Xi0/g 0.06219f
C2555 Xd0/a_3408_3416# Xr/vsp 0.00421f
C2556 Xi2/g Xi3/a_1378_4392# 0
C2557 vdd Xi1/a_528_4392# 0
C2558 Xi4/a_3928_4170# vbn_prb 0
C2559 Xi4/g Xvi/m1_4546_7560# 0.27007f
C2560 bias_en Xm/iint 1.27428f
C2561 i0_b1 Xi2/a_528_4170# 0.02371f
C2562 vdd Xr/vsp 2.23127f
C2563 Xvi/m1_5388_6960# vth_cmp 0.00362f
C2564 Xi0/g Xi0/m1_240_3480# 0.01724f
C2565 ua0_stim_out Xi0/g 0.61444f
C2566 r2_b2 i2_b2 0.044f
C2567 Xi4/a_3282_4170# vreset_src 0.00389f
C2568 r2_b0 r0_b1 0.40076f
C2569 r0_b1 ua0_stim_out 0.039f
C2570 r2_b0 r1_b1 0.03141f
C2571 Xi0/a_1378_4392# Xi0/m1_1500_4312# -0
C2572 i4_b3 i0_b3 0.02948f
C2573 i3_b1 vdd 0.88816f
C2574 i3_b4 r1_b3 0.03945f
C2575 ua0_stim_out r1_b1 0.04081f
C2576 Xd1/a_2456_3416# r1_b4 0.00306f
C2577 Xr/vgln ib_x2 0.47635f
C2578 vbp_w vbp_st 0.00387f
C2579 vbp_w Xi0/a_3928_4392# 0.04854f
C2580 i0_b3 i4_b0 0.02448f
C2581 i4_b4 i2_b4 0.24271f
C2582 i4_b4 Xm/in_p 0.37614f
C2583 Xd0/m1_617_3840# Xr/vsp 0.11054f
C2584 r0_b3 vbp_syn 0.16553f
C2585 r2_b0 r2_b3 0.12993f
C2586 vdd Xd3/a_4584_3816# -0.00141f
C2587 i1_b3 v0_c4 0
C2588 r1_b4 el 0.07445f
C2589 i4_b1 vbp_st 0.04702f
C2590 Xi4/a_3078_4170# i4_b4 0
C2591 ib_x2 Xr/vsp 0.14179f
C2592 i3_b2 Xi3/a_4132_4392# 0.00296f
C2593 r2_b3 ua0_stim_out 0.12912f
C2594 Xd2/m1_756_3240# vbn_prb 0.0785f
C2595 Xr/vsn Xi2/m1_260_2080# -0.06498f
C2596 bias_en Xvi/m1_4894_1238# 0.05569f
C2597 v0_c0 Xi1/a_3078_4392# 0
C2598 i3_b4 vdd 0.9729f
C2599 r2_b4 i2_b1 0.03342f
C2600 r1_b3 i2_b1 0.03696f
C2601 Xr/vgln el 0.12331f
C2602 Xr/vglp Xi3/g 0.13691f
C2603 Xvi/m1_8042_6360# Xvi/a_864_6450# -0
C2604 Xd1/a_2456_3416# Xr/vsp 0.07912f
C2605 r1_b2 Xi3/a_528_4392# 0
C2606 v0_c1 Xd3/m1_5422_4448# 0.09131f
C2607 Xg/a_5188_4156# vdd -0.05974f
C2608 r2_b2 r1_b2 0.04298f
C2609 Xr/vglp i3_b3 0.34381f
C2610 Xg/m1_5022_10210# i0_b3 0.0405f
C2611 v0_c3 Xd3/m1_4102_4448# 0
C2612 i0_b0 i2_b4 0.1411f
C2613 i0_b1 Xg/m1_3666_9610# 0.01459f
C2614 i0_b0 Xm/in_p 0.09262f
C2615 r1_b4 i2_b2 0.07913f
C2616 el Xr/vsp 0.44876f
C2617 i0_b3 Xi2/a_2228_4170# 0.00376f
C2618 Xi2/m1_260_2080# vbp_syn 0
C2619 ib_x2 Xg/m1_5516_1920# 0
C2620 Xg/m1_3530_1930# el 0
C2621 Xvi/m1_8646_1098# Xr/vglp 0
C2622 Xg/a_3036_4156# Xg/a_1580_5314# -0.01366f
C2623 i2_b1 vdd 0.22544f
C2624 ib_r1 vbn_prb 0.00332f
C2625 r2_b2 vbp_st 0.03557f
C2626 i1_b0 Xr/vgln 0.00825f
C2627 Xr/vgln i2_b2 0.055f
C2628 Xi4/a_3078_4170# vreset_src 0.04825f
C2629 Xd3/a_1624_3816# ua0_stim 0.00212f
C2630 Xr/vsn Xg/a_4580_5314# 0.0597f
C2631 r1_b3 vbn_ref 0.03618f
C2632 r1_b3 i0_b2 0.05091f
C2633 Xd2/a_1272_3416# r2_b0 0.00306f
C2634 Xd1/m1_1780_5040# vbn_prb 0.12725f
C2635 Xi2/g r2_b1 0
C2636 r2_b4 i0_b2 0.03085f
C2637 Xg/a_3036_4156# i3_b2 0.27476f
C2638 Xi0/g vbn_ax 0.03592f
C2639 i1_b0 Xi1/a_528_4392# 0.00298f
C2640 r2_b4 vbn_ref 0.03324f
C2641 Xd0/m1_382_4048# vbn_prb 0.05142f
C2642 vdd Xd3/m1_382_4448# 0.09969f
C2643 r0_b3 Xi2/m1_260_2080# 0
C2644 i1_b0 Xr/vsp 0.15529f
C2645 Xi4/g vth_ref 0.02639f
C2646 r0_b1 vbn_ax 0.04222f
C2647 i4_b2 Xr/vglp 0.09902f
C2648 i3_b1 i1_b0 0.07921f
C2649 v0_c2 Xr/vsp 0.02534f
C2650 Xvi/m1_942_738# vbn_prb 0.00534f
C2651 ib_x2 Xr/m1_2542_438# 0.00364f
C2652 i3_b2 Xi3/a_3928_4392# 0.00658f
C2653 Xd1/a_680_3416# Xd2/a_3048_3416# 0.02371f
C2654 r1_b4 r1_b2 0.26774f
C2655 r2_b0 vbn_prb 0.03914f
C2656 bias_en Xr/vglp 0.2598f
C2657 Xd3/m1_1262_4448# ua0_s0 0.00157f
C2658 Xr/vgln Xi1/m1_988_888# 0
C2659 vdd vbn_ref 0.93919f
C2660 r2_b0 i0_b3 0.03426f
C2661 Xr/vgln Xvi/m1_4546_7560# 0.03005f
C2662 r2_b3 vbn_ax 0.14046f
C2663 Xi2/g i4_b4 0.09872f
C2664 ua0_stim_out vbn_prb 0.17991f
C2665 Xi0/m1_240_3480# vbn_prb 0.00769f
C2666 vdd i0_b2 0.52903f
C2667 Xd3/a_1624_3816# Xd3/m1_2408_3600# -0.00351f
C2668 Xi0/a_2432_4392# i0_b1 0.01666f
C2669 v0_c2 Xd3/a_4584_3816# 0.08066f
C2670 r1_b2 Xr/vgln 0.02933f
C2671 Xi2/m1_988_888# i3_b2 0.00141f
C2672 ib_x2 Xd3/m1_382_4448# 0
C2673 ua0_stim_out i0_b3 0
C2674 i2_b3 i0_b1 0.37107f
C2675 Xd3/a_2216_3816# ua0_s1 0.09983f
C2676 v0_c1 Xd3/m1_3908_2760# 0.11711f
C2677 r1_b4 vbp_st 0.02941f
C2678 Xm/in_n vdd 0.46296f
C2679 Xi1/m1_988_888# Xr/vsp 0.34817f
C2680 r2_b3 Xi4/m1_260_2080# 0
C2681 i3_b4 i1_b0 0.30479f
C2682 Xi2/a_3928_4170# i0_b4 0.03905f
C2683 Xr/vgln Xi1/m1_988_3464# 0.18877f
C2684 ib_x2 Xd3/m1_4078_3250# 0
C2685 vdd ua0_int 2.09354f
C2686 ua0_stim v0_c3 0.05662f
C2687 r1_b2 Xr/vsp 0.05193f
C2688 ib_x2 Xg/m1_6282_1450# 0
C2689 Xi2/m1_988_888# i3_b0 0.39171f
C2690 Xg/a_7580_5314# vdd -0.11926f
C2691 Xg/a_3036_4156# i0_b4 0.03079f
C2692 Xm/in_n Xm/a_420_700# 0.00101f
C2693 Xr/vgln vbp_st 0.17283f
C2694 r2_b0 r0_b4 0.11095f
C2695 Xi1/m1_988_3464# Xr/vsp 0.11403f
C2696 r0_b4 ua0_stim_out 0.03518f
C2697 Xm/a_420_700# ua0_int 0.09263f
C2698 Xi2/m1_988_2644# i3_b0 0.01169f
C2699 Xm/in_n ib_x2 0.40544f
C2700 Xd0/a_2224_3416# vdd 0
C2701 Xi2/g Xi3/a_3282_4392# 0.05591f
C2702 r2_b0 r0_b0 0.01516f
C2703 vbp_st Xr/vsp 0.20758f
C2704 i2_b1 i2_b2 0.58986f
C2705 Xi1/m1_240_3480# Xi1/m1_988_2804# -0
C2706 r0_b0 ua0_stim_out 0.03653f
C2707 Xd0/m1_617_3840# Xd1/m1_2862_4048# 0.02288f
C2708 Xd3/m1_3222_4448# Xd3/m1_2408_3600# -0.02335f
C2709 vdd v0_c4 0.68278f
C2710 Xi2/g vreset_src 0
C2711 i3_b1 vbp_st 0.05669f
C2712 vbp_w Xi0/g 0.28927f
C2713 Xd1/a_680_3416# vreset_src 0.00274f
C2714 Xm/in_n el 0
C2715 r0_b1 vbp_w 0.03885f
C2716 vbp_w r1_b1 0.04476f
C2717 vbn_leak vbn_prb 0.47303f
C2718 Xd1/a_1272_3416# Xr/vsp 0.00625f
C2719 Xvi/m1_8042_6360# Xr/vglp 0.10203f
C2720 Xd3/a_1624_3816# Xd3/m1_1523_3480# -0
C2721 i4_b1 Xi0/g 0.16252f
C2722 Xi0/a_2228_4392# i0_b1 0.01936f
C2723 ib_x2 v0_c4 0.04158f
C2724 vbn_leak i0_b3 0.00166f
C2725 ib_x2 Xr/m1_342_438# 0.43008f
C2726 Xr/vsn i4_b3 0.37492f
C2727 Xi2/a_3078_4170# Xi2/m1_988_2644# -0.00524f
C2728 i0_b1 i2_b4 0.08018f
C2729 vbn_prb vbn_ax 0.04419f
C2730 i4_b1 r1_b1 0.85172f
C2731 r1_b3 Xi4/a_2432_4170# 0
C2732 i3_b4 vbp_st 0.08741f
C2733 v0_c2 Xd3/m1_4078_3250# 0.05033f
C2734 i0_b1 Xm/in_p 0.22423f
C2735 v0_c5 vdd 0.16769f
C2736 Xr/vsn i4_b0 0.15389f
C2737 i1_b0 i0_b2 0.05053f
C2738 Xd1/a_3048_3416# vdd 0.02297f
C2739 r2_b3 vbp_w 0.19003f
C2740 v0_c0 Xd3/m1_1262_4448# 0.00572f
C2741 i1_b0 vbn_ref 0.33894f
C2742 i0_b2 i2_b2 0.11945f
C2743 vbn_ref i2_b2 0.03468f
C2744 r1_b2 i2_b1 0
C2745 Xd2/a_1864_3416# vbn_prb 0.05838f
C2746 Xi3/m1_988_2804# Xi3/g 0.16271f
C2747 Xi4/g r1_b1 0
C2748 v0_c1 ua0_s1 0.28833f
C2749 i0_b3 vbn_ax 0.04215f
C2750 r1_b0 i3_b2 0.03557f
C2751 Xr/vgln vth_ref 0.04784f
C2752 Xd0/a_2224_3416# el 0.01347f
C2753 Xg/a_5188_4156# vbp_st 0.06413f
C2754 vbn_ax Xi2/a_1582_4170# 0
C2755 Xi1/a_3078_4392# Xi1/m1_1500_4312# -0
C2756 Xi4/m1_260_2080# vbn_prb 0.14186f
C2757 Xd3/a_2808_3816# vdd -0.00243f
C2758 r2_b3 Xi4/g 0
C2759 Xvi/a_5712_1328# bias_en 0.22107f
C2760 vdd Xi0/m1_988_3464# -0.01293f
C2761 i0_b4 r0_b2 0.05627f
C2762 v0_c5 ib_x2 0.35743f
C2763 r1_b0 i3_b0 0.2378f
C2764 Xi4/a_2432_4170# vdd 0.02487f
C2765 Xi2/g Xi3/a_3078_4392# 0.04439f
C2766 v0_c2 ua0_int 0.04352f
C2767 Xd3/m1_3222_4448# Xd3/m1_1523_3480# -0.00421f
C2768 Xd3/m1_2720_2760# Xd3/m1_2408_3600# -0.0047f
C2769 r0_b4 vbn_ax 0.90602f
C2770 r2_b2 Xi0/g 0.04596f
C2771 Xg/a_1580_5314# Xi3/g 0.04158f
C2772 r2_b2 r1_b1 0.4782f
C2773 r1_b2 vbn_ref 0.40816f
C2774 r0_b0 vbn_ax 0.03578f
C2775 r1_b2 i0_b2 0.1003f
C2776 Xg/a_1580_5314# i3_b3 0.05921f
C2777 Xd3/m1_382_4448# vbp_st 0
C2778 v0_c0 Xi1/m1_988_2804# 0.25387f
C2779 r2_b3 Xi3/a_528_4392# 0
C2780 Xi0/a_732_4392# vbn_prb 0.04977f
C2781 r1_b0 i0_b4 0.03329f
C2782 bias_en Xd3/m1_3222_4448# 0.07058f
C2783 Xd3/m1_5422_4448# ua0_s0 0.02225f
C2784 Xd3/a_3400_3816# ua0_s1 0.10145f
C2785 v0_c0 Xi1/m1_1500_4312# 0
C2786 v0_c2 v0_c4 0.4583f
C2787 bias_en v0_c3 0.05149f
C2788 r2_b3 r2_b2 0.13081f
C2789 vdd Xi3/a_4132_4392# 0
C2790 Xi0/g Xg/m1_6020_10200# 0.09055f
C2791 i3_b2 Xi3/g 0.57991f
C2792 r2_b1 i0_b0 0.02666f
C2793 Xr/m1_782_438# ib_r1 0.00208f
C2794 vbn_ref vbp_st 0.54107f
C2795 i0_b2 vbp_st 0.06111f
C2796 i3_b2 i3_b3 0.43428f
C2797 Xi0/a_3928_4392# i0_b2 0
C2798 vbn_ref Xi2/a_732_4170# 0.01575f
C2799 Xi0/m1_988_3464# el 0.05082f
C2800 Xr/vgln Xvi/m1_8332_7080# 0.0373f
C2801 ua0_stim_out Xr/m1_3862_3522# 0
C2802 Xr/en_b Xm/in_p 0.0458f
C2803 r2_b1 vreset_src 0.02871f
C2804 Xm/in_n vbp_st 0.00778f
C2805 r2_b4 Xi2/a_3928_4170# 0.00608f
C2806 Xd3/a_3992_3816# v0_c3 0.043f
C2807 vbp_w vbn_prb 0.08785f
C2808 r1_b4 Xi0/g 0.03497f
C2809 Xd0/a_2224_3416# r1_b2 0.00174f
C2810 Xi1/m1_988_888# v0_c4 0.1685f
C2811 ua0_stim_out ua0_s0 0.0428f
C2812 vbp_w i0_b3 0.00151f
C2813 i4_b2 Xg/a_1580_5314# 0.13236f
C2814 v0_c2 v0_c5 0.24663f
C2815 v0_c0 i1_b4 0.18756f
C2816 Xr/vgln Xvi/m1_7440_2050# 0.00184f
C2817 vth_ref Xr/m1_2542_438# 0.02533f
C2818 ua0_s1 Xm/a_736_7228# 0.23938f
C2819 Xi2/g i0_b1 0.03136f
C2820 Xi4/a_2228_4170# vdd 0
C2821 Xg/a_7580_5314# vbp_st 0.07506f
C2822 i4_b4 i0_b0 0.09977f
C2823 r1_b4 r1_b1 1.52067f
C2824 Xi4/g vbn_prb 0.71314f
C2825 r2_b1 Xi4/a_732_4170# 0
C2826 Xd3/m1_2720_2760# Xd3/m1_1523_3480# -0.00269f
C2827 Xr/vglp vth_cmp 0.11124f
C2828 Xr/vgln Xi0/g 0.04008f
C2829 Xi2/g Xi2/m1_1500_3762# -0.0219f
C2830 Xr/vsn ua0_stim_out 0.52498f
C2831 i4_b1 i0_b3 0.02961f
C2832 i4_b4 vreset_src 0.03444f
C2833 i4_b2 i3_b2 0.04288f
C2834 Xd3/a_2808_3816# v0_c2 0.08201f
C2835 r0_b1 Xr/vgln 0.15549f
C2836 Xi2/a_3928_4170# vdd 0.00138f
C2837 i0_b4 Xi3/g 0.17178f
C2838 r2_b3 r1_b4 0.03538f
C2839 Xr/vgln r1_b1 0.37195f
C2840 Xd0/m1_2742_3250# Xd0/m1_2242_4966# -0
C2841 vth_ref Xd3/m1_382_4448# 0
C2842 Xvi/m1_8042_6360# vss -0.34565f
C2843 vbn_prb vss -0.80409f
C2844 el vss 3.13891f
C2845 Xvi/m1_4546_7560# vss -0.34374f
C2846 ib_x2 vss 1.35023f
C2847 Xm/iint vss 1.6956f
C2848 vth_cmp vss 4.1751f
C2849 Xvi/m1_1382_738# vss -0.27155f
C2850 Xvi/m1_942_738# vss -0.31031f
C2851 Xvi/m1_502_738# vss -0.26607f
C2852 Xvi/m1_7440_2050# vss -0.41505f
C2853 vth_ref vss -0.34935f
C2854 Xvi/m1_8332_7080# vss -0.29841f
C2855 Xvi/a_2102_5152# vss -0.50206f
C2856 Xvi/a_4976_1528# vss -0.86111f
C2857 Xvi/a_864_6450# vss -2.92249f
C2858 Xvi/m1_4894_1238# vss -0.71829f
C2859 Xr/vglp vss -3.00906f
C2860 vreset_src vss -3.35967f
C2861 Xvi/m1_5388_6960# vss -0.33944f
C2862 Xvi/a_5712_1328# vss -1.7249f
C2863 Xvi/m1_8646_1098# vss -0.08118f
C2864 bias_en vss 3.23981f
C2865 Xvi/m1_7102_850# vss -0.71745f
C2866 Xvi/m1_1276_6360# vss -0.32612f
C2867 ib_r1 vss 0.46959f
C2868 vdd vss -0.30037p
C2869 Xd3/m1_4078_3250# vss -0.84258f
C2870 Xd3/m1_3908_2760# vss -0.86655f
C2871 Xd3/m1_1262_4448# vss -0.25195f
C2872 Xd3/m1_1702_4448# vss -0.25059f
C2873 Xd3/m1_3222_4448# vss -0.86758f
C2874 Xd3/m1_2720_2760# vss -0.86709f
C2875 Xd3/m1_822_4448# vss -0.29374f
C2876 Xd3/m1_2408_3600# vss -0.9332f
C2877 Xd3/m1_1523_3480# vss -0.7523f
C2878 Xd3/m1_382_4448# vss -0.26389f
C2879 Xd3/m1_5422_4448# vss -0.30445f
C2880 Xd3/m1_4982_4448# vss -0.30733f
C2881 Xd3/a_1624_3816# vss -0.34045f
C2882 v0_c0 vss 0.4401f
C2883 Xd3/a_2216_3816# vss -0.42735f
C2884 v0_c1 vss 0.92795f
C2885 v0_c2 vss 0.47829f
C2886 Xd3/a_2808_3816# vss -0.4166f
C2887 Xd3/a_3400_3816# vss -0.36232f
C2888 v0_c3 vss 0.38421f
C2889 Xd3/a_3992_3816# vss -0.48076f
C2890 v0_c4 vss 0.69339f
C2891 Xd3/a_4584_3816# vss -0.28943f
C2892 v0_c5 vss 1.60308f
C2893 Xd3/m1_4102_4448# vss -0.2692f
C2894 Xd2/m1_2964_2640# vss -0.66883f
C2895 Xd2/m1_1342_4048# vss -0.29877f
C2896 Xd2/m1_2382_2650# vss -0.75792f
C2897 Xd2/m1_1780_2760# vss -0.80272f
C2898 Xd2/m1_902_4048# vss -0.31033f
C2899 Xd2/m1_756_3240# vss -0.92736f
C2900 Xd2/m1_596_2880# vss -0.70252f
C2901 Xd2/m1_462_4048# vss -0.29908f
C2902 Xd2/a_680_3416# vss -0.2682f
C2903 r2_b0 vss 1.94451f
C2904 Xd2/a_1272_3416# vss -0.35115f
C2905 r2_b1 vss 1.18967f
C2906 Xd2/a_1864_3416# vss -0.41299f
C2907 r2_b2 vss 0.56138f
C2908 r2_b4 vss 1.85869f
C2909 Xd2/a_2456_3416# vss -0.38522f
C2910 r2_b3 vss 2.11462f
C2911 Xd2/a_3048_3416# vss -0.25569f
C2912 Xr/m1_3862_3522# vss -0.25117f
C2913 Xr/m1_3422_438# vss -0.23682f
C2914 Xr/m1_2542_438# vss -0.23682f
C2915 Xr/m1_1662_438# vss -0.23682f
C2916 Xr/m1_1222_3522# vss -0.25114f
C2917 Xr/m1_782_438# vss -0.23682f
C2918 Xr/m1_342_438# vss -0.31439f
C2919 Xd1/m1_2974_2650# vss -0.76409f
C2920 Xd1/m1_2372_2520# vss -0.79011f
C2921 Xd1/m1_1780_5040# vss -0.72013f
C2922 Xd1/m1_860_4046# vss -0.26351f
C2923 Xd1/m1_756_3120# vss -0.7821f
C2924 Xd1/m1_606_2410# vss -0.69042f
C2925 Xd1/m1_462_4048# vss -0.28155f
C2926 Xd1/a_680_3416# vss -0.29199f
C2927 r1_b0 vss 0.36582f
C2928 Xd1/a_1272_3416# vss -0.34725f
C2929 r1_b1 vss 0.19279f
C2930 Xd1/a_1864_3416# vss -0.40058f
C2931 r1_b2 vss 1.50736f
C2932 r1_b4 vss 0.51473f
C2933 Xd1/a_2456_3416# vss -0.3394f
C2934 r1_b3 vss 2.35938f
C2935 Xd1/a_3048_3416# vss -0.24023f
C2936 Xd1/m1_2862_4048# vss -0.27205f
C2937 Xd0/m1_3310_2880# vss -0.71916f
C2938 Xd0/m1_1262_4048# vss -0.2535f
C2939 Xd0/m1_2242_4966# vss -0.68579f
C2940 Xd0/m1_2742_3250# vss -0.69701f
C2941 Xd0/m1_822_4048# vss -0.24452f
C2942 Xd0/m1_617_3840# vss -0.84707f
C2943 Xd0/m1_956_3000# vss -0.63354f
C2944 Xd0/m1_382_4048# vss -0.29049f
C2945 Xd0/a_1040_3416# vss -0.14776f
C2946 r0_b0 vss 0.61156f
C2947 Xd0/a_1632_3416# vss -0.31392f
C2948 r0_b1 vss 1.63381f
C2949 Xd0/a_2224_3416# vss -0.28114f
C2950 r0_b2 vss 1.12231f
C2951 Xd0/a_2816_3416# vss -0.26411f
C2952 r0_b3 vss 0.93871f
C2953 Xd0/a_3408_3416# vss -0.14913f
C2954 r0_b4 vss 0.4969f
C2955 Xd0/m1_3662_4048# vss -0.27715f
C2956 Xi4/m1_988_888# vss -1.31115f
C2957 Xr/vsn vss -10.1941f
C2958 Xi4/g vss -12.17781f
C2959 Xi4/a_4132_4170# vss -0.26626f
C2960 Xi4/a_3928_4170# vss -0.18564f
C2961 Xi4/a_3282_4170# vss -0.272f
C2962 Xi4/a_3078_4170# vss -0.24951f
C2963 Xi4/m1_1500_3762# vss -0.11584f
C2964 Xi4/a_1582_4170# vss -0.27201f
C2965 Xi4/a_1378_4170# vss -0.18612f
C2966 Xi4/a_2432_4170# vss -0.27132f
C2967 Xi4/a_2228_4170# vss -0.18393f
C2968 Xi4/m1_260_2080# vss -0.17079f
C2969 vbp_w vss 1.82713f
C2970 Xi4/a_732_4170# vss -0.27256f
C2971 Xi4/a_528_4170# vss -0.18526f
C2972 Xi4/m1_988_3304# vss -0.27347f
C2973 i4_b4 vss 0.49219f
C2974 i4_b2 vss 1.18873f
C2975 i4_b3 vss 0.87944f
C2976 i4_b1 vss 0.66851f
C2977 i4_b0 vss 0.58409f
C2978 Xi4/m1_988_2644# vss -0.71384f
C2979 Xi3/m1_988_888# vss -0.05251f
C2980 Xr/vsp vss -13.69557f
C2981 Xi3/g vss -5.46151f
C2982 Xi3/a_4132_4392# vss -0.12f
C2983 Xi3/a_3928_4392# vss -0.20245f
C2984 Xi3/a_3282_4392# vss -0.1242f
C2985 Xi3/a_3078_4392# vss -0.20572f
C2986 Xi3/m1_1500_4312# vss -0.03078f
C2987 Xi3/a_1582_4392# vss -0.12117f
C2988 Xi3/a_1378_4392# vss -0.20974f
C2989 Xi3/a_2432_4392# vss -0.11998f
C2990 Xi3/a_2228_4392# vss -0.21858f
C2991 Xi3/m1_240_3480# vss -0.14358f
C2992 vbn_ax vss 1.23639f
C2993 Xi3/a_732_4392# vss -0.125f
C2994 Xi3/a_528_4392# vss -0.20738f
C2995 Xi3/m1_988_3464# vss -0.06174f
C2996 i3_b4 vss 0.6256f
C2997 i3_b3 vss 0.59201f
C2998 i3_b2 vss 0.90858f
C2999 i3_b1 vss 0.78445f
C3000 i3_b0 vss 0.64575f
C3001 Xi3/m1_988_2804# vss -0.07595f
C3002 vbp_st vss 0.89499f
C3003 Xi2/m1_988_888# vss -1.40833f
C3004 Xi2/g vss -13.23401f
C3005 Xi2/a_4132_4170# vss -0.26671f
C3006 Xi2/a_3928_4170# vss -0.18615f
C3007 Xi2/a_3282_4170# vss -0.27218f
C3008 Xi2/a_3078_4170# vss -0.25662f
C3009 Xi2/m1_1500_3762# vss -0.11584f
C3010 Xi2/a_1582_4170# vss -0.27188f
C3011 Xi2/a_1378_4170# vss -0.18612f
C3012 Xi2/a_2432_4170# vss -0.27133f
C3013 Xi2/a_2228_4170# vss -0.18393f
C3014 Xi2/m1_260_2080# vss -0.18275f
C3015 vbp_syn vss 1.03899f
C3016 Xi2/a_732_4170# vss -0.27257f
C3017 Xi2/a_528_4170# vss -0.18553f
C3018 Xi2/m1_988_3304# vss -0.27347f
C3019 i2_b4 vss 0.12661f
C3020 i2_b2 vss 0.56609f
C3021 i2_b3 vss 0.09033f
C3022 i2_b1 vss 0.7167f
C3023 i2_b0 vss 0.21621f
C3024 Xi2/m1_988_2644# vss -0.71384f
C3025 Xm/a_2240_11218# vss -0.63922f
C3026 ua0_int vss 1.65578f
C3027 Xm/a_736_7228# vss -7.56386f
C3028 Xr/en_b vss -0.86446f
C3029 ua0_stim_out vss 0.8302f
C3030 ua0_stim vss 0.11709f
C3031 Xm/a_1764_11418# vss -0.45062f
C3032 Xm/a_736_5516# vss -6.71035f
C3033 Xm/a_1744_9182# vss -0.51751f
C3034 Xm/a_420_700# vss -1.49621f
C3035 ua0_s0 vss 1.94228f
C3036 ua0_s1 vss 1.54648f
C3037 ua0 vss 0.45596f
C3038 Xm/a_1744_10100# vss -0.53234f
C3039 Xi0/m1_988_888# vss 0.21207f
C3040 Xi0/g vss -4.65607f
C3041 Xi0/a_4132_4392# vss -0.117f
C3042 Xi0/a_3928_4392# vss -0.20262f
C3043 Xi0/a_3282_4392# vss -0.12232f
C3044 Xi0/a_3078_4392# vss -0.20545f
C3045 Xi0/m1_1500_4312# vss -0.03026f
C3046 Xi0/a_1582_4392# vss -0.12169f
C3047 Xi0/a_1378_4392# vss -0.22299f
C3048 Xi0/a_2432_4392# vss -0.11912f
C3049 Xi0/a_2228_4392# vss -0.20325f
C3050 Xi0/m1_240_3480# vss -0.09276f
C3051 vbn_leak vss -1.75756f
C3052 Xi0/a_732_4392# vss -0.12107f
C3053 Xi0/a_528_4392# vss -0.20257f
C3054 Xi0/m1_988_3464# vss -0.06152f
C3055 i0_b4 vss 1.24382f
C3056 i0_b3 vss 0.39587f
C3057 i0_b2 vss 1.07142f
C3058 i0_b1 vss 0.62884f
C3059 i0_b0 vss 1.49001f
C3060 Xi0/m1_988_2804# vss -0.07353f
C3061 Xi1/m1_988_888# vss -0.17694f
C3062 Xi1/g vss -4.92602f
C3063 Xi1/a_4132_4392# vss -0.12f
C3064 Xi1/a_3928_4392# vss -0.20768f
C3065 Xi1/a_3282_4392# vss -0.12439f
C3066 Xi1/a_3078_4392# vss -0.20561f
C3067 Xi1/m1_1500_4312# vss -0.04526f
C3068 Xi1/a_1582_4392# vss -0.11984f
C3069 Xi1/a_1378_4392# vss -0.20229f
C3070 Xi1/a_2432_4392# vss -0.12277f
C3071 Xi1/a_2228_4392# vss -0.20862f
C3072 Xi1/m1_240_3480# vss -0.07128f
C3073 vbn_ref vss 0.29444f
C3074 Xi1/a_732_4392# vss -0.12131f
C3075 Xi1/a_528_4392# vss -0.19992f
C3076 Xi1/m1_988_3464# vss -0.05258f
C3077 i1_b4 vss 0.27516f
C3078 i1_b3 vss 0.91794f
C3079 i1_b2 vss 0.47888f
C3080 i1_b1 vss 0.78736f
C3081 i1_b0 vss 0.43101f
C3082 Xi1/m1_988_2804# vss -0.07371f
C3083 Xg/a_1580_5314# vss -0.48255f
C3084 Xg/m1_4906_9490# vss -0.10145f
C3085 Xg/m1_3898_9610# vss -0.0928f
C3086 Xg/m1_3666_9610# vss -0.0919f
C3087 Xm/in_p vss -0.19996f
C3088 Xg/m1_4538_1930# vss -0.22289f
C3089 Xg/m1_3530_1930# vss -0.41603f
C3090 Xg/m1_3298_2050# vss -0.2563f
C3091 Xm/in_n vss 0.09055f
C3092 Xr/vgln vss -10.18547f
C3093 Xg/a_5188_4156# vss -0.90635f
C3094 Xg/a_7580_5314# vss -0.0773f
C3095 Xg/a_3036_4156# vss -0.89798f
C3096 Xg/a_4580_5314# vss -0.16895f
C3097 Xg/m1_6282_1450# vss -0.11818f
C3098 Xg/m1_5516_1920# vss -0.25055f
C3099 Xg/m1_4760_1320# vss -0.18804f
C3100 Xg/m1_6020_10200# vss -0.14796f
C3101 Xg/m1_5022_10210# vss -0.09562f
.ends
