* NGSPICE file created from cslot_ah_f.ext - technology: gf180mcuD

.subckt cslot_ah_f vss vbp_syn vdd el aux vbn_leak vsrc vbp_st vbn_prb vbn_ref en
+ vreset abus sta stb hold mreset rsel sub sub_b spk vm
X0 vss spk a_1750_1798# vss nfet_03v3 ad=0.13p pd=1.02u as=0.22p ps=1.88u w=0.5u l=0.28u
X1 a_1492_3386# a_1492_3386# a_188_3512# vss nfet_03v3 ad=1.02p pd=3.02u as=1.02p ps=3.02u w=2u l=0.5u
X2 a_492_184# stb vss vdd pfet_03v3 ad=0.44p pd=2.88u as=0.26p ps=1.52u w=1u l=0.28u
X3 vdd spk a_2128_4314# vdd pfet_03v3 ad=0.1516p pd=1.64u as=0.1516p ps=1.64u w=0.22u l=1u
X4 spk a_2128_4314# vss vss nfet_03v3 ad=0.22p pd=1.88u as=0.13p ps=1.02u w=0.5u l=0.28u
X5 a_2998_3512# el a_1492_3386# vss nfet_03v3 ad=1.02p pd=3.02u as=1.38p ps=5.38u w=2u l=0.5u
X6 spk a_2128_4314# vdd vdd pfet_03v3 ad=0.44p pd=2.88u as=0.26p ps=1.52u w=1u l=0.28u
X7 a_2998_3512# a_2998_3512# vdd vdd pfet_03v3 ad=0.88p pd=4.88u as=0.52p ps=2.52u w=2u l=4u
X8 vm sta a_188_184# vss nfet_03v3 ad=0.13p pd=1.02u as=0.22p ps=1.88u w=0.5u l=0.28u
X9 vss vm vss vss nfet_03v3 ad=0.9191p pd=4.055u as=9.167p ps=47.39u w=3.535u l=7.07u
X10 a_3234_1924# vbp_st vdd vdd pfet_03v3 ad=0.14p pd=1.28u as=0.26p ps=1.52u w=1u l=2u
X11 vss a_276_5220# vss vss nfet_03v3 ad=0.7788p pd=4.42u as=0 ps=0 w=1.77u l=3.54u
X12 a_188_3512# a_1492_3386# a_1492_3386# vss nfet_03v3 ad=1.02p pd=3.02u as=1.02p ps=3.02u w=2u l=0.5u
X13 a_2274_1924# a_1328_4116# a_1728_4160# vdd pfet_03v3 ad=0.14p pd=1.28u as=0.44p ps=2.88u w=1u l=0.28u
X14 a_188_4160# a_188_4160# a_188_3512# vss nfet_03v3 ad=1.02p pd=3.02u as=1.02p ps=3.02u w=2u l=0.5u
X15 vdd mreset a_276_5220# vss nfet_03v3 ad=0.22p pd=1.88u as=0.22p ps=1.88u w=0.5u l=0.28u
X16 a_188_3512# a_1492_3386# a_1492_3386# vss nfet_03v3 ad=1.38p pd=5.38u as=1.02p ps=3.02u w=2u l=0.5u
X17 vdd vbp_st a_2358_2372# vdd pfet_03v3 ad=0.26p pd=1.52u as=0.14p ps=1.28u w=1u l=2u
X18 vss sta a_188_184# vdd pfet_03v3 ad=0.26p pd=1.52u as=0.44p ps=2.88u w=1u l=0.28u
X19 a_1154_2372# hold vdd vdd pfet_03v3 ad=0.44p pd=2.88u as=0.44p ps=2.88u w=1u l=2u
X20 vsrc a_1728_4160# a_2128_4314# vss nfet_03v3 ad=0.22p pd=1.88u as=0.22p ps=1.88u w=0.5u l=0.28u
X21 a_2358_2372# a_1728_4160# a_2128_4314# vdd pfet_03v3 ad=0.14p pd=1.28u as=0.44p ps=2.88u w=1u l=0.28u
X22 vss a_276_5220# vss vss nfet_03v3 ad=0.4602p pd=2.29u as=0 ps=0 w=1.77u l=3.54u
X23 vdd vbp_st a_2274_1924# vdd pfet_03v3 ad=0.26p pd=1.52u as=0.14p ps=1.28u w=1u l=2u
X24 a_276_4614# a_276_4614# a_188_4160# vss nfet_03v3 ad=1.02p pd=3.02u as=1.38p ps=5.38u w=2u l=0.5u
X25 a_188_3512# a_188_4160# a_188_4160# vss nfet_03v3 ad=1.02p pd=3.02u as=1.02p ps=3.02u w=2u l=0.5u
X26 a_1728_4160# a_1328_4116# vsrc vss nfet_03v3 ad=0.1516p pd=1.64u as=0.1516p ps=1.64u w=0.22u l=2u
X27 a_188_4160# a_188_4160# a_188_3512# vss nfet_03v3 ad=1.02p pd=3.02u as=1.38p ps=5.38u w=2u l=0.5u
X28 vss vm vss vss nfet_03v3 ad=1.5554p pd=7.95u as=0 ps=0 w=3.535u l=7.07u
X29 a_3176_4160# vbn_prb vss vss nfet_03v3 ad=0.88p pd=4.88u as=0.52p ps=2.52u w=2u l=2u
X30 a_1750_1798# spk vdd vdd pfet_03v3 ad=0.44p pd=2.88u as=0.26p ps=1.52u w=1u l=0.28u
X31 a_492_184# stb vm vss nfet_03v3 ad=0.22p pd=1.88u as=0.13p ps=1.02u w=0.5u l=0.28u
X32 a_2904_4160# rsel a_2792_4160# vss nfet_03v3 ad=0.14p pd=1.28u as=0.14p ps=1.28u w=1u l=0.28u
X33 vm hold a_276_4614# vdd pfet_03v3 ad=0.44p pd=2.88u as=0.44p ps=2.88u w=1u l=0.28u
X34 a_1328_4116# vm vsrc vss nfet_03v3 ad=0.44p pd=2.88u as=0.44p ps=2.88u w=1u l=0.5u
X35 a_2792_4160# sub_b abus vss nfet_03v3 ad=0.14p pd=1.28u as=0.44p ps=2.88u w=1u l=0.28u
X36 vss vbn_leak a_188_3512# vss nfet_03v3 ad=0.44p pd=2.88u as=0.44p ps=2.88u w=1u l=4u
X37 a_1136_184# vm vdd vss nfet_03v3 ad=1.76p pd=8.88u as=1.76p ps=8.88u w=4u l=2u
X38 vreset a_276_5220# vm vss nfet_03v3 ad=0.44p pd=2.88u as=0.44p ps=2.88u w=1u l=0.5u
X39 a_1492_3386# el a_2998_3512# vss nfet_03v3 ad=1.38p pd=5.38u as=1.02p ps=3.02u w=2u l=0.5u
X40 a_492_184# vbp_syn a_1154_2372# vdd pfet_03v3 ad=0.88p pd=4.88u as=0.52p ps=2.52u w=2u l=4u
X41 vdd a_2998_3512# a_276_4614# vdd pfet_03v3 ad=0.52p pd=2.52u as=0.88p ps=4.88u w=2u l=4u
X42 vss vbn_ref a_276_5220# vss nfet_03v3 ad=0.52p pd=2.52u as=0.88p ps=4.88u w=2u l=4u
X43 a_1328_4116# vm a_3234_1924# vdd pfet_03v3 ad=0.44p pd=2.88u as=0.14p ps=1.28u w=1u l=0.5u
X44 a_1136_184# en a_2904_4160# vss nfet_03v3 ad=0.26p pd=1.52u as=0.14p ps=1.28u w=1u l=0.28u
X45 a_3176_4160# en a_1136_184# vss nfet_03v3 ad=0.44p pd=2.88u as=0.26p ps=1.52u w=1u l=0.28u
X46 vdd a_1750_1798# a_276_5220# vdd pfet_03v3 ad=0.26p pd=1.52u as=0.44p ps=2.88u w=1u l=0.28u
X47 a_1154_2372# vbp_syn a_188_184# vdd pfet_03v3 ad=0.52p pd=2.52u as=0.88p ps=4.88u w=2u l=4u
X48 a_1492_3386# a_1492_3386# a_188_3512# vss nfet_03v3 ad=1.02p pd=3.02u as=1.02p ps=3.02u w=2u l=0.5u
X49 a_188_4160# a_276_4614# a_276_4614# vss nfet_03v3 ad=1.38p pd=5.38u as=1.02p ps=3.02u w=2u l=0.5u
X50 a_188_3512# a_188_4160# a_188_4160# vss nfet_03v3 ad=1.02p pd=3.02u as=1.02p ps=3.02u w=2u l=0.5u
C0 a_2128_4314# spk 0.40082f
C1 a_2904_4160# en 0
C2 rsel a_1492_3386# 0.00104f
C3 a_492_184# a_188_184# 0.0668f
C4 sta hold 0.00202f
C5 vdd vbp_syn 2.66467f
C6 a_1750_1798# a_1154_2372# 0.00107f
C7 a_188_3512# vm 0
C8 a_1492_3386# spk 0.04955f
C9 a_276_4614# vm 0.06743f
C10 vbn_prb vdd 0.10971f
C11 a_3234_1924# vbp_syn 0
C12 hold stb 0.05112f
C13 a_1328_4116# vbp_st 0.55496f
C14 a_2998_3512# vbp_syn 0.1631f
C15 a_1728_4160# vm 0
C16 abus a_1328_4116# 0
C17 a_2128_4314# a_1328_4116# 0.09456f
C18 a_188_3512# a_1750_1798# 0.15339f
C19 vbn_prb a_2998_3512# 0.08471f
C20 a_1750_1798# a_276_4614# 0.04f
C21 a_492_184# vbp_st 0
C22 vsrc sta 0
C23 a_276_5220# vdd 0.43909f
C24 a_2128_4314# a_492_184# 0.0871f
C25 vsrc vbn_leak 1.13026f
C26 a_1728_4160# a_1750_1798# 0.14006f
C27 a_188_4160# a_1328_4116# 0
C28 a_1492_3386# a_1328_4116# 0.11556f
C29 a_492_184# a_188_4160# 0
C30 a_1154_2372# hold 0.33862f
C31 vsrc stb 0.00154f
C32 a_492_184# a_1492_3386# 0
C33 el vsrc 0.06406f
C34 mreset spk 0
C35 a_2904_4160# a_3176_4160# 0
C36 vsrc vreset 0.29248f
C37 vbn_prb vbp_syn 0.03439f
C38 vsrc en 0.12651f
C39 rsel spk 0.0115f
C40 a_188_3512# hold 0.17172f
C41 a_276_4614# hold 0.09276f
C42 vsrc vbn_ref 0.11634f
C43 a_1728_4160# hold 0
C44 a_276_5220# vbp_syn 0.13651f
C45 sta vdd 0.21606f
C46 vdd vbn_leak 0.14214f
C47 a_1328_4116# mreset 0.00557f
C48 a_276_5220# vbn_prb 0
C49 a_1136_184# vm 0.2849f
C50 vsrc a_2792_4160# 0
C51 a_2998_3512# vbn_leak 0.11706f
C52 vdd stb 0.46117f
C53 rsel a_1328_4116# 0
C54 a_188_3512# vsrc 0.00762f
C55 el vdd 1.34048f
C56 vsrc a_276_4614# 0
C57 vdd vreset 0.2291f
C58 vdd en 0.13744f
C59 a_1136_184# a_1750_1798# 0.06063f
C60 vsrc a_1728_4160# 0.15491f
C61 a_1328_4116# spk 0.2415f
C62 el a_2998_3512# 0.21869f
C63 a_2904_4160# a_1136_184# 0.00418f
C64 vdd vbn_ref 0.11324f
C65 a_3234_1924# vreset 0
C66 vsrc a_3176_4160# 0.05458f
C67 a_2998_3512# vreset 0.0118f
C68 a_2358_2372# vdd 0.00375f
C69 a_492_184# spk 0.0025f
C70 a_2998_3512# en 0.02492f
C71 sta vbp_syn 0.06459f
C72 vdd a_1154_2372# 0.41501f
C73 vbn_leak vbp_syn 0.03551f
C74 a_2998_3512# vbn_ref 0.07977f
C75 vbn_prb vbn_leak 0.02393f
C76 stb vbp_syn 0.09737f
C77 el vbp_syn 0.09725f
C78 a_188_3512# vdd 0.2512f
C79 aux vm 0.04475f
C80 vdd a_276_4614# 0.42586f
C81 a_1136_184# hold 0.00989f
C82 a_188_184# vm 0.14126f
C83 vreset vbp_syn 0.03672f
C84 a_492_184# a_1328_4116# 0.17652f
C85 en vbp_syn 0.02652f
C86 el vbn_prb 0.02326f
C87 a_276_5220# sta 0
C88 a_276_5220# sub 0.00183f
C89 a_1728_4160# vdd 0.35937f
C90 vbn_prb vreset 0.03869f
C91 a_188_3512# a_2998_3512# 0.15381f
C92 vbn_prb en 0.0287f
C93 a_2998_3512# a_276_4614# 0.09643f
C94 vbn_ref vbp_syn 0.03832f
C95 sub_b a_2904_4160# 0.00129f
C96 a_2358_2372# vbp_syn 0
C97 vdd a_3176_4160# 0.0035f
C98 a_2274_1924# vdd 0.00364f
C99 a_188_184# a_1750_1798# 0
C100 vbn_prb vbn_ref 1.50807f
C101 a_2998_3512# a_1728_4160# 0
C102 a_276_5220# stb 0
C103 a_1154_2372# vbp_syn 0.2886f
C104 el a_276_5220# 0
C105 vbp_st vm 0.14846f
C106 a_1136_184# vsrc 0.10606f
C107 a_276_5220# vreset 0.10439f
C108 a_2998_3512# a_3176_4160# 0
C109 abus vm 0.00248f
C110 a_2128_4314# vm 0.01427f
C111 a_2792_4160# vbp_syn 0
C112 a_188_3512# vbp_syn 0.24493f
C113 a_276_5220# vbn_ref 0.13223f
C114 a_276_4614# vbp_syn 0.29975f
C115 vbp_st a_1750_1798# 0
C116 abus a_1750_1798# 0
C117 a_1492_3386# vm 0
C118 a_2128_4314# a_1750_1798# 0.05576f
C119 a_188_3512# vbn_prb 0
C120 a_1728_4160# vbp_syn 0.05725f
C121 a_276_5220# a_1154_2372# 0.00382f
C122 a_2904_4160# abus 0.00275f
C123 a_2128_4314# a_2904_4160# 0
C124 a_188_184# hold 0
C125 a_3176_4160# vbp_syn 0.03841f
C126 a_1492_3386# a_1750_1798# 0.06131f
C127 sta stb 0.33633f
C128 vbn_prb a_3176_4160# 0.12978f
C129 sub stb 0.00421f
C130 a_188_3512# a_276_5220# 0.12849f
C131 el vbn_leak 0.06784f
C132 a_276_5220# a_276_4614# 0.17813f
C133 sub_b vsrc 0.04f
C134 a_1136_184# vdd 0.1884f
C135 vreset vbn_leak 0.03381f
C136 en vbn_leak 0.02853f
C137 a_276_5220# a_1728_4160# 0.22476f
C138 vbp_st hold 0
C139 vsrc aux 0.06315f
C140 vsrc a_188_184# 0.00636f
C141 a_3234_1924# a_1136_184# 0
C142 a_1136_184# a_2998_3512# 0.05007f
C143 vbn_ref vbn_leak 0.02332f
C144 a_276_5220# a_3176_4160# 0
C145 a_276_5220# a_2274_1924# 0
C146 vreset stb 0
C147 el vreset 0.03339f
C148 el en 0.03381f
C149 sta a_1154_2372# 0.00355f
C150 en vreset 1.10086f
C151 a_188_4160# hold 0.10083f
C152 el vbn_ref 0.02339f
C153 vbn_ref vreset 0.03945f
C154 en vbn_ref 1.1023f
C155 a_1154_2372# stb 0.06781f
C156 a_2358_2372# vreset 0
C157 vsrc vbp_st 1.11255f
C158 a_188_3512# sta 0.12078f
C159 sta a_276_4614# 0.19455f
C160 spk vm 6.56643f
C161 a_188_3512# vbn_leak 0.07358f
C162 a_188_3512# sub 0
C163 abus vsrc 0.26641f
C164 a_276_4614# vbn_leak 0
C165 a_276_4614# sub 0.0219f
C166 a_1136_184# vbp_syn 0.05978f
C167 a_2128_4314# vsrc 0.07938f
C168 sub_b vdd 0
C169 vbn_prb a_1136_184# 0
C170 a_2904_4160# rsel 0.00659f
C171 vdd aux 0.07939f
C172 a_188_3512# stb 0.1673f
C173 a_276_4614# stb 0.26102f
C174 el a_188_3512# 0.08287f
C175 vdd a_188_184# 0.23248f
C176 spk a_1750_1798# 0.17992f
C177 a_188_4160# vsrc 0.00105f
C178 el a_276_4614# 0.00378f
C179 a_3176_4160# vbn_leak 0
C180 a_1492_3386# vsrc 0.00639f
C181 a_276_4614# vreset 0
C182 a_188_3512# en 0
C183 a_2904_4160# spk 0
C184 a_1728_4160# stb 0
C185 en a_276_4614# 0
C186 a_2998_3512# aux 0.07205f
C187 el a_1728_4160# 0
C188 a_1328_4116# vm 0.35138f
C189 a_276_5220# a_1136_184# 0.08721f
C190 a_1728_4160# vreset 0.00119f
C191 a_188_3512# vbn_ref 0
C192 a_1728_4160# en 0
C193 el a_3176_4160# 0.00422f
C194 a_2358_2372# a_276_4614# 0.00138f
C195 a_492_184# vm 0.29517f
C196 a_3176_4160# en 0.1422f
C197 vbp_st vdd 1.87341f
C198 a_188_3512# a_1154_2372# 0.00523f
C199 a_1728_4160# vbn_ref 0.00736f
C200 a_1154_2372# a_276_4614# 0.10573f
C201 abus vdd 0.10266f
C202 a_2358_2372# a_1728_4160# 0.00433f
C203 a_1328_4116# a_1750_1798# 0.43809f
C204 sub_b vbp_syn 0
C205 a_2128_4314# vdd 0.49695f
C206 a_3176_4160# vbn_ref 0.08962f
C207 a_1728_4160# a_1154_2372# 0
C208 a_3234_1924# vbp_st 0.00133f
C209 a_492_184# a_1750_1798# 0.14435f
C210 spk hold 0
C211 vbp_st a_2998_3512# 0.1142f
C212 aux vbp_syn 0
C213 a_188_184# vbp_syn 0.07823f
C214 vsrc mreset 0.01195f
C215 abus a_2998_3512# 0.00407f
C216 a_3234_1924# a_2128_4314# 0.00195f
C217 a_188_4160# vdd 0.039f
C218 a_2128_4314# a_2998_3512# 0.06322f
C219 a_188_3512# a_276_4614# 0.29873f
C220 vbn_prb aux 0.02282f
C221 a_1492_3386# vdd 0.0065f
C222 a_188_3512# a_1728_4160# 0.08595f
C223 a_3176_4160# a_2792_4160# 0
C224 a_1728_4160# a_276_4614# 0.07006f
C225 rsel vsrc 0.0698f
C226 a_1136_184# sta 0
C227 sub_b a_276_5220# 0
C228 a_1136_184# vbn_leak 0
C229 a_1492_3386# a_2998_3512# 0.29783f
C230 a_188_3512# a_2274_1924# 0
C231 a_2274_1924# a_276_4614# 0
C232 vsrc spk 0.70062f
C233 vbp_st vbp_syn 0.06387f
C234 a_1328_4116# hold 0.00887f
C235 a_276_5220# a_188_184# 0
C236 abus vbp_syn 0.04426f
C237 a_1728_4160# a_3176_4160# 0
C238 a_2128_4314# vbp_syn 0.14439f
C239 a_1136_184# stb 0
C240 a_2274_1924# a_1728_4160# 0.01123f
C241 vbn_prb vbp_st 1.08625f
C242 el a_1136_184# 0.03972f
C243 a_492_184# hold 0.07552f
C244 abus vbn_prb 0.38123f
C245 a_2128_4314# vbn_prb 0
C246 a_1136_184# vreset 0.09467f
C247 a_1136_184# en 0.0705f
C248 a_188_4160# vbp_syn 0.02847f
C249 mreset vdd 0.04285f
C250 a_1492_3386# vbp_syn 0.01649f
C251 a_1136_184# vbn_ref 0
C252 a_2358_2372# a_1136_184# 0.00111f
C253 a_276_5220# vbp_st 0
C254 a_1328_4116# vsrc 0.22724f
C255 vbn_prb a_1492_3386# 0
C256 abus a_276_5220# 0
C257 rsel vdd 0
C258 a_1136_184# a_1154_2372# 0
C259 a_492_184# vsrc 0.00591f
C260 a_1136_184# a_2792_4160# 0.00341f
C261 spk vdd 1.02424f
C262 sta a_188_184# 0.20913f
C263 aux vbn_leak 1.10901f
C264 a_276_5220# a_188_4160# 0.20452f
C265 a_276_5220# a_1492_3386# 0.05803f
C266 a_188_3512# a_1136_184# 0.14124f
C267 a_1136_184# a_276_4614# 0.15981f
C268 a_3234_1924# spk 0.00254f
C269 a_2998_3512# spk 0.30461f
C270 sub_b en 0.01658f
C271 mreset vbp_syn 0
C272 a_188_184# stb 0.03815f
C273 el aux 1.06224f
C274 a_1136_184# a_1728_4160# 0.08623f
C275 aux vreset 0.03356f
C276 en aux 0.02423f
C277 sub_b vbn_ref 0
C278 a_1136_184# a_3176_4160# 0.05766f
C279 a_1136_184# a_2274_1924# 0.00179f
C280 rsel vbp_syn 0
C281 vbp_st vbn_leak 0.03876f
C282 a_1328_4116# vdd 0.65833f
C283 abus vbn_leak 0.02214f
C284 vbn_ref aux 0.02246f
C285 a_2128_4314# vbn_leak 0
C286 vbn_prb rsel 0
C287 a_492_184# vdd 0.56632f
C288 a_3234_1924# a_1328_4116# 0.00842f
C289 a_1328_4116# a_2998_3512# 0.0012f
C290 spk vbp_syn 0.39838f
C291 sub_b a_2792_4160# 0.00664f
C292 a_276_5220# mreset 0.1008f
C293 a_188_184# a_1154_2372# 0.01183f
C294 a_188_4160# sta 0.07183f
C295 el vbp_st 0.04596f
C296 a_188_4160# sub 0.02273f
C297 el abus 0.02168f
C298 vbn_prb spk 0.01172f
C299 vbp_st vreset 0.20485f
C300 a_1492_3386# vbn_leak 0.00154f
C301 el a_2128_4314# 0.00535f
C302 sub_b a_188_3512# 0
C303 sub_b a_276_4614# 0
C304 vbp_st en 0.0259f
C305 abus vreset 1.08903f
C306 abus en 0.03072f
C307 a_2128_4314# vreset 0.00906f
C308 a_276_5220# rsel 0
C309 a_2128_4314# en 0
C310 sub_b a_1728_4160# 0.01106f
C311 a_188_3512# aux 0.00143f
C312 a_188_4160# stb 0.08068f
C313 a_276_4614# aux 0
C314 vbp_st vbn_ref 0.02596f
C315 a_188_3512# a_188_184# 0.01184f
C316 a_188_184# a_276_4614# 0.0042f
C317 a_2358_2372# vbp_st 0.00397f
C318 abus vbn_ref 0.26603f
C319 a_1750_1798# vm 0.0033f
C320 el a_1492_3386# 0.17594f
C321 a_2128_4314# vbn_ref 0.00215f
C322 a_2128_4314# a_2358_2372# 0.00876f
C323 sub_b a_3176_4160# 0.00236f
C324 a_276_5220# spk 0.05938f
C325 a_1328_4116# vbp_syn 0.11725f
C326 vbp_st a_1154_2372# 0
C327 a_1492_3386# en 0.01084f
C328 a_3176_4160# aux 0
C329 a_492_184# vbp_syn 0.12894f
C330 a_1492_3386# vbn_ref 0
C331 abus a_2792_4160# 0.00434f
C332 a_2128_4314# a_2792_4160# 0
C333 a_188_3512# vbp_st 0.00243f
C334 a_188_4160# a_1154_2372# 0
C335 mreset sub 0.007f
C336 vbp_st a_276_4614# 0.07066f
C337 a_188_3512# abus 0.0046f
C338 a_188_3512# a_2128_4314# 0.20206f
C339 abus a_276_4614# 0
C340 a_2128_4314# a_276_4614# 0.29188f
C341 vbp_st a_1728_4160# 0.17562f
C342 a_276_5220# a_1328_4116# 0.32208f
C343 abus a_1728_4160# 0.01299f
C344 rsel vbn_leak 0
C345 hold vm 0.09251f
C346 a_2128_4314# a_1728_4160# 0.39687f
C347 a_188_3512# a_188_4160# 0.67601f
C348 vbp_st a_3176_4160# 0
C349 a_492_184# a_276_5220# 0.05024f
C350 a_188_4160# a_276_4614# 0.61928f
C351 a_188_3512# a_1492_3386# 0.95999f
C352 abus a_3176_4160# 0.08963f
C353 a_1492_3386# a_276_4614# 0
C354 spk vbn_leak 0.02085f
C355 el rsel 0.00417f
C356 a_1750_1798# hold 0.01155f
C357 a_1492_3386# a_1728_4160# 0.18096f
C358 rsel en 0.07315f
C359 sub_b a_1136_184# 0.01376f
C360 a_1492_3386# a_3176_4160# 0.00154f
C361 spk stb 0
C362 el spk 0.0524f
C363 mreset a_1154_2372# 0
C364 vsrc vm 0.7072f
C365 rsel vbn_ref 0
C366 a_1136_184# aux 0
C367 spk vreset 0.3535f
C368 spk en 0.08613f
C369 a_1136_184# a_188_184# 0.00189f
C370 a_1328_4116# sta 0
C371 a_1328_4116# sub 0
C372 spk vbn_ref 0.29743f
C373 vsrc a_1750_1798# 0.00133f
C374 a_188_3512# mreset 0.0082f
C375 mreset a_276_4614# 0.02055f
C376 a_492_184# sta 0.07518f
C377 rsel a_2792_4160# 0.00214f
C378 a_2904_4160# vsrc 0
C379 a_1328_4116# stb 0
C380 mreset a_1728_4160# 0
C381 el a_1328_4116# 0
C382 a_188_3512# rsel 0
C383 rsel a_276_4614# 0
C384 a_1136_184# vbp_st 0.18093f
C385 a_1328_4116# vreset 0.05524f
C386 spk a_2792_4160# 0
C387 abus a_1136_184# 0.01103f
C388 a_1328_4116# en 0
C389 a_492_184# stb 0.31991f
C390 a_2128_4314# a_1136_184# 0.10478f
C391 rsel a_1728_4160# 0.00168f
C392 a_188_3512# spk 0.12087f
C393 a_492_184# vreset 0
C394 spk a_276_4614# 0.1022f
C395 vdd vm 0.78951f
C396 rsel a_3176_4160# 0.00887f
C397 a_1728_4160# spk 0.10948f
C398 a_1136_184# a_1492_3386# 0.15833f
C399 a_1328_4116# a_1154_2372# 0
C400 vsrc hold 0
C401 a_3234_1924# vm 0
C402 a_2998_3512# vm 0.01518f
C403 spk a_3176_4160# 0.10825f
C404 vdd a_1750_1798# 0.40846f
C405 a_492_184# a_1154_2372# 0.05992f
C406 a_188_3512# a_1328_4116# 0.07536f
C407 a_1328_4116# a_276_4614# 0.05621f
C408 sub_b vbp_st 0
C409 sub_b abus 0.06516f
C410 sub_b a_2128_4314# 0
C411 a_188_3512# a_492_184# 0.00131f
C412 a_1328_4116# a_1728_4160# 0.76985f
C413 a_492_184# a_276_4614# 0.22371f
C414 vbp_st aux 0.037f
C415 vm vbp_syn 0.39407f
C416 abus aux 0.02195f
C417 a_1328_4116# a_3176_4160# 0
C418 a_2128_4314# aux 0
C419 a_2274_1924# a_1328_4116# 0.00216f
C420 a_492_184# a_1728_4160# 0.00756f
C421 vbn_prb vm 0.01898f
C422 sub_b a_1492_3386# 0.00162f
C423 vdd hold 1.15839f
C424 a_1750_1798# vbp_syn 0.12773f
C425 a_1136_184# rsel 0.0763f
C426 a_188_4160# a_188_184# 0.00348f
C427 a_2904_4160# vbp_syn 0
C428 a_276_5220# vm 0.28789f
C429 abus vbp_st 0.02234f
C430 a_1136_184# spk 0.11427f
C431 a_2128_4314# vbp_st 0.26977f
C432 a_2128_4314# abus 0.00119f
C433 vsrc vdd 0.23389f
C434 a_276_5220# a_1750_1798# 0.15208f
C435 a_1492_3386# vbp_st 0.00215f
C436 abus a_1492_3386# 0
C437 a_2128_4314# a_1492_3386# 0.12349f
C438 hold vbp_syn 0.08367f
C439 vsrc a_2998_3512# 0.09069f
C440 a_1136_184# a_1328_4116# 0.31019f
C441 sub_b rsel 0.06737f
C442 a_188_4160# a_1492_3386# 0.00708f
C443 a_492_184# a_1136_184# 0.02258f
C444 sta vm 0.08135f
C445 rsel aux 0
C446 vm vbn_leak 0.04773f
C447 sub_b spk 0.00492f
C448 a_276_5220# hold 0.01943f
C449 vsrc vbp_syn 0.06201f
C450 spk aux 0.00225f
C451 sta a_1750_1798# 0
C452 vm stb 0.07551f
C453 el vm 0.04456f
C454 a_1750_1798# vbn_leak 0
C455 vbn_prb vsrc 0.02967f
C456 vreset vm 0.26041f
C457 en vm 0.01268f
C458 a_3234_1924# vdd 0.0038f
C459 a_2998_3512# vdd 1.79212f
C460 a_1750_1798# stb 0.00217f
C461 sub_b a_1328_4116# 0
C462 abus rsel 0.0407f
C463 vbn_ref vm 0.01449f
C464 a_2128_4314# rsel 0.00797f
C465 el a_1750_1798# 0
C466 a_188_4160# mreset 0.02393f
C467 a_1750_1798# vreset 0.00361f
C468 a_276_5220# vsrc 0.21615f
C469 vbp_st spk 0.25863f
C470 el a_2904_4160# 0
C471 a_1154_2372# vm 0.00344f
C472 a_1328_4116# a_188_184# 0
C473 abus spk 0.17054f
C474 aux vss 0.42379f
C475 sub vss 0.00938f
C476 vreset vss 1.06861f
C477 vsrc vss 2.74542f
C478 abus vss 3.34071f
C479 vdd vss 22.4882f
C480 a_3234_1924# vss 0.31703f
C481 a_2274_1924# vss 0.54566f
C482 a_492_184# vss 1.16036f
C483 a_1154_2372# vss 0.70921f
C484 a_188_184# vss 1.36731f
C485 a_188_3512# vss 4.57244f
C486 a_1136_184# vss 1.57461f
C487 a_2904_4160# vss 0.91803f
C488 a_2792_4160# vss 0.23623f
C489 a_2128_4314# vss 0.664f
C490 a_3176_4160# vss 0.99181f
C491 a_276_5220# vss 2.12311f
.ends
