* NGSPICE file created from ce1_fb.ext - technology: gf180mcuD

.subckt ce1_fb vss vbp_syn vdd el aux vbn_leak vsrc vbp_st vbn_prb vbn_ref en vreset
+ abus sta stb hold mreset rsel sub sub_b grp_en spk vm
X0 a_2904_1670# a_2574_2878# a_2486_3004# vdd pfet_03v3 ad=0.26p pd=1.52u as=0.44p ps=2.88u w=1u l=2u
X1 a_2574_2878# a_280_1974# vss vss nfet_03v3 ad=0.1516p pd=1.64u as=86.8f ps=0.92u w=0.22u l=3.3u
X2 vss a_276_4459# vss vss nfet_03v3 ad=0.7788p pd=4.42u as=11.8206p ps=63.23u w=1.77u l=3.54u
X3 vss a_280_1974# a_188_2018# vss nfet_03v3 ad=86.8f pd=0.92u as=0.1516p ps=1.64u w=0.22u l=13u
X4 a_188_2018# a_276_6148# a_276_6148# vss nfet_03v3 ad=1.02p pd=3.02u as=1.02p ps=3.02u w=2u l=0.5u
X5 vss stb a_2904_1670# vdd pfet_03v3 ad=0.26p pd=1.52u as=0.26p ps=1.52u w=1u l=0.28u
X6 a_276_6148# a_276_6148# a_188_2018# vss nfet_03v3 ad=1.02p pd=3.02u as=1.38p ps=5.38u w=2u l=0.5u
X7 a_1018_3452# a_1872_1544# a_1826_3452# vdd pfet_03v3 ad=0.44p pd=2.88u as=0.14p ps=1.28u w=1u l=0.28u
X8 vdd a_2574_2878# a_2574_2878# vdd pfet_03v3 ad=0.88p pd=4.88u as=0.88p ps=4.88u w=2u l=1u
X9 a_2218_3004# vbp_st vdd vdd pfet_03v3 ad=0.14p pd=1.28u as=0.26p ps=1.52u w=1u l=2u
X10 a_332_184# grp_en a_188_184# vss nfet_03v3 ad=0.22p pd=1.88u as=0.22p ps=1.88u w=0.5u l=0.28u
X11 vss vm vss vss nfet_03v3 ad=0.9191p pd=4.055u as=0 ps=0 w=3.535u l=7.07u
X12 a_1018_3452# spk vdd vdd pfet_03v3 ad=0.1516p pd=1.64u as=0.1516p ps=1.64u w=0.22u l=1u
X13 vdd a_1018_3452# spk vdd pfet_03v3 ad=0.26p pd=1.52u as=0.44p ps=2.88u w=1u l=0.28u
X14 a_276_4459# a_280_1974# vss vss nfet_03v3 ad=0.13p pd=1.02u as=0.13p ps=1.02u w=0.5u l=1.3u
X15 vdd spk a_266_3452# vdd pfet_03v3 ad=0.26p pd=1.52u as=0.44p ps=2.88u w=1u l=0.28u
X16 a_280_1974# a_576_5641# a_576_5641# vss nfet_03v3 ad=0.1516p pd=1.64u as=0.1516p ps=1.64u w=0.22u l=7u
X17 vss a_488_184# a_488_184# vss nfet_03v3 ad=0.26p pd=1.52u as=0.44p ps=2.88u w=1u l=0.5u
X18 vss a_276_4459# vss vss nfet_03v3 ad=0.4602p pd=2.29u as=0 ps=0 w=1.77u l=3.54u
X19 a_1636_1670# vbp_st vdd vdd pfet_03v3 ad=0.22p pd=1.88u as=0.13p ps=1.02u w=0.5u l=4u
X20 a_280_1974# a_280_1974# vss vss nfet_03v3 ad=0.52p pd=2.52u as=0.88p ps=4.88u w=2u l=1u
X21 vss a_280_1974# a_280_1974# vss nfet_03v3 ad=0.52p pd=2.52u as=0.52p ps=2.52u w=2u l=1u
X22 a_332_184# a_332_184# vss vss nfet_03v3 ad=0.26p pd=1.52u as=0.26p ps=1.52u w=1u l=0.5u
X23 a_2072_184# vm vdd vss nfet_03v3 ad=1.76p pd=8.88u as=1.76p ps=8.88u w=4u l=2u
X24 a_1492_6148# a_2848_6148# a_2848_6148# vss nfet_03v3 ad=1.38p pd=5.38u as=1.02p ps=3.02u w=2u l=0.5u
X25 a_514_2878# a_514_2878# vdd vdd pfet_03v3 ad=0.44p pd=2.88u as=0.26p ps=1.52u w=1u l=2u
X26 a_1872_1544# a_1070_3004# a_488_184# vss nfet_03v3 ad=0.1516p pd=1.64u as=0.1516p ps=1.64u w=0.22u l=2u
X27 vdd vbp_st a_1258_3004# vdd pfet_03v3 ad=0.26p pd=1.52u as=0.14p ps=1.28u w=1u l=2u
X28 a_514_2878# a_576_5641# a_276_6148# vss nfet_03v3 ad=1.02p pd=3.02u as=1.38p ps=5.38u w=2u l=0.5u
X29 a_1070_3004# vm a_332_184# vss nfet_03v3 ad=0.44p pd=2.88u as=0.26p ps=1.52u w=1u l=0.5u
X30 vss grp_en a_188_1670# vss nfet_03v3 ad=0.13p pd=1.02u as=0.22p ps=1.88u w=0.5u l=0.28u
X31 vss vm vss vss nfet_03v3 ad=1.5554p pd=7.95u as=0 ps=0 w=3.535u l=7.07u
X32 a_2848_6148# a_514_2878# vdd vdd pfet_03v3 ad=0.26p pd=1.52u as=0.26p ps=1.52u w=1u l=2u
X33 a_1636_1670# grp_en a_576_5641# vss nfet_03v3 ad=0.22p pd=1.88u as=0.13p ps=1.02u w=0.5u l=0.28u
X34 a_576_5641# a_188_1670# vss vss nfet_03v3 ad=0.13p pd=1.02u as=0.13p ps=1.02u w=0.5u l=0.28u
X35 vss a_280_1974# a_280_1974# vss nfet_03v3 ad=0.52p pd=2.52u as=0.52p ps=2.52u w=2u l=1u
X36 vdd hold a_2486_3004# vdd pfet_03v3 ad=0.44p pd=2.88u as=0.26p ps=1.52u w=1u l=2u
X37 a_576_5641# a_276_4459# vm vss nfet_03v3 ad=0.44p pd=2.88u as=0.44p ps=2.88u w=1u l=0.5u
X38 a_1492_6148# a_1492_6148# a_188_2018# vss nfet_03v3 ad=1.02p pd=3.02u as=1.02p ps=3.02u w=2u l=0.5u
X39 a_276_4459# mreset vdd vss nfet_03v3 ad=0.22p pd=1.88u as=0.13p ps=1.02u w=0.5u l=0.28u
X40 a_188_2018# a_276_6148# a_276_6148# vss nfet_03v3 ad=1.02p pd=3.02u as=1.02p ps=3.02u w=2u l=0.5u
X41 vdd grp_en a_188_1670# vdd pfet_03v3 ad=0.26p pd=1.52u as=0.44p ps=2.88u w=1u l=0.28u
X42 vdd a_188_1670# a_276_4459# vss nfet_03v3 ad=0.13p pd=1.02u as=0.13p ps=1.02u w=0.5u l=0.28u
X43 vm stb a_2904_1670# vss nfet_03v3 ad=0.13p pd=1.02u as=0.22p ps=1.88u w=0.5u l=0.28u
X44 a_1258_3004# vm a_1070_3004# vdd pfet_03v3 ad=0.14p pd=1.28u as=0.44p ps=2.88u w=1u l=0.5u
X45 a_1492_6148# a_1492_6148# a_188_2018# vss nfet_03v3 ad=1.02p pd=3.02u as=1.02p ps=3.02u w=2u l=0.5u
X46 a_2072_184# en a_2888_5187# vss nfet_03v3 ad=0.26p pd=1.52u as=0.44p ps=2.88u w=1u l=0.28u
X47 a_3304_5187# rsel a_3192_5187# vss nfet_03v3 ad=0.14p pd=1.28u as=0.14p ps=1.28u w=1u l=0.28u
X48 vdd vbp_st a_2096_1670# vdd pfet_03v3 ad=0.13p pd=1.02u as=0.22p ps=1.88u w=0.5u l=1u
X49 a_3208_1670# sta vm vss nfet_03v3 ad=0.22p pd=1.88u as=0.13p ps=1.02u w=0.5u l=0.28u
X50 a_3192_5187# en a_2072_184# vss nfet_03v3 ad=0.14p pd=1.28u as=0.26p ps=1.52u w=1u l=0.28u
X51 a_1872_1544# a_1070_3004# a_2218_3004# vdd pfet_03v3 ad=0.44p pd=2.88u as=0.14p ps=1.28u w=1u l=0.28u
X52 a_2848_6148# a_2848_6148# a_1492_6148# vss nfet_03v3 ad=1.02p pd=3.02u as=1.38p ps=5.38u w=2u l=0.5u
X53 vdd vbp_st a_188_184# vdd pfet_03v3 ad=0.26p pd=1.52u as=0.44p ps=2.88u w=1u l=2u
X54 a_2486_3004# a_2574_2878# a_3208_1670# vdd pfet_03v3 ad=0.26p pd=1.52u as=0.26p ps=1.52u w=1u l=2u
X55 a_488_184# a_1872_1544# a_1018_3452# vss nfet_03v3 ad=0.13p pd=1.02u as=0.22p ps=1.88u w=0.5u l=0.28u
X56 a_280_1974# a_280_1974# vss vss nfet_03v3 ad=0.52p pd=2.52u as=0.52p ps=2.52u w=2u l=1u
X57 a_3208_1670# sta vss vdd pfet_03v3 ad=0.26p pd=1.52u as=0.26p ps=1.52u w=1u l=0.28u
X58 a_2096_1670# grp_en a_488_184# vss nfet_03v3 ad=0.22p pd=1.88u as=0.13p ps=1.02u w=0.5u l=0.28u
X59 a_188_2018# a_1492_6148# a_1492_6148# vss nfet_03v3 ad=1.02p pd=3.02u as=1.02p ps=3.02u w=2u l=0.5u
X60 vss a_1018_3452# spk vss nfet_03v3 ad=0.13p pd=1.02u as=0.22p ps=1.88u w=0.5u l=0.28u
X61 a_276_6148# a_276_6148# a_188_2018# vss nfet_03v3 ad=1.02p pd=3.02u as=1.02p ps=3.02u w=2u l=0.5u
X62 abus sub_b a_3304_5187# vss nfet_03v3 ad=0.44p pd=2.88u as=0.14p ps=1.28u w=1u l=0.28u
X63 a_1826_3452# vbp_st vdd vdd pfet_03v3 ad=0.14p pd=1.28u as=0.26p ps=1.52u w=1u l=2u
X64 vm hold a_2848_6148# vdd pfet_03v3 ad=0.44p pd=2.88u as=0.26p ps=1.52u w=1u l=0.28u
X65 a_2888_5187# vbn_prb vss vss nfet_03v3 ad=0.88p pd=4.88u as=0.52p ps=2.52u w=2u l=2u
X66 a_276_4459# a_266_3452# vdd vdd pfet_03v3 ad=0.44p pd=2.88u as=0.26p ps=1.52u w=1u l=0.28u
X67 a_188_2018# a_1492_6148# a_1492_6148# vss nfet_03v3 ad=1.38p pd=5.38u as=1.02p ps=3.02u w=2u l=0.5u
X68 a_266_3452# spk vss vss nfet_03v3 ad=0.22p pd=1.88u as=0.22p ps=1.88u w=0.5u l=0.28u
X69 a_276_6148# a_576_5641# a_514_2878# vss nfet_03v3 ad=1.38p pd=5.38u as=1.02p ps=3.02u w=2u l=0.5u
C0 mreset a_1070_3004# 0.00125f
C1 mreset vdd 0.34602f
C2 a_488_184# a_1872_1544# 0.13447f
C3 a_188_184# a_1872_1544# 0.1013f
C4 el a_1070_3004# 0
C5 spk a_1872_1544# 0.00395f
C6 el vdd 1.41047f
C7 stb hold 0.01908f
C8 abus el 0.02302f
C9 a_576_5641# a_188_2018# 0.25991f
C10 sta aux 0
C11 en a_280_1974# 0.00502f
C12 vbn_ref vbp_st 0.01253f
C13 rsel a_2888_5187# 0.00401f
C14 vbn_prb a_2888_5187# 0.21339f
C15 stb vm 0.39977f
C16 spk a_2888_5187# 0.09304f
C17 mreset a_1872_1544# 0
C18 hold a_2486_3004# 0.20337f
C19 a_1636_1670# a_1018_3452# 0.23051f
C20 el a_1872_1544# 0
C21 grp_en a_2574_2878# 0
C22 vreset en 1.23609f
C23 hold a_2904_1670# 0
C24 vsrc vbn_leak 1.23275f
C25 vm a_2486_3004# 0.00939f
C26 sta rsel 0
C27 a_488_184# sta 0.00202f
C28 a_576_5641# a_1018_3452# 0.19418f
C29 grp_en a_2096_1670# 0.0221f
C30 sta vbn_prb 0.01985f
C31 spk sta 0.39004f
C32 a_1492_6148# vsrc 0
C33 el a_2888_5187# 0.00262f
C34 a_3208_1670# en 0
C35 vm a_2904_1670# 0.03965f
C36 hold aux 0.03395f
C37 grp_en a_266_3452# 0.06936f
C38 en vdd 0.13111f
C39 abus en 0.07513f
C40 spk a_276_6148# 0.03113f
C41 vm aux 0.0407f
C42 sub a_514_2878# 0
C43 sta el 0
C44 a_1492_6148# vbp_syn 0.00281f
C45 sub_b vdd 0.00131f
C46 abus sub_b 0.04582f
C47 a_280_1974# vsrc 0
C48 sub a_2072_184# 0
C49 hold rsel 0.04483f
C50 a_3304_5187# a_2848_6148# 0
C51 mreset a_276_6148# 0.00746f
C52 grp_en a_514_2878# 0.19786f
C53 a_1636_1670# a_2574_2878# 0.01518f
C54 a_1492_6148# vbn_leak 0
C55 hold vbn_prb 0.18929f
C56 spk hold 0.07302f
C57 sub vbp_st 0.00874f
C58 a_276_4459# a_280_1974# 0.45282f
C59 vm rsel 0
C60 grp_en a_2072_184# 0.00456f
C61 a_488_184# vm 0.31412f
C62 vm a_188_184# 0.02492f
C63 a_1636_1670# a_2096_1670# 0.52434f
C64 vm vbn_prb 0.02351f
C65 spk vm 6.36688f
C66 en a_2888_5187# 0.01406f
C67 vbp_syn a_280_1974# 0.0069f
C68 grp_en vbp_st 0
C69 vm a_332_184# 0.09232f
C70 a_576_5641# a_2096_1670# 0.00226f
C71 a_3208_1670# vsrc 0
C72 sub_b a_2888_5187# 0.00388f
C73 hold el 0.09024f
C74 a_3304_5187# a_2072_184# 0.00302f
C75 mreset vm 0.00292f
C76 a_1636_1670# a_2848_6148# 0.07203f
C77 a_280_1974# vbn_leak 0
C78 a_576_5641# a_266_3452# 0
C79 vdd vsrc 0.08555f
C80 vm el 0.0379f
C81 abus vsrc 0.02326f
C82 a_1492_6148# a_280_1974# 0
C83 a_576_5641# a_2848_6148# 0.02024f
C84 a_576_5641# a_3192_5187# 0
C85 a_3208_1670# vbp_syn 0.04813f
C86 a_1636_1670# a_514_2878# 0.21233f
C87 a_1070_3004# a_276_4459# 0.01961f
C88 vdd a_276_4459# 0.98915f
C89 vbp_syn a_1070_3004# 0
C90 a_1636_1670# a_2072_184# 0.11441f
C91 a_576_5641# a_514_2878# 0.28051f
C92 a_3208_1670# vbn_leak 0
C93 vdd vbp_syn 1.43234f
C94 abus vbp_syn 0.02286f
C95 a_576_5641# a_2072_184# 0.00219f
C96 a_1636_1670# vbp_st 0.2675f
C97 a_2888_5187# vsrc 0
C98 a_1872_1544# a_276_4459# 0
C99 vdd vbn_leak 0.1f
C100 hold en 0
C101 abus vbn_leak 0.02329f
C102 a_2486_3004# a_1018_3452# 0
C103 a_576_5641# vbp_st 0.15033f
C104 a_1492_6148# vdd 0.00256f
C105 vbp_syn a_1872_1544# 0
C106 vreset a_280_1974# 0
C107 hold sub_b 0
C108 en vm 0.01326f
C109 a_2888_5187# a_276_4459# 0
C110 sta vsrc 0
C111 a_1872_1544# vbn_leak 0
C112 a_3208_1670# a_280_1974# 0.03142f
C113 vbp_syn a_2888_5187# 0.01705f
C114 grp_en a_188_1670# 0.41736f
C115 a_1826_3452# a_280_1974# 0.00492f
C116 a_188_184# a_188_2018# 0.00951f
C117 a_1070_3004# a_280_1974# 0.15766f
C118 spk a_188_2018# 0.39487f
C119 sta a_276_4459# 0
C120 vdd a_280_1974# 0.30388f
C121 a_2888_5187# vbn_leak 0.00106f
C122 stb a_2574_2878# 0.13048f
C123 a_1492_6148# a_2888_5187# 0
C124 sta vbp_syn 0.28158f
C125 mreset a_188_2018# 0.01862f
C126 stb a_2096_1670# 0.07375f
C127 vreset vdd 0.09751f
C128 a_2486_3004# a_2574_2878# 0.27195f
C129 a_276_6148# a_276_4459# 0.0115f
C130 vreset abus 1.25948f
C131 a_488_184# a_1018_3452# 0.05224f
C132 sta vbn_leak 0
C133 a_1872_1544# a_280_1974# 0.31181f
C134 a_188_184# a_1018_3452# 0.11719f
C135 hold vsrc 0.00381f
C136 spk a_1018_3452# 0.39352f
C137 a_3208_1670# a_1070_3004# 0
C138 a_2904_1670# a_2574_2878# 0.33475f
C139 a_2486_3004# a_2096_1670# 0.0069f
C140 a_3208_1670# vdd 0.06914f
C141 stb a_2848_6148# 0.06236f
C142 vm vsrc 0.08302f
C143 a_2888_5187# a_280_1974# 0.18799f
C144 hold a_276_4459# 0
C145 vdd a_1826_3452# 0
C146 a_2904_1670# a_2096_1670# 0
C147 mreset a_1018_3452# 0.11351f
C148 a_188_1670# a_1636_1670# 0
C149 vdd a_1070_3004# 0.45899f
C150 abus vdd 0.10617f
C151 a_2574_2878# aux 0
C152 hold vbp_syn 0.07017f
C153 a_576_5641# a_188_1670# 0.09754f
C154 a_1492_6148# a_276_6148# 0.01893f
C155 vm a_276_4459# 0.09735f
C156 a_3208_1670# a_1872_1544# 0
C157 stb a_514_2878# 0.09403f
C158 vreset a_2888_5187# 0
C159 a_2096_1670# aux 0.00202f
C160 sta a_280_1974# 0.05227f
C161 a_2904_1670# a_2848_6148# 0
C162 vm vbp_syn 0.38905f
C163 hold vbn_leak 0.00725f
C164 stb a_2072_184# 0.33558f
C165 a_1070_3004# a_1872_1544# 0.42056f
C166 vdd a_1872_1544# 0.39069f
C167 a_2486_3004# a_514_2878# 0
C168 vdd a_2218_3004# 0.00518f
C169 en a_188_2018# 0
C170 a_488_184# a_2574_2878# 0
C171 vm vbn_leak 0.04587f
C172 stb vbp_st 0.00124f
C173 a_2848_6148# aux 0
C174 vbn_prb a_2574_2878# 0.00885f
C175 spk a_2574_2878# 0.05456f
C176 a_2904_1670# a_514_2878# 0.00523f
C177 a_2486_3004# a_2072_184# 0.06727f
C178 vdd a_2888_5187# 0.01185f
C179 rsel a_2096_1670# 0
C180 abus a_2888_5187# 0
C181 a_488_184# a_2096_1670# 0.11459f
C182 a_188_184# a_2096_1670# 0.06266f
C183 vbn_prb a_2096_1670# 0.00185f
C184 a_3208_1670# sta 0.33256f
C185 spk a_2096_1670# 0.09311f
C186 a_2486_3004# vbp_st 0.00779f
C187 a_2904_1670# a_2072_184# 0.01727f
C188 vbn_ref a_1636_1670# 0.06423f
C189 a_2218_3004# a_1872_1544# 0.01419f
C190 hold a_280_1974# 0.03221f
C191 rsel a_3192_5187# 0.00155f
C192 sta a_1070_3004# 0
C193 rsel a_2848_6148# 0.00444f
C194 a_188_184# a_266_3452# 0
C195 el a_2574_2878# 0
C196 spk a_266_3452# 0.27272f
C197 sta vdd 0.43365f
C198 a_188_184# a_2848_6148# 0
C199 vbn_prb a_2848_6148# 0
C200 spk a_2848_6148# 0.25076f
C201 a_2072_184# aux 0
C202 vm a_280_1974# 0.09049f
C203 el a_2096_1670# 0.00504f
C204 vreset hold 0
C205 vbp_st aux 0.0615f
C206 mreset a_266_3452# 0.0025f
C207 a_188_184# a_514_2878# 0.16884f
C208 sta a_1872_1544# 0.00123f
C209 spk a_514_2878# 0.32245f
C210 vreset vm 0.01102f
C211 a_3208_1670# hold 0.11378f
C212 el a_2848_6148# 0
C213 rsel a_2072_184# 0.03385f
C214 a_488_184# a_2072_184# 0.02093f
C215 a_188_184# a_2072_184# 0
C216 vbn_prb a_2072_184# 0.01063f
C217 spk a_2072_184# 0.02548f
C218 sta a_2888_5187# 0.07059f
C219 a_3208_1670# vm 0.20156f
C220 hold a_1070_3004# 0
C221 vbp_st rsel 0.02675f
C222 mreset a_514_2878# 0.20618f
C223 hold vdd 0.95991f
C224 a_488_184# vbp_st 0
C225 abus hold 0.00117f
C226 a_188_184# vbp_st 0.18795f
C227 vbn_prb vbp_st 1.2911f
C228 a_276_4459# a_188_2018# 0.17036f
C229 spk vbp_st 0.61988f
C230 en a_2574_2878# 0
C231 vm a_1070_3004# 0.79272f
C232 vm vdd 0.55925f
C233 abus vm 0.00291f
C234 el a_2072_184# 0
C235 en a_2096_1670# 0
C236 mreset vbp_st 0.00179f
C237 hold a_1872_1544# 0
C238 el vbp_st 0.05893f
C239 a_576_5641# sub 0.01777f
C240 a_1018_3452# a_276_4459# 0.11024f
C241 grp_en a_1636_1670# 0.04286f
C242 a_1492_6148# a_188_2018# 0.7412f
C243 vm a_1872_1544# 0.1405f
C244 en a_3192_5187# 0.00224f
C245 hold a_2888_5187# 0.08016f
C246 en a_2848_6148# 0.10504f
C247 grp_en a_576_5641# 0.30769f
C248 vm a_2888_5187# 0
C249 sub_b a_3192_5187# 0.00301f
C250 sub_b a_2848_6148# 0.00552f
C251 hold sta 0.32449f
C252 a_576_5641# a_3304_5187# 0
C253 a_280_1974# a_188_2018# 0.04681f
C254 a_2574_2878# vsrc 0
C255 en a_2072_184# 0.08009f
C256 vm sta 0.44412f
C257 vbn_ref a_2486_3004# 0
C258 a_2096_1670# vsrc 0
C259 en vbp_st 0.37625f
C260 sub_b a_2072_184# 0.01641f
C261 a_488_184# a_188_1670# 0
C262 a_188_1670# a_188_184# 0.20522f
C263 spk a_188_1670# 0.00298f
C264 sub_b vbp_st 0
C265 a_1018_3452# a_280_1974# 0.546f
C266 vbp_syn a_2574_2878# 0.19724f
C267 a_2096_1670# a_276_4459# 0
C268 a_576_5641# a_1636_1670# 0.08822f
C269 a_332_184# a_188_1670# 0.00592f
C270 vsrc a_2848_6148# 0
C271 mreset a_188_1670# 0.11758f
C272 vbp_syn a_2096_1670# 0.07707f
C273 a_2574_2878# vbn_leak 0
C274 vdd a_188_2018# 0.16371f
C275 a_266_3452# a_276_4459# 0.32886f
C276 hold vm 0.10183f
C277 a_276_4459# a_2848_6148# 0
C278 a_2096_1670# vbn_leak 0.00125f
C279 vbp_syn a_2848_6148# 0.00141f
C280 a_2072_184# vsrc 0
C281 a_1826_3452# a_1018_3452# 0.0073f
C282 a_1872_1544# a_188_2018# 0
C283 a_276_4459# a_514_2878# 0.20389f
C284 a_1070_3004# a_1018_3452# 0.12317f
C285 vbn_ref vbn_prb 1.23617f
C286 a_2848_6148# vbn_leak 0
C287 vdd a_1018_3452# 0.71402f
C288 vbn_ref spk 0.00745f
C289 vbp_st vsrc 1.3033f
C290 a_1492_6148# a_2848_6148# 0.42897f
C291 vbp_syn a_514_2878# 0
C292 a_276_4459# a_2072_184# 0
C293 a_2574_2878# a_280_1974# 0.12557f
C294 grp_en stb 0
C295 vbp_syn a_2072_184# 0
C296 vbp_st a_276_4459# 0.0434f
C297 a_2096_1670# a_280_1974# 0.08363f
C298 a_1018_3452# a_1872_1544# 0.12175f
C299 vreset a_2574_2878# 0
C300 vbp_syn vbp_st 0.02762f
C301 a_2072_184# vbn_leak 0
C302 a_266_3452# a_280_1974# 0
C303 a_280_1974# a_2848_6148# 0.31733f
C304 a_3208_1670# a_2574_2878# 0.23758f
C305 vbp_st vbn_leak 0.06683f
C306 a_1492_6148# vbp_st 0.12224f
C307 a_1070_3004# a_2574_2878# 0.01029f
C308 a_276_6148# a_188_2018# 0.93001f
C309 vdd a_2574_2878# 1.44238f
C310 abus a_2574_2878# 0
C311 a_1258_3004# a_280_1974# 0
C312 a_280_1974# a_514_2878# 0.12377f
C313 a_2096_1670# a_1826_3452# 0
C314 a_1070_3004# a_2096_1670# 0.25695f
C315 vdd a_2096_1670# 0.44105f
C316 stb a_1636_1670# 0.09814f
C317 a_2072_184# a_280_1974# 0.0972f
C318 spk sub 0.01786f
C319 vbn_ref en 1.263f
C320 a_1872_1544# a_2574_2878# 0.09117f
C321 vdd a_266_3452# 0.32409f
C322 vbp_st a_280_1974# 0.77669f
C323 a_2486_3004# a_1636_1670# 0.02616f
C324 vdd a_2848_6148# 0.2408f
C325 vm a_188_2018# 0
C326 abus a_3192_5187# 0.00194f
C327 grp_en a_488_184# 0.28983f
C328 vbn_ref sub_b 0
C329 a_2096_1670# a_1872_1544# 0.17156f
C330 grp_en a_188_184# 0.29463f
C331 grp_en spk 0.16315f
C332 a_2218_3004# a_2096_1670# 0.00182f
C333 a_1636_1670# a_2904_1670# 0.00449f
C334 a_576_5641# a_2486_3004# 0
C335 a_2888_5187# a_2574_2878# 0.00126f
C336 grp_en a_332_184# 0.02563f
C337 vreset vbp_st 0
C338 a_1826_3452# a_514_2878# 0
C339 a_1070_3004# a_1258_3004# 0.01118f
C340 a_3208_1670# a_2072_184# 0
C341 a_1070_3004# a_514_2878# 0.07462f
C342 a_188_1670# a_276_4459# 0.06568f
C343 a_266_3452# a_1872_1544# 0
C344 a_2096_1670# a_2888_5187# 0
C345 rsel a_3304_5187# 0.00178f
C346 vdd a_514_2878# 1.34991f
C347 vdd a_1258_3004# 0.0025f
C348 grp_en mreset 0.30362f
C349 a_1872_1544# a_2848_6148# 0
C350 a_1636_1670# aux 0.03029f
C351 a_3208_1670# vbp_st 0
C352 vm a_1018_3452# 0.21977f
C353 sta a_2574_2878# 0.47299f
C354 a_1070_3004# a_2072_184# 0.32562f
C355 vdd a_2072_184# 0.16392f
C356 abus a_2072_184# 0.00997f
C357 a_576_5641# aux 0
C358 vbp_st a_1826_3452# 0.00154f
C359 a_2888_5187# a_2848_6148# 0.16313f
C360 a_3192_5187# a_2888_5187# 0
C361 sta a_2096_1670# 0.06853f
C362 vbp_st a_1070_3004# 0.18664f
C363 vdd vbp_st 3.69222f
C364 a_1872_1544# a_514_2878# 0.03573f
C365 abus vbp_st 0.0241f
C366 a_1636_1670# rsel 0
C367 a_488_184# a_1636_1670# 0.00274f
C368 a_1636_1670# a_188_184# 0.00237f
C369 a_1872_1544# a_2072_184# 0.20432f
C370 vbn_prb a_1636_1670# 0.21895f
C371 spk a_1636_1670# 0.04597f
C372 a_2218_3004# a_2072_184# 0
C373 a_2888_5187# a_514_2878# 0.00529f
C374 sta a_2848_6148# 0
C375 a_576_5641# rsel 0
C376 a_576_5641# a_188_184# 0.03782f
C377 a_488_184# a_576_5641# 0.06645f
C378 vbp_st a_1872_1544# 0.31726f
C379 spk a_576_5641# 0.60676f
C380 a_2888_5187# a_2072_184# 0.12413f
C381 hold a_2574_2878# 0.39898f
C382 a_332_184# a_576_5641# 0
C383 a_276_6148# a_266_3452# 0.03465f
C384 a_188_1670# a_280_1974# 0.06072f
C385 vbp_st a_2888_5187# 0.01354f
C386 el a_1636_1670# 0.03363f
C387 hold a_2096_1670# 0.05743f
C388 vm a_2574_2878# 0.35367f
C389 mreset a_576_5641# 0.00261f
C390 sta a_2072_184# 0.1882f
C391 a_576_5641# el 0
C392 vm a_2096_1670# 0.00544f
C393 hold a_2848_6148# 0.01812f
C394 vbn_ref a_1492_6148# 0
C395 sta vbp_st 0.00173f
C396 a_276_6148# a_514_2878# 0.17945f
C397 sub_b a_3304_5187# 0.00789f
C398 vm a_2848_6148# 0.06162f
C399 stb a_2486_3004# 0.05727f
C400 hold a_514_2878# 0.0262f
C401 a_188_1670# a_1070_3004# 0.00251f
C402 a_276_6148# vbp_st 0
C403 vdd a_188_1670# 0.45619f
C404 stb a_2904_1670# 0.20038f
C405 a_1018_3452# a_188_2018# 0
C406 vbn_ref a_280_1974# 0
C407 en a_1636_1670# 0.03049f
C408 hold a_2072_184# 0.15068f
C409 vm a_1258_3004# 0
C410 vm a_514_2878# 0.01852f
C411 a_2486_3004# a_2904_1670# 0.06008f
C412 sub a_276_4459# 0.00234f
C413 hold vbp_st 0.01356f
C414 en a_576_5641# 0.00103f
C415 vm a_2072_184# 0.43142f
C416 a_188_1670# a_1872_1544# 0
C417 vm vbp_st 0.11643f
C418 sub_b a_576_5641# 0
C419 grp_en a_276_4459# 0.74721f
C420 a_2486_3004# aux 0.00142f
C421 vbn_ref a_3208_1670# 0
C422 stb a_488_184# 0
C423 spk stb 0
C424 vbn_ref vdd 0.07446f
C425 vbn_ref abus 0.02331f
C426 a_2486_3004# a_188_184# 0.00101f
C427 vbn_prb a_2486_3004# 0
C428 spk a_2486_3004# 0.00216f
C429 a_1636_1670# vsrc 0.02905f
C430 a_488_184# a_2904_1670# 0
C431 sub a_280_1974# 0
C432 a_266_3452# a_188_2018# 0.19908f
C433 a_1636_1670# a_276_4459# 0
C434 a_2848_6148# a_188_2018# 0
C435 rsel aux 0
C436 vbn_ref a_2888_5187# 0
C437 el a_2486_3004# 0.00286f
C438 vbn_prb aux 0.02783f
C439 grp_en a_280_1974# 0.18956f
C440 spk aux 0.1049f
C441 a_2096_1670# a_1018_3452# 0.17689f
C442 a_1636_1670# vbp_syn 0.03129f
C443 a_576_5641# a_276_4459# 0.28126f
C444 a_576_5641# vbp_syn 0
C445 a_514_2878# a_188_2018# 0.19808f
C446 a_1636_1670# vbn_leak 0.02901f
C447 a_266_3452# a_1018_3452# 0.00154f
C448 vm a_188_1670# 0.01005f
C449 a_1018_3452# a_2848_6148# 0
C450 el aux 1.23275f
C451 vbn_prb rsel 0.00682f
C452 spk rsel 0.15215f
C453 a_488_184# a_188_184# 0.07993f
C454 spk a_188_184# 0.15698f
C455 spk a_488_184# 0.00648f
C456 spk vbn_prb 0.04945f
C457 a_1492_6148# a_576_5641# 0.01921f
C458 stb en 0.00306f
C459 vbp_st a_188_2018# 0.00632f
C460 a_488_184# a_332_184# 0.17391f
C461 a_332_184# a_188_184# 0.08852f
C462 a_1018_3452# a_514_2878# 0.0781f
C463 mreset a_488_184# 0
C464 grp_en a_1070_3004# 0.08247f
C465 mreset a_188_184# 0.17996f
C466 grp_en vdd 0.39283f
C467 en a_2486_3004# 0
C468 spk mreset 0.17656f
C469 el rsel 0
C470 a_1018_3452# a_2072_184# 0
C471 a_1636_1670# a_280_1974# 0.13381f
C472 el vbn_prb 0.02744f
C473 mreset a_332_184# 0.00302f
C474 a_2096_1670# a_2574_2878# 0.08233f
C475 spk el 0.29471f
C476 vbn_ref hold 0.00107f
C477 a_576_5641# a_280_1974# 0.38496f
C478 vbp_st a_1018_3452# 0.45273f
C479 abus a_3304_5187# 0.00254f
C480 vbn_ref vm 0.01603f
C481 grp_en a_1872_1544# 0.14706f
C482 vreset a_1636_1670# 0.00712f
C483 a_2574_2878# a_2848_6148# 0.00273f
C484 en aux 0.02484f
C485 a_2096_1670# a_2848_6148# 0.02062f
C486 sub_b aux 0
C487 a_2574_2878# a_514_2878# 0.01604f
C488 a_1636_1670# a_1070_3004# 0.07871f
C489 vdd a_1636_1670# 0.51276f
C490 abus a_1636_1670# 0.00373f
C491 en rsel 0.09434f
C492 a_3304_5187# a_2888_5187# 0
C493 a_3192_5187# a_2848_6148# 0
C494 a_2096_1670# a_1258_3004# -0
C495 a_2096_1670# a_514_2878# 0.11174f
C496 a_2574_2878# a_2072_184# 0.24114f
C497 a_576_5641# a_1070_3004# 0.15048f
C498 a_576_5641# vdd 0.2423f
C499 en vbn_prb 0.03033f
C500 spk en 0.06495f
C501 a_2486_3004# vsrc 0
C502 stb a_276_4459# 0
C503 abus a_576_5641# 0
C504 sub_b rsel 0.09682f
C505 a_2096_1670# a_2072_184# 0.18382f
C506 vbp_st a_2574_2878# 0.00184f
C507 a_188_1670# a_188_2018# 0.17484f
C508 sub_b vbn_prb 0.00298f
C509 spk sub_b 0.0017f
C510 a_266_3452# a_514_2878# 0.00289f
C511 stb vbp_syn 0.00183f
C512 a_1636_1670# a_1872_1544# 0.25568f
C513 a_1636_1670# a_2218_3004# 0.00256f
C514 a_514_2878# a_2848_6148# 0.30751f
C515 vbp_st a_2096_1670# 0.11536f
C516 grp_en a_276_6148# 0.03038f
C517 a_576_5641# a_1872_1544# 0.00571f
C518 en el 0.02445f
C519 a_2486_3004# vbp_syn 0.06396f
C520 a_3192_5187# a_2072_184# 0.00575f
C521 a_2072_184# a_2848_6148# 0.03011f
C522 a_1636_1670# a_2888_5187# 0.12078f
C523 sub_b el 0
C524 a_1258_3004# a_514_2878# 0
C525 vbp_st a_3192_5187# 0
C526 a_576_5641# a_2888_5187# 0.01504f
C527 vbp_syn a_2904_1670# 0
C528 vbp_st a_2848_6148# 0.36086f
C529 a_188_1670# a_1018_3452# 0.04138f
C530 a_2486_3004# vbn_leak 0
C531 a_2072_184# a_514_2878# 0.01582f
C532 sta a_1636_1670# 0.0359f
C533 grp_en vm 0.15075f
C534 rsel vsrc 0
C535 vbp_st a_1258_3004# 0
C536 vbn_prb vsrc 0.02796f
C537 vbp_st a_514_2878# 0.29053f
C538 spk vsrc 0.02569f
C539 stb a_280_1974# 0.1108f
C540 vbn_leak aux 1.23275f
C541 vbp_st a_2072_184# 0.00203f
C542 a_488_184# a_276_4459# 0.02501f
C543 a_188_184# a_276_4459# 0.09405f
C544 a_1492_6148# aux 0
C545 spk a_276_4459# 0.3371f
C546 a_2486_3004# a_280_1974# 0.26071f
C547 vbp_syn rsel 0
C548 a_276_6148# a_576_5641# 0.22877f
C549 a_332_184# a_276_4459# 0
C550 en sub_b 0.02929f
C551 vbn_prb vbp_syn 0.02192f
C552 a_2904_1670# a_280_1974# 0.06244f
C553 spk vbp_syn 0.66229f
C554 hold a_1636_1670# 0.02395f
C555 mreset a_276_4459# 0.39698f
C556 rsel vbn_leak 0
C557 a_3208_1670# stb 0.0013f
C558 vreset a_2486_3004# 0
C559 vbn_prb vbn_leak 0.02785f
C560 spk vbn_leak 0.04829f
C561 vm a_1636_1670# 0.09021f
C562 a_280_1974# aux 0
C563 stb a_1070_3004# 0.00713f
C564 a_1492_6148# vbn_prb 0
C565 stb vdd 0.25546f
C566 spk a_1492_6148# 0.25471f
C567 a_3208_1670# a_2486_3004# 0.02631f
C568 vm a_576_5641# 0.28789f
C569 a_188_1670# a_266_3452# 0.0044f
C570 a_3208_1670# a_2904_1670# 0
C571 a_2486_3004# a_1070_3004# 0.01683f
C572 vdd a_2486_3004# 0.32031f
C573 abus a_2486_3004# 0
C574 a_2904_1670# a_1070_3004# 0.00143f
C575 stb a_1872_1544# 0.05872f
C576 a_1492_6148# el 0
C577 a_488_184# a_280_1974# 0.00824f
C578 vdd a_2904_1670# 0.0809f
C579 a_188_184# a_280_1974# 0.24487f
C580 stb a_2218_3004# 0
C581 en vsrc 0.02484f
C582 vbn_prb a_280_1974# 0.0119f
C583 a_3208_1670# aux 0
C584 spk a_280_1974# 0.13581f
C585 vbn_ref a_2574_2878# 0
C586 a_188_1670# a_514_2878# 0
C587 stb a_2888_5187# 0.08107f
C588 a_332_184# a_280_1974# 0
C589 a_2486_3004# a_1872_1544# 0.09243f
C590 sub_b vsrc 0
C591 a_1070_3004# aux 0
C592 grp_en a_188_2018# 0.34426f
C593 vdd aux 0.09576f
C594 a_188_1670# a_2072_184# 0
C595 abus aux 0.02334f
C596 mreset a_280_1974# 0.03778f
C597 vbn_ref a_2096_1670# 0
C598 vreset vbn_prb 0
C599 vreset spk 0.00432f
C600 a_2904_1670# a_1872_1544# 0.03689f
C601 el a_280_1974# 0
C602 en vbp_syn 0.02785f
C603 stb sta 0.10787f
C604 a_3208_1670# vbn_prb 0
C605 spk a_3208_1670# 0
C606 vbn_ref a_2848_6148# 0
C607 a_2904_1670# a_2888_5187# 0
C608 sub_b vbp_syn 0.00107f
C609 a_1872_1544# aux 0
C610 vdd rsel 0.00116f
C611 en vbn_leak 0.02483f
C612 a_188_184# a_1826_3452# 0
C613 a_488_184# a_1070_3004# 0.3572f
C614 grp_en a_1018_3452# 0.01871f
C615 spk a_1826_3452# 0
C616 abus rsel 0.04939f
C617 a_188_184# a_1070_3004# 0.14523f
C618 a_488_184# vdd 0.05111f
C619 vdd a_188_184# 0.38619f
C620 spk a_1070_3004# 0.10334f
C621 vbn_prb vdd 0.13374f
C622 sta a_2486_3004# 0.10624f
C623 spk vdd 1.45976f
C624 a_1492_6148# en 0.0051f
C625 abus vbn_prb 0.02551f
C626 spk abus 0.02804f
C627 sub_b vbn_leak 0
C628 a_332_184# a_1070_3004# 0.04691f
C629 a_2888_5187# aux 0.00159f
C630 a_332_184# vdd 0.00754f
C631 sta a_2904_1670# 0.00724f
C632 a_1492_6148# sub_b 0
C633 a_3208_1670# el 0
C634 vreset vss 0.61498f
C635 vbn_ref vss 0.55773f
C636 vsrc vss 0.52706f
C637 vbn_leak vss 0.53059f
C638 aux vss 0.52968f
C639 el vss 0.50417f
C640 vbp_syn vss 0.52387f
C641 sub vss 0.01476f
C642 vm vss 0.36621f
C643 abus vss 3.37168f
C644 vdd vss 28.39752f
C645 a_488_184# vss 0.85812f
C646 a_3208_1670# vss 0.69905f
C647 a_2904_1670# vss 0.7611f
C648 a_2486_3004# vss 0.95038f
C649 a_2218_3004# vss 0.93572f
C650 a_1636_1670# vss 0.62983f
C651 a_2096_1670# vss 0.28965f
C652 a_188_184# vss 1.94036f
C653 a_1826_3452# vss 0.26245f
C654 a_276_4459# vss 0.79739f
C655 a_3304_5187# vss 0.29147f
C656 a_3192_5187# vss 0.1953f
C657 a_2072_184# vss 1.45935f
C658 a_2888_5187# vss 1.78421f
C659 a_514_2878# vss 0.35013f
C660 a_266_3452# vss 0.07151f
C661 a_188_2018# vss 3.85808f
C662 a_276_6148# vss 0.35013f
.ends
