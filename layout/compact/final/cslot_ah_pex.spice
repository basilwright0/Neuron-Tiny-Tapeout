* NGSPICE file created from cslot_ah.ext - technology: gf180mcuD

.subckt cslot_ah vss vbp_syn vdd el aux vbn_leak vsrc vbp_st vbn_prb vbn_ref en vreset
+ abus sta stb hold mreset rsel sub sub_b spk vm
X0 a_346_1676# vm a_1370_1924# vdd pfet_03v3 ad=0.44p pd=2.88u as=0.14p ps=1.28u w=1u l=0.5u
X1 a_276_5174# el a_2826_2328# vss nfet_03v3 ad=1.38p pd=5.38u as=1.02p ps=3.02u w=2u l=0.5u
X2 a_1824_184# sta vss vdd pfet_03v3 ad=0.44p pd=2.88u as=0.26p ps=1.52u w=1u l=0.28u
X3 a_2040_4614# a_2040_4614# a_1492_5174# vss nfet_03v3 ad=1.02p pd=3.02u as=1.38p ps=5.38u w=2u l=0.5u
X4 vdd mreset a_276_4116# vss nfet_03v3 ad=0.22p pd=1.88u as=0.22p ps=1.88u w=0.5u l=0.28u
X5 vdd spk a_188_3812# vdd pfet_03v3 ad=0.1516p pd=1.64u as=0.1516p ps=1.64u w=0.22u l=1u
X6 a_1492_5174# a_1492_5174# a_188_5300# vss nfet_03v3 ad=1.02p pd=3.02u as=1.02p ps=3.02u w=2u l=0.5u
X7 a_676_184# vm vdd vss nfet_03v3 ad=1.76p pd=8.88u as=1.76p ps=8.88u w=4u l=2u
X8 vreset a_276_4116# vm vss nfet_03v3 ad=0.44p pd=2.88u as=0.44p ps=2.88u w=1u l=0.5u
X9 vss vm vss vss nfet_03v3 ad=0.9191p pd=4.055u as=9.607p ps=49.39u w=3.535u l=7.07u
X10 a_188_5300# a_276_5174# a_276_5174# vss nfet_03v3 ad=1.02p pd=3.02u as=1.02p ps=3.02u w=2u l=0.5u
X11 vss a_276_4116# vss vss nfet_03v3 ad=0.7788p pd=4.42u as=0 ps=0 w=1.77u l=3.54u
X12 vm stb a_1520_184# vss nfet_03v3 ad=0.13p pd=1.02u as=0.22p ps=1.88u w=0.5u l=0.28u
X13 a_1492_5174# a_1492_5174# a_188_5300# vss nfet_03v3 ad=1.02p pd=3.02u as=1.02p ps=3.02u w=2u l=0.5u
X14 vss vbn_leak a_188_5300# vss nfet_03v3 ad=0.52p pd=2.52u as=0.77p ps=2.77u w=2u l=4u
X15 vss vbn_ref a_276_4116# vss nfet_03v3 ad=0.88p pd=4.88u as=0.88p ps=4.88u w=2u l=4u
X16 vdd vbp_st a_410_1924# vdd pfet_03v3 ad=0.26p pd=1.52u as=0.14p ps=1.28u w=1u l=2u
X17 vsrc vm a_346_1676# vss nfet_03v3 ad=0.44p pd=2.88u as=0.44p ps=2.88u w=1u l=0.5u
X18 vsrc a_266_1924# a_188_3812# vss nfet_03v3 ad=0.22p pd=1.88u as=0.22p ps=1.88u w=0.5u l=0.28u
X19 a_1370_1924# vbp_st vdd vdd pfet_03v3 ad=0.14p pd=1.28u as=0.26p ps=1.52u w=1u l=2u
X20 a_1492_5174# a_2040_4614# a_2040_4614# vss nfet_03v3 ad=1.38p pd=5.38u as=1.02p ps=3.02u w=2u l=0.5u
X21 vsrc a_346_1676# a_266_1924# vss nfet_03v3 ad=0.1516p pd=1.64u as=0.1516p ps=1.64u w=0.22u l=2u
X22 a_410_1924# a_346_1676# a_266_1924# vdd pfet_03v3 ad=0.14p pd=1.28u as=0.44p ps=2.88u w=1u l=0.28u
X23 vss stb a_1520_184# vdd pfet_03v3 ad=0.26p pd=1.52u as=0.44p ps=2.88u w=1u l=0.28u
X24 a_3004_4160# en a_676_184# vss nfet_03v3 ad=0.14p pd=1.28u as=0.26p ps=1.52u w=1u l=0.28u
X25 a_1824_184# sta vm vss nfet_03v3 ad=0.22p pd=1.88u as=0.13p ps=1.02u w=0.5u l=0.28u
X26 a_188_5300# a_1492_5174# a_1492_5174# vss nfet_03v3 ad=1.02p pd=3.02u as=1.02p ps=3.02u w=2u l=0.5u
X27 a_276_5174# a_276_5174# a_188_5300# vss nfet_03v3 ad=1.02p pd=3.02u as=1.02p ps=3.02u w=2u l=0.5u
X28 vss a_276_4116# vss vss nfet_03v3 ad=0.4602p pd=2.29u as=0 ps=0 w=1.77u l=3.54u
X29 a_188_5300# a_1492_5174# a_1492_5174# vss nfet_03v3 ad=0.77p pd=2.77u as=1.02p ps=3.02u w=2u l=0.5u
X30 a_2582_2372# hold vdd vdd pfet_03v3 ad=0.44p pd=2.88u as=0.44p ps=2.88u w=1u l=2u
X31 vss vm vss vss nfet_03v3 ad=1.5554p pd=7.95u as=0 ps=0 w=3.535u l=7.07u
X32 vdd a_2826_2328# a_2040_4614# vdd pfet_03v3 ad=0.52p pd=2.52u as=0.88p ps=4.88u w=2u l=4u
X33 a_2582_2372# vbp_syn a_1520_184# vdd pfet_03v3 ad=0.52p pd=2.52u as=0.88p ps=4.88u w=2u l=4u
X34 a_2700_4160# vbn_prb vss vss nfet_03v3 ad=0.88p pd=4.88u as=0.52p ps=2.52u w=2u l=2u
X35 a_276_5174# a_276_5174# a_188_5300# vss nfet_03v3 ad=1.02p pd=3.02u as=1.38p ps=5.38u w=2u l=0.5u
X36 a_188_5300# a_276_5174# a_276_5174# vss nfet_03v3 ad=1.02p pd=3.02u as=1.02p ps=3.02u w=2u l=0.5u
X37 a_676_184# en a_2700_4160# vss nfet_03v3 ad=0.26p pd=1.52u as=0.44p ps=2.88u w=1u l=0.28u
X38 vm hold a_2040_4614# vdd pfet_03v3 ad=0.44p pd=2.88u as=0.44p ps=2.88u w=1u l=0.28u
X39 a_1824_184# vbp_syn a_2582_2372# vdd pfet_03v3 ad=0.88p pd=4.88u as=0.52p ps=2.52u w=2u l=4u
X40 a_1444_3812# spk vss vss nfet_03v3 ad=0.22p pd=1.88u as=0.13p ps=1.02u w=0.5u l=0.28u
X41 a_2826_2328# el a_276_5174# vss nfet_03v3 ad=1.02p pd=3.02u as=1.38p ps=5.38u w=2u l=0.5u
X42 abus sub_b a_3116_4160# vss nfet_03v3 ad=0.44p pd=2.88u as=0.14p ps=1.28u w=1u l=0.28u
X43 vss a_188_3812# spk vss nfet_03v3 ad=0.13p pd=1.02u as=0.22p ps=1.88u w=0.5u l=0.28u
X44 a_3116_4160# rsel a_3004_4160# vss nfet_03v3 ad=0.14p pd=1.28u as=0.14p ps=1.28u w=1u l=0.28u
X45 vdd vbp_st a_410_2372# vdd pfet_03v3 ad=0.26p pd=1.52u as=0.14p ps=1.28u w=1u l=2u
X46 spk a_188_3812# vdd vdd pfet_03v3 ad=0.44p pd=2.88u as=0.26p ps=1.52u w=1u l=0.28u
X47 a_1444_3812# spk vdd vdd pfet_03v3 ad=0.44p pd=2.88u as=0.26p ps=1.52u w=1u l=0.28u
X48 a_410_2372# a_266_1924# a_188_3812# vdd pfet_03v3 ad=0.14p pd=1.28u as=0.44p ps=2.88u w=1u l=0.28u
X49 vdd a_1444_3812# a_276_4116# vdd pfet_03v3 ad=0.26p pd=1.52u as=0.44p ps=2.88u w=1u l=0.28u
X50 a_2826_2328# a_2826_2328# vdd vdd pfet_03v3 ad=0.88p pd=4.88u as=0.52p ps=2.52u w=2u l=4u
C0 vbn_leak vreset 0.03592f
C1 vbp_st a_1520_184# 0.00199f
C2 el hold 0
C3 a_2040_4614# hold 0.64427f
C4 a_266_1924# vm 0.00225f
C5 vbp_st a_410_1924# 0.00113f
C6 a_276_5174# a_188_3812# 0
C7 abus vbn_leak 0.02444f
C8 a_1370_1924# vm 0.00146f
C9 a_2040_4614# vbp_syn 0.00761f
C10 el vbp_syn 0.06981f
C11 vbp_st a_346_1676# 0.60386f
C12 a_188_3812# mreset 0
C13 el aux 1.06136f
C14 a_2040_4614# vbn_ref 0.14005f
C15 el vbn_ref 0.03559f
C16 vbp_st a_2700_4160# 0.00156f
C17 vdd sta 0.32987f
C18 vsrc vbn_leak 1.09793f
C19 vdd hold 0.73511f
C20 a_276_4116# stb 0.0395f
C21 el vbn_prb 0.03599f
C22 a_1444_3812# stb 0
C23 a_2040_4614# a_1520_184# 0.00339f
C24 stb a_1492_5174# 0.00251f
C25 vsrc a_410_2372# 0
C26 vreset vm 0.76509f
C27 vdd vbp_syn 2.50768f
C28 vbp_st a_1824_184# 0.00262f
C29 a_188_3812# a_676_184# 0.00201f
C30 spk a_2582_2372# 0
C31 en vreset 1.09681f
C32 a_2826_2328# a_2582_2372# 0.01864f
C33 vdd aux 0.04757f
C34 vdd vbn_ref 0.41662f
C35 a_276_4116# a_1444_3812# 0.34239f
C36 abus vm 0.00242f
C37 a_276_4116# a_1492_5174# 0.04306f
C38 a_3004_4160# spk 0
C39 a_1444_3812# a_1492_5174# 0
C40 vdd vbn_prb 0.1714f
C41 abus en 0.13127f
C42 a_2040_4614# a_2700_4160# 0.00896f
C43 el a_2700_4160# 0.03131f
C44 a_1520_184# vdd 0.17339f
C45 vsrc vm 0.40856f
C46 a_3004_4160# sub_b 0.00226f
C47 vdd a_410_1924# 0.00631f
C48 a_276_5174# a_3004_4160# 0
C49 stb spk 0.07115f
C50 a_2826_2328# stb 0.18518f
C51 en vsrc 0.0278f
C52 a_2040_4614# a_188_5300# 0
C53 a_2040_4614# a_1824_184# 0.07104f
C54 el a_1824_184# 0.03345f
C55 vdd a_346_1676# 0.62468f
C56 sub_b stb 0
C57 a_276_5174# stb 0.02877f
C58 vdd a_2700_4160# 0.07768f
C59 a_276_4116# spk 0.17448f
C60 a_2826_2328# a_276_4116# 0
C61 a_1444_3812# spk 0.38576f
C62 a_2826_2328# a_1444_3812# 0.00158f
C63 a_266_1924# vbn_ref 0
C64 stb mreset 0.07539f
C65 vbp_st a_188_3812# 0.26223f
C66 a_676_184# a_2582_2372# 0.08026f
C67 vdd a_188_5300# 0.00114f
C68 a_1824_184# vdd 0.51161f
C69 a_276_5174# a_276_4116# 0.10868f
C70 a_3004_4160# a_676_184# 0.00635f
C71 sub_b a_1492_5174# 0.00229f
C72 sta vreset 0.03854f
C73 a_276_5174# a_1492_5174# 0.36542f
C74 vreset hold 0
C75 vbn_leak vm 0.04326f
C76 a_266_1924# a_410_1924# 0.00721f
C77 a_276_4116# mreset 0.30596f
C78 a_1444_3812# mreset 0.00242f
C79 a_1370_1924# a_1520_184# 0
C80 en vbn_leak 0.1119f
C81 a_1492_5174# mreset 0.00878f
C82 a_3004_4160# rsel 0.00212f
C83 a_266_1924# a_346_1676# 0.16142f
C84 vreset vbp_syn 0.08564f
C85 a_676_184# stb 0.20723f
C86 vreset aux 0.03589f
C87 a_2826_2328# spk 0.15248f
C88 a_2040_4614# a_188_3812# 0
C89 vbn_ref vreset 0.04758f
C90 a_188_5300# sub 0.00143f
C91 a_1370_1924# a_346_1676# 0.01044f
C92 vsrc sta 0.05513f
C93 abus vbp_syn 0.02158f
C94 vsrc hold 0.08251f
C95 a_276_4116# a_676_184# 0.42616f
C96 vbn_prb vreset 0.03456f
C97 sub_b spk 0.00197f
C98 abus aux 0.02246f
C99 a_2826_2328# sub_b 0
C100 a_1520_184# vreset 0.16495f
C101 a_1444_3812# a_676_184# 0.00494f
C102 abus vbn_ref 0.02244f
C103 a_276_5174# spk 0.125f
C104 a_276_5174# a_2826_2328# 0.17246f
C105 a_676_184# a_1492_5174# 0.00155f
C106 a_266_1924# a_188_5300# 0
C107 vbp_st a_2582_2372# 0.00534f
C108 vsrc vbp_syn 0.33811f
C109 rsel a_276_4116# 0
C110 spk mreset 0.15713f
C111 abus vbn_prb 0.02315f
C112 a_2826_2328# mreset 0
C113 a_276_5174# sub_b 0.01255f
C114 a_188_3812# vdd 0.46783f
C115 vsrc aux 0.03516f
C116 en vm 0.01226f
C117 rsel a_1492_5174# 0
C118 a_346_1676# vreset 0.00716f
C119 vsrc vbn_ref 0.11058f
C120 a_276_5174# mreset 0
C121 vsrc vbn_prb 0.03071f
C122 a_2700_4160# vreset 0
C123 a_1520_184# vsrc 0.03751f
C124 vbp_st stb 0.09234f
C125 abus a_2700_4160# 0
C126 a_676_184# spk 0.13259f
C127 a_2826_2328# a_676_184# 0.11236f
C128 a_2040_4614# a_2582_2372# 0.14145f
C129 el a_2582_2372# 0
C130 a_1824_184# vreset 0.05978f
C131 vsrc a_346_1676# 0.54969f
C132 abus a_3116_4160# 0.00274f
C133 vbp_st a_276_4116# 0.15913f
C134 rsel spk 0.01201f
C135 vbn_leak vbp_syn 0.08505f
C136 sub_b a_676_184# 0.01761f
C137 vbp_st a_1444_3812# 0.16943f
C138 rsel a_2826_2328# 0
C139 vsrc a_2700_4160# 0.00149f
C140 a_276_5174# a_676_184# 0.06306f
C141 abus a_1824_184# 0
C142 vbp_st a_1492_5174# 0.00399f
C143 vbn_leak aux 1.08504f
C144 vbn_leak vbn_ref 0.03234f
C145 a_188_3812# a_266_1924# 0.23495f
C146 a_676_184# mreset 0.0014f
C147 rsel sub_b 0.13858f
C148 a_276_5174# rsel 0.1553f
C149 a_2040_4614# stb 0.07213f
C150 el stb 0.22155f
C151 vdd a_2582_2372# 0.27523f
C152 vbn_leak vbn_prb 0.1541f
C153 vsrc a_188_5300# 0
C154 a_1824_184# vsrc 0.10177f
C155 sta vm 0.05843f
C156 hold vm 0.07175f
C157 el a_276_4116# 0
C158 a_2040_4614# a_276_4116# 0.02f
C159 a_2040_4614# a_1444_3812# 0.00237f
C160 vbp_st spk 0.29914f
C161 el a_1492_5174# 0
C162 vbp_st a_2826_2328# 0.21495f
C163 a_2040_4614# a_1492_5174# 0.38623f
C164 vbp_syn vm 0.43534f
C165 stb vdd 0.29328f
C166 vbn_leak a_2700_4160# 0.17495f
C167 en vbp_syn 0.02427f
C168 aux vm 0.04104f
C169 a_410_2372# a_346_1676# 0
C170 vbn_ref vm 0.01485f
C171 vbp_st sub_b 0
C172 rsel a_676_184# 0.03859f
C173 a_276_5174# vbp_st 0.00571f
C174 en aux 0.02484f
C175 en vbn_ref 1.09168f
C176 vbn_prb vm 0.01955f
C177 a_276_4116# vdd 0.72222f
C178 a_1520_184# vm 0.45878f
C179 vbn_leak a_188_5300# 0.07916f
C180 a_1824_184# vbn_leak 0.0143f
C181 a_1444_3812# vdd 0.50421f
C182 vbp_st mreset 0.01674f
C183 en vbn_prb 0.04257f
C184 vdd a_1492_5174# 0.00161f
C185 a_188_3812# vsrc 0.35899f
C186 el spk 0.17661f
C187 a_2040_4614# spk 0.13992f
C188 a_2040_4614# a_2826_2328# 0.07901f
C189 el a_2826_2328# 0.23974f
C190 a_346_1676# vm 0.29275f
C191 el sub_b 0.0016f
C192 a_276_5174# a_2040_4614# 0.02713f
C193 a_276_5174# el 0.14293f
C194 a_276_4116# sub 0.02387f
C195 vbp_st a_676_184# 0.19058f
C196 en a_2700_4160# 0.08471f
C197 a_1492_5174# sub 0.00295f
C198 sta hold 0.1389f
C199 a_2040_4614# mreset 0.00802f
C200 a_2582_2372# vreset 0.01398f
C201 spk vdd 1.24165f
C202 a_2826_2328# vdd 1.70623f
C203 a_1824_184# vm 0.23503f
C204 vbp_st rsel 0
C205 a_276_4116# a_266_1924# 0.00511f
C206 a_1444_3812# a_266_1924# 0
C207 sta vbp_syn 0
C208 en a_1824_184# 0
C209 vbp_syn hold 0.01912f
C210 sub_b vdd 0
C211 a_276_5174# vdd 0.00813f
C212 a_1370_1924# a_276_4116# 0.00319f
C213 sta vbn_ref 0.03905f
C214 vbn_ref hold 0.11215f
C215 abus a_3004_4160# 0.00209f
C216 stb vreset 0.12088f
C217 vdd mreset 0.10747f
C218 a_2040_4614# a_676_184# 0.16764f
C219 el a_676_184# 0.02276f
C220 vsrc a_2582_2372# 0.11748f
C221 a_1520_184# sta 0.20272f
C222 a_188_3812# a_410_2372# 0.00616f
C223 spk sub 0
C224 a_1520_184# hold 0.06005f
C225 aux vbp_syn 0.00935f
C226 vbn_ref vbp_syn 0.05738f
C227 a_2040_4614# rsel 0
C228 rsel el 0.00411f
C229 vbn_ref aux 0.03156f
C230 vbn_prb vbp_syn 0.06016f
C231 a_276_4116# vreset 0.07527f
C232 a_1520_184# vbp_syn 0.07694f
C233 a_276_5174# sub 0
C234 sta a_346_1676# 0
C235 spk a_266_1924# 0.00262f
C236 a_346_1676# hold 0
C237 vbn_prb aux 0.03665f
C238 vbn_ref vbn_prb 1.10031f
C239 vsrc stb 0.16108f
C240 a_676_184# vdd 0.17953f
C241 a_1520_184# vbn_ref 0
C242 mreset sub 0.00267f
C243 a_1370_1924# spk 0
C244 a_188_3812# vm 0.0037f
C245 a_276_5174# a_266_1924# 0
C246 a_346_1676# vbp_syn 0
C247 rsel vdd 0
C248 vbn_ref a_346_1676# 0
C249 a_2700_4160# vbp_syn 0.05022f
C250 vbn_leak a_2582_2372# 0
C251 a_276_4116# vsrc 0.17668f
C252 a_1824_184# sta 0.43161f
C253 a_1444_3812# vsrc 0.1505f
C254 a_1824_184# hold 0.11556f
C255 a_2700_4160# aux 0.00583f
C256 vbp_st el 0.03969f
C257 vbp_st a_2040_4614# 0.0641f
C258 vbn_ref a_2700_4160# 0.00538f
C259 a_1520_184# a_346_1676# 0.06436f
C260 spk vreset 0.32759f
C261 a_2826_2328# vreset 0.0032f
C262 a_188_5300# vbp_syn 0.00246f
C263 a_1824_184# vbp_syn 0.97384f
C264 a_410_1924# a_346_1676# 0.00292f
C265 vbn_prb a_2700_4160# 0.25945f
C266 a_1824_184# aux 0.05093f
C267 a_188_5300# vbn_ref 0
C268 stb vbn_leak 0.00138f
C269 abus spk 0.24648f
C270 a_1824_184# vbn_ref 0.00509f
C271 abus a_2826_2328# 0.00125f
C272 a_676_184# a_266_1924# 0
C273 a_188_5300# vbn_prb 0
C274 a_1824_184# vbn_prb 0.00141f
C275 vbp_st vdd 1.9243f
C276 a_1520_184# a_1824_184# 0.16624f
C277 abus sub_b 0.02921f
C278 a_1370_1924# a_676_184# 0.0011f
C279 a_276_5174# abus 0.04095f
C280 a_2582_2372# vm 0.01362f
C281 vsrc spk 0.44862f
C282 a_2826_2328# vsrc 0.14502f
C283 a_2040_4614# el 0
C284 a_1492_5174# vbn_leak 0.02234f
C285 a_1824_184# a_346_1676# 0.0014f
C286 sub_b vsrc 0
C287 a_188_3812# sta 0
C288 a_276_5174# vsrc 0.00803f
C289 a_3004_4160# en 0.00225f
C290 a_188_3812# hold 0
C291 a_188_5300# a_2700_4160# 0.02133f
C292 vbp_st sub 0
C293 vsrc mreset 0
C294 a_676_184# vreset 0.00865f
C295 stb vm 0.27788f
C296 a_2040_4614# vdd 0.40729f
C297 el vdd 1.2374f
C298 en stb 0
C299 abus a_676_184# 0.01097f
C300 a_188_3812# vbn_ref 0
C301 vbp_st a_266_1924# 0.15843f
C302 a_276_4116# vm 0.35052f
C303 spk vbn_leak 0.11189f
C304 a_2826_2328# vbn_leak 0.07394f
C305 a_1444_3812# vm 0
C306 abus rsel 0.04134f
C307 en a_276_4116# 0
C308 a_676_184# vsrc 0.43666f
C309 sub_b vbn_leak 0
C310 en a_1492_5174# 0.02565f
C311 a_188_3812# a_410_1924# 0
C312 a_2040_4614# sub 0.00533f
C313 a_276_5174# vbn_leak 0.13909f
C314 rsel vsrc 0
C315 a_188_3812# a_346_1676# 0.25158f
C316 a_2582_2372# hold 0.04859f
C317 vbp_st vreset 0.03429f
C318 spk vm 6.27647f
C319 a_2582_2372# vbp_syn 0.1848f
C320 a_2826_2328# vm 0.00193f
C321 vdd sub 0.00215f
C322 vbp_st abus 0.02255f
C323 a_2582_2372# aux 0
C324 en spk 0.21401f
C325 a_2826_2328# en 0.00234f
C326 a_188_3812# a_188_5300# 0.00135f
C327 a_2582_2372# vbn_ref 0
C328 stb sta 0.27042f
C329 stb hold 0.05767f
C330 a_676_184# vbn_leak 0
C331 vdd a_266_1924# 0.41511f
C332 a_2582_2372# vbn_prb 0
C333 a_1520_184# a_2582_2372# 0.00709f
C334 en sub_b 0.03144f
C335 vbp_st vsrc 1.41057f
C336 a_276_5174# en 0.2375f
C337 rsel vbn_leak 0.01136f
C338 stb vbp_syn 0.16826f
C339 a_276_4116# sta 0.11943f
C340 el vreset 0.03608f
C341 a_1370_1924# vdd 0.00213f
C342 a_2040_4614# vreset 0
C343 a_1444_3812# sta 0.09302f
C344 a_276_4116# hold 0.00118f
C345 stb aux 0.00182f
C346 a_1444_3812# hold 0.0023f
C347 a_1492_5174# sta 0
C348 stb vbn_ref 0.50468f
C349 a_1492_5174# hold 0.0015f
C350 abus el 0.02287f
C351 stb vbn_prb 0
C352 a_276_4116# vbp_syn 0
C353 a_1520_184# stb 0.29551f
C354 a_1492_5174# vbp_syn 0.00162f
C355 a_276_4116# vbn_ref 0.03485f
C356 a_676_184# vm 0.2678f
C357 a_1444_3812# vbn_ref 0.0019f
C358 vdd vreset 0.19474f
C359 a_2040_4614# vsrc 0.06427f
C360 a_3004_4160# a_2700_4160# 0
C361 el vsrc 0.03536f
C362 a_1492_5174# vbn_ref 0.00714f
C363 en a_676_184# 0.08784f
C364 stb a_346_1676# 0.00717f
C365 a_1824_184# a_2582_2372# 0.10722f
C366 vbp_st vbn_leak 0.03375f
C367 a_1520_184# a_276_4116# 0.08246f
C368 a_1520_184# a_1444_3812# 0
C369 abus vdd 0.10367f
C370 a_1492_5174# vbn_prb 0
C371 spk sta 0.05124f
C372 a_2826_2328# sta 0
C373 stb a_2700_4160# 0.00167f
C374 spk hold 0.06746f
C375 rsel en 0.13259f
C376 a_2826_2328# hold 0.00377f
C377 vbp_st a_410_2372# 0.00225f
C378 a_276_4116# a_346_1676# 0.13448f
C379 a_1444_3812# a_346_1676# 0
C380 vsrc vdd 0.52925f
C381 spk vbp_syn 0.43452f
C382 a_2826_2328# vbp_syn 0.15292f
C383 a_1824_184# stb 0.11685f
C384 a_276_4116# a_2700_4160# 0
C385 spk aux 0.09577f
C386 a_2826_2328# aux 0.07281f
C387 sta mreset 0.08773f
C388 spk vbn_ref 0.26358f
C389 a_2826_2328# vbn_ref 0.51164f
C390 a_1492_5174# a_2700_4160# 0.15819f
C391 mreset hold 0.01321f
C392 sub_b vbp_syn 0
C393 el vbn_leak 0.02743f
C394 a_276_5174# vbp_syn 0.02419f
C395 spk vbn_prb 0.10093f
C396 a_2826_2328# vbn_prb 0.00593f
C397 vbp_st vm 0.10436f
C398 sub_b aux 0
C399 a_1520_184# spk 0.00176f
C400 a_276_4116# a_188_5300# 0.02816f
C401 a_276_4116# a_1824_184# 0
C402 a_276_5174# aux 0.00141f
C403 a_276_5174# vbn_ref 0
C404 a_1444_3812# a_1824_184# 0
C405 a_1492_5174# a_188_5300# 0.58286f
C406 vbp_st en 0.02922f
C407 sub_b vbn_prb 0
C408 a_276_5174# vbn_prb 0
C409 mreset vbn_ref 0.18329f
C410 a_676_184# sta 0.07027f
C411 spk a_346_1676# 0.03131f
C412 a_676_184# hold 0.1236f
C413 vdd vbn_leak 0.11493f
C414 vsrc a_266_1924# 0.12057f
C415 a_1520_184# mreset 0
C416 spk a_2700_4160# 0.00483f
C417 a_676_184# vbp_syn 0.00492f
C418 a_1370_1924# vsrc 0
C419 vdd a_410_2372# 0.00534f
C420 spk a_3116_4160# 0
C421 el vm 0.04238f
C422 a_2040_4614# vm 0.07327f
C423 sub_b a_2700_4160# 0.00671f
C424 a_676_184# aux 0
C425 mreset a_346_1676# 0
C426 a_276_5174# a_2700_4160# 0.17986f
C427 a_676_184# vbn_ref 0.03321f
C428 a_1824_184# spk 0.00424f
C429 a_2040_4614# en 0.01488f
C430 el en 0.02532f
C431 a_2826_2328# a_1824_184# 0.00143f
C432 rsel vbp_syn 0
C433 abus vreset 1.08631f
C434 sub_b a_3116_4160# 0.00727f
C435 a_676_184# vbn_prb 0
C436 rsel aux 0
C437 a_1520_184# a_676_184# 0.06693f
C438 a_188_3812# a_276_4116# 0.01501f
C439 a_276_5174# a_188_5300# 0.7165f
C440 a_188_3812# a_1444_3812# 0.00949f
C441 vsrc vreset 0.08277f
C442 vdd vm 0.62807f
C443 vbp_st sta 0.04785f
C444 a_676_184# a_346_1676# 0.29548f
C445 en vdd 0.13892f
C446 vbp_st hold 0.05399f
C447 abus vsrc 0.02242f
C448 a_676_184# a_2700_4160# 0.06402f
C449 a_410_2372# a_266_1924# 0.0036f
C450 vbp_st vbp_syn 0.05593f
C451 a_676_184# a_3116_4160# 0.00356f
C452 rsel a_2700_4160# 0.01505f
C453 vbp_st aux 0.03231f
C454 stb a_2582_2372# 0.10338f
C455 vbp_st vbn_ref 0.29221f
C456 a_1824_184# a_676_184# 0.00452f
C457 a_188_3812# spk 0.36001f
C458 rsel a_3116_4160# 0.00272f
C459 vbp_st vbn_prb 1.09203f
C460 a_2040_4614# sta 0.08349f
C461 aux vss 0.44588f
C462 sub vss 0.01992f
C463 vreset vss 2.64865f
C464 vsrc vss 4.83279f
C465 abus vss 2.88808f
C466 vdd vss 25.13855f
C467 a_1824_184# vss 0.91021f
C468 a_1520_184# vss 1.98335f
C469 a_1370_1924# vss 3.62775f
C470 a_410_1924# vss 0.49598f
C471 a_2582_2372# vss 0.65724f
C472 a_410_2372# vss 1.31415f
C473 a_188_3812# vss 1.31393f
C474 a_3116_4160# vss 0.25855f
C475 a_3004_4160# vss 0.85315f
C476 a_676_184# vss 1.29536f
C477 a_276_4116# vss 0.48919f
C478 a_2040_4614# vss 0.73498f
C479 a_2700_4160# vss 1.19379f
C480 a_188_5300# vss 4.5005f
.ends
