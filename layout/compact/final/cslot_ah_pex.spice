* NGSPICE file created from cslot_ah.ext - technology: gf180mcuD

.subckt cslot_ah vss vbp_syn vdd el aux vbn_leak vsrc vbp_st vbn_prb vbn_ref en vreset
+ abus sta stb hold mreset rsel sub sub_b spk vm
X0 a_346_1676# vm a_1370_1924# vdd pfet_03v3 ad=0.44p pd=2.88u as=0.14p ps=1.28u w=1u l=0.5u
X1 a_1824_184# sta vss vdd pfet_03v3 ad=0.44p pd=2.88u as=0.26p ps=1.52u w=1u l=0.28u
X2 vdd mreset a_276_4116# vss nfet_03v3 ad=0.22p pd=1.88u as=0.22p ps=1.88u w=0.5u l=0.28u
X3 vdd spk a_188_3812# vdd pfet_03v3 ad=0.1516p pd=1.64u as=0.1516p ps=1.64u w=0.22u l=1u
X4 a_188_5300# a_1492_5174# a_1492_5174# vss nfet_03v3 ad=0.52p pd=2.52u as=0.52p ps=2.52u w=2u l=1u
X5 a_676_184# vm vdd vss nfet_03v3 ad=1.76p pd=8.88u as=1.76p ps=8.88u w=4u l=2u
X6 vreset a_276_4116# vm vss nfet_03v3 ad=0.44p pd=2.88u as=0.44p ps=2.88u w=1u l=0.5u
X7 vss vm vss vss nfet_03v3 ad=0.9191p pd=4.055u as=9.607p ps=49.39u w=3.535u l=7.07u
X8 a_276_5174# a_276_5174# a_188_5300# vss nfet_03v3 ad=0.52p pd=2.52u as=0.52p ps=2.52u w=2u l=1u
X9 vss a_276_4116# vss vss nfet_03v3 ad=0.7788p pd=4.42u as=0 ps=0 w=1.77u l=3.54u
X10 vm stb a_1520_184# vss nfet_03v3 ad=0.13p pd=1.02u as=0.22p ps=1.88u w=0.5u l=0.28u
X11 vss vbn_leak a_188_5300# vss nfet_03v3 ad=0.52p pd=2.52u as=0.52p ps=2.52u w=2u l=4u
X12 vss vbn_ref a_276_4116# vss nfet_03v3 ad=0.88p pd=4.88u as=0.88p ps=4.88u w=2u l=4u
X13 vdd vbp_st a_410_1924# vdd pfet_03v3 ad=0.26p pd=1.52u as=0.14p ps=1.28u w=1u l=2u
X14 vsrc vm a_346_1676# vss nfet_03v3 ad=0.44p pd=2.88u as=0.44p ps=2.88u w=1u l=0.5u
X15 vsrc a_266_1924# a_188_3812# vss nfet_03v3 ad=0.22p pd=1.88u as=0.22p ps=1.88u w=0.5u l=0.28u
X16 a_2826_2328# el a_276_5174# vss nfet_03v3 ad=0.52p pd=2.52u as=0.88p ps=4.88u w=2u l=1u
X17 a_1370_1924# vbp_st vdd vdd pfet_03v3 ad=0.14p pd=1.28u as=0.26p ps=1.52u w=1u l=2u
X18 vsrc a_346_1676# a_266_1924# vss nfet_03v3 ad=0.1516p pd=1.64u as=0.1516p ps=1.64u w=0.22u l=2u
X19 a_410_1924# a_346_1676# a_266_1924# vdd pfet_03v3 ad=0.14p pd=1.28u as=0.44p ps=2.88u w=1u l=0.28u
X20 vss stb a_1520_184# vdd pfet_03v3 ad=0.26p pd=1.52u as=0.44p ps=2.88u w=1u l=0.28u
X21 a_3004_4160# en a_676_184# vss nfet_03v3 ad=0.14p pd=1.28u as=0.26p ps=1.52u w=1u l=0.28u
X22 a_1824_184# sta vm vss nfet_03v3 ad=0.22p pd=1.88u as=0.13p ps=1.02u w=0.5u l=0.28u
X23 a_276_5174# a_276_5174# a_188_5300# vss nfet_03v3 ad=0.52p pd=2.52u as=0.88p ps=4.88u w=2u l=1u
X24 a_188_5300# a_276_5174# a_276_5174# vss nfet_03v3 ad=0.52p pd=2.52u as=0.52p ps=2.52u w=2u l=1u
X25 vss a_276_4116# vss vss nfet_03v3 ad=0.4602p pd=2.29u as=0 ps=0 w=1.77u l=3.54u
X26 a_2582_2372# hold vdd vdd pfet_03v3 ad=0.44p pd=2.88u as=0.44p ps=2.88u w=1u l=2u
X27 vss vm vss vss nfet_03v3 ad=1.5554p pd=7.95u as=0 ps=0 w=3.535u l=7.07u
X28 a_276_5174# el a_2826_2328# vss nfet_03v3 ad=0.88p pd=4.88u as=0.52p ps=2.52u w=2u l=1u
X29 vdd a_2826_2328# a_2040_4116# vdd pfet_03v3 ad=0.52p pd=2.52u as=0.88p ps=4.88u w=2u l=4u
X30 a_2582_2372# vbp_syn a_1520_184# vdd pfet_03v3 ad=0.52p pd=2.52u as=0.88p ps=4.88u w=2u l=4u
X31 a_2040_4116# a_2040_4116# a_1492_5174# vss nfet_03v3 ad=0.52p pd=2.52u as=0.88p ps=4.88u w=2u l=1u
X32 a_2700_4160# vbn_prb vss vss nfet_03v3 ad=0.88p pd=4.88u as=0.52p ps=2.52u w=2u l=2u
X33 a_676_184# en a_2700_4160# vss nfet_03v3 ad=0.26p pd=1.52u as=0.44p ps=2.88u w=1u l=0.28u
X34 vm hold a_2040_4116# vdd pfet_03v3 ad=0.44p pd=2.88u as=0.44p ps=2.88u w=1u l=0.28u
X35 a_1824_184# vbp_syn a_2582_2372# vdd pfet_03v3 ad=0.88p pd=4.88u as=0.52p ps=2.52u w=2u l=4u
X36 a_1492_5174# a_1492_5174# a_188_5300# vss nfet_03v3 ad=0.52p pd=2.52u as=0.52p ps=2.52u w=2u l=1u
X37 a_1444_3812# spk vss vss nfet_03v3 ad=0.22p pd=1.88u as=0.13p ps=1.02u w=0.5u l=0.28u
X38 a_1492_5174# a_2040_4116# a_2040_4116# vss nfet_03v3 ad=0.88p pd=4.88u as=0.52p ps=2.52u w=2u l=1u
X39 abus sub_b a_3116_4160# vss nfet_03v3 ad=0.44p pd=2.88u as=0.14p ps=1.28u w=1u l=0.28u
X40 vss a_188_3812# spk vss nfet_03v3 ad=0.13p pd=1.02u as=0.22p ps=1.88u w=0.5u l=0.28u
X41 a_1492_5174# a_1492_5174# a_188_5300# vss nfet_03v3 ad=0.52p pd=2.52u as=0.52p ps=2.52u w=2u l=1u
X42 a_3116_4160# rsel a_3004_4160# vss nfet_03v3 ad=0.14p pd=1.28u as=0.14p ps=1.28u w=1u l=0.28u
X43 vdd vbp_st a_410_2372# vdd pfet_03v3 ad=0.26p pd=1.52u as=0.14p ps=1.28u w=1u l=2u
X44 spk a_188_3812# vdd vdd pfet_03v3 ad=0.44p pd=2.88u as=0.26p ps=1.52u w=1u l=0.28u
X45 a_1444_3812# spk vdd vdd pfet_03v3 ad=0.44p pd=2.88u as=0.26p ps=1.52u w=1u l=0.28u
X46 a_188_5300# a_276_5174# a_276_5174# vss nfet_03v3 ad=0.52p pd=2.52u as=0.52p ps=2.52u w=2u l=1u
X47 a_410_2372# a_266_1924# a_188_3812# vdd pfet_03v3 ad=0.14p pd=1.28u as=0.44p ps=2.88u w=1u l=0.28u
X48 vdd a_1444_3812# a_276_4116# vdd pfet_03v3 ad=0.26p pd=1.52u as=0.44p ps=2.88u w=1u l=0.28u
X49 a_2826_2328# a_2826_2328# vdd vdd pfet_03v3 ad=0.88p pd=4.88u as=0.52p ps=2.52u w=2u l=4u
X50 a_188_5300# a_1492_5174# a_1492_5174# vss nfet_03v3 ad=0.52p pd=2.52u as=0.52p ps=2.52u w=2u l=1u
C0 a_2700_4160# vbp_st 0.00156f
C1 a_2700_4160# aux 0.00583f
C2 rsel spk 0.01201f
C3 a_188_3812# vbp_st 0.26223f
C4 a_1824_184# sta 0.43161f
C5 vbn_prb en 0.04257f
C6 vm vbn_leak 0.04326f
C7 a_188_3812# sta 0
C8 a_1370_1924# vm 0.00146f
C9 a_188_5300# vdd 0.00114f
C10 a_410_1924# a_346_1676# 0.00292f
C11 a_2040_4116# hold 0.64446f
C12 vm a_2582_2372# 0.01362f
C13 vbn_prb spk 0.10093f
C14 a_188_3812# mreset 0
C15 a_1824_184# vbn_leak 0.0143f
C16 rsel a_2040_4116# 0
C17 a_2700_4160# vbn_leak 0.17495f
C18 a_276_5174# a_3004_4160# 0
C19 a_1824_184# a_2582_2372# 0.10722f
C20 a_1444_3812# vdd 0.50421f
C21 abus aux 0.02246f
C22 abus vbp_st 0.02255f
C23 vsrc a_346_1676# 0.54969f
C24 a_276_4116# a_346_1676# 0.13448f
C25 a_266_1924# vbp_st 0.15843f
C26 vm a_676_184# 0.2678f
C27 en stb 0
C28 a_276_4116# vsrc 0.17668f
C29 a_1444_3812# a_2826_2328# 0.00158f
C30 en vbp_st 0.02922f
C31 vbp_syn vreset 0.08564f
C32 en aux 0.02484f
C33 a_1520_184# vm 0.45878f
C34 a_2700_4160# a_1492_5174# 0.1628f
C35 a_1824_184# a_676_184# 0.00452f
C36 stb spk 0.07115f
C37 spk vbp_st 0.29914f
C38 spk aux 0.09577f
C39 sub_b a_2700_4160# 0.00671f
C40 a_2700_4160# a_676_184# 0.06402f
C41 vbn_ref vreset 0.04758f
C42 a_276_5174# vbp_syn 0.02419f
C43 a_188_3812# a_676_184# 0.00201f
C44 a_1824_184# a_1520_184# 0.16624f
C45 abus vbn_leak 0.02444f
C46 spk sta 0.05124f
C47 a_1444_3812# hold 0.0023f
C48 el vreset 0.03608f
C49 a_276_5174# vbn_ref 0
C50 en vbn_leak 0.1119f
C51 spk sub 0
C52 a_346_1676# a_410_2372# 0
C53 a_188_5300# vbn_prb 0
C54 spk mreset 0.15713f
C55 a_2040_4116# stb 0.07255f
C56 abus a_3116_4160# 0.00274f
C57 a_2040_4116# vbp_st 0.06605f
C58 vsrc a_410_2372# 0
C59 spk vbn_leak 0.11189f
C60 a_276_5174# el 0.22384f
C61 a_1370_1924# spk 0
C62 spk a_2582_2372# 0
C63 sub_b abus 0.02921f
C64 a_2040_4116# sta 0.08349f
C65 abus a_676_184# 0.01097f
C66 a_346_1676# vm 0.29275f
C67 a_266_1924# a_676_184# 0
C68 en a_1492_5174# 0.02563f
C69 a_2040_4116# sub 0.006f
C70 spk a_3116_4160# 0
C71 a_2040_4116# mreset 0.012f
C72 a_410_1924# a_188_3812# 0
C73 sub_b en 0.03144f
C74 vbn_ref vbp_syn 0.05738f
C75 en a_676_184# 0.08784f
C76 vsrc vm 0.40856f
C77 a_276_4116# vm 0.35052f
C78 vdd vreset 0.19474f
C79 a_1824_184# a_346_1676# 0.0014f
C80 sub_b spk 0.00197f
C81 a_676_184# spk 0.13259f
C82 a_1824_184# vsrc 0.10177f
C83 a_346_1676# a_188_3812# 0.25158f
C84 a_276_4116# a_1824_184# 0
C85 a_2040_4116# a_2582_2372# 0.14145f
C86 el vbp_syn 0.06983f
C87 a_2826_2328# vreset 0.0032f
C88 vsrc a_2700_4160# 0.00149f
C89 a_276_4116# a_2700_4160# 0
C90 a_276_5174# vdd 0.00813f
C91 a_1520_184# spk 0.00176f
C92 vsrc a_188_3812# 0.35899f
C93 a_276_4116# a_188_3812# 0.01501f
C94 a_1444_3812# stb 0
C95 vbn_ref el 0.036f
C96 a_188_5300# sub 0.00143f
C97 a_1444_3812# vbp_st 0.16943f
C98 a_2040_4116# a_1492_5174# 0.41566f
C99 a_276_5174# a_2826_2328# 0.13925f
C100 a_410_1924# a_266_1924# 0.00721f
C101 a_188_5300# vbn_leak 0.07916f
C102 a_2040_4116# a_676_184# 0.16824f
C103 a_1444_3812# sta 0.09302f
C104 vreset hold 0
C105 a_1520_184# a_2040_4116# 0.00339f
C106 a_1444_3812# mreset 0.00242f
C107 a_266_1924# a_346_1676# 0.16142f
C108 vdd vbp_syn 2.50768f
C109 vsrc abus 0.02242f
C110 a_266_1924# vsrc 0.12057f
C111 a_276_4116# a_266_1924# 0.00511f
C112 a_188_3812# a_410_2372# 0.00616f
C113 a_188_5300# a_1492_5174# 0.6382f
C114 rsel a_3004_4160# 0.00212f
C115 a_276_5174# rsel 0.15361f
C116 a_2826_2328# vbp_syn 0.15292f
C117 vbn_ref vdd 0.41662f
C118 vsrc en 0.0278f
C119 a_276_4116# en 0
C120 vbn_prb vreset 0.03456f
C121 a_346_1676# spk 0.03131f
C122 a_1824_184# vm 0.23503f
C123 vsrc spk 0.44862f
C124 vbn_ref a_2826_2328# 0.51164f
C125 a_276_4116# spk 0.17448f
C126 el vdd 1.23743f
C127 a_276_5174# vbn_prb 0
C128 a_1444_3812# a_1492_5174# 0
C129 a_188_3812# vm 0.0037f
C130 el a_2826_2328# 0.28196f
C131 vbp_syn hold 0.01912f
C132 a_1444_3812# a_676_184# 0.00494f
C133 rsel vbp_syn 0
C134 a_1444_3812# a_1520_184# 0
C135 a_266_1924# a_410_2372# 0.0036f
C136 vbn_ref hold 0.11215f
C137 vsrc a_2040_4116# 0.06427f
C138 a_276_4116# a_2040_4116# 0.02248f
C139 stb vreset 0.12088f
C140 aux vreset 0.03589f
C141 vreset vbp_st 0.03429f
C142 el hold 0
C143 vbn_prb vbp_syn 0.06016f
C144 a_276_5174# stb 0.02632f
C145 vreset sta 0.03854f
C146 vm abus 0.00242f
C147 a_276_5174# aux 0.00141f
C148 a_276_5174# vbp_st 0.00472f
C149 a_266_1924# vm 0.00225f
C150 rsel el 0.00749f
C151 vbn_prb vbn_ref 1.10031f
C152 a_2826_2328# vdd 1.70623f
C153 a_1824_184# abus 0
C154 en vm 0.01226f
C155 vbn_leak vreset 0.03592f
C156 a_2700_4160# abus 0
C157 a_188_5300# vsrc 0
C158 a_188_5300# a_276_4116# 0.02692f
C159 a_276_5174# sub 0
C160 a_276_5174# mreset 0
C161 vm spk 6.27647f
C162 a_266_1924# a_188_3812# 0.23495f
C163 vbn_prb el 0.036f
C164 a_1824_184# en 0
C165 a_2582_2372# vreset 0.01398f
C166 a_2700_4160# en 0.08471f
C167 a_1444_3812# a_346_1676# 0
C168 a_276_5174# vbn_leak 0.13905f
C169 stb vbp_syn 0.16826f
C170 a_1824_184# spk 0.00424f
C171 vbp_syn vbp_st 0.05593f
C172 aux vbp_syn 0.00935f
C173 vdd hold 0.73511f
C174 a_1444_3812# vsrc 0.1505f
C175 a_276_4116# a_1444_3812# 0.34239f
C176 a_2700_4160# spk 0.00483f
C177 a_188_3812# spk 0.36001f
C178 rsel vdd 0
C179 vbn_ref stb 0.50468f
C180 a_2826_2328# hold 0.00377f
C181 vbp_syn sta 0
C182 vbn_ref aux 0.03156f
C183 vbn_ref vbp_st 0.29221f
C184 a_2040_4116# vm 0.07327f
C185 a_676_184# vreset 0.00865f
C186 rsel a_2826_2328# 0
C187 a_276_5174# a_1492_5174# 0.37498f
C188 a_1520_184# vreset 0.16495f
C189 el stb 0.22743f
C190 a_1824_184# a_2040_4116# 0.07104f
C191 vbn_ref sta 0.03905f
C192 el aux 1.06137f
C193 a_276_5174# sub_b 0.01243f
C194 el vbp_st 0.04117f
C195 sub_b a_3004_4160# 0.00226f
C196 vbn_prb vdd 0.1714f
C197 a_676_184# a_3004_4160# 0.00635f
C198 a_276_5174# a_676_184# 0.0578f
C199 a_2700_4160# a_2040_4116# 0.00968f
C200 vbn_leak vbp_syn 0.08505f
C201 en abus 0.13127f
C202 a_188_3812# a_2040_4116# 0
C203 vbn_ref mreset 0.18329f
C204 a_2582_2372# vbp_syn 0.1848f
C205 vbn_prb a_2826_2328# 0.00593f
C206 abus spk 0.24648f
C207 vbn_ref vbn_leak 0.03234f
C208 a_266_1924# spk 0.00262f
C209 vbn_ref a_2582_2372# 0
C210 en spk 0.21401f
C211 a_1492_5174# vbp_syn 0.00204f
C212 el vbn_leak 0.02787f
C213 sub_b vbp_syn 0
C214 a_188_5300# a_2700_4160# 0.01808f
C215 a_676_184# vbp_syn 0.00492f
C216 el a_2582_2372# 0
C217 stb vdd 0.29328f
C218 a_188_5300# a_188_3812# 0.00135f
C219 vdd aux 0.04757f
C220 vdd vbp_st 1.9243f
C221 a_1444_3812# vm 0
C222 vbn_ref a_1492_5174# 0.00714f
C223 a_1520_184# vbp_syn 0.07694f
C224 a_346_1676# vreset 0.00716f
C225 a_2826_2328# stb 0.18365f
C226 vbn_ref a_676_184# 0.03321f
C227 a_2826_2328# vbp_st 0.21478f
C228 a_2826_2328# aux 0.07281f
C229 a_1824_184# a_1444_3812# 0
C230 vdd sta 0.32987f
C231 en a_2040_4116# 0.01592f
C232 vsrc vreset 0.08277f
C233 a_276_4116# vreset 0.07527f
C234 el a_1492_5174# 0
C235 vbn_ref a_1520_184# 0
C236 vdd sub 0.00215f
C237 a_1444_3812# a_188_3812# 0.00949f
C238 sub_b el 0.00293f
C239 vdd mreset 0.10747f
C240 el a_676_184# 0.03563f
C241 a_2040_4116# spk 0.13992f
C242 a_2826_2328# sta 0
C243 a_276_5174# vsrc 0.00803f
C244 a_276_5174# a_276_4116# 0.10997f
C245 vdd vbn_leak 0.11493f
C246 a_1370_1924# vdd 0.00213f
C247 a_2826_2328# mreset 0
C248 stb hold 0.05767f
C249 a_188_5300# a_266_1924# 0
C250 vbp_st hold 0.05399f
C251 vdd a_2582_2372# 0.27523f
C252 a_2826_2328# vbn_leak 0.07394f
C253 rsel aux 0
C254 rsel vbp_st 0
C255 sta hold 0.1389f
C256 a_2826_2328# a_2582_2372# 0.01864f
C257 vdd a_1492_5174# 0.00166f
C258 a_346_1676# vbp_syn 0
C259 mreset hold 0.01321f
C260 a_1444_3812# a_266_1924# 0
C261 sub_b vdd 0
C262 vbn_prb stb 0
C263 a_676_184# vdd 0.17953f
C264 a_276_4116# vbp_syn 0
C265 vsrc vbp_syn 0.33811f
C266 vbn_prb vbp_st 1.09203f
C267 vbn_prb aux 0.03665f
C268 vbn_ref a_346_1676# 0
C269 a_1520_184# vdd 0.17339f
C270 sub_b a_2826_2328# 0
C271 rsel vbn_leak 0.01136f
C272 a_2826_2328# a_676_184# 0.10806f
C273 a_2582_2372# hold 0.04859f
C274 vbn_ref vsrc 0.11058f
C275 a_276_4116# vbn_ref 0.03485f
C276 a_1444_3812# spk 0.38576f
C277 vm vreset 0.76509f
C278 a_188_5300# a_2040_4116# 0
C279 vsrc el 0.03537f
C280 a_276_4116# el 0
C281 a_1824_184# vreset 0.05978f
C282 rsel a_3116_4160# 0.00272f
C283 a_1492_5174# hold 0.0015f
C284 vbn_prb vbn_leak 0.1541f
C285 a_2700_4160# vreset 0
C286 rsel a_1492_5174# 0
C287 a_676_184# hold 0.1236f
C288 stb vbp_st 0.09234f
C289 stb aux 0.00182f
C290 vbn_prb a_2582_2372# 0
C291 aux vbp_st 0.03231f
C292 a_1444_3812# a_2040_4116# 0.00237f
C293 sub_b rsel 0.13858f
C294 a_410_1924# vdd 0.00631f
C295 rsel a_676_184# 0.03859f
C296 a_1520_184# hold 0.06005f
C297 a_276_5174# a_2700_4160# 0.1802f
C298 a_2700_4160# a_3004_4160# 0
C299 stb sta 0.27042f
C300 a_276_5174# a_188_3812# 0
C301 sta vbp_st 0.04785f
C302 vbn_prb a_1492_5174# 0
C303 stb mreset 0.07539f
C304 a_346_1676# vdd 0.62468f
C305 sub vbp_st 0
C306 mreset vbp_st 0.01674f
C307 sub_b vbn_prb 0
C308 vbn_prb a_676_184# 0
C309 vm vbp_syn 0.43534f
C310 vsrc vdd 0.52925f
C311 a_276_4116# vdd 0.72222f
C312 stb vbn_leak 0.00138f
C313 vbn_leak aux 1.08504f
C314 vbn_leak vbp_st 0.03375f
C315 abus vreset 1.08631f
C316 mreset sta 0.08773f
C317 stb a_2582_2372# 0.10338f
C318 a_1824_184# vbp_syn 0.97384f
C319 a_2582_2372# vbp_st 0.00534f
C320 vbn_ref vm 0.01485f
C321 vsrc a_2826_2328# 0.14502f
C322 a_2582_2372# aux 0
C323 a_276_4116# a_2826_2328# 0
C324 mreset sub 0.00267f
C325 en vreset 1.09681f
C326 a_2700_4160# vbp_syn 0.05022f
C327 abus a_3004_4160# 0.00209f
C328 a_276_5174# abus 0.04095f
C329 a_276_5174# a_266_1924# 0
C330 a_1824_184# vbn_ref 0.00509f
C331 el vm 0.04238f
C332 stb a_1492_5174# 0.00251f
C333 spk vreset 0.32759f
C334 vbn_ref a_2700_4160# 0.00538f
C335 a_1492_5174# vbp_st 0.00254f
C336 a_346_1676# hold 0
C337 a_276_5174# en 0.23629f
C338 vbn_ref a_188_3812# 0
C339 en a_3004_4160# 0.00225f
C340 sub_b stb 0
C341 a_676_184# stb 0.20723f
C342 sub_b aux 0
C343 sub_b vbp_st 0
C344 a_1824_184# el 0.03345f
C345 a_676_184# vbp_st 0.19058f
C346 a_676_184# aux 0
C347 a_276_4116# hold 0.00118f
C348 vsrc hold 0.08251f
C349 a_1492_5174# sta 0
C350 vbn_leak a_2582_2372# 0
C351 a_2700_4160# el 0.03132f
C352 a_276_5174# spk 0.11624f
C353 spk a_3004_4160# 0
C354 vdd a_410_2372# 0.00534f
C355 a_1520_184# stb 0.29551f
C356 vsrc rsel 0
C357 a_1520_184# vbp_st 0.00199f
C358 a_276_4116# rsel 0
C359 a_1492_5174# sub 0.0024f
C360 a_676_184# sta 0.07027f
C361 mreset a_1492_5174# 0.00584f
C362 a_2040_4116# vreset 0
C363 abus vbp_syn 0.02158f
C364 a_1520_184# sta 0.20272f
C365 a_676_184# mreset 0.0014f
C366 vbn_leak a_1492_5174# 0.02436f
C367 sub_b vbn_leak 0
C368 vm vdd 0.62807f
C369 vbn_prb vsrc 0.03071f
C370 a_1520_184# mreset 0
C371 en vbp_syn 0.02427f
C372 a_676_184# vbn_leak 0
C373 vbn_ref abus 0.02244f
C374 a_276_5174# a_2040_4116# 0.03036f
C375 a_1370_1924# a_676_184# 0.0011f
C376 a_266_1924# vbn_ref 0
C377 a_676_184# a_2582_2372# 0.08026f
C378 a_1370_1924# a_1520_184# 0
C379 spk vbp_syn 0.43452f
C380 a_1824_184# vdd 0.51161f
C381 vm a_2826_2328# 0.00193f
C382 vbn_ref en 1.09168f
C383 el abus 0.02335f
C384 sub_b a_3116_4160# 0.00727f
C385 a_410_1924# vbp_st 0.00113f
C386 a_2700_4160# vdd 0.07768f
C387 a_1520_184# a_2582_2372# 0.00709f
C388 a_676_184# a_3116_4160# 0.00356f
C389 a_188_3812# vdd 0.46783f
C390 a_1824_184# a_2826_2328# 0.00143f
C391 sub_b a_1492_5174# 0.00229f
C392 vbn_ref spk 0.26358f
C393 a_676_184# a_1492_5174# 0.00114f
C394 en el 0.02716f
C395 a_346_1676# stb 0.00717f
C396 a_346_1676# vbp_st 0.60386f
C397 sub_b a_676_184# 0.01761f
C398 a_276_5174# a_188_5300# 0.78227f
C399 vsrc stb 0.16108f
C400 a_276_4116# stb 0.0395f
C401 a_2040_4116# vbp_syn 0.00761f
C402 el spk 0.19786f
C403 vm hold 0.07175f
C404 vsrc vbp_st 1.41057f
C405 a_276_4116# vbp_st 0.15913f
C406 vsrc aux 0.03516f
C407 a_346_1676# sta 0
C408 a_1520_184# a_676_184# 0.06693f
C409 a_1824_184# hold 0.11556f
C410 vbn_ref a_2040_4116# 0.14504f
C411 vsrc sta 0.05513f
C412 a_346_1676# mreset 0
C413 a_276_4116# sta 0.11943f
C414 abus vdd 0.10367f
C415 a_188_3812# hold 0
C416 a_276_4116# sub 0.02387f
C417 a_266_1924# vdd 0.41511f
C418 vsrc mreset 0
C419 a_276_4116# mreset 0.30596f
C420 rsel a_2700_4160# 0.01505f
C421 a_1370_1924# a_346_1676# 0.01044f
C422 a_2040_4116# el 0
C423 vbn_prb vm 0.01955f
C424 en vdd 0.13892f
C425 abus a_2826_2328# 0.00125f
C426 vsrc vbn_leak 1.09793f
C427 vsrc a_1370_1924# 0
C428 a_276_4116# a_1370_1924# 0.00319f
C429 a_188_5300# vbp_syn 0.0022f
C430 a_1824_184# vbn_prb 0.00141f
C431 vsrc a_2582_2372# 0.11748f
C432 spk vdd 1.24165f
C433 en a_2826_2328# 0.00231f
C434 a_410_2372# vbp_st 0.00225f
C435 vbn_prb a_2700_4160# 0.25945f
C436 a_188_5300# vbn_ref 0
C437 a_2826_2328# spk 0.14516f
C438 a_276_4116# a_1492_5174# 0.0421f
C439 a_346_1676# a_676_184# 0.29548f
C440 sub_b vsrc 0
C441 rsel abus 0.04134f
C442 vm stb 0.27788f
C443 a_346_1676# a_1520_184# 0.06436f
C444 vsrc a_676_184# 0.43666f
C445 a_276_4116# a_676_184# 0.42616f
C446 a_2040_4116# vdd 0.40729f
C447 vm aux 0.04104f
C448 vm vbp_st 0.10436f
C449 a_1444_3812# vbn_ref 0.0019f
C450 vsrc a_1520_184# 0.03751f
C451 a_276_4116# a_1520_184# 0.08246f
C452 rsel en 0.13259f
C453 a_1824_184# stb 0.11685f
C454 a_1824_184# aux 0.05093f
C455 spk hold 0.06746f
C456 a_1824_184# vbp_st 0.00262f
C457 a_2040_4116# a_2826_2328# 0.07901f
C458 vm sta 0.05843f
C459 a_2700_4160# stb 0.00167f
C460 vbn_prb abus 0.02315f
C461 aux vss 0.44588f
C462 sub vss 0.01986f
C463 vreset vss 2.64726f
C464 vsrc vss 4.8319f
C465 abus vss 2.88664f
C466 vdd vss 25.14417f
C467 a_1824_184# vss 0.91021f
C468 a_1520_184# vss 1.98207f
C469 a_1370_1924# vss 3.62775f
C470 a_410_1924# vss 0.49556f
C471 a_2582_2372# vss 0.65708f
C472 a_410_2372# vss 1.314f
C473 a_188_3812# vss 1.31379f
C474 a_3116_4160# vss 0.25598f
C475 a_3004_4160# vss 0.85124f
C476 a_676_184# vss 1.29256f
C477 a_276_4116# vss 0.489f
C478 a_2700_4160# vss 1.19193f
C479 a_188_5300# vss 4.75618f
.ends
