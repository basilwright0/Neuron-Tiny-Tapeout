* NGSPICE file created from cxslot_ah_f.ext - technology: gf180mcuD

.subckt cxslot_ah_f vss vbp_syn vdd el aux vbn_leak vsrc vbp_st vbn_prb vbn_ref en
+ vreset abus sta stb hold mreset rsel sub sub_b spk vm
X0 vm hold a_266_2577# vdd pfet_03v3 ad=0.44p pd=2.88u as=0.44p ps=2.88u w=1u l=0.28u
X1 a_1054_2577# vbp_syn a_266_1929# vdd pfet_03v3 ad=0.52p pd=2.52u as=0.88p ps=4.88u w=2u l=4u
X2 a_2192_4096# a_2214_2129# vsrc vss nfet_03v3 ad=0.22p pd=1.88u as=0.22p ps=1.88u w=0.5u l=0.28u
X3 a_1492_5788# a_1492_5788# a_188_5914# vss nfet_03v3 ad=0.52p pd=2.52u as=0.52p ps=2.52u w=2u l=1u
X4 vss vbn_leak a_188_5914# vss nfet_03v3 ad=0.44p pd=2.88u as=0.44p ps=2.88u w=1u l=4u
X5 a_188_5914# a_188_4570# a_188_4570# vss nfet_03v3 ad=0.52p pd=2.52u as=0.52p ps=2.52u w=2u l=1u
X6 a_2628_4570# vbn_prb vss vss nfet_03v3 ad=0.88p pd=4.88u as=0.52p ps=2.52u w=2u l=2u
X7 a_676_184# vm vdd vss nfet_03v3 ad=1.76p pd=8.88u as=1.76p ps=8.88u w=4u l=2u
X8 vm sta a_266_1929# vss nfet_03v3 ad=0.13p pd=1.02u as=0.22p ps=1.88u w=0.5u l=0.28u
X9 vss vm vss vss nfet_03v3 ad=0.9191p pd=4.055u as=9.167p ps=47.39u w=3.535u l=7.07u
X10 a_188_5914# a_1492_5788# a_1492_5788# vss nfet_03v3 ad=0.88p pd=4.88u as=0.52p ps=2.52u w=2u l=1u
X11 a_188_4570# a_266_2577# a_266_2577# vss nfet_03v3 ad=0.88p pd=4.88u as=0.52p ps=2.52u w=2u l=1u
X12 vss spk a_1750_2831# vss nfet_03v3 ad=0.13p pd=1.02u as=0.22p ps=1.88u w=0.5u l=0.28u
X13 a_2294_1881# vm a_3318_2129# vdd pfet_03v3 ad=0.44p pd=2.88u as=0.14p ps=1.28u w=1u l=0.5u
X14 a_1750_2831# spk vdd vdd pfet_03v3 ad=0.44p pd=2.88u as=0.26p ps=1.52u w=1u l=0.28u
X15 vreset a_276_3842# vm vss nfet_03v3 ad=0.44p pd=2.88u as=0.44p ps=2.88u w=1u l=0.5u
X16 a_1054_2577# hold vdd vdd pfet_03v3 ad=0.44p pd=2.88u as=0.44p ps=2.88u w=1u l=2u
X17 a_1480_184# stb vss vdd pfet_03v3 ad=0.44p pd=2.88u as=0.26p ps=1.52u w=1u l=0.28u
X18 a_188_5914# a_1492_5788# a_1492_5788# vss nfet_03v3 ad=0.52p pd=2.52u as=0.52p ps=2.52u w=2u l=1u
X19 a_188_4570# a_188_4570# a_188_5914# vss nfet_03v3 ad=0.52p pd=2.52u as=0.52p ps=2.52u w=2u l=1u
X20 vdd a_3048_5914# a_266_2577# vdd pfet_03v3 ad=0.52p pd=2.52u as=0.88p ps=4.88u w=2u l=4u
X21 vss a_276_3842# vss vss nfet_03v3 ad=0.7788p pd=4.42u as=0 ps=0 w=1.77u l=3.54u
X22 vss vm vss vss nfet_03v3 ad=1.5554p pd=7.95u as=0 ps=0 w=3.535u l=7.07u
X23 a_188_5914# a_188_4570# a_188_4570# vss nfet_03v3 ad=0.52p pd=2.52u as=0.52p ps=2.52u w=2u l=1u
X24 vss sta a_266_1929# vdd pfet_03v3 ad=0.26p pd=1.52u as=0.44p ps=2.88u w=1u l=0.28u
X25 vdd a_1750_2831# a_276_3842# vdd pfet_03v3 ad=0.26p pd=1.52u as=0.44p ps=2.88u w=1u l=0.28u
X26 a_3048_5914# a_3048_5914# vdd vdd pfet_03v3 ad=0.88p pd=4.88u as=0.52p ps=2.52u w=2u l=4u
X27 a_1480_184# stb vm vss nfet_03v3 ad=0.22p pd=1.88u as=0.13p ps=1.02u w=0.5u l=0.28u
X28 a_188_4570# a_188_4570# a_188_5914# vss nfet_03v3 ad=0.52p pd=2.52u as=0.88p ps=4.88u w=2u l=1u
X29 vsrc vm a_2294_1881# vss nfet_03v3 ad=0.44p pd=2.88u as=0.44p ps=2.88u w=1u l=0.5u
X30 abus sub_b a_3200_4570# vss nfet_03v3 ad=0.44p pd=2.88u as=0.14p ps=1.28u w=1u l=0.28u
X31 vsrc a_2294_1881# a_2214_2129# vss nfet_03v3 ad=0.1516p pd=1.64u as=0.1516p ps=1.64u w=0.22u l=2u
X32 a_3318_2129# vbp_st vdd vdd pfet_03v3 ad=0.14p pd=1.28u as=0.26p ps=1.52u w=1u l=2u
X33 a_266_2577# a_266_2577# a_188_4570# vss nfet_03v3 ad=0.52p pd=2.52u as=0.88p ps=4.88u w=2u l=1u
X34 a_3200_4570# rsel a_3088_4570# vss nfet_03v3 ad=0.14p pd=1.28u as=0.14p ps=1.28u w=1u l=0.28u
X35 a_276_3842# mreset vdd vss nfet_03v3 ad=0.22p pd=1.88u as=0.22p ps=1.88u w=0.5u l=0.28u
X36 a_676_184# en a_2628_4570# vss nfet_03v3 ad=0.26p pd=1.52u as=0.44p ps=2.88u w=1u l=0.28u
X37 vss a_276_3842# vss vss nfet_03v3 ad=0.4602p pd=2.29u as=0 ps=0 w=1.77u l=3.54u
X38 a_3088_4570# en a_676_184# vss nfet_03v3 ad=0.14p pd=1.28u as=0.26p ps=1.52u w=1u l=0.28u
X39 vdd spk a_2192_4096# vdd pfet_03v3 ad=0.1516p pd=1.64u as=0.1516p ps=1.64u w=0.22u l=1u
X40 a_1480_184# vbp_syn a_1054_2577# vdd pfet_03v3 ad=0.88p pd=4.88u as=0.52p ps=2.52u w=2u l=4u
X41 a_1492_5788# el a_3048_5914# vss nfet_03v3 ad=0.88p pd=4.88u as=0.52p ps=2.52u w=2u l=1u
X42 a_2778_2577# vbp_st vdd vdd pfet_03v3 ad=0.14p pd=1.28u as=0.26p ps=1.52u w=1u l=2u
X43 a_2192_4096# a_2214_2129# a_2778_2577# vdd pfet_03v3 ad=0.44p pd=2.88u as=0.14p ps=1.28u w=1u l=0.28u
X44 vdd vbp_st a_2358_2129# vdd pfet_03v3 ad=0.26p pd=1.52u as=0.14p ps=1.28u w=1u l=2u
X45 spk a_2192_4096# vss vss nfet_03v3 ad=0.22p pd=1.88u as=0.13p ps=1.02u w=0.5u l=0.28u
X46 vdd a_2192_4096# spk vdd pfet_03v3 ad=0.26p pd=1.52u as=0.44p ps=2.88u w=1u l=0.28u
X47 a_1492_5788# a_1492_5788# a_188_5914# vss nfet_03v3 ad=0.52p pd=2.52u as=0.52p ps=2.52u w=2u l=1u
X48 a_2358_2129# a_2294_1881# a_2214_2129# vdd pfet_03v3 ad=0.14p pd=1.28u as=0.44p ps=2.88u w=1u l=0.28u
X49 a_3048_5914# el a_1492_5788# vss nfet_03v3 ad=0.52p pd=2.52u as=0.88p ps=4.88u w=2u l=1u
X50 vss vbn_ref a_276_3842# vss nfet_03v3 ad=0.52p pd=2.52u as=0.88p ps=4.88u w=2u l=4u
C0 vbn_ref rsel 0
C1 abus a_676_184# 0.01712f
C2 vbp_syn vdd 2.66507f
C3 a_276_3842# hold 0.1535f
C4 vreset vbp_syn 0.16167f
C5 a_2358_2129# a_2214_2129# 0.00912f
C6 a_1750_2831# a_2214_2129# 0
C7 mreset stb 0.00241f
C8 a_2294_1881# a_3318_2129# 0.01093f
C9 a_1750_2831# a_266_2577# 0.04969f
C10 vm a_276_3842# 0.13467f
C11 a_2294_1881# a_676_184# 0.10081f
C12 a_3318_2129# a_676_184# 0
C13 vm el 0.04355f
C14 vbp_st stb 0
C15 a_276_3842# sta 0.25138f
C16 vbp_syn aux 0
C17 vbn_prb a_188_4570# 0
C18 a_276_3842# a_1492_5788# 0
C19 vbp_st sub_b 0
C20 spk vbp_syn 0.33071f
C21 a_1492_5788# el 0.26149f
C22 vbp_st vbn_prb 1.24805f
C23 a_3048_5914# vbp_syn 0.09468f
C24 vdd en 0.47707f
C25 vbp_st vbn_leak 0.03579f
C26 abus vm 0.00273f
C27 vreset en 1.25559f
C28 vbp_st a_1480_184# 0.00998f
C29 a_276_3842# a_2214_2129# 0
C30 vbn_ref a_1750_2831# 0.00172f
C31 a_266_1929# stb 0.10814f
C32 hold a_676_184# 0
C33 mreset a_188_5914# 0.00235f
C34 a_266_2577# a_276_3842# 0.15987f
C35 a_2214_2129# el 0
C36 vreset vdd 0.18925f
C37 a_2192_4096# stb 0
C38 a_2294_1881# vm 0.45005f
C39 a_188_4570# a_188_5914# 0.77829f
C40 vm a_3318_2129# 0.00122f
C41 vbp_st vsrc 1.20856f
C42 vm a_676_184# 0.39902f
C43 a_2628_4570# a_2214_2129# 0
C44 a_2192_4096# sub_b 0
C45 en aux 0.03421f
C46 a_2192_4096# vbn_prb 0.03663f
C47 a_2294_1881# sta 0
C48 spk en 0.37996f
C49 a_2294_1881# a_1492_5788# 0
C50 vbp_st rsel 0
C51 a_2192_4096# vbn_leak 0.00212f
C52 a_676_184# sta 0.10246f
C53 a_266_1929# a_1480_184# 0.02867f
C54 vdd aux 0.07629f
C55 a_3048_5914# en 0.09678f
C56 a_1492_5788# a_676_184# 0
C57 vreset aux 0.03726f
C58 a_2192_4096# a_1480_184# 0
C59 spk vdd 1.07265f
C60 vreset spk 0.08788f
C61 a_3048_5914# vdd 1.77382f
C62 a_3048_5914# vreset 0.00375f
C63 a_2192_4096# vsrc 0.12314f
C64 vbn_ref a_276_3842# 0.09793f
C65 a_1054_2577# a_266_1929# 0.17181f
C66 a_2294_1881# a_2214_2129# 0.48215f
C67 vm hold 0.07273f
C68 vbn_ref el 0.24167f
C69 a_2294_1881# a_266_2577# 0.13941f
C70 a_2192_4096# a_1054_2577# 0
C71 a_2214_2129# a_676_184# 0.14238f
C72 a_266_2577# a_676_184# 0.09674f
C73 a_2192_4096# rsel 0
C74 hold sta 0.02863f
C75 spk aux 0.00729f
C76 vbp_syn stb 0.11311f
C77 a_3048_5914# aux 0.07619f
C78 vm sta 0.03233f
C79 vbp_syn sub_b 0.00165f
C80 abus vbn_ref 0.05123f
C81 vbn_prb vbp_syn 0.04659f
C82 a_3048_5914# spk 0.33378f
C83 vbp_st a_2358_2129# 0
C84 vbp_syn vbn_leak 0.03466f
C85 en sub 0
C86 a_266_2577# hold 0.22046f
C87 vbn_ref a_2294_1881# 0
C88 vbp_syn a_1480_184# 0.21882f
C89 vbn_ref a_676_184# 0
C90 vm a_2214_2129# 0.01652f
C91 vbp_syn a_3200_4570# 0
C92 a_266_2577# vm 0.07973f
C93 vsrc vbp_syn 0.09696f
C94 en stb 0
C95 vbp_syn a_1054_2577# 0.30642f
C96 a_2214_2129# sta 0
C97 vbp_syn a_188_5914# 0.02076f
C98 a_276_3842# mreset 0.13581f
C99 a_266_2577# sta 0.05288f
C100 a_2192_4096# a_1750_2831# 0.01512f
C101 en sub_b 0.02198f
C102 vbp_syn a_3088_4570# 0
C103 rsel vbp_syn 0.0283f
C104 vbn_prb en 0.43653f
C105 a_188_4570# a_276_3842# 0.03245f
C106 vdd stb 0.19492f
C107 vreset stb 0.07237f
C108 vbp_st a_276_3842# 0
C109 a_2628_4570# mreset 0
C110 en vbn_leak 0.03457f
C111 vdd sub_b 0
C112 vbp_st el 0.03393f
C113 vbn_prb vdd 0.138f
C114 en a_1480_184# 0
C115 vreset vbn_prb 0.03817f
C116 a_3048_5914# sub 0.01336f
C117 vdd vbn_leak 0.12951f
C118 vreset vbn_leak 0.03755f
C119 a_266_2577# a_2214_2129# 0.11801f
C120 vbn_ref vm 0.01307f
C121 vsrc en 0.03892f
C122 vdd a_1480_184# 0.35182f
C123 vreset a_1480_184# 0.08281f
C124 en a_188_5914# 0
C125 spk stb 0.02679f
C126 a_276_3842# a_266_1929# 0.11943f
C127 vbn_ref sta 0
C128 sub_b aux 0
C129 abus vbp_st 0.02416f
C130 vbn_prb aux 0.03441f
C131 vsrc vdd 0.1361f
C132 a_2192_4096# a_276_3842# 0.00283f
C133 a_3048_5914# stb 0.08286f
C134 vbn_ref a_1492_5788# 0.28027f
C135 en a_3088_4570# 0
C136 rsel en 0.07284f
C137 vreset vsrc 0.03759f
C138 spk sub_b 0.00892f
C139 vdd a_1054_2577# 0.28219f
C140 vdd a_188_5914# 0.0025f
C141 a_2192_4096# el 0.00455f
C142 vbn_leak aux 1.21485f
C143 spk vbn_prb 0.14236f
C144 vreset a_1054_2577# 0
C145 a_3048_5914# sub_b 0
C146 a_3048_5914# vbn_prb 0.23573f
C147 a_2358_2129# vbp_syn 0
C148 spk vbn_leak 0.00501f
C149 rsel vdd 0.00103f
C150 vbp_st a_2294_1881# 0.33135f
C151 a_1750_2831# vbp_syn 0.00589f
C152 vbp_st a_3318_2129# 0
C153 a_3048_5914# vbn_leak 0.08811f
C154 vbp_st a_676_184# 0.07887f
C155 spk a_1480_184# 0.26262f
C156 vbn_ref a_2214_2129# 0
C157 vsrc aux 0.03573f
C158 a_3048_5914# a_1480_184# 0
C159 vbn_ref a_266_2577# 0.01496f
C160 a_2192_4096# abus 0.00117f
C161 spk a_3200_4570# 0
C162 a_188_5914# aux 0
C163 vsrc spk 0.01172f
C164 a_3048_5914# a_3200_4570# 0
C165 a_3048_5914# vsrc 0.08461f
C166 spk a_188_5914# 0.00538f
C167 rsel aux 0
C168 a_2294_1881# a_266_1929# 0
C169 a_3048_5914# a_188_5914# 0.01058f
C170 a_188_4570# hold 0.01862f
C171 spk a_3088_4570# 0
C172 a_2192_4096# a_2294_1881# 0.25468f
C173 spk rsel 0.03962f
C174 a_676_184# a_266_1929# 0.087f
C175 a_2192_4096# a_3318_2129# 0
C176 a_3048_5914# a_3088_4570# 0
C177 a_3048_5914# rsel 0.00137f
C178 a_2192_4096# a_676_184# 0.06484f
C179 a_2358_2129# en 0.00123f
C180 a_276_3842# vbp_syn 0.25996f
C181 mreset sta 0.00476f
C182 vbp_syn el 0.03569f
C183 vbp_st vm 0.10603f
C184 a_2358_2129# vdd 0.00116f
C185 a_1750_2831# vdd 0.31481f
C186 a_188_4570# a_1492_5788# 0.05641f
C187 a_2628_4570# vbp_syn 0
C188 vbp_st a_1492_5788# 0
C189 hold a_266_1929# 0.01385f
C190 a_2778_2577# a_2294_1881# 0
C191 a_2192_4096# hold 0
C192 abus vbp_syn 0.03122f
C193 a_2778_2577# a_676_184# 0
C194 a_266_2577# mreset 0.00356f
C195 vm a_266_1929# 0.17543f
C196 vbn_prb sub_b 0.00835f
C197 a_2192_4096# vm 0.21119f
C198 spk a_2358_2129# 0.00214f
C199 a_266_2577# a_188_4570# 0.46139f
C200 a_276_3842# en 0
C201 vbp_st a_2214_2129# 0.27708f
C202 a_1750_2831# spk 0.36235f
C203 stb a_1480_184# 0.25351f
C204 sub_b vbn_leak 0
C205 en el 0.03505f
C206 sta a_266_1929# 0.51794f
C207 a_2294_1881# vbp_syn 0.07898f
C208 vbn_prb vbn_leak 0.03522f
C209 vbp_st a_266_2577# 0.06767f
C210 a_3318_2129# vbp_syn 0
C211 a_3048_5914# a_1750_2831# 0.11878f
C212 a_2192_4096# sta 0
C213 vbp_syn a_676_184# 0.17216f
C214 a_276_3842# vdd 0.61113f
C215 a_2192_4096# a_1492_5788# 0
C216 a_2628_4570# en 0.2287f
C217 vreset a_276_3842# 0.17995f
C218 vdd el 1.38526f
C219 vreset el 0.03693f
C220 a_1054_2577# stb 0.00156f
C221 stb a_188_5914# 0
C222 sub_b a_3200_4570# 0
C223 vbn_prb a_3200_4570# 0
C224 vsrc sub_b 0.00827f
C225 a_2628_4570# vdd 0
C226 vsrc vbn_prb 0.12721f
C227 abus en 0.02853f
C228 vbn_prb a_188_5914# 0
C229 vbn_ref mreset 0.04259f
C230 vsrc vbn_leak 1.20885f
C231 a_266_2577# a_266_1929# 0.0227f
C232 a_2192_4096# a_2214_2129# 0.23523f
C233 rsel sub_b 0.11717f
C234 vbn_leak a_188_5914# 0.04293f
C235 a_2192_4096# a_266_2577# 0.17385f
C236 vbn_prb a_3088_4570# 0.00104f
C237 vbn_prb rsel 0.01011f
C238 vbn_ref a_188_4570# 0.01108f
C239 abus vdd 0.10651f
C240 el aux 1.16968f
C241 vbp_syn hold 0.01829f
C242 abus vreset 1.19942f
C243 spk a_276_3842# 0.01673f
C244 a_2294_1881# en 0.09228f
C245 vbn_ref vbp_st 0.03163f
C246 rsel vbn_leak 0
C247 a_1054_2577# a_1480_184# 0.00872f
C248 a_3318_2129# en 0
C249 vsrc a_3200_4570# 0.00194f
C250 spk el 0.01789f
C251 a_3048_5914# a_276_3842# 0.40247f
C252 a_676_184# en 0.30312f
C253 a_2628_4570# aux 0
C254 vm vbp_syn 0.55515f
C255 a_3048_5914# el 0.2742f
C256 a_2294_1881# vdd 0.59517f
C257 a_2628_4570# spk 0.00137f
C258 a_3318_2129# vdd 0.00114f
C259 vreset a_2294_1881# 0.00315f
C260 vdd a_676_184# 0.13879f
C261 rsel a_3200_4570# 0.00308f
C262 a_2628_4570# a_3048_5914# 0.00156f
C263 vsrc a_3088_4570# 0.00194f
C264 vbp_syn sta 0.07658f
C265 vsrc rsel 0.01264f
C266 vreset a_676_184# 0.01978f
C267 abus aux 0.02381f
C268 a_1492_5788# vbp_syn 0.00961f
C269 rsel a_188_5914# 0
C270 a_2778_2577# a_2214_2129# 0.0024f
C271 abus spk 0.00412f
C272 a_2778_2577# a_266_2577# 0
C273 rsel a_3088_4570# 0.00121f
C274 a_3048_5914# abus 0.00238f
C275 a_2192_4096# vbn_ref 0
C276 a_2294_1881# aux 0
C277 a_1750_2831# stb 0.0563f
C278 a_676_184# aux 0
C279 spk a_2294_1881# 0.11836f
C280 a_2214_2129# vbp_syn 0.00836f
C281 spk a_3318_2129# 0
C282 a_3048_5914# a_2294_1881# 0.3536f
C283 hold vdd 1.02399f
C284 a_266_2577# vbp_syn 0.00792f
C285 spk a_676_184# 0.12237f
C286 vm en 0.04771f
C287 a_3048_5914# a_676_184# 0.07143f
C288 a_188_4570# mreset 0.03521f
C289 a_276_3842# sub 0.00114f
C290 a_2358_2129# a_1480_184# 0
C291 vm vdd 1.01301f
C292 a_1750_2831# a_1480_184# 0.0183f
C293 vreset vm 0.38464f
C294 a_1492_5788# en 0
C295 vdd sta 0.3034f
C296 vreset sta 0.0655f
C297 a_1492_5788# vdd 0.00104f
C298 a_276_3842# stb 0.58164f
C299 spk hold 0
C300 a_2214_2129# en 0.1542f
C301 vm aux 0.04265f
C302 a_3048_5914# hold 0
C303 vbn_ref vbp_syn 0.05812f
C304 a_266_2577# en 0.03336f
C305 vbn_prb a_276_3842# 0
C306 el sub_b 0
C307 vbn_prb el 0.03426f
C308 spk vm 6.50046f
C309 a_2214_2129# vdd 0.5186f
C310 a_3048_5914# vm 0.20163f
C311 el vbn_leak 0.1201f
C312 a_266_2577# vdd 0.30422f
C313 vreset a_2214_2129# 0
C314 a_2628_4570# sub_b 0
C315 a_1492_5788# aux 0
C316 a_2628_4570# vbn_prb 0.09284f
C317 a_276_3842# a_1480_184# 0.2421f
C318 spk sta 0.00111f
C319 spk a_1492_5788# 0.02645f
C320 a_2192_4096# vbp_st 0.3873f
C321 a_3048_5914# sta 0.00491f
C322 a_3048_5914# a_1492_5788# 0.22132f
C323 abus sub_b 0.01658f
C324 abus vbn_prb 0.02598f
C325 vsrc el 0.03568f
C326 a_276_3842# a_1054_2577# 0.01479f
C327 a_276_3842# a_188_5914# 0
C328 a_2294_1881# stb 0
C329 a_2214_2129# aux 0
C330 abus vbn_leak 0.02439f
C331 el a_188_5914# 0.03813f
C332 a_2628_4570# a_3200_4570# 0
C333 a_676_184# stb 0.08696f
C334 vbn_ref en 1.21132f
C335 spk a_2214_2129# 0.06633f
C336 a_2294_1881# sub_b 0.00149f
C337 rsel el 0.00719f
C338 vbn_prb a_2294_1881# 0.30218f
C339 spk a_266_2577# 0.04031f
C340 a_3048_5914# a_2214_2129# 0.09882f
C341 a_2192_4096# a_266_1929# 0
C342 a_676_184# sub_b 0.00391f
C343 a_3048_5914# a_266_2577# 0.19713f
C344 vbn_prb a_676_184# 0.19119f
C345 a_2294_1881# vbn_leak 0
C346 vbn_ref vdd 0.13695f
C347 abus a_3200_4570# 0.00414f
C348 a_2628_4570# rsel 0
C349 a_2628_4570# a_3088_4570# 0
C350 abus vsrc 0.03952f
C351 vbn_ref vreset 0.0388f
C352 a_2778_2577# vbp_st 0.00283f
C353 a_676_184# vbn_leak 0
C354 a_2294_1881# a_1480_184# 0.03851f
C355 a_3318_2129# a_1480_184# 0
C356 a_676_184# a_1480_184# 0.06314f
C357 abus rsel 0.03502f
C358 a_2294_1881# a_3200_4570# 0
C359 abus a_3088_4570# 0.00316f
C360 vsrc a_2294_1881# 0.0463f
C361 a_676_184# a_3200_4570# 0.00392f
C362 vsrc a_676_184# 0.05831f
C363 a_2294_1881# a_1054_2577# 0
C364 vbp_st vbp_syn 0.08215f
C365 a_2294_1881# a_188_5914# 0
C366 vbn_ref aux 0.03953f
C367 a_1492_5788# sub 0
C368 a_1054_2577# a_676_184# 0.01414f
C369 vm stb 0.0959f
C370 a_2294_1881# a_3088_4570# 0
C371 a_2294_1881# rsel 0.00186f
C372 vbn_ref spk 0.12906f
C373 a_3048_5914# vbn_ref 0.31558f
C374 a_2192_4096# a_2778_2577# 0.00895f
C375 a_676_184# a_3088_4570# 0.005f
C376 rsel a_676_184# 0.00719f
C377 a_1750_2831# a_276_3842# 0.29966f
C378 sta stb 0.17812f
C379 vbn_prb vm 0.08392f
C380 a_1492_5788# stb 0.0013f
C381 vm vbn_leak 0.0434f
C382 mreset en 0
C383 a_266_2577# sub 0.00106f
C384 vbp_syn a_266_1929# 0.25897f
C385 a_2192_4096# vbp_syn 0.17114f
C386 vbn_prb a_1492_5788# 0.00327f
C387 vm a_1480_184# 0.1169f
C388 hold a_1054_2577# 0.08385f
C389 mreset vdd 0.00576f
C390 a_1492_5788# vbn_leak 0.01953f
C391 vbp_st en 0.39783f
C392 vsrc vm 0.09761f
C393 a_2214_2129# stb 0
C394 sta a_1480_184# 0.00402f
C395 a_188_4570# vdd 0.06308f
C396 a_266_2577# stb 0.04456f
C397 vm a_1054_2577# 0.06901f
C398 vbp_st vdd 1.70807f
C399 vbp_st vreset 0.03838f
C400 vbn_prb a_2214_2129# 0.13817f
C401 vm rsel 0
C402 a_2358_2129# a_2294_1881# 0.00169f
C403 vbn_prb a_266_2577# 0
C404 vsrc a_1492_5788# 0
C405 a_1054_2577# sta 0.14599f
C406 a_2214_2129# vbn_leak 0
C407 a_1750_2831# a_2294_1881# 0
C408 a_2358_2129# a_676_184# 0
C409 a_1492_5788# a_188_5914# 1.11534f
C410 vbn_ref sub 0.02378f
C411 a_1750_2831# a_676_184# 0.02561f
C412 a_2214_2129# a_1480_184# 0.05124f
C413 spk mreset 0
C414 a_1492_5788# rsel 0
C415 a_2192_4096# en 0.20201f
C416 a_266_2577# a_1480_184# 0.00164f
C417 a_3048_5914# mreset 0.00762f
C418 vbp_st aux 0.03419f
C419 a_2628_4570# el 0
C420 vdd a_266_1929# 0.39156f
C421 vsrc a_2214_2129# 0.0892f
C422 vreset a_266_1929# 0.17074f
C423 a_3048_5914# a_188_4570# 0
C424 vbp_st spk 0.07591f
C425 a_2192_4096# vdd 0.55217f
C426 a_2192_4096# vreset 0
C427 vbn_ref stb 0.01102f
C428 a_3048_5914# vbp_st 0.17536f
C429 a_266_2577# a_1054_2577# 0.00467f
C430 a_266_2577# a_188_5914# 0.00119f
C431 abus el 0.02501f
C432 rsel a_2214_2129# 0.00201f
C433 vbn_ref sub_b 0
C434 vbn_ref vbn_prb 1.21752f
C435 a_1750_2831# hold 0
C436 a_2628_4570# abus 0
C437 a_2294_1881# a_276_3842# 0
C438 vbn_ref vbn_leak 0.07897f
C439 a_2294_1881# el 0
C440 a_2778_2577# en 0.00182f
C441 a_276_3842# a_676_184# 0.309f
C442 a_2192_4096# aux 0.00299f
C443 a_1750_2831# vm 0
C444 spk a_266_1929# 0
C445 a_676_184# el 0
C446 a_2192_4096# spk 0.19594f
C447 a_2628_4570# a_2294_1881# 0.00264f
C448 a_2778_2577# vdd 0.00398f
C449 vbn_ref a_3200_4570# 0
C450 a_2192_4096# a_3048_5914# 0.20533f
C451 a_1750_2831# sta 0.00122f
C452 a_2628_4570# a_676_184# 0.06252f
C453 vbn_ref vsrc 0.03239f
C454 vbp_syn en 0.13396f
C455 mreset sub 0
C456 vbn_ref a_188_5914# 0.01232f
C457 a_188_4570# sub 0.00149f
C458 aux vss 0.46447f
C459 sub vss 0.00751f
C460 vreset vss 2.82673f
C461 vsrc vss 1.99406f
C462 spk vss 0.75298f
C463 abus vss 3.26913f
C464 vdd vss 26.67753f
C465 a_3318_2129# vss 0.31881f
C466 a_2778_2577# vss 0.33214f
C467 a_1480_184# vss 1.09812f
C468 a_266_1929# vss 1.59523f
C469 a_1054_2577# vss 0.77833f
C470 a_3200_4570# vss 0.24992f
C471 a_3088_4570# vss 0.16368f
C472 a_676_184# vss 4.99199f
C473 a_2628_4570# vss 1.48532f
C474 a_276_3842# vss 1.25967f
C475 a_3048_5914# vss 0.62622f
C476 a_188_5914# vss 4.74546f
C477 a_188_4570# vss 0.48286f
.ends
