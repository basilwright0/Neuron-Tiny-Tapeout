* LVS reference for e1_fb: flattened from cells/neuron/slot.spice by layout/slot/flatten.py
* Cfb (MOM capacitor, value from PEX) omitted: XD.CFB
.subckt ce1_fb vm spk rsel sub sub_b el vsrc vreset vbn_leak vbp_st vbn_ref vbn_prb en abus vdd vss aux vbp_syn sta stb hold mreset grp_en
XXI_XN gb grp_en vss vss nfet_03v3 W=0.5u L=0.28u
XXI_XP gb grp_en vdd vdd pfet_03v3 W=1u L=0.28u
XXEL el_l gb vss vss nfet_03v3 W=0.5u L=0.28u
XXMK vdd gb vr vss nfet_03v3 W=0.5u L=0.28u
XXP1 l1 vbp_st vdd vdd pfet_03v3 W=0.5u L=4u
XXG1 l1 grp_en el_l vss nfet_03v3 W=0.5u L=0.28u
XXE1 el_l el_l mid vss nfet_03v3 W=0.22u L=7u
XXE2 mid mid vss vss nfet_03v3 W=8u L=1u
XXP2 l2 vbp_st vdd vdd pfet_03v3 W=1u L=2u
XXG2 l2 grp_en vsl vss nfet_03v3 W=0.5u L=0.28u
XXV vsl vsl vss vss nfet_03v3 W=1u L=0.5u
XXP3 l3 vbp_st vdd vdd pfet_03v3 W=0.5u L=1u
XXG3 l3 grp_en vs2 vss nfet_03v3 W=0.5u L=0.28u
XXV2 vs2 vs2 vss vss nfet_03v3 W=1u L=0.5u
XXNW vbw mid vss vss nfet_03v3 W=0.22u L=3.3u
XXPW vbw vbw vdd vdd pfet_03v3 W=2u L=1u
XXC_XC vss vm vss vss nfet_03v3 W=7.07u L=7.07u
XXL_XMT XL.t mid vss vss nfet_03v3 W=0.22u L=13u
XXL_XM1 la el_l XL.s1 vss nfet_03v3 W=4u L=0.5u
XXL_XD1 XL.s1 XL.s1 XL.t vss nfet_03v3 W=8u L=0.5u
XXL_XM2 vl vl XL.s2 vss nfet_03v3 W=4u L=0.5u
XXL_XD2 XL.s2 XL.s2 XL.t vss nfet_03v3 W=8u L=0.5u
XXL_XP1 la la vdd vdd pfet_03v3 W=1u L=2u
XXL_XP2 vl la vdd vdd pfet_03v3 W=1u L=2u
XXD_XPS XD.s vbp_st vdd vdd pfet_03v3 W=1u L=2u
XXD_XPI XD.n1 vm XD.s vdd pfet_03v3 W=1u L=0.5u
XXD_XNI XD.n1 vm vsl vss nfet_03v3 W=1u L=0.5u
XXD_XS2 XD.s2 vbp_st vdd vdd pfet_03v3 W=1u L=2u
XXD_XP2 XD.p XD.n1 XD.s2 vdd pfet_03v3 W=1u L=0.28u
XXD_XN2 XD.p XD.n1 vs2 vss nfet_03v3 W=0.22u L=2u
XXD_XS3 XD.s3 vbp_st vdd vdd pfet_03v3 W=1u L=2u
XXD_XP3 XD.pb XD.p XD.s3 vdd pfet_03v3 W=1u L=0.28u
XXD_XN3 XD.pb XD.p vs2 vss nfet_03v3 W=0.5u L=0.28u
XXD_XK XD.pb spk vdd vdd pfet_03v3 W=0.22u L=1u
XXD_Xi4_XN spk XD.pb vss vss nfet_03v3 W=0.5u L=0.28u
XXD_Xi4_XP spk XD.pb vdd vdd pfet_03v3 W=1u L=0.28u
XXR_Xi_XN XR.spkb spk vss vss nfet_03v3 W=0.5u L=0.28u
XXR_Xi_XP XR.spkb spk vdd vdd pfet_03v3 W=1u L=0.28u
XXR_XPC vr XR.spkb vdd vdd pfet_03v3 W=1u L=0.28u
XXR_XNR vr mid vss vss nfet_03v3 W=0.5u L=1.3u
XXR_XCR_XC vss vr vss vss nfet_03v3 W=3.54u L=3.54u
XXR_XSW vm vr el_l vss nfet_03v3 W=1u L=0.5u
XXPM_XMF vdd vm XPM.prb vss nfet_03v3 W=4u L=2u
XXPM_XME XPM.prb en XPM.s vss nfet_03v3 W=1u L=0.28u
XXPM_XMB XPM.s vbn_prb vss vss nfet_03v3 W=2u L=2u
XXPM_XSC XPM.prb en XPM.mc vss nfet_03v3 W=1u L=0.28u
XXPM_XSW XPM.mc rsel XPM.m vss nfet_03v3 W=1u L=0.28u
XXPM_XSB XPM.m sub_b abus vss nfet_03v3 W=1u L=0.28u
XXS_XPH XS.h hold vdd vdd pfet_03v3 W=1u L=2u
XXS_XWA XS.da vbw XS.h vdd pfet_03v3 W=1u L=2u
XXS_XWB XS.db vbw XS.h vdd pfet_03v3 W=1u L=2u
XXS_XNA XS.da sta vm vss nfet_03v3 W=0.5u L=0.28u
XXS_XNB XS.db stb vm vss nfet_03v3 W=0.5u L=0.28u
XXS_XQA vss sta XS.da vdd pfet_03v3 W=1u L=0.28u
XXS_XQB vss stb XS.db vdd pfet_03v3 W=1u L=0.28u
XXS_XHL vm hold vl vdd pfet_03v3 W=1u L=0.28u
XXS_XMR vdd mreset vr vss nfet_03v3 W=0.5u L=0.28u
.ends ce1_fb
