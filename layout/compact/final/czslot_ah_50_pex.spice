* NGSPICE file created from czslot_ah_50.ext - technology: gf180mcuD

.subckt czslot_ah_50 vss vbp_syn vdd el aux vbn_leak vsrc vbp_st vbn_prb vbn_ref en
+ vreset abus sta stb hold mreset rsel sub sub_b spk vm
X0 vdd a_2280_4810# a_276_4082# vdd pfet_03v3 ad=0.26p pd=1.52u as=0.44p ps=2.88u w=1u l=0.28u
X1 a_2088_184# en a_2996_4810# vss nfet_03v3 ad=0.26p pd=1.52u as=0.14p ps=1.28u w=1u l=0.28u
X2 vdd spk a_2520_4964# vdd pfet_03v3 ad=0.1516p pd=1.64u as=0.1516p ps=1.64u w=0.22u l=1u
X3 a_1154_2049# hold vdd vdd pfet_03v3 ad=0.44p pd=2.88u as=0.44p ps=2.88u w=1u l=2u
X4 a_188_6274# a_276_6148# a_276_6148# vss nfet_03v3 ad=1.02p pd=3.02u as=1.02p ps=3.02u w=2u l=0.5u
X5 a_3268_4810# vbn_prb vss vss nfet_03v3 ad=0.88p pd=4.88u as=0.52p ps=2.52u w=2u l=2u
X6 vss sta a_188_184# vdd pfet_03v3 ad=0.26p pd=1.52u as=0.44p ps=2.88u w=1u l=0.28u
X7 a_276_6148# a_276_6148# a_188_6274# vss nfet_03v3 ad=1.02p pd=3.02u as=1.38p ps=5.38u w=2u l=0.5u
X8 vm sta a_188_184# vss nfet_03v3 ad=0.13p pd=1.02u as=0.22p ps=1.88u w=0.5u l=0.28u
X9 a_2088_184# vm vdd vss nfet_03v3 ad=1.76p pd=8.88u as=1.76p ps=8.88u w=4u l=2u
X10 a_1154_2049# vbp_syn a_188_184# vdd pfet_03v3 ad=0.52p pd=2.52u as=0.88p ps=4.88u w=2u l=4u
X11 vdd vbp_st a_2818_2249# vdd pfet_03v3 ad=0.26p pd=1.52u as=0.14p ps=1.28u w=1u l=2u
X12 vsrc a_2720_4336# a_2520_4964# vss nfet_03v3 ad=0.22p pd=1.88u as=0.22p ps=1.88u w=0.5u l=0.28u
X13 a_2818_2249# a_2720_4336# a_2520_4964# vdd pfet_03v3 ad=0.14p pd=1.28u as=0.44p ps=2.88u w=1u l=0.28u
X14 spk a_2520_4964# vdd vdd pfet_03v3 ad=0.44p pd=2.88u as=0.26p ps=1.52u w=1u l=0.28u
X15 spk a_2520_4964# vss vss nfet_03v3 ad=0.22p pd=1.88u as=0.13p ps=1.02u w=0.5u l=0.28u
X16 vsrc a_1670_2697# a_2720_4336# vss nfet_03v3 ad=0.1516p pd=1.64u as=0.1516p ps=1.64u w=0.22u l=2u
X17 a_276_4082# mreset vdd vss nfet_03v3 ad=0.22p pd=1.88u as=0.22p ps=1.88u w=0.5u l=0.28u
X18 vdd a_3174_2653# a_1320_5264# vdd pfet_03v3 ad=0.52p pd=2.52u as=0.88p ps=4.88u w=2u l=4u
X19 a_276_6148# el a_3174_2653# vss nfet_03v3 ad=1.38p pd=5.38u as=1.02p ps=3.02u w=2u l=0.5u
X20 a_1320_5264# hold vm vdd pfet_03v3 ad=0.44p pd=2.88u as=0.44p ps=2.88u w=1u l=0.28u
X21 vdd vbp_st a_1858_2697# vdd pfet_03v3 ad=0.26p pd=1.52u as=0.14p ps=1.28u w=1u l=2u
X22 a_1320_5264# a_1320_5264# a_1232_4810# vss nfet_03v3 ad=1.02p pd=3.02u as=1.38p ps=5.38u w=2u l=0.5u
X23 vss a_276_4082# vss vss nfet_03v3 ad=0.7788p pd=4.42u as=7.7732p ps=41.3u w=1.77u l=3.54u
X24 a_2818_2697# vbp_st vdd vdd pfet_03v3 ad=0.14p pd=1.28u as=0.26p ps=1.52u w=1u l=2u
X25 a_3174_2653# a_3174_2653# vdd vdd pfet_03v3 ad=0.88p pd=4.88u as=0.52p ps=2.52u w=2u l=4u
X26 a_276_4082# vbn_ref vss vss nfet_03v3 ad=0.88p pd=4.88u as=0.88p ps=4.88u w=2u l=4u
X27 vss spk a_2280_4810# vss nfet_03v3 ad=0.13p pd=1.02u as=0.22p ps=1.88u w=0.5u l=0.28u
X28 a_2884_4810# sub_b abus vss nfet_03v3 ad=0.14p pd=1.28u as=0.44p ps=2.88u w=1u l=0.28u
X29 a_492_184# stb vm vss nfet_03v3 ad=0.22p pd=1.88u as=0.13p ps=1.02u w=0.5u l=0.28u
X30 a_1232_4810# a_1232_4810# a_188_6274# vss nfet_03v3 ad=1.02p pd=3.02u as=1.02p ps=3.02u w=2u l=0.5u
X31 a_188_6274# a_276_6148# a_276_6148# vss nfet_03v3 ad=1.02p pd=3.02u as=1.02p ps=3.02u w=2u l=0.5u
X32 vreset a_276_4082# vm vss nfet_03v3 ad=0.44p pd=2.88u as=0.44p ps=2.88u w=1u l=0.5u
X33 a_1858_2697# vm a_1670_2697# vdd pfet_03v3 ad=0.14p pd=1.28u as=0.44p ps=2.88u w=1u l=0.5u
X34 a_1232_4810# a_1320_5264# a_1320_5264# vss nfet_03v3 ad=1.38p pd=5.38u as=1.02p ps=3.02u w=2u l=0.5u
X35 vss a_276_4082# vss vss nfet_03v3 ad=0.4602p pd=2.29u as=0 ps=0 w=1.77u l=3.54u
X36 vss vm vss vss nfet_03v3 ad=1.5576p pd=7.96u as=0 ps=0 w=3.54u l=3.54u
X37 a_1232_4810# a_1232_4810# a_188_6274# vss nfet_03v3 ad=1.02p pd=3.02u as=1.02p ps=3.02u w=2u l=0.5u
X38 vss vbn_leak a_188_6274# vss nfet_03v3 ad=0.52p pd=2.52u as=0.77p ps=2.77u w=2u l=4u
X39 a_1670_2697# vm vsrc vss nfet_03v3 ad=0.44p pd=2.88u as=0.44p ps=2.88u w=1u l=0.5u
X40 a_2720_4336# a_1670_2697# a_2818_2697# vdd pfet_03v3 ad=0.44p pd=2.88u as=0.14p ps=1.28u w=1u l=0.28u
X41 a_2996_4810# rsel a_2884_4810# vss nfet_03v3 ad=0.14p pd=1.28u as=0.14p ps=1.28u w=1u l=0.28u
X42 a_3268_4810# en a_2088_184# vss nfet_03v3 ad=0.44p pd=2.88u as=0.26p ps=1.52u w=1u l=0.28u
X43 a_3174_2653# el a_276_6148# vss nfet_03v3 ad=1.02p pd=3.02u as=1.38p ps=5.38u w=2u l=0.5u
X44 a_492_184# stb vss vdd pfet_03v3 ad=0.44p pd=2.88u as=0.26p ps=1.52u w=1u l=0.28u
X45 a_188_6274# a_1232_4810# a_1232_4810# vss nfet_03v3 ad=1.02p pd=3.02u as=1.02p ps=3.02u w=2u l=0.5u
X46 a_276_6148# a_276_6148# a_188_6274# vss nfet_03v3 ad=1.02p pd=3.02u as=1.02p ps=3.02u w=2u l=0.5u
X47 a_492_184# vbp_syn a_1154_2049# vdd pfet_03v3 ad=0.88p pd=4.88u as=0.52p ps=2.52u w=2u l=4u
X48 a_188_6274# a_1232_4810# a_1232_4810# vss nfet_03v3 ad=0.77p pd=2.77u as=1.02p ps=3.02u w=2u l=0.5u
X49 a_2280_4810# spk vdd vdd pfet_03v3 ad=0.44p pd=2.88u as=0.26p ps=1.52u w=1u l=0.28u
C0 mreset a_276_4082# 0.01602f
C1 en a_2996_4810# 0
C2 spk a_1232_4810# 0.12536f
C3 a_2088_184# en 0.0994f
C4 a_2818_2249# spk 0
C5 a_276_6148# a_1154_2049# 0.00231f
C6 sub_b a_2280_4810# 0
C7 a_3268_4810# a_2520_4964# 0
C8 a_2818_2697# a_276_4082# 0
C9 a_2088_184# a_276_6148# 0.14453f
C10 a_3268_4810# vbn_ref 0.05297f
C11 vbn_ref stb 0.01052f
C12 a_2088_184# a_1858_2697# 0
C13 sub_b a_1232_4810# 0
C14 a_2720_4336# a_1320_5264# 0.09498f
C15 a_2720_4336# a_1670_2697# 0.43401f
C16 a_276_4082# a_1154_2049# 0.0051f
C17 el vbp_syn 0.09598f
C18 a_276_6148# a_188_6274# 0.54882f
C19 vdd sta 0.1805f
C20 a_2520_4964# a_1320_5264# 0.07796f
C21 a_2520_4964# a_1670_2697# 0.31984f
C22 rsel vdd 0
C23 a_2088_184# a_276_4082# 0.01227f
C24 a_276_6148# a_2280_4810# 0.1908f
C25 vreset vdd 0.23811f
C26 vbn_ref a_1320_5264# 0.04737f
C27 vbn_ref a_1670_2697# 0
C28 a_276_4082# a_188_6274# 0
C29 a_276_6148# a_1232_4810# 0.04893f
C30 a_276_4082# a_2280_4810# 0.38876f
C31 stb a_492_184# 0.29367f
C32 a_2818_2249# a_276_4082# 0
C33 a_276_4082# a_1232_4810# 0.1551f
C34 a_2720_4336# spk 0.02598f
C35 rsel sub 0
C36 vbn_leak vbp_syn 0.05519f
C37 a_2520_4964# spk 0.65297f
C38 a_1320_5264# a_492_184# 0.00978f
C39 a_2720_4336# sub_b 0
C40 a_1670_2697# a_492_184# 0
C41 rsel a_2884_4810# 0
C42 vbn_ref spk 0.12529f
C43 a_3174_2653# vdd 1.92099f
C44 a_188_184# vbp_syn 0.07719f
C45 a_2520_4964# sub_b 0.00367f
C46 vm vdd 0.76445f
C47 vbn_ref sub_b 0.00108f
C48 vdd hold 0.94522f
C49 a_2520_4964# en 0
C50 el vbn_leak 0.02539f
C51 vdd vsrc 0.13596f
C52 a_276_6148# a_2720_4336# 0.04468f
C53 a_3268_4810# a_1320_5264# 0
C54 a_1320_5264# stb 0.00405f
C55 a_3268_4810# a_1670_2697# 0.00693f
C56 a_1670_2697# stb 0
C57 vbn_ref en 1.26151f
C58 a_2520_4964# a_276_6148# 0.11344f
C59 vbp_syn sta 0.04631f
C60 vdd vbp_st 1.95358f
C61 a_2720_4336# a_276_4082# 0.00249f
C62 vbn_ref a_276_6148# 0.20245f
C63 spk a_492_184# 0.05088f
C64 mreset vdd 0.09411f
C65 rsel vbp_syn 0
C66 vm sub 0
C67 vdd aux 0.07029f
C68 vreset vbp_syn 0.04059f
C69 vdd abus 0.10457f
C70 a_1320_5264# a_1670_2697# 0.19159f
C71 a_2520_4964# a_276_4082# 0.023f
C72 vdd vbn_prb 0.14527f
C73 a_2818_2697# vdd 0.00226f
C74 vbn_ref a_276_4082# 0.1088f
C75 vdd a_1154_2049# 0.30881f
C76 a_3268_4810# spk 0.20383f
C77 stb spk 0.00379f
C78 a_2884_4810# vsrc 0.00158f
C79 rsel el 0
C80 mreset sub 0.01016f
C81 vreset el 0.0784f
C82 a_2088_184# vdd 0.18224f
C83 a_276_6148# a_492_184# 0.00363f
C84 a_3268_4810# sub_b 0.01862f
C85 a_1320_5264# spk 0.01014f
C86 a_1670_2697# spk 0.02295f
C87 a_3174_2653# vbp_syn 0.27247f
C88 a_2884_4810# abus 0.00663f
C89 a_3268_4810# en 0.07378f
C90 vdd a_2280_4810# 0.64981f
C91 a_276_4082# a_492_184# 0.09276f
C92 vm vbp_syn 0.19518f
C93 a_1320_5264# sub_b 0
C94 vdd a_1232_4810# 0.03541f
C95 a_2818_2249# vdd 0.00252f
C96 a_3268_4810# a_276_6148# 0.00157f
C97 hold vbp_syn 0.01978f
C98 a_276_6148# stb 0.17066f
C99 vbp_syn vsrc 0.03943f
C100 a_1670_2697# en 0.0052f
C101 rsel vbn_leak 0.00144f
C102 vreset vbn_leak 0.03768f
C103 a_3174_2653# el 0.30456f
C104 a_188_184# sta 0.39575f
C105 a_276_4082# stb 0.06711f
C106 vbp_syn vbp_st 0.1669f
C107 a_2280_4810# sub 0.0171f
C108 a_1858_2697# a_1320_5264# 0
C109 a_2088_184# a_2884_4810# 0.00483f
C110 a_276_6148# a_1320_5264# 0.03548f
C111 a_1858_2697# a_1670_2697# 0.00952f
C112 a_276_6148# a_1670_2697# 0.14305f
C113 vm el 0
C114 vbp_syn aux 0
C115 abus vbp_syn 0.02323f
C116 a_1232_4810# sub 0.01922f
C117 el vsrc 0.08616f
C118 a_1320_5264# a_276_4082# 0.2007f
C119 vbn_prb vbp_syn 0.06389f
C120 sub_b spk 0.02895f
C121 a_1670_2697# a_276_4082# 0.20278f
C122 a_2818_2697# vbp_syn 0
C123 a_1154_2049# vbp_syn 0.18016f
C124 el vbp_st 0.03877f
C125 spk en 0.03584f
C126 el aux 1.23792f
C127 a_2720_4336# vdd 0.39029f
C128 el abus 0.0226f
C129 a_2088_184# vbp_syn 0.11096f
C130 a_3174_2653# vbn_leak 0.09577f
C131 a_276_6148# spk 0.2136f
C132 sub_b en 0.01536f
C133 a_2520_4964# vdd 0.62086f
C134 vreset rsel 0
C135 a_188_6274# vbp_syn 0.00286f
C136 el vbn_prb 0.02703f
C137 vbn_ref vdd 0.12638f
C138 a_2280_4810# vbp_syn 0.30306f
C139 a_276_6148# sub_b 0
C140 vbn_leak vsrc 1.27886f
C141 a_276_4082# spk 0.00391f
C142 vm a_188_184# 0.07348f
C143 a_1232_4810# vbp_syn 0.00234f
C144 a_2818_2249# vbp_syn 0
C145 a_2088_184# el 0.00187f
C146 a_276_6148# en 0.00219f
C147 vbn_leak vbp_st 0.03962f
C148 vbn_leak aux 1.2577f
C149 a_1858_2697# a_276_6148# 0
C150 vbn_leak abus 0.02484f
C151 vbn_ref sub 0
C152 vdd a_492_184# 0.47575f
C153 vm sta 0.06898f
C154 vbn_leak vbn_prb 0.12838f
C155 a_2520_4964# a_2884_4810# 0.001f
C156 a_3174_2653# vreset 0.11019f
C157 a_276_6148# a_276_4082# 0.51326f
C158 a_1858_2697# a_276_4082# 0.00368f
C159 vm vreset 0.2037f
C160 vreset hold 0
C161 rsel vsrc 0.01174f
C162 vreset vsrc 0.14072f
C163 a_2088_184# vbn_leak 0.00296f
C164 a_188_184# a_1154_2049# 0.01081f
C165 a_3268_4810# vdd 0.08117f
C166 stb vdd 0.2121f
C167 vbn_leak a_188_6274# 0.06524f
C168 a_2720_4336# vbp_syn 0.04393f
C169 rsel vbp_st 0
C170 vreset vbp_st 0.05349f
C171 a_2280_4810# vbn_leak 0.00122f
C172 rsel aux 0
C173 a_2520_4964# vbp_syn 0.16896f
C174 rsel abus 0.09391f
C175 vreset aux 0.03757f
C176 vreset abus 1.26776f
C177 a_1320_5264# vdd 0.39293f
C178 vbn_leak a_1232_4810# 0.00855f
C179 vbn_ref vbp_syn 0.02296f
C180 a_1670_2697# vdd 0.40334f
C181 rsel vbn_prb 0
C182 a_188_184# a_2280_4810# 0.00238f
C183 a_1154_2049# sta 0.00208f
C184 vreset vbn_prb 0.039f
C185 vm a_3174_2653# 0
C186 a_2720_4336# el 0
C187 a_3174_2653# vsrc 0.0835f
C188 a_2520_4964# el 0.00213f
C189 rsel a_2996_4810# 0.00211f
C190 vm hold 0.08093f
C191 a_2088_184# rsel 0.01024f
C192 a_3268_4810# a_2884_4810# 0
C193 a_2088_184# vreset 0.02698f
C194 vm vsrc 0.07183f
C195 a_1320_5264# sub 0
C196 vbn_ref el 0.02417f
C197 a_3174_2653# vbp_st 0.08478f
C198 a_2280_4810# sta 0.00411f
C199 a_492_184# vbp_syn 0.43634f
C200 a_3174_2653# aux 0.08067f
C201 spk vdd 1.00325f
C202 vm vbp_st 0.04939f
C203 rsel a_2280_4810# 0
C204 a_3174_2653# abus 0.0023f
C205 vreset a_2280_4810# 0.00193f
C206 mreset vm 0.00117f
C207 hold vbp_st 0
C208 rsel a_1232_4810# 0
C209 vbp_st vsrc 1.27881f
C210 vreset a_1232_4810# 0
C211 a_3174_2653# vbn_prb 0.07785f
C212 sub_b vdd 0
C213 a_2720_4336# vbn_leak 0
C214 aux vsrc 0.03879f
C215 abus vsrc 0.03651f
C216 a_3268_4810# vbp_syn 0.04358f
C217 stb vbp_syn 0.07447f
C218 vdd en 0.13662f
C219 a_2520_4964# vbn_leak 0
C220 vm a_1154_2049# 0.14229f
C221 vbn_prb vsrc 0.03133f
C222 spk sub 0
C223 aux vbp_st 0.03845f
C224 abus vbp_st 0.02242f
C225 a_2088_184# a_3174_2653# 0.01942f
C226 vbn_ref vbn_leak 0.15092f
C227 hold a_1154_2049# 0.0473f
C228 a_1858_2697# vdd 0.00349f
C229 a_276_6148# vdd 0.15757f
C230 a_2088_184# vm 0.14495f
C231 abus aux 0.02232f
C232 vbn_prb vbp_st 1.26698f
C233 a_1320_5264# vbp_syn 0.02589f
C234 a_2818_2697# vbp_st 0
C235 a_1670_2697# vbp_syn 0.00815f
C236 spk a_2884_4810# 0
C237 a_2088_184# hold 0
C238 a_2996_4810# vsrc 0.00159f
C239 vbn_prb aux 0.02611f
C240 a_2088_184# vsrc 0.08831f
C241 abus vbn_prb 0.02301f
C242 a_3268_4810# el 0.03194f
C243 a_276_4082# vdd 0.673f
C244 vm a_2280_4810# 0.10097f
C245 sub_b a_2884_4810# 0
C246 a_2280_4810# hold 0.0384f
C247 a_2088_184# vbp_st 0.16604f
C248 vm a_1232_4810# 0
C249 rsel a_2720_4336# 0.00126f
C250 a_2280_4810# vsrc 0.00769f
C251 vreset a_2720_4336# 0.0339f
C252 abus a_2996_4810# 0.00411f
C253 hold a_1232_4810# 0.01574f
C254 a_2088_184# aux 0
C255 a_2088_184# abus 0.02664f
C256 a_1670_2697# el 0.00376f
C257 vbn_ref sta 0.00797f
C258 a_2520_4964# rsel 0
C259 mreset a_188_6274# 0
C260 a_2520_4964# vreset 0.02828f
C261 a_2280_4810# vbp_st 0.09956f
C262 abus a_188_6274# 0
C263 vbn_ref rsel 0.00157f
C264 a_276_4082# sub 0
C265 a_188_184# a_492_184# 0.02037f
C266 a_2088_184# a_2818_2697# 0
C267 vbn_ref vreset 0.03975f
C268 spk vbp_syn 0.57745f
C269 mreset a_2280_4810# 0.03235f
C270 a_2818_2249# vbp_st 0.00186f
C271 a_2280_4810# abus 0.00724f
C272 vbn_prb a_188_6274# 0
C273 mreset a_1232_4810# 0.11287f
C274 a_1232_4810# abus 0
C275 a_3268_4810# vbn_leak 0.18385f
C276 sub_b vbp_syn 0
C277 a_2088_184# a_2996_4810# 0.00704f
C278 a_2280_4810# a_1154_2049# 0.00585f
C279 en vbp_syn 0.02255f
C280 stb a_188_184# 0.01281f
C281 a_492_184# sta 0.16991f
C282 el spk 0.03651f
C283 a_3174_2653# a_2720_4336# 0.00145f
C284 a_1670_2697# vbn_leak 0.00141f
C285 a_2088_184# a_2280_4810# 0.045f
C286 vm a_2720_4336# 0.02001f
C287 a_276_6148# vbp_syn 0.07493f
C288 a_3174_2653# a_2520_4964# 0.15189f
C289 sub_b el 0
C290 a_2280_4810# a_188_6274# 0.03729f
C291 a_2720_4336# hold 0
C292 a_2088_184# a_2818_2249# 0
C293 a_1320_5264# a_188_184# 0
C294 a_2720_4336# vsrc 0.14863f
C295 vm a_2520_4964# 0.01908f
C296 vbn_ref a_3174_2653# 0.04304f
C297 a_1232_4810# a_188_6274# 0.53058f
C298 a_276_4082# vbp_syn 0.05323f
C299 vm vbn_ref 0
C300 stb sta 0.5388f
C301 el en 0.02415f
C302 a_2520_4964# vsrc 0.15653f
C303 a_2280_4810# a_1232_4810# 0.26834f
C304 a_2720_4336# vbp_st 0.28891f
C305 a_2818_2249# a_2280_4810# 0
C306 a_3268_4810# rsel 0.05611f
C307 a_3268_4810# vreset 0
C308 vbn_ref vsrc 0.03039f
C309 vreset stb 0
C310 a_276_6148# el 0.27747f
C311 a_2720_4336# aux 0
C312 a_2720_4336# abus 0.0028f
C313 a_2520_4964# vbp_st 0.24064f
C314 a_1320_5264# sta 0
C315 spk vbn_leak 0.44128f
C316 mreset a_2520_4964# 0
C317 a_1670_2697# sta 0
C318 vbn_ref vbp_st 0.02699f
C319 a_2520_4964# aux 0.00134f
C320 a_2520_4964# abus 0.02905f
C321 a_2818_2697# a_2720_4336# 0.01162f
C322 rsel a_1320_5264# 0
C323 mreset vbn_ref 0.00849f
C324 vreset a_1320_5264# 0.00765f
C325 rsel a_1670_2697# 0.00108f
C326 vbn_ref aux 0.024f
C327 vreset a_1670_2697# 0.1807f
C328 sub_b vbn_leak 0.00245f
C329 vbn_ref abus 0.42886f
C330 a_2720_4336# a_1154_2049# 0
C331 a_2520_4964# vbn_prb 0
C332 vm a_492_184# 0.32021f
C333 vbn_ref vbn_prb 1.28089f
C334 hold a_492_184# 0.08438f
C335 en vbn_leak 0.02561f
C336 a_2088_184# a_2720_4336# 0.2637f
C337 a_2520_4964# a_2996_4810# 0
C338 a_2088_184# a_2520_4964# 0.18912f
C339 a_276_6148# vbn_leak 0.03024f
C340 a_492_184# vbp_st 0.00999f
C341 a_2720_4336# a_2280_4810# 0.00744f
C342 vdd sub 0.00252f
C343 a_2088_184# vbn_ref 0
C344 vm stb 0.06234f
C345 rsel spk 0.04806f
C346 stb hold 0.02514f
C347 a_2720_4336# a_2818_2249# 0.0043f
C348 vbn_ref a_188_6274# 0.00505f
C349 vreset spk 0.0663f
C350 a_2520_4964# a_2280_4810# 0.08935f
C351 a_3268_4810# vsrc 0.00799f
C352 a_3174_2653# a_1320_5264# 0.0733f
C353 a_3174_2653# a_1670_2697# 0.01305f
C354 vbn_ref a_2280_4810# 0.36369f
C355 a_2520_4964# a_2818_2249# 0.00907f
C356 a_2520_4964# a_1232_4810# 0
C357 rsel sub_b 0.03655f
C358 vm a_1320_5264# 0.31651f
C359 vreset sub_b 0
C360 vm a_1670_2697# 0.17148f
C361 a_276_4082# a_188_184# 0.00102f
C362 a_3268_4810# vbp_st 0.00123f
C363 vbn_ref a_1232_4810# 0.14566f
C364 a_1320_5264# hold 0.42402f
C365 a_492_184# a_1154_2049# 0.07814f
C366 a_1320_5264# vsrc 0
C367 a_1670_2697# hold 0
C368 a_3268_4810# aux 0.00708f
C369 rsel en 0.2539f
C370 a_1670_2697# vsrc 0.20047f
C371 a_3268_4810# abus 0.05121f
C372 vreset en 1.27652f
C373 a_276_6148# sta 0.03801f
C374 a_2088_184# a_492_184# 0.0035f
C375 a_3268_4810# vbn_prb 0.32123f
C376 a_1320_5264# vbp_st 0.16851f
C377 a_276_6148# rsel 0
C378 a_1670_2697# vbp_st 0.21205f
C379 vreset a_276_6148# 0.30986f
C380 mreset a_1320_5264# 0.03222f
C381 mreset a_1670_2697# 0
C382 a_276_4082# sta 0.04123f
C383 a_1320_5264# abus 0
C384 a_1670_2697# aux 0
C385 stb a_1154_2049# 0.00412f
C386 a_2280_4810# a_492_184# 0.42009f
C387 a_3174_2653# spk 0.12373f
C388 a_1670_2697# abus 0
C389 vdd vbp_syn 2.90413f
C390 vm spk 3.09236f
C391 a_3268_4810# a_2996_4810# 0.00108f
C392 vreset a_276_4082# 0.09391f
C393 a_1670_2697# vbn_prb 0
C394 a_2818_2697# a_1320_5264# 0
C395 a_2088_184# a_3268_4810# 0.06697f
C396 a_2088_184# stb 0
C397 a_2818_2697# a_1670_2697# 0
C398 spk vsrc 0.09756f
C399 a_1320_5264# a_1154_2049# 0.00228f
C400 a_2520_4964# a_2720_4336# 0.25033f
C401 a_3174_2653# en 0.00851f
C402 stb a_2280_4810# 0.33156f
C403 vbn_ref a_2720_4336# 0
C404 a_2088_184# a_1320_5264# 0.09771f
C405 el vdd 1.52249f
C406 sub_b vsrc 0.00575f
C407 spk vbp_st 0.18807f
C408 a_2088_184# a_1670_2697# 0.23218f
C409 a_3268_4810# a_1232_4810# 0.00172f
C410 a_1320_5264# a_188_6274# 0.00108f
C411 mreset spk 0.0118f
C412 vbn_ref a_2520_4964# 0
C413 a_3174_2653# a_276_6148# 0.60156f
C414 spk aux 0.0065f
C415 spk abus 0.27569f
C416 en vsrc 0.03083f
C417 a_1320_5264# a_2280_4810# 0.05901f
C418 vm a_1858_2697# 0
C419 vm a_276_6148# 0.07197f
C420 a_1670_2697# a_2280_4810# 0.00223f
C421 spk vbn_prb 0.01148f
C422 mreset sub_b 0
C423 sub_b aux 0
C424 a_276_6148# hold 0.0436f
C425 sub_b abus 0.09105f
C426 a_1320_5264# a_1232_4810# 0.37355f
C427 a_1320_5264# a_2818_2249# 0
C428 a_3174_2653# a_276_4082# 0
C429 a_276_6148# vsrc 0.08587f
C430 en vbp_st 0.02449f
C431 a_1670_2697# a_1232_4810# 0
C432 vm a_276_4082# 0.54977f
C433 en aux 0.0237f
C434 a_2720_4336# a_492_184# 0
C435 en abus 0.25982f
C436 a_276_4082# hold 0.23184f
C437 spk a_2996_4810# 0
C438 a_276_6148# vbp_st 0.01237f
C439 a_1858_2697# vbp_st 0
C440 a_276_4082# vsrc 0.00757f
C441 a_2088_184# spk 0.46406f
C442 vdd vbn_leak 0.10758f
C443 mreset a_276_6148# 0
C444 a_2520_4964# a_492_184# 0
C445 en vbn_prb 0.02526f
C446 a_276_6148# aux 0.12592f
C447 a_276_6148# abus 0.0011f
C448 spk a_188_6274# 0.10556f
C449 a_2088_184# sub_b 0.00562f
C450 a_276_4082# vbp_st 0.08712f
C451 spk a_2280_4810# 0.33927f
C452 vdd a_188_184# 0.21896f
C453 a_276_6148# vbn_prb 0.00411f
C454 aux vss 0.34017f
C455 sub vss 0.00975f
C456 vsrc vss 1.75217f
C457 vreset vss 1.76623f
C458 abus vss 2.83061f
C459 vdd vss 26.67602f
C460 a_2818_2249# vss 0.57944f
C461 a_2818_2697# vss 0.27202f
C462 a_1858_2697# vss 0.54403f
C463 a_1154_2049# vss 0.89626f
C464 a_492_184# vss 0.95779f
C465 a_188_184# vss 2.37538f
C466 a_2720_4336# vss 0.83331f
C467 a_2088_184# vss 2.97303f
C468 a_2996_4810# vss 0.74083f
C469 a_2884_4810# vss 0.24889f
C470 a_2280_4810# vss 0.60935f
C471 a_3268_4810# vss 1.10599f
C472 a_188_6274# vss 4.75976f
.ends
