* NGSPICE file created from czslot_ah_50.ext - technology: gf180mcuD

.subckt czslot_ah_50 vss vbp_syn vdd el aux vbn_leak vsrc vbp_st vbn_prb vbn_ref en
+ vreset abus sta stb hold mreset rsel sub sub_b spk vm
X0 vdd a_2280_4810# a_276_4082# vdd pfet_03v3 ad=0.26p pd=1.52u as=0.44p ps=2.88u w=1u l=0.28u
X1 a_2088_184# en a_2996_4810# vss nfet_03v3 ad=0.26p pd=1.52u as=0.14p ps=1.28u w=1u l=0.28u
X2 vdd spk a_2520_4964# vdd pfet_03v3 ad=0.1516p pd=1.64u as=0.1516p ps=1.64u w=0.22u l=1u
X3 a_1154_2049# hold vdd vdd pfet_03v3 ad=0.44p pd=2.88u as=0.44p ps=2.88u w=1u l=2u
X4 a_3268_4810# vbn_prb vss vss nfet_03v3 ad=0.88p pd=4.88u as=0.52p ps=2.52u w=2u l=2u
X5 vss sta a_188_184# vdd pfet_03v3 ad=0.26p pd=1.52u as=0.44p ps=2.88u w=1u l=0.28u
X6 vm sta a_188_184# vss nfet_03v3 ad=0.13p pd=1.02u as=0.22p ps=1.88u w=0.5u l=0.28u
X7 a_2088_184# vm vdd vss nfet_03v3 ad=1.76p pd=8.88u as=1.76p ps=8.88u w=4u l=2u
X8 a_1232_4810# a_1320_4766# a_1320_4766# vss nfet_03v3 ad=0.88p pd=4.88u as=0.52p ps=2.52u w=2u l=1u
X9 a_1154_2049# vbp_syn a_188_184# vdd pfet_03v3 ad=0.52p pd=2.52u as=0.88p ps=4.88u w=2u l=4u
X10 vdd vbp_st a_2818_2249# vdd pfet_03v3 ad=0.26p pd=1.52u as=0.14p ps=1.28u w=1u l=2u
X11 a_1232_4810# a_1232_4810# a_188_6274# vss nfet_03v3 ad=0.52p pd=2.52u as=0.52p ps=2.52u w=2u l=1u
X12 vsrc a_2720_4336# a_2520_4964# vss nfet_03v3 ad=0.22p pd=1.88u as=0.22p ps=1.88u w=0.5u l=0.28u
X13 a_2818_2249# a_2720_4336# a_2520_4964# vdd pfet_03v3 ad=0.14p pd=1.28u as=0.44p ps=2.88u w=1u l=0.28u
X14 spk a_2520_4964# vdd vdd pfet_03v3 ad=0.44p pd=2.88u as=0.26p ps=1.52u w=1u l=0.28u
X15 spk a_2520_4964# vss vss nfet_03v3 ad=0.22p pd=1.88u as=0.13p ps=1.02u w=0.5u l=0.28u
X16 vsrc a_1670_2697# a_2720_4336# vss nfet_03v3 ad=0.1516p pd=1.64u as=0.1516p ps=1.64u w=0.22u l=2u
X17 a_276_4082# mreset vdd vss nfet_03v3 ad=0.22p pd=1.88u as=0.22p ps=1.88u w=0.5u l=0.28u
X18 vdd a_3174_2653# a_1320_4766# vdd pfet_03v3 ad=0.52p pd=2.52u as=0.88p ps=4.88u w=2u l=4u
X19 a_1232_4810# a_1232_4810# a_188_6274# vss nfet_03v3 ad=0.52p pd=2.52u as=0.52p ps=2.52u w=2u l=1u
X20 a_1320_4766# hold vm vdd pfet_03v3 ad=0.44p pd=2.88u as=0.44p ps=2.88u w=1u l=0.28u
X21 a_188_6274# a_276_6148# a_276_6148# vss nfet_03v3 ad=0.52p pd=2.52u as=0.52p ps=2.52u w=2u l=1u
X22 vdd vbp_st a_1858_2697# vdd pfet_03v3 ad=0.26p pd=1.52u as=0.14p ps=1.28u w=1u l=2u
X23 a_188_6274# a_1232_4810# a_1232_4810# vss nfet_03v3 ad=0.52p pd=2.52u as=0.52p ps=2.52u w=2u l=1u
X24 vss a_276_4082# vss vss nfet_03v3 ad=0.7788p pd=4.42u as=7.7732p ps=41.3u w=1.77u l=3.54u
X25 a_2818_2697# vbp_st vdd vdd pfet_03v3 ad=0.14p pd=1.28u as=0.26p ps=1.52u w=1u l=2u
X26 a_3174_2653# a_3174_2653# vdd vdd pfet_03v3 ad=0.88p pd=4.88u as=0.52p ps=2.52u w=2u l=4u
X27 a_3174_2653# el a_276_6148# vss nfet_03v3 ad=0.52p pd=2.52u as=0.88p ps=4.88u w=2u l=1u
X28 a_276_4082# vbn_ref vss vss nfet_03v3 ad=0.88p pd=4.88u as=0.88p ps=4.88u w=2u l=4u
X29 vss spk a_2280_4810# vss nfet_03v3 ad=0.13p pd=1.02u as=0.22p ps=1.88u w=0.5u l=0.28u
X30 a_2884_4810# sub_b abus vss nfet_03v3 ad=0.14p pd=1.28u as=0.44p ps=2.88u w=1u l=0.28u
X31 a_492_184# stb vm vss nfet_03v3 ad=0.22p pd=1.88u as=0.13p ps=1.02u w=0.5u l=0.28u
X32 a_188_6274# a_1232_4810# a_1232_4810# vss nfet_03v3 ad=0.52p pd=2.52u as=0.52p ps=2.52u w=2u l=1u
X33 a_276_6148# a_276_6148# a_188_6274# vss nfet_03v3 ad=0.52p pd=2.52u as=0.52p ps=2.52u w=2u l=1u
X34 vreset a_276_4082# vm vss nfet_03v3 ad=0.44p pd=2.88u as=0.44p ps=2.88u w=1u l=0.5u
X35 a_1858_2697# vm a_1670_2697# vdd pfet_03v3 ad=0.14p pd=1.28u as=0.44p ps=2.88u w=1u l=0.5u
X36 vss a_276_4082# vss vss nfet_03v3 ad=0.4602p pd=2.29u as=0 ps=0 w=1.77u l=3.54u
X37 vss vm vss vss nfet_03v3 ad=1.5576p pd=7.96u as=0 ps=0 w=3.54u l=3.54u
X38 vss vbn_leak a_188_6274# vss nfet_03v3 ad=0.52p pd=2.52u as=0.52p ps=2.52u w=2u l=4u
X39 a_1670_2697# vm vsrc vss nfet_03v3 ad=0.44p pd=2.88u as=0.44p ps=2.88u w=1u l=0.5u
X40 a_2720_4336# a_1670_2697# a_2818_2697# vdd pfet_03v3 ad=0.44p pd=2.88u as=0.14p ps=1.28u w=1u l=0.28u
X41 a_2996_4810# rsel a_2884_4810# vss nfet_03v3 ad=0.14p pd=1.28u as=0.14p ps=1.28u w=1u l=0.28u
X42 a_3268_4810# en a_2088_184# vss nfet_03v3 ad=0.44p pd=2.88u as=0.26p ps=1.52u w=1u l=0.28u
X43 a_276_6148# el a_3174_2653# vss nfet_03v3 ad=0.88p pd=4.88u as=0.52p ps=2.52u w=2u l=1u
X44 a_492_184# stb vss vdd pfet_03v3 ad=0.44p pd=2.88u as=0.26p ps=1.52u w=1u l=0.28u
X45 a_188_6274# a_276_6148# a_276_6148# vss nfet_03v3 ad=0.52p pd=2.52u as=0.52p ps=2.52u w=2u l=1u
X46 a_276_6148# a_276_6148# a_188_6274# vss nfet_03v3 ad=0.52p pd=2.52u as=0.88p ps=4.88u w=2u l=1u
X47 a_1320_4766# a_1320_4766# a_1232_4810# vss nfet_03v3 ad=0.52p pd=2.52u as=0.88p ps=4.88u w=2u l=1u
X48 a_492_184# vbp_syn a_1154_2049# vdd pfet_03v3 ad=0.88p pd=4.88u as=0.52p ps=2.52u w=2u l=4u
X49 a_2280_4810# spk vdd vdd pfet_03v3 ad=0.44p pd=2.88u as=0.26p ps=1.52u w=1u l=0.28u
C0 abus a_2720_4336# 0.0028f
C1 a_1154_2049# a_276_4082# 0.0051f
C2 a_3174_2653# vreset 0.11019f
C3 vdd hold 0.94522f
C4 a_3174_2653# aux 0.08067f
C5 rsel a_1320_4766# 0
C6 vm a_1232_4810# 0
C7 a_1670_2697# a_2088_184# 0.23218f
C8 vdd sub 0.00252f
C9 a_2818_2249# spk 0
C10 a_2088_184# a_2280_4810# 0.045f
C11 vdd en 0.13662f
C12 vm a_2520_4964# 0.01908f
C13 a_1320_4766# spk 0.01029f
C14 sub_b mreset 0
C15 vdd vbn_leak 0.10758f
C16 a_1858_2697# vdd 0.00349f
C17 a_3174_2653# en 0.00851f
C18 sub_b rsel 0.03655f
C19 aux vsrc 0.03879f
C20 vreset vsrc 0.14072f
C21 vdd a_492_184# 0.47575f
C22 a_3174_2653# vbn_leak 0.09577f
C23 vbn_ref stb 0.01052f
C24 vbn_ref vreset 0.03975f
C25 vbn_ref aux 0.024f
C26 a_2818_2249# a_1320_4766# 0
C27 sub_b spk 0.02895f
C28 a_2996_4810# a_2088_184# 0.00704f
C29 a_188_184# vbp_syn 0.07719f
C30 a_2088_184# vbp_st 0.16604f
C31 vdd a_1232_4810# 0.03409f
C32 abus rsel 0.09391f
C33 en vsrc 0.03083f
C34 a_276_6148# stb 0.17066f
C35 el vbp_syn 0.10804f
C36 a_2520_4964# vdd 0.62086f
C37 a_276_6148# vreset 0.30952f
C38 a_276_6148# aux 0.12408f
C39 vbn_ref sub 0
C40 vbn_ref en 1.26151f
C41 vbn_leak vsrc 1.27886f
C42 abus spk 0.27569f
C43 vbn_prb vbp_syn 0.06388f
C44 el a_1670_2697# 0.00396f
C45 a_188_184# a_2280_4810# 0.00238f
C46 a_2818_2697# vdd 0.00226f
C47 vbn_ref vbn_leak 0.15092f
C48 a_3174_2653# a_2520_4964# 0.15189f
C49 sub_b a_1320_4766# 0
C50 a_276_6148# hold 0.0436f
C51 vbn_prb a_1670_2697# 0
C52 sta vbp_syn 0.04631f
C53 vbn_prb a_188_6274# 0
C54 a_2088_184# vm 0.14495f
C55 a_1154_2049# a_1320_4766# 0.00228f
C56 a_2884_4810# vsrc 0.00158f
C57 a_276_6148# en 0.00219f
C58 a_1670_2697# sta 0
C59 a_276_6148# vbn_leak 0.03024f
C60 abus a_1320_4766# 0
C61 sta a_2280_4810# 0.00411f
C62 a_276_6148# a_1858_2697# 0
C63 a_3268_4810# vbp_syn 0.04358f
C64 a_2720_4336# vbp_syn 0.04393f
C65 vbn_ref a_1232_4810# 0.14416f
C66 a_2520_4964# vsrc 0.15653f
C67 a_276_6148# a_492_184# 0.00363f
C68 stb vreset 0
C69 aux vreset 0.03757f
C70 a_1670_2697# a_3268_4810# 0.00693f
C71 a_1670_2697# a_2720_4336# 0.43401f
C72 vbn_ref a_2520_4964# 0
C73 a_276_4082# vbp_syn 0.05323f
C74 el vbp_st 0.03878f
C75 a_2720_4336# a_2280_4810# 0.00744f
C76 stb hold 0.02514f
C77 hold vreset 0
C78 sub_b abus 0.09105f
C79 a_276_6148# a_1232_4810# 0.05392f
C80 vbn_prb vbp_st 1.26698f
C81 a_276_4082# a_1670_2697# 0.20278f
C82 a_2088_184# vdd 0.18224f
C83 a_276_4082# a_188_6274# 0
C84 en vreset 1.27652f
C85 en aux 0.0237f
C86 a_276_4082# a_2280_4810# 0.38876f
C87 a_276_6148# a_2520_4964# 0.11344f
C88 vm a_188_184# 0.07348f
C89 vbn_leak vreset 0.03768f
C90 vbn_leak aux 1.2577f
C91 a_2088_184# a_3174_2653# 0.01942f
C92 el vm 0
C93 stb a_492_184# 0.29367f
C94 a_2996_4810# a_3268_4810# 0.00108f
C95 a_1670_2697# mreset 0
C96 a_188_6274# mreset 0
C97 a_3268_4810# vbp_st 0.00123f
C98 rsel vbp_syn 0
C99 a_2720_4336# vbp_st 0.28891f
C100 mreset a_2280_4810# 0.03235f
C101 en vbn_leak 0.02561f
C102 a_492_184# hold 0.08438f
C103 vm sta 0.06898f
C104 a_1670_2697# rsel 0.00108f
C105 spk vbp_syn 0.57745f
C106 a_1232_4810# vreset 0
C107 a_2088_184# vsrc 0.08831f
C108 a_276_4082# vbp_st 0.08712f
C109 rsel a_2280_4810# 0
C110 a_1670_2697# spk 0.02295f
C111 vbn_ref a_2088_184# 0
C112 a_2520_4964# vreset 0.02828f
C113 a_2520_4964# aux 0.00134f
C114 a_188_6274# spk 0.10333f
C115 a_1232_4810# hold 0.01489f
C116 vdd a_188_184# 0.21896f
C117 spk a_2280_4810# 0.33927f
C118 a_2720_4336# vm 0.02001f
C119 el vdd 1.53761f
C120 a_1232_4810# sub 0.01922f
C121 a_2818_2249# vbp_syn 0
C122 a_1320_4766# vbp_syn 0.02589f
C123 a_276_6148# a_2088_184# 0.14418f
C124 vbn_prb vdd 0.14526f
C125 a_276_4082# vm 0.54977f
C126 a_2520_4964# en 0
C127 vbn_leak a_1232_4810# 0.01056f
C128 el a_3174_2653# 0.35744f
C129 a_2996_4810# rsel 0.00211f
C130 a_1670_2697# a_1320_4766# 0.19159f
C131 a_188_6274# a_1320_4766# 0.00108f
C132 a_2818_2249# a_2280_4810# 0
C133 sta vdd 0.1805f
C134 a_2520_4964# vbn_leak 0
C135 rsel vbp_st 0
C136 vbn_prb a_3174_2653# 0.07785f
C137 a_1320_4766# a_2280_4810# 0.06369f
C138 a_2996_4810# spk 0
C139 a_2520_4964# a_492_184# 0
C140 spk vbp_st 0.18807f
C141 sub_b vbp_syn 0
C142 vm mreset 0.00117f
C143 a_3268_4810# vdd 0.08117f
C144 a_2520_4964# a_2884_4810# 0.001f
C145 el vsrc 0.09574f
C146 a_2720_4336# vdd 0.39029f
C147 a_1154_2049# vbp_syn 0.18016f
C148 a_2520_4964# a_1232_4810# 0
C149 sub_b a_2280_4810# 0
C150 el vbn_ref 0.02425f
C151 vbn_prb vsrc 0.03133f
C152 a_2088_184# stb 0
C153 a_2088_184# vreset 0.02698f
C154 a_2088_184# aux 0
C155 abus vbp_syn 0.02323f
C156 a_276_4082# vdd 0.67299f
C157 a_2720_4336# a_3174_2653# 0.00145f
C158 a_2818_2249# vbp_st 0.00186f
C159 vbn_prb vbn_ref 1.28089f
C160 a_1154_2049# a_2280_4810# 0.00585f
C161 vm spk 3.09236f
C162 a_1320_4766# vbp_st 0.16851f
C163 abus a_1670_2697# 0
C164 a_2088_184# hold 0
C165 a_188_6274# abus 0
C166 a_276_4082# a_3174_2653# 0
C167 el a_276_6148# 0.3118f
C168 vbn_ref sta 0.00797f
C169 abus a_2280_4810# 0.00724f
C170 a_2088_184# en 0.0994f
C171 vbn_prb a_276_6148# 0.00411f
C172 a_3268_4810# vsrc 0.00799f
C173 mreset vdd 0.09409f
C174 a_2720_4336# vsrc 0.14863f
C175 a_2088_184# vbn_leak 0.00296f
C176 a_1858_2697# a_2088_184# 0
C177 vbn_ref a_3268_4810# 0.05297f
C178 a_1320_4766# vm 0.31653f
C179 a_276_6148# sta 0.03803f
C180 vbn_ref a_2720_4336# 0
C181 rsel vdd 0
C182 a_2088_184# a_492_184# 0.0035f
C183 a_276_4082# vsrc 0.00757f
C184 a_276_4082# vbn_ref 0.1088f
C185 a_2996_4810# abus 0.00411f
C186 a_2088_184# a_2884_4810# 0.00483f
C187 spk vdd 1.00325f
C188 stb a_188_184# 0.01281f
C189 a_276_6148# a_3268_4810# 0.00157f
C190 abus vbp_st 0.02242f
C191 a_276_6148# a_2720_4336# 0.04468f
C192 el vreset 0.07882f
C193 el aux 1.24053f
C194 a_3174_2653# spk 0.12309f
C195 a_2088_184# a_2520_4964# 0.18912f
C196 vbn_prb vreset 0.039f
C197 vbn_prb aux 0.02611f
C198 a_276_4082# a_276_6148# 0.51326f
C199 a_1154_2049# vm 0.14229f
C200 a_2818_2249# vdd 0.00252f
C201 vbn_ref mreset 0.00849f
C202 sta stb 0.5388f
C203 a_2088_184# a_2818_2697# 0
C204 a_1320_4766# vdd 0.3958f
C205 rsel vsrc 0.01174f
C206 el en 0.02448f
C207 vbn_ref rsel 0.00157f
C208 vbn_prb en 0.02526f
C209 el vbn_leak 0.02549f
C210 a_1320_4766# a_3174_2653# 0.0733f
C211 spk vsrc 0.09756f
C212 a_188_184# a_492_184# 0.02037f
C213 a_276_6148# mreset 0
C214 a_3268_4810# vreset 0
C215 a_3268_4810# aux 0.00708f
C216 vbn_ref spk 0.12529f
C217 a_2720_4336# vreset 0.0339f
C218 vbn_prb vbn_leak 0.12838f
C219 a_2720_4336# aux 0
C220 sub_b vdd 0
C221 a_276_6148# rsel 0
C222 a_1670_2697# vbp_syn 0.00815f
C223 a_188_6274# vbp_syn 0.00245f
C224 a_276_4082# stb 0.06711f
C225 a_276_4082# vreset 0.09391f
C226 a_2720_4336# hold 0
C227 a_2280_4810# vbp_syn 0.30306f
C228 a_1154_2049# vdd 0.30881f
C229 a_276_6148# spk 0.20807f
C230 sta a_492_184# 0.16991f
C231 a_3268_4810# en 0.07378f
C232 a_1320_4766# vsrc 0
C233 a_1670_2697# a_2280_4810# 0.00223f
C234 a_188_6274# a_2280_4810# 0.0336f
C235 a_276_4082# hold 0.23184f
C236 abus vdd 0.10457f
C237 el a_2520_4964# 0.00214f
C238 vbn_ref a_1320_4766# 0.05177f
C239 a_3268_4810# vbn_leak 0.18385f
C240 a_2720_4336# vbn_leak 0
C241 a_276_4082# sub 0
C242 vbn_prb a_2520_4964# 0
C243 abus a_3174_2653# 0.0023f
C244 a_2720_4336# a_492_184# 0
C245 sub_b vsrc 0.00575f
C246 a_276_4082# a_1858_2697# 0.00368f
C247 a_276_6148# a_1320_4766# 0.03558f
C248 a_3268_4810# a_2884_4810# 0
C249 rsel vreset 0
C250 vbp_st vbp_syn 0.1669f
C251 rsel aux 0
C252 sub_b vbn_ref 0.00108f
C253 a_276_4082# a_492_184# 0.09276f
C254 a_3268_4810# a_1232_4810# 0.00172f
C255 mreset sub 0.01016f
C256 stb spk 0.00379f
C257 a_1670_2697# vbp_st 0.21205f
C258 spk vreset 0.0663f
C259 spk aux 0.0065f
C260 a_3268_4810# a_2520_4964# 0
C261 abus vsrc 0.03651f
C262 a_2280_4810# vbp_st 0.09956f
C263 a_2720_4336# a_2520_4964# 0.25033f
C264 rsel sub 0
C265 a_276_4082# a_1232_4810# 0.15146f
C266 sub_b a_276_6148# 0
C267 rsel en 0.2539f
C268 abus vbn_ref 0.42886f
C269 a_2720_4336# a_2818_2697# 0.01162f
C270 vm vbp_syn 0.19518f
C271 a_276_4082# a_2520_4964# 0.023f
C272 a_1154_2049# a_276_6148# 0.00231f
C273 rsel vbn_leak 0.00144f
C274 spk sub 0
C275 spk en 0.03584f
C276 a_1320_4766# stb 0.00405f
C277 a_1670_2697# vm 0.17148f
C278 a_276_4082# a_2818_2697# 0
C279 el a_2088_184# 0.00224f
C280 a_1320_4766# vreset 0.00765f
C281 abus a_276_6148# 0.0011f
C282 spk vbn_leak 0.44128f
C283 vm a_2280_4810# 0.10097f
C284 mreset a_1232_4810# 0.10672f
C285 rsel a_2884_4810# 0
C286 spk a_492_184# 0.05088f
C287 a_1320_4766# hold 0.42608f
C288 mreset a_2520_4964# 0
C289 rsel a_1232_4810# 0
C290 a_1320_4766# sub 0
C291 spk a_2884_4810# 0
C292 sub_b vreset 0
C293 sub_b aux 0
C294 rsel a_2520_4964# 0
C295 spk a_1232_4810# 0.13124f
C296 vdd vbp_syn 2.90413f
C297 a_1154_2049# stb 0.00412f
C298 a_1858_2697# a_1320_4766# 0
C299 a_2088_184# a_3268_4810# 0.06697f
C300 a_2520_4964# spk 0.65297f
C301 a_2088_184# a_2720_4336# 0.2637f
C302 a_1320_4766# a_492_184# 0.00978f
C303 a_1670_2697# vdd 0.40334f
C304 vm vbp_st 0.04939f
C305 a_3174_2653# vbp_syn 0.26765f
C306 abus vreset 1.26776f
C307 abus aux 0.02232f
C308 vdd a_2280_4810# 0.64981f
C309 a_1154_2049# hold 0.0473f
C310 sub_b en 0.01536f
C311 a_276_4082# a_2088_184# 0.01227f
C312 a_1670_2697# a_3174_2653# 0.01305f
C313 sub_b vbn_leak 0.00245f
C314 a_1320_4766# a_1232_4810# 0.40824f
C315 a_2818_2249# a_2520_4964# 0.00907f
C316 a_1320_4766# a_2520_4964# 0.07796f
C317 vbn_prb el 0.02754f
C318 abus en 0.25982f
C319 vbp_syn vsrc 0.03943f
C320 sta a_188_184# 0.39575f
C321 a_1154_2049# a_492_184# 0.07814f
C322 a_2818_2697# a_1320_4766# 0
C323 sub_b a_2884_4810# 0
C324 abus vbn_leak 0.02484f
C325 vbn_ref vbp_syn 0.02296f
C326 a_1670_2697# vsrc 0.20047f
C327 vdd vbp_st 1.95358f
C328 sub_b a_1232_4810# 0
C329 a_2280_4810# vsrc 0.00769f
C330 a_1670_2697# vbn_ref 0
C331 a_2088_184# rsel 0.01024f
C332 a_188_6274# vbn_ref 0.00396f
C333 sub_b a_2520_4964# 0.00367f
C334 vbn_ref a_2280_4810# 0.36369f
C335 el a_3268_4810# 0.03195f
C336 abus a_2884_4810# 0.00663f
C337 a_3174_2653# vbp_st 0.08478f
C338 el a_2720_4336# 0
C339 a_276_6148# vbp_syn 0.07112f
C340 a_2088_184# spk 0.46406f
C341 vbn_prb a_3268_4810# 0.32123f
C342 abus a_1232_4810# 0
C343 a_276_4082# a_188_184# 0.00102f
C344 a_1670_2697# a_276_6148# 0.14305f
C345 a_188_6274# a_276_6148# 0.61462f
C346 vm vdd 0.76445f
C347 abus a_2520_4964# 0.02905f
C348 a_276_6148# a_2280_4810# 0.19214f
C349 a_2996_4810# vsrc 0.00159f
C350 vbp_st vsrc 1.27881f
C351 vm a_3174_2653# 0
C352 a_2818_2249# a_2088_184# 0
C353 a_2088_184# a_1320_4766# 0.09771f
C354 a_276_4082# sta 0.04123f
C355 vbn_ref vbp_st 0.02699f
C356 stb vbp_syn 0.07447f
C357 vbp_syn vreset 0.04059f
C358 aux vbp_syn 0
C359 a_1670_2697# stb 0
C360 el rsel 0
C361 a_276_4082# a_2720_4336# 0.00249f
C362 a_276_6148# vbp_st 0.01237f
C363 a_1670_2697# vreset 0.1807f
C364 a_1670_2697# aux 0
C365 vm vsrc 0.07183f
C366 vbp_syn hold 0.01978f
C367 stb a_2280_4810# 0.33156f
C368 sub_b a_2088_184# 0.00562f
C369 vbn_prb rsel 0
C370 a_2280_4810# vreset 0.00193f
C371 vbn_ref vm 0
C372 el spk 0.04491f
C373 en vbp_syn 0.02255f
C374 a_1670_2697# hold 0
C375 a_3174_2653# vdd 1.90965f
C376 vbn_prb spk 0.01148f
C377 a_2280_4810# hold 0.0384f
C378 vbn_leak vbp_syn 0.05519f
C379 a_1670_2697# en 0.0052f
C380 abus a_2088_184# 0.02664f
C381 a_2280_4810# sub 0.0171f
C382 a_276_6148# vm 0.07197f
C383 a_492_184# vbp_syn 0.43634f
C384 a_1320_4766# a_188_184# 0
C385 a_1670_2697# vbn_leak 0.00141f
C386 a_188_6274# vbn_leak 0.06524f
C387 a_1670_2697# a_1858_2697# 0.00952f
C388 a_3268_4810# rsel 0.05611f
C389 a_2280_4810# vbn_leak 0.00122f
C390 rsel a_2720_4336# 0.00126f
C391 a_276_4082# mreset 0.01592f
C392 a_1670_2697# a_492_184# 0
C393 vbp_st vreset 0.05349f
C394 vdd vsrc 0.13596f
C395 aux vbp_st 0.03845f
C396 a_3268_4810# spk 0.20383f
C397 a_2280_4810# a_492_184# 0.42009f
C398 a_1232_4810# vbp_syn 0.00289f
C399 a_2720_4336# spk 0.02598f
C400 vbn_ref vdd 0.12638f
C401 a_1320_4766# sta 0
C402 a_3174_2653# vsrc 0.08058f
C403 vbp_st hold 0
C404 a_2520_4964# vbp_syn 0.16896f
C405 a_1670_2697# a_1232_4810# 0
C406 a_188_6274# a_1232_4810# 0.58808f
C407 a_2996_4810# en 0
C408 a_276_4082# spk 0.00391f
C409 el sub_b 0
C410 vbn_ref a_3174_2653# 0.04304f
C411 a_2280_4810# a_1232_4810# 0.27016f
C412 en vbp_st 0.02449f
C413 a_2818_2697# vbp_syn 0
C414 a_1154_2049# a_188_184# 0.01081f
C415 a_1670_2697# a_2520_4964# 0.31984f
C416 vm stb 0.06234f
C417 a_276_6148# vdd 0.15757f
C418 vm vreset 0.2037f
C419 a_2818_2249# a_2720_4336# 0.0043f
C420 a_2520_4964# a_2280_4810# 0.08935f
C421 a_3268_4810# a_1320_4766# 0
C422 vbn_leak vbp_st 0.03962f
C423 a_1670_2697# a_2818_2697# 0
C424 a_1858_2697# vbp_st 0
C425 a_2720_4336# a_1320_4766# 0.09498f
C426 el abus 0.02276f
C427 a_276_6148# a_3174_2653# 0.57486f
C428 a_492_184# vbp_st 0.00999f
C429 vm hold 0.08093f
C430 a_276_4082# a_2818_2249# 0
C431 mreset spk 0.0118f
C432 a_276_4082# a_1320_4766# 0.21088f
C433 a_1154_2049# sta 0.00208f
C434 vm sub 0
C435 vbn_ref vsrc 0.03039f
C436 vbn_prb abus 0.02301f
C437 rsel spk 0.04806f
C438 sub_b a_3268_4810# 0.01862f
C439 sub_b a_2720_4336# 0
C440 a_1858_2697# vm 0
C441 a_2996_4810# a_2520_4964# 0
C442 a_2520_4964# vbp_st 0.24064f
C443 a_276_6148# vsrc 0.08095f
C444 vm a_492_184# 0.32021f
C445 stb vdd 0.2121f
C446 a_1154_2049# a_2720_4336# 0
C447 vdd vreset 0.23811f
C448 vdd aux 0.07029f
C449 a_1320_4766# mreset 0.03969f
C450 a_276_6148# vbn_ref 0.20245f
C451 a_2818_2697# vbp_st 0
C452 a_2088_184# vbp_syn 0.11096f
C453 abus a_3268_4810# 0.05121f
C454 aux vss 0.3398f
C455 sub vss 0.00975f
C456 vsrc vss 1.75089f
C457 vreset vss 1.76535f
C458 abus vss 2.83061f
C459 vdd vss 26.41889f
C460 a_2818_2249# vss 0.57944f
C461 a_2818_2697# vss 0.27181f
C462 a_1858_2697# vss 0.54363f
C463 a_1154_2049# vss 0.89492f
C464 a_492_184# vss 0.95779f
C465 a_188_184# vss 2.37439f
C466 a_3174_2653# vss 0.51916f
C467 a_2720_4336# vss 0.83291f
C468 a_2088_184# vss 2.973f
C469 a_2996_4810# vss 0.74081f
C470 a_2884_4810# vss 0.24888f
C471 a_2280_4810# vss 0.60888f
C472 a_3268_4810# vss 1.10539f
C473 a_188_6274# vss 4.70826f
C474 a_1232_4810# vss 0.24815f
.ends
