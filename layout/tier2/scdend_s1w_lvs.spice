* LVS reference for scdend_s1: flattened from its cell file by layout/tier2/flatten.py
* MOM capacitors (Cfb, SC caps; values from PEX) omitted: XS.XD.CFB, CL, CA
.subckt scdend_s1w vs d spk sel0 sel2 sc_clk sta stb hold mreset vbp_syn el vsrc vreset vbn_leak vbp_st vbn_ref vbn_prb en abus vdd vss
XXS_XC_XC vss vs vss vss nfet_03v3 W=7.07u L=7.07u
XXS_XL_XMT XS.XL.t vbn_leak vss vss nfet_03v3 W=2u L=4u
XXS_XL_XM1 XS.XL.a el XS.XL.s1 vss nfet_03v3 W=2u L=2u
XXS_XL_XD1 XS.XL.s1 XS.XL.s1 XS.XL.t vss nfet_03v3 W=2u L=2u
XXS_XL_XM2 vs vs XS.XL.s2 vss nfet_03v3 W=2u L=2u
XXS_XL_XD2 XS.XL.s2 XS.XL.s2 XS.XL.t vss nfet_03v3 W=2u L=2u
XXS_XL_XP1 XS.XL.a XS.XL.a vdd vdd pfet_03v3 W=2u L=4u
XXS_XL_XP2 vs XS.XL.a vdd vdd pfet_03v3 W=2u L=4u
XXS_XD_XPS XS.XD.s vbp_st vdd vdd pfet_03v3 W=1u L=2u
XXS_XD_XPI XS.XD.n1 vs XS.XD.s vdd pfet_03v3 W=1u L=0.5u
XXS_XD_XNI XS.XD.n1 vs vsrc vss nfet_03v3 W=1u L=0.5u
XXS_XD_XS2 XS.XD.s2 vbp_st vdd vdd pfet_03v3 W=1u L=2u
XXS_XD_XP2 XS.XD.p XS.XD.n1 XS.XD.s2 vdd pfet_03v3 W=1u L=0.28u
XXS_XD_XN2 XS.XD.p XS.XD.n1 vsrc vss nfet_03v3 W=0.22u L=2u
XXS_XD_XP3 XS.XD.pb XS.XD.p vdd vdd pfet_03v3 W=1u L=0.28u
XXS_XD_XN3 XS.XD.pb XS.XD.p vsrc vss nfet_03v3 W=0.5u L=0.28u
XXS_XD_Xi4_XN spk XS.XD.pb vss vss nfet_03v3 W=0.5u L=0.28u
XXS_XD_Xi4_XP spk XS.XD.pb vdd vdd pfet_03v3 W=1u L=0.28u
XXS_XR_Xi_XN XS.XR.spkb spk vss vss nfet_03v3 W=0.5u L=0.28u
XXS_XR_Xi_XP XS.XR.spkb spk vdd vdd pfet_03v3 W=1u L=0.28u
XXS_XR_XPC vr XS.XR.spkb vdd vdd pfet_03v3 W=1u L=0.28u
XXS_XR_XNR vr vbn_ref vss vss nfet_03v3 W=2u L=4u
XXS_XR_XCR_XC vss vr vss vss nfet_03v3 W=3.54u L=3.54u
XXS_XR_XSW vs vr vreset vss nfet_03v3 W=0.5u L=0.5u
XXCD_XC vss d vss vss nfet_03v3 W=7.07u L=7.07u
XXY_XPH XY.h hold vdd vdd pfet_03v3 W=1u L=2u
XXY_XWA XY.da vbp_syn XY.h vdd pfet_03v3 W=2u L=4u
XXY_XWB XY.db vbp_syn XY.h vdd pfet_03v3 W=2u L=4u
XXY_XNA XY.da sta d vss nfet_03v3 W=0.5u L=0.28u
XXY_XNB XY.db stb d vss nfet_03v3 W=0.5u L=0.28u
XXY_XQA vss sta XY.da vdd pfet_03v3 W=1u L=0.28u
XXY_XQB vss stb XY.db vdd pfet_03v3 W=1u L=0.28u
XXY_XHL d hold dl vdd pfet_03v3 W=1u L=0.28u
XXY_XMR vdd mreset vr vss nfet_03v3 W=0.5u L=0.28u
XXN_Xi0_XN XN.ckb sc_clk vss vss nfet_03v3 W=0.5u L=0.28u
XXN_Xi0_XP XN.ckb sc_clk vdd vdd pfet_03v3 W=1u L=0.28u
XXN_XO1_XP1 XN.XO1.m XN.ckb vdd vdd pfet_03v3 W=1u L=0.28u
XXN_XO1_XP2 XN.a1 p2 XN.XO1.m vdd pfet_03v3 W=1u L=0.28u
XXN_XO1_XN1 XN.a1 XN.ckb vss vss nfet_03v3 W=0.5u L=0.28u
XXN_XO1_XN2 XN.a1 p2 vss vss nfet_03v3 W=0.5u L=0.28u
XXN_Xd1_XN XN.b1 XN.a1 vss vss nfet_03v3 W=0.5u L=0.28u
XXN_Xd1_XP XN.b1 XN.a1 vdd vdd pfet_03v3 W=1u L=0.28u
XXN_Xd2_XN p1 XN.b1 vss vss nfet_03v3 W=0.5u L=0.28u
XXN_Xd2_XP p1 XN.b1 vdd vdd pfet_03v3 W=1u L=0.28u
XXN_XO2_XP1 XN.XO2.m sc_clk vdd vdd pfet_03v3 W=1u L=0.28u
XXN_XO2_XP2 XN.a2 p1 XN.XO2.m vdd pfet_03v3 W=1u L=0.28u
XXN_XO2_XN1 XN.a2 sc_clk vss vss nfet_03v3 W=0.5u L=0.28u
XXN_XO2_XN2 XN.a2 p1 vss vss nfet_03v3 W=0.5u L=0.28u
XXN_Xd3_XN XN.b2 XN.a2 vss vss nfet_03v3 W=0.5u L=0.28u
XXN_Xd3_XP XN.b2 XN.a2 vdd vdd pfet_03v3 W=1u L=0.28u
XXN_Xd4_XN p2 XN.b2 vss vss nfet_03v3 W=0.5u L=0.28u
XXN_Xd4_XP p2 XN.b2 vdd vdd pfet_03v3 W=1u L=0.28u
XXL1 dl p1 cl vss nfet_03v3 W=0.22u L=0.28u
XXL2 el p2 cl vss nfet_03v3 W=0.22u L=0.28u
XXA1 d p1 ca vss nfet_03v3 W=0.22u L=0.28u
XXA2 vs p2 ca vss nfet_03v3 W=0.22u L=0.28u
XXT0_XMF vdd vs XT0.prb vss nfet_03v3 W=4u L=2u
XXT0_XME XT0.prb en XT0.s vss nfet_03v3 W=1u L=0.28u
XXT0_XMB XT0.s vbn_prb vss vss nfet_03v3 W=2u L=2u
XXT0_XSW XT0.prb sel0 abus vss nfet_03v3 W=1u L=0.28u
XXT2_XMF vdd d XT2.prb vss nfet_03v3 W=4u L=2u
XXT2_XME XT2.prb en XT2.s vss nfet_03v3 W=1u L=0.28u
XXT2_XMB XT2.s vbn_prb vss vss nfet_03v3 W=2u L=2u
XXT2_XSW XT2.prb sel2 abus vss nfet_03v3 W=1u L=0.28u
.ends scdend_s1w
