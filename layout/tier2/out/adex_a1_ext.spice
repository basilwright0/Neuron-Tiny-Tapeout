* NGSPICE file created from adex_a1.ext - technology: gf180mcuD

.subckt p_w2_l4 a_400_n200# a_n400_n244# w_n574_n330# a_n488_n200#
X0 a_400_n200# a_n400_n244# a_n488_n200# w_n574_n330# pfet_03v3 ad=0.88p pd=4.88u as=0.88p ps=4.88u w=2u l=4u
.ends

.subckt n_w2_l4 a_400_n200# a_n400_n244# a_n488_n200# VSUBS
X0 a_400_n200# a_n400_n244# a_n488_n200# VSUBS nfet_03v3 ad=0.88p pd=4.88u as=0.88p ps=4.88u w=2u l=4u
.ends

.subckt n_w2_l2 a_n288_n200# a_200_n200# a_n200_n244# VSUBS
X0 a_200_n200# a_n200_n244# a_n288_n200# VSUBS nfet_03v3 ad=0.88p pd=4.88u as=0.88p ps=4.88u w=2u l=2u
.ends

.subckt n_w0p5_l0p28 a_n28_n94# a_n116_n50# a_28_n50# VSUBS
X0 a_28_n50# a_n28_n94# a_n116_n50# VSUBS nfet_03v3 ad=0.22p pd=1.88u as=0.22p ps=1.88u w=0.5u l=0.28u
.ends

.subckt n_w1_l0p28 a_28_n100# a_n28_n144# a_n116_n100# VSUBS
X0 a_28_n100# a_n28_n144# a_n116_n100# VSUBS nfet_03v3 ad=0.44p pd=2.88u as=0.44p ps=2.88u w=1u l=0.28u
.ends

.subckt p_w1_l0p5 a_n138_n100# a_50_n100# a_n50_n144# w_n224_n230#
X0 a_50_n100# a_n50_n144# a_n138_n100# w_n224_n230# pfet_03v3 ad=0.44p pd=2.88u as=0.44p ps=2.88u w=1u l=0.5u
.ends

.subckt n_w0p5_l0p5 a_n138_n50# a_50_n50# a_n50_n94# VSUBS
X0 a_50_n50# a_n50_n94# a_n138_n50# VSUBS nfet_03v3 ad=0.22p pd=1.88u as=0.22p ps=1.88u w=0.5u l=0.5u
.ends

.subckt p_w1_l0p28 w_n202_n230# a_28_n100# a_n28_n144# a_n116_n100#
X0 a_28_n100# a_n28_n144# a_n116_n100# w_n202_n230# pfet_03v3 ad=0.44p pd=2.88u as=0.44p ps=2.88u w=1u l=0.28u
.ends

.subckt n_w1_l0p5 a_n138_n100# a_50_n100# a_n50_n144# VSUBS
X0 a_50_n100# a_n50_n144# a_n138_n100# VSUBS nfet_03v3 ad=0.44p pd=2.88u as=0.44p ps=2.88u w=1u l=0.5u
.ends

.subckt p_w1_l2 w_n374_n230# a_n288_n100# a_200_n100# a_n200_n144#
X0 a_200_n100# a_n200_n144# a_n288_n100# w_n374_n230# pfet_03v3 ad=0.44p pd=2.88u as=0.44p ps=2.88u w=1u l=2u
.ends

.subckt n_w0p22_l15 a_1500_n22# a_n1500_n66# a_n1592_n36# VSUBS
X0 a_1500_n22# a_n1500_n66# a_n1592_n36# VSUBS nfet_03v3 ad=0.1516p pd=1.64u as=0.1516p ps=1.64u w=0.22u l=15u
.ends

.subckt n_w0p22_l2 a_200_n22# a_n200_n66# a_n292_n36# VSUBS
X0 a_200_n22# a_n200_n66# a_n292_n36# VSUBS nfet_03v3 ad=0.1516p pd=1.64u as=0.1516p ps=1.64u w=0.22u l=2u
.ends

.subckt n_w0p22_l8 a_800_n22# a_n800_n66# a_n892_n36# VSUBS
X0 a_800_n22# a_n800_n66# a_n892_n36# VSUBS nfet_03v3 ad=0.1516p pd=1.64u as=0.1516p ps=1.64u w=0.22u l=8u
.ends

.subckt p_w2_l0p5 a_50_n200# a_n50_n244# w_n224_n330# a_n138_n200#
X0 a_50_n200# a_n50_n244# a_n138_n200# w_n224_n330# pfet_03v3 ad=0.88p pd=4.88u as=0.88p ps=4.88u w=2u l=0.5u
.ends

.subckt n_w7p07_l7p07 a_707_n707# a_n795_n707# a_n707_n751# VSUBS
X0 a_707_n707# a_n707_n751# a_n795_n707# VSUBS nfet_03v3 ad=3.1108p pd=15.02u as=3.1108p ps=15.02u w=7.07u l=7.07u
.ends

.subckt p_w0p22_l8 a_800_n22# a_n800_n66# w_n978_n159# a_n892_n36#
X0 a_800_n22# a_n800_n66# a_n892_n36# w_n978_n159# pfet_03v3 ad=0.1516p pd=1.64u as=0.1516p ps=1.64u w=0.22u l=8u
.ends

.subckt n_w4_l2 a_n288_n400# a_200_n400# a_n200_n444# VSUBS
X0 a_200_n400# a_n200_n444# a_n288_n400# VSUBS nfet_03v3 ad=1.76p pd=8.88u as=1.76p ps=8.88u w=4u l=2u
.ends

.subckt n_w3p54_l3p54 a_354_n354# a_n354_n398# a_n442_n354# VSUBS
X0 a_354_n354# a_n354_n398# a_n442_n354# VSUBS nfet_03v3 ad=1.5576p pd=7.96u as=1.5576p ps=7.96u w=3.54u l=3.54u
.ends

.subckt p_w7p07_l7p07 w_n881_n837# a_707_n707# a_n795_n707# a_n707_n751#
X0 a_707_n707# a_n707_n751# a_n795_n707# w_n881_n837# pfet_03v3 ad=3.1108p pd=15.02u as=3.1108p ps=15.02u w=7.07u l=7.07u
.ends

.subckt p_w0p5_l1 a_100_n50# a_n100_n94# a_n188_n50# w_n274_n180#
X0 a_100_n50# a_n100_n94# a_n188_n50# w_n274_n180# pfet_03v3 ad=0.22p pd=1.88u as=0.22p ps=1.88u w=0.5u l=1u
.ends

.subckt p_w4_l0p5 a_n138_n400# a_50_n400# a_n50_n444# w_n224_n530#
X0 a_50_n400# a_n50_n444# a_n138_n400# w_n224_n530# pfet_03v3 ad=1.76p pd=8.88u as=1.76p ps=8.88u w=4u l=0.5u
.ends

.subckt adex_a1 vdd vss el vbn_leak vsrc vbp_st vbn_ref vreset vbn_prb vbp_syn vbp_w
+ abus mreset spk en sta stb hold sel_adex sub0 sub1 vm vw
XXL_XP1 m1_186_2812# m1_186_2812# vdd vdd p_w2_l4
XXL_XP2 a_2536_3080# m1_186_2812# vdd vdd p_w2_l4
XXL_XMT m1_1704_2490# vbn_leak vss vss n_w2_l4
XXL_XM1 m1_186_2812# a_1024_3080# el vss n_w2_l2
XXS_XWA m1_3872_1730# vbp_syn vdd m1_4242_4630# p_w2_l4
XXL_XM2 a_1780_3080# a_2536_3080# a_2536_3080# vss n_w2_l2
XXR_Xi_XN spk vss a_8356_5974# vss n_w0p5_l0p28
XXP_XSA m1_3262_1784# sel_adex m1_4932_8400# vss n_w1_l0p28
XXD_XPI m1_6086_5726# a_7000_3738# vm vdd p_w1_l0p5
XXS_XWB m1_4392_1730# vbp_syn vdd m1_4242_4630# p_w2_l4
XXR_XSW vreset vm a_480_5974# vss n_w0p5_l0p5
XXR_XNR a_480_5974# vbn_ref vss vss n_w2_l4
XXR_Xi_XP vdd a_8356_5974# spk vdd p_w1_l0p28
XXD_XNI vsrc a_7000_3738# vm vss n_w1_l0p5
XXP_XSC m1_4932_8400# a_5492_8534# abus vss n_w1_l0p28
XXP_XPB vdd m1_6290_9150# m1_7186_9150# vbp_st p_w1_l2
XXS_XQA vdd vss sta m1_3872_1730# p_w1_l0p28
XXA_XT1 vw vbn_leak m1_186_3686# vss n_w0p22_l15
XXP_Xi0_XN sub0 vss a_3332_1974# vss n_w0p5_l0p28
XXS_XQB vdd vss stb m1_4392_1730# p_w1_l0p28
XXA_XT2 m1_186_3686# vbn_leak m1_3408_5970# vss n_w0p22_l15
XXP_XPE vdd m1_6290_9150# a_3332_1974# vdd p_w1_l0p28
XXA_XR1 vw mreset m1_2516_8340# vss n_w0p22_l2
XXA_XT3 m1_3408_5970# vbn_leak vss vss n_w0p22_l15
XXA_XPS vdd m1_988_5716# a_912_5974# vdd p_w1_l0p28
XXA_XW a_2536_3080# vw vss vss n_w0p22_l8
XXL_XD1 a_1024_3080# m1_1704_2490# a_1024_3080# vss n_w2_l2
XXP_XPF vss vw vdd m1_7186_9150# p_w2_l0p5
XXP_Xi0_XP vdd a_3332_1974# sub0 vdd p_w1_l0p28
XXA_XR2 m1_2516_8340# mreset vss vss n_w0p22_l2
XXL_XD2 m1_1704_2490# a_1780_3080# a_1780_3080# vss n_w2_l2
XXS_XNA sta vm m1_3872_1730# vss n_w0p5_l0p28
XXD_XS2 vdd vdd m1_6552_5730# vbp_st p_w1_l2
XXD_XPS vdd vdd m1_6086_5726# vbp_st p_w1_l2
XXP_XT0_XMB vss m1_2772_1784# vbn_prb vss n_w2_l2
XXS_XNB stb vm m1_4392_1730# vss n_w0p5_l0p28
XXA_XPW vdd m1_988_5716# m1_1656_4620# vbp_w p_w1_l2
XXE_XE1 a_2884_5778# vm vsrc vss n_w0p22_l8
XXC_XC vss vss vm vss n_w7p07_l7p07
XXD_XP2 vdd a_7060_5974# a_7000_3738# m1_6552_5730# p_w1_l0p28
XXE_XE2 a_2884_5778# a_2884_5778# vdd vdd p_w2_l0p5
XXS_XPH vdd vdd m1_4242_4630# hold p_w1_l2
XXP_XT0_XME m1_2916_1640# en m1_2772_1784# vss n_w1_l0p28
XXD_XP3 vdd a_7148_1874# a_7060_5974# vdd p_w1_l0p28
XXE_XE3 a_2536_3080# a_2884_5778# vdd vdd p_w0p22_l8
XXD_Xi4_XN a_7148_1874# vss spk vss n_w0p5_l0p28
XXP_XT0_XMF m1_2916_1640# vdd vm vss n_w4_l2
XXD_XN2 a_7060_5974# a_7000_3738# vsrc vss n_w0p22_l2
XXR_XCR_XC vss a_480_5974# vss vss n_w3p54_l3p54
XXD_Xi4_XP vdd spk a_7148_1874# vdd p_w1_l0p28
XXD_XN3 a_7060_5974# vsrc a_7148_1874# vss n_w0p5_l0p28
XXP_Xi1_XN sub1 vss a_5492_8534# vss n_w0p5_l0p28
XXR_XPC vdd a_480_5974# a_8356_5974# vdd p_w1_l0p28
XXP_Xi1_XP vdd a_5492_8534# sub1 vdd p_w1_l0p28
XXP_XS1 m1_7186_9150# sub0 m1_3262_1784# vss n_w1_l0p28
XXA_Xi_XN a_480_5974# vss a_912_5974# vss n_w0p5_l0p28
XXA_Xi_XP vdd a_912_5974# a_480_5974# m1_406_5430# p_w1_l0p28
XXA_XCW vdd vdd vdd vw p_w7p07_l7p07
XXS_XHL vdd vm hold a_2536_3080# p_w1_l0p28
XXA_XPA vw vw m1_1656_4620# vdd p_w0p5_l1
XXP_XT0_XSW m1_2916_1640# a_3332_1974# m1_3262_1784# vss n_w1_l0p28
XXA_XPB m1_1656_4620# vss vbn_leak vdd p_w4_l0p5
XXA_Xi_XS vdd vdd m1_406_5430# vbp_st p_w1_l2
XXS_XMR mreset a_480_5974# vdd vss n_w0p5_l0p28
.ends
