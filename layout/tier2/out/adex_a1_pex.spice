* NGSPICE file created from adex_a1.ext - technology: gf180mcuD

.subckt p_w0p22_l1 a_100_n22# a_n100_n66# w_n278_n159# a_n192_n36# VSUBS
X0 a_100_n22# a_n100_n66# a_n192_n36# w_n278_n159# pfet_03v3 ad=0.1516p pd=1.64u as=0.1516p ps=1.64u w=0.22u l=1u
C0 a_n192_n36# a_n100_n66# 0.00509f
C1 a_100_n22# w_n278_n159# 0.00771f
C2 a_100_n22# a_n100_n66# 0.00509f
C3 a_n100_n66# w_n278_n159# 0.13163f
C4 a_100_n22# a_n192_n36# 0.00453f
C5 a_n192_n36# w_n278_n159# 0.00771f
C6 a_100_n22# VSUBS 0.05952f
C7 a_n192_n36# VSUBS 0.05952f
C8 w_n278_n159# VSUBS 0.53042f
.ends

.subckt p_w2_l4 a_400_n200# a_n400_n244# w_n574_n330# a_n488_n200# VSUBS
X0 a_400_n200# a_n400_n244# a_n488_n200# w_n574_n330# pfet_03v3 ad=0.88p pd=4.88u as=0.88p ps=4.88u w=2u l=4u
C0 a_n400_n244# a_n488_n200# 0.07019f
C1 a_400_n200# w_n574_n330# 0.07409f
C2 a_400_n200# a_n488_n200# 0.01073f
C3 a_n488_n200# w_n574_n330# 0.07409f
C4 a_400_n200# a_n400_n244# 0.07019f
C5 a_n400_n244# w_n574_n330# 0.42229f
C6 a_400_n200# VSUBS 0.18936f
C7 a_n488_n200# VSUBS 0.18936f
C8 w_n574_n330# VSUBS 2.27304f
.ends

.subckt n_w2_l4 a_400_n200# a_n400_n244# a_n488_n200# VSUBS
X0 a_400_n200# a_n400_n244# a_n488_n200# VSUBS nfet_03v3 ad=0.88p pd=4.88u as=0.88p ps=4.88u w=2u l=4u
C0 a_n488_n200# a_400_n200# 0.01073f
C1 a_400_n200# a_n400_n244# 0.07019f
C2 a_n488_n200# a_n400_n244# 0.07019f
C3 a_400_n200# VSUBS 0.41684f
C4 a_n488_n200# VSUBS 0.41684f
.ends

.subckt n_w4_l0p5_k1 a_n188_n400# a_50_n400# a_n50_n444# VSUBS
X0 a_50_n400# a_n50_n444# a_n188_n400# VSUBS nfet_03v3 ad=2.76p pd=9.38u as=2.76p ps=9.38u w=4u l=0.5u
C0 a_n188_n400# a_50_n400# 0.10174f
C1 a_50_n400# a_n50_n444# 0.04238f
C2 a_n188_n400# a_n50_n444# 0.04238f
C3 a_50_n400# VSUBS 0.23105f
C4 a_n188_n400# VSUBS 0.23105f
.ends

.subckt n_w0p5_l0p28 a_n28_n94# a_n116_n50# a_28_n50# VSUBS
X0 a_28_n50# a_n28_n94# a_n116_n50# VSUBS nfet_03v3 ad=0.22p pd=1.88u as=0.22p ps=1.88u w=0.5u l=0.28u
C0 a_n116_n50# a_28_n50# 0.02085f
C1 a_28_n50# a_n28_n94# 0.00377f
C2 a_n116_n50# a_n28_n94# 0.00377f
C3 a_28_n50# VSUBS 0.07987f
C4 a_n116_n50# VSUBS 0.07987f
.ends

.subckt p_w1_l0p5 a_n138_n100# a_50_n100# a_n50_n144# w_n224_n230# VSUBS
X0 a_50_n100# a_n50_n144# a_n138_n100# w_n224_n230# pfet_03v3 ad=0.44p pd=2.88u as=0.44p ps=2.88u w=1u l=0.5u
C0 a_n50_n144# a_n138_n100# 0.01275f
C1 a_50_n100# w_n224_n230# 0.0205f
C2 a_50_n100# a_n138_n100# 0.03085f
C3 a_n138_n100# w_n224_n230# 0.0205f
C4 a_50_n100# a_n50_n144# 0.01275f
C5 a_n50_n144# w_n224_n230# 0.07993f
C6 a_50_n100# VSUBS 0.06546f
C7 a_n138_n100# VSUBS 0.06546f
C8 w_n224_n230# VSUBS 0.61824f
.ends

.subckt n_w1_l0p28 a_28_n100# a_n28_n144# a_n116_n100# VSUBS
X0 a_28_n100# a_n28_n144# a_n116_n100# VSUBS nfet_03v3 ad=0.44p pd=2.88u as=0.44p ps=2.88u w=1u l=0.28u
C0 a_n116_n100# a_28_n100# 0.04256f
C1 a_28_n100# a_n28_n144# 0.00769f
C2 a_n116_n100# a_n28_n144# 0.00769f
C3 a_28_n100# VSUBS 0.09911f
C4 a_n116_n100# VSUBS 0.09911f
.ends

.subckt n_w0p5_l0p5 a_n138_n50# a_50_n50# a_n50_n94# VSUBS
X0 a_50_n50# a_n50_n94# a_n138_n50# VSUBS nfet_03v3 ad=0.22p pd=1.88u as=0.22p ps=1.88u w=0.5u l=0.5u
C0 a_n138_n50# a_50_n50# 0.01511f
C1 a_50_n50# a_n50_n94# 0.00625f
C2 a_n138_n50# a_n50_n94# 0.00625f
C3 a_50_n50# VSUBS 0.09639f
C4 a_n138_n50# VSUBS 0.09639f
.ends

.subckt p_w1_l0p28 w_n202_n230# a_28_n100# a_n28_n144# a_n116_n100# VSUBS
X0 a_28_n100# a_n28_n144# a_n116_n100# w_n202_n230# pfet_03v3 ad=0.44p pd=2.88u as=0.44p ps=2.88u w=1u l=0.28u
C0 a_n28_n144# a_n116_n100# 0.00769f
C1 a_28_n100# w_n202_n230# 0.01808f
C2 a_28_n100# a_n116_n100# 0.04256f
C3 a_n116_n100# w_n202_n230# 0.01808f
C4 a_28_n100# a_n28_n144# 0.00769f
C5 a_n28_n144# w_n202_n230# 0.05841f
C6 a_28_n100# VSUBS 0.0597f
C7 a_n116_n100# VSUBS 0.0597f
C8 w_n202_n230# VSUBS 0.55752f
.ends

.subckt n_w1_l0p5 a_n138_n100# a_50_n100# a_n50_n144# VSUBS
X0 a_50_n100# a_n50_n144# a_n138_n100# VSUBS nfet_03v3 ad=0.44p pd=2.88u as=0.44p ps=2.88u w=1u l=0.5u
C0 a_n138_n100# a_50_n100# 0.03085f
C1 a_50_n100# a_n50_n144# 0.01275f
C2 a_n138_n100# a_n50_n144# 0.01275f
C3 a_50_n100# VSUBS 0.11563f
C4 a_n138_n100# VSUBS 0.11563f
.ends

.subckt n_w2_l1 a_100_n200# a_n100_n244# a_n188_n200# VSUBS
X0 a_100_n200# a_n100_n244# a_n188_n200# VSUBS nfet_03v3 ad=0.88p pd=4.88u as=0.88p ps=4.88u w=2u l=1u
C0 a_n188_n200# a_100_n200# 0.03858f
C1 a_100_n200# a_n100_n244# 0.04231f
C2 a_n188_n200# a_n100_n244# 0.04231f
C3 a_100_n200# VSUBS 0.19164f
C4 a_n188_n200# VSUBS 0.19164f
.ends

.subckt p_w1_l2 w_n374_n230# a_n288_n100# a_200_n100# a_n200_n144# VSUBS
X0 a_200_n100# a_n200_n144# a_n288_n100# w_n374_n230# pfet_03v3 ad=0.44p pd=2.88u as=0.44p ps=2.88u w=1u l=2u
C0 a_n200_n144# a_n288_n100# 0.02905f
C1 a_200_n100# w_n374_n230# 0.03135f
C2 a_200_n100# a_n288_n100# 0.01056f
C3 a_n288_n100# w_n374_n230# 0.03135f
C4 a_200_n100# a_n200_n144# 0.02905f
C5 a_n200_n144# w_n374_n230# 0.22666f
C6 a_200_n100# VSUBS 0.1047f
C7 a_n288_n100# VSUBS 0.1047f
C8 w_n374_n230# VSUBS 1.03224f
.ends

.subckt n_w0p5_l10 a_n1088_n50# a_1000_n50# a_n1000_n94# VSUBS
X0 a_1000_n50# a_n1000_n94# a_n1088_n50# VSUBS nfet_03v3 ad=0.22p pd=1.88u as=0.22p ps=1.88u w=0.5u l=10u
C0 a_1000_n50# a_n1000_n94# 0.01858f
C1 a_n1088_n50# a_n1000_n94# 0.01858f
C2 a_1000_n50# VSUBS 0.81206f
C3 a_n1088_n50# VSUBS 0.81206f
.ends

.subckt n_w0p22_l2 a_200_n22# a_n200_n66# a_n292_n36# VSUBS
X0 a_200_n22# a_n200_n66# a_n292_n36# VSUBS nfet_03v3 ad=0.1516p pd=1.64u as=0.1516p ps=1.64u w=0.22u l=2u
C0 a_n200_n66# a_200_n22# 0.00705f
C1 a_200_n22# a_n292_n36# 0.00245f
C2 a_n200_n66# a_n292_n36# 0.00705f
C3 a_200_n22# VSUBS 0.20767f
C4 a_n292_n36# VSUBS 0.20767f
.ends

.subckt n_w8_l0p5_k1 a_50_n800# a_n50_n844# a_n188_n800# VSUBS
X0 a_50_n800# a_n50_n844# a_n188_n800# VSUBS nfet_03v3 ad=5.52p pd=17.38u as=5.52p ps=17.38u w=8u l=0.5u
C0 a_n188_n800# a_50_n800# 0.204f
C1 a_50_n800# a_n50_n844# 0.08497f
C2 a_n188_n800# a_n50_n844# 0.08497f
C3 a_50_n800# VSUBS 0.38495f
C4 a_n188_n800# VSUBS 0.38495f
.ends

.subckt p_w8_l0p5 a_50_n800# a_n50_n844# w_n224_n930# a_n138_n800# VSUBS
X0 a_50_n800# a_n50_n844# a_n138_n800# w_n224_n930# pfet_03v3 ad=3.52p pd=16.88u as=3.52p ps=16.88u w=8u l=0.5u
C0 a_n50_n844# a_n138_n800# 0.10385f
C1 a_50_n800# w_n224_n930# 0.14631f
C2 a_50_n800# a_n138_n800# 0.25117f
C3 a_n138_n800# w_n224_n930# 0.14631f
C4 a_50_n800# a_n50_n844# 0.10385f
C5 a_n50_n844# w_n224_n930# 0.07993f
C6 a_50_n800# VSUBS 0.29186f
C7 a_n138_n800# VSUBS 0.29186f
C8 w_n224_n930# VSUBS 2.49984f
.ends

.subckt p_w2_l0p5 a_50_n200# a_n50_n244# w_n224_n330# a_n138_n200# VSUBS
X0 a_50_n200# a_n50_n244# a_n138_n200# w_n224_n330# pfet_03v3 ad=0.88p pd=4.88u as=0.88p ps=4.88u w=2u l=0.5u
C0 a_n50_n244# a_n138_n200# 0.02577f
C1 a_50_n200# w_n224_n330# 0.03848f
C2 a_50_n200# a_n138_n200# 0.06232f
C3 a_n138_n200# w_n224_n330# 0.03848f
C4 a_50_n200# a_n50_n244# 0.02577f
C5 a_n50_n244# w_n224_n330# 0.07993f
C6 a_50_n200# VSUBS 0.0978f
C7 a_n138_n200# VSUBS 0.0978f
C8 w_n224_n330# VSUBS 0.88704f
.ends

.subckt n_w2_l2 a_n288_n200# a_200_n200# a_n200_n244# VSUBS
X0 a_200_n200# a_n200_n244# a_n288_n200# VSUBS nfet_03v3 ad=0.88p pd=4.88u as=0.88p ps=4.88u w=2u l=2u
C0 a_n288_n200# a_200_n200# 0.02133f
C1 a_200_n200# a_n200_n244# 0.0587f
C2 a_n288_n200# a_n200_n244# 0.0587f
C3 a_200_n200# VSUBS 0.2667f
C4 a_n288_n200# VSUBS 0.2667f
.ends

.subckt n_w0p22_l8 a_800_n22# a_n800_n66# a_n892_n36# VSUBS
X0 a_800_n22# a_n800_n66# a_n892_n36# VSUBS nfet_03v3 ad=0.1516p pd=1.64u as=0.1516p ps=1.64u w=0.22u l=8u
C0 a_n800_n66# a_800_n22# 0.00918f
C1 a_n800_n66# a_n892_n36# 0.00918f
C2 a_800_n22# VSUBS 0.65928f
C3 a_n892_n36# VSUBS 0.65928f
.ends

.subckt n_w7p07_l7p07 a_707_n707# a_n795_n707# a_n707_n751# VSUBS
X0 a_707_n707# a_n707_n751# a_n795_n707# VSUBS nfet_03v3 ad=3.1108p pd=15.02u as=3.1108p ps=15.02u w=7.07u l=7.07u
C0 a_n795_n707# a_707_n707# 0.0212f
C1 a_707_n707# a_n707_n751# 0.27012f
C2 a_n795_n707# a_n707_n751# 0.27012f
C3 a_707_n707# VSUBS 0.84237f
C4 a_n795_n707# VSUBS 0.84237f
.ends

.subckt p_w0p22_l8 a_800_n22# a_n800_n66# w_n978_n159# a_n892_n36# VSUBS
X0 a_800_n22# a_n800_n66# a_n892_n36# w_n978_n159# pfet_03v3 ad=0.1516p pd=1.64u as=0.1516p ps=1.64u w=0.22u l=8u
C0 a_n892_n36# a_n800_n66# 0.00918f
C1 a_800_n22# w_n978_n159# 0.0077f
C2 a_800_n22# a_n800_n66# 0.00918f
C3 a_n800_n66# w_n978_n159# 0.83403f
C4 a_n892_n36# w_n978_n159# 0.0077f
C5 a_800_n22# VSUBS 0.23501f
C6 a_n892_n36# VSUBS 0.23501f
C7 w_n978_n159# VSUBS 1.86602f
.ends

.subckt n_w4_l2 a_n288_n400# a_200_n400# a_n200_n444# VSUBS
X0 a_200_n400# a_n200_n444# a_n288_n400# VSUBS nfet_03v3 ad=1.76p pd=8.88u as=1.76p ps=8.88u w=4u l=2u
C0 a_n288_n400# a_200_n400# 0.04287f
C1 a_200_n400# a_n200_n444# 0.11799f
C2 a_n288_n400# a_n200_n444# 0.11799f
C3 a_200_n400# VSUBS 0.34365f
C4 a_n288_n400# VSUBS 0.34365f
.ends

.subckt n_w3p54_l3p54 a_354_n354# a_n354_n398# a_n442_n354# VSUBS
X0 a_354_n354# a_n354_n398# a_n442_n354# VSUBS nfet_03v3 ad=1.5576p pd=7.96u as=1.5576p ps=7.96u w=3.54u l=3.54u
C0 a_n442_n354# a_354_n354# 0.02161f
C1 a_354_n354# a_n354_n398# 0.12189f
C2 a_n442_n354# a_n354_n398# 0.12189f
C3 a_354_n354# VSUBS 0.44156f
C4 a_n442_n354# VSUBS 0.44156f
.ends

.subckt p_w7p07_l7p07 w_n881_n837# a_707_n707# a_n795_n707# a_n707_n751# VSUBS
X0 a_707_n707# a_n707_n751# a_n795_n707# w_n881_n837# pfet_03v3 ad=3.1108p pd=15.02u as=3.1108p ps=15.02u w=7.07u l=7.07u
C0 a_n707_n751# a_n795_n707# 0.27012f
C1 a_707_n707# w_n881_n837# 0.28802f
C2 a_707_n707# a_n795_n707# 0.0212f
C3 a_n795_n707# w_n881_n837# 0.28802f
C4 a_707_n707# a_n707_n751# 0.27012f
C5 a_n707_n751# w_n881_n837# 0.72259f
C6 a_707_n707# VSUBS 0.43364f
C7 a_n795_n707# VSUBS 0.43364f
C8 w_n881_n837# VSUBS 8.84876f
.ends

.subckt p_w0p5_l2 a_n200_n94# w_n374_n180# a_n288_n50# a_200_n50# VSUBS
X0 a_200_n50# a_n200_n94# a_n288_n50# w_n374_n180# pfet_03v3 ad=0.22p pd=1.88u as=0.22p ps=1.88u w=0.5u l=2u
C0 a_n200_n94# a_n288_n50# 0.01423f
C1 a_200_n50# w_n374_n180# 0.01613f
C2 a_200_n50# a_n288_n50# 0.00517f
C3 a_n288_n50# w_n374_n180# 0.01613f
C4 a_200_n50# a_n200_n94# 0.01423f
C5 a_n200_n94# w_n374_n180# 0.22666f
C6 a_200_n50# VSUBS 0.08852f
C7 a_n288_n50# VSUBS 0.08852f
C8 w_n374_n180# VSUBS 0.80784f
.ends

.subckt adex_a1 vdd vss el vbn_leak vsrc vbp_st vbn_ref vreset vbn_prb vbp_syn vbp_w
+ abus sta spk stb en mreset sub0 sel_adex sub1 hold vm vw
XXD_XK a_5944_8034# spk vdd vdd vss p_w0p22_l1
XXL_XP1 a_3224_9320# a_3224_9320# vdd vdd vss p_w2_l4
XXL_XP2 a_6794_3960# a_3224_9320# vdd vdd vss p_w2_l4
XXL_XMT m1_5870_3330# vbn_leak vss vss n_w2_l4
XXL_XM1 a_3224_9320# a_5682_4760# el vss n_w4_l0p5_k1
XXS_XWA m1_1350_9910# vbp_syn vdd m1_4306_8930# vss p_w2_l4
XXR_Xi_XN spk vss a_4652_12054# vss n_w0p5_l0p28
XXL_XM2 a_6238_4760# a_6794_3960# a_6794_3960# vss n_w4_l0p5_k1
XXD_XPI m1_5010_11806# a_5308_6338# vm vdd vss p_w1_l0p5
XXS_XWB m1_2328_11796# vbp_syn vdd m1_4306_8930# vss p_w2_l4
XXP_XSA m1_3342_6130# sel_adex m1_3152_6276# vss n_w1_l0p28
XXR_XSW vreset vm a_2000_6434# vss n_w0p5_l0p5
XXR_XNR a_2000_6434# vbn_ref vss vss n_w2_l4
XXR_Xi_XP vdd a_4652_12054# spk vdd vss p_w1_l0p28
XXD_XNI vsrc a_5308_6338# vm vss n_w1_l0p5
XXP_XSC m1_3152_6276# a_3648_6534# abus vss n_w1_l0p28
XXA_XW_a a_6794_3960# vw vss vss n_w2_l1
XXS_XQA vdd vss sta m1_1350_9910# vss p_w1_l0p28
XXP_XPB vdd m1_2978_10750# m1_3242_10926# vbp_st vss p_w1_l2
XXA_XW_b a_6794_3960# vw vss vss n_w2_l1
XXA_XT1 vw m1_4290_5170# vbn_leak vss n_w0p5_l10
XXS_XQB vdd vss stb m1_2328_11796# vss p_w1_l0p28
XXP_Xi0_XN sub0 vss a_2884_11174# vss n_w0p5_l0p28
XXA_XT2 m1_4290_5170# m1_4046_5170# vbn_leak vss n_w0p5_l10
XXP_XPE vdd m1_2978_10750# a_2884_11174# vdd vss p_w1_l0p28
XXA_XPS vdd m1_2578_10926# a_2472_11174# vdd vss p_w1_l0p28
XXA_XR1 vw mreset m1_2438_5766# vss n_w0p22_l2
XXA_XT3 m1_1926_4740# m1_4046_5170# vbn_leak vss n_w0p5_l10
XXL_XD1 m1_5870_3330# a_5682_4760# a_5682_4760# vss n_w8_l0p5_k1
XXA_XPB_b vss vbn_leak vdd m1_5964_12420# vss p_w8_l0p5
XXA_XPB_a vss vbn_leak vdd m1_5964_12420# vss p_w8_l0p5
XXP_Xi0_XP vdd a_2884_11174# sub0 vdd vss p_w1_l0p28
XXP_XPF vss vw vdd m1_3242_10926# vss p_w2_l0p5
XXA_XR2 m1_2438_5766# mreset vss vss n_w0p22_l2
XXA_XT4 m1_1926_4740# m1_4000_4210# vbn_leak vss n_w0p5_l10
XXL_XD2 a_6238_4760# a_6238_4760# m1_5870_3330# vss n_w8_l0p5_k1
XXS_XNA sta vm m1_1350_9910# vss n_w0p5_l0p28
XXA_XPB_c vss vbn_leak vdd m1_5964_12420# vss p_w8_l0p5
XXD_XS2 vdd vdd m1_5478_11590# vbp_st vss p_w1_l2
XXD_XPS vdd vdd m1_5010_11806# vbp_st vss p_w1_l2
XXA_XT5 vss m1_4000_4210# vbn_leak vss n_w0p5_l10
XXP_XT0_XMB vss m1_2438_3470# vbn_prb vss n_w2_l2
XXS_XNB stb vm m1_2328_11796# vss n_w0p5_l0p28
XXA_XPB_d vss vbn_leak vdd m1_5964_12420# vss p_w8_l0p5
XXD_XS3 vdd vdd m1_5918_11806# vbp_st vss p_w1_l2
XXA_XPW vdd m1_2578_10926# m1_5964_12420# vbp_w vss p_w1_l2
XXE_XE1 a_3764_10978# vm vsrc vss n_w0p22_l8
XXC_XC vss vss vm vss n_w7p07_l7p07
XXD_XP2 vdd a_5532_8034# a_5308_6338# m1_5478_11590# vss p_w1_l0p28
XXE_XE2 a_3764_10978# a_3764_10978# vdd vdd vss p_w2_l0p5
XXS_XPH vdd vdd m1_4306_8930# hold vss p_w1_l2
XXP_XT0_XME m1_4970_6412# en m1_2438_3470# vss n_w1_l0p28
XXD_XP3 vdd a_5944_8034# a_5532_8034# m1_5918_11806# vss p_w1_l0p28
XXE_XE3 a_6794_3960# a_3764_10978# vdd vdd vss p_w0p22_l8
XXD_Xi4_XN a_5944_8034# vss spk vss n_w0p5_l0p28
XXP_XT0_XMF m1_4970_6412# vdd vm vss n_w4_l2
XXD_XN2 a_5532_8034# a_5308_6338# vsrc vss n_w0p22_l2
XXR_XCR_XC vss a_2000_6434# vss vss n_w3p54_l3p54
XXD_Xi4_XP vdd spk a_5944_8034# vdd vss p_w1_l0p28
XXD_XN3 a_5532_8034# vsrc a_5944_8034# vss n_w0p5_l0p28
XXP_Xi1_XN sub1 vss a_3648_6534# vss n_w0p5_l0p28
XXR_XPC vdd a_2000_6434# a_4652_12054# vdd vss p_w1_l0p28
XXP_Xi1_XP vdd a_3648_6534# sub1 vdd vss p_w1_l0p28
XXP_XS1 m1_3242_10926# sub0 m1_3342_6130# vss n_w1_l0p28
XXA_Xi_XN a_2000_6434# vss a_2472_11174# vss n_w0p5_l0p28
XXA_Xi_XP vdd a_2472_11174# a_2000_6434# m1_1926_10610# vss p_w1_l0p28
XXA_XCW vdd vdd vdd vw vss p_w7p07_l7p07
XXS_XHL vdd vm hold a_6794_3960# vss p_w1_l0p28
XXA_XPA vw vdd m1_5964_12420# vw vss p_w0p5_l2
XXP_XT0_XSW m1_4970_6412# a_2884_11174# m1_3342_6130# vss n_w1_l0p28
XXA_Xi_XS vdd vdd m1_1926_10610# vbp_st vss p_w1_l2
XXS_XMR mreset a_2000_6434# vdd vss n_w0p5_l0p28
C0 m1_1350_9910# en 0.06011f
C1 abus vbn_leak 0.64741f
C2 m1_4306_8930# m1_1350_9910# 0.15062f
C3 vdd abus 0.19513f
C4 m1_2578_10926# a_2884_11174# 0.04349f
C5 m1_5964_12420# hold 0.76925f
C6 stb sel_adex 0
C7 a_3224_9320# vbn_ref 0
C8 m1_5918_11806# vw 0.19032f
C9 vbn_prb vbn_leak 0.05959f
C10 mreset vreset 0.01469f
C11 vdd vbn_prb 0.09004f
C12 m1_1926_4740# a_2000_6434# 0.00747f
C13 vsrc vbp_w 0.06132f
C14 vw vm 0.20122f
C15 m1_2978_10750# vbp_syn 0.00203f
C16 a_6794_3960# a_4652_12054# 0.1212f
C17 vsrc a_2884_11174# 0.00134f
C18 vsrc a_5944_8034# 0.00825f
C19 m1_4046_5170# abus 0
C20 vbp_w m1_1350_9910# 0.14658f
C21 vbp_w a_3648_6534# 0
C22 vw a_3224_9320# 0.06628f
C23 m1_1350_9910# a_2884_11174# 0.07911f
C24 a_2884_11174# a_3648_6534# 0.07274f
C25 m1_1350_9910# a_5944_8034# 0
C26 a_2472_11174# abus 0
C27 hold abus 0
C28 sta sub0 0
C29 a_3764_10978# a_5532_8034# 0.04348f
C30 vw m1_3152_6276# 0.31262f
C31 m1_5964_12420# spk 0.16269f
C32 sub1 vsrc 0.04215f
C33 m1_4290_5170# a_6794_3960# 0.0023f
C34 a_4652_12054# m1_5010_11806# 0.00645f
C35 sub1 m1_1350_9910# 0.04592f
C36 sub1 a_3648_6534# 0.77155f
C37 m1_2438_3470# vbn_leak 0.4593f
C38 mreset m1_4290_5170# 0.02959f
C39 vm vreset 0.52685f
C40 m1_3242_10926# en 0.13694f
C41 vdd en 0.02974f
C42 vbn_leak en 0.36091f
C43 m1_2438_3470# a_5308_6338# 0
C44 sel_adex a_5532_8034# 0.00476f
C45 m1_3242_10926# m1_4306_8930# 0.18642f
C46 m1_5918_11806# a_4652_12054# 0
C47 m1_4306_8930# vdd 0.22581f
C48 a_3224_9320# vreset 0
C49 vm a_4652_12054# 0.04282f
C50 m1_2438_3470# m1_4046_5170# 0.08566f
C51 vbp_st a_6794_3960# 0.16171f
C52 a_5308_6338# en 0
C53 m1_4306_8930# a_5308_6338# 0.06359f
C54 mreset vbp_st 0
C55 m1_4046_5170# en 0.00296f
C56 vw sub0 0.433f
C57 m1_2978_10750# m1_2578_10926# 0.00916f
C58 m1_4000_4210# a_2000_6434# 0
C59 vbp_w vbn_leak 0.05425f
C60 vdd vbp_w 1.05695f
C61 m1_3242_10926# a_2884_11174# 0.1088f
C62 vbn_leak a_2884_11174# 0.00347f
C63 vdd a_2884_11174# 0.96853f
C64 a_5944_8034# vbn_leak 0.00489f
C65 vdd a_5944_8034# 1.19724f
C66 m1_5964_12420# m1_5478_11590# 0.0675f
C67 m1_4306_8930# hold -0.01212f
C68 vm m1_4290_5170# 0.08608f
C69 a_6794_3960# vbp_syn 0.22214f
C70 vbp_st m1_5010_11806# 0.07722f
C71 m1_2438_5766# a_2000_6434# 0.02478f
C72 a_5308_6338# a_2884_11174# 0.00423f
C73 a_3764_10978# a_2000_6434# 0
C74 a_5944_8034# a_5308_6338# 0.00456f
C75 mreset vbp_syn 0
C76 a_6794_3960# m1_2328_11796# 0.13318f
C77 m1_4000_4210# sel_adex 0
C78 m1_2978_10750# a_3648_6534# 0.01933f
C79 a_3224_9320# m1_4290_5170# 0.00279f
C80 m1_3242_10926# sub1 0.18454f
C81 stb abus 0.04053f
C82 sub1 vbn_leak 0.00636f
C83 vdd sub1 1.02338f
C84 vbp_w a_2472_11174# 0.04811f
C85 mreset m1_2328_11796# 0.09605f
C86 vbp_w hold 0.07849f
C87 a_2472_11174# a_2884_11174# 0.64399f
C88 hold a_2884_11174# 0.06583f
C89 m1_3342_6130# vw 0.34933f
C90 vbp_st m1_5918_11806# 0.17882f
C91 a_5944_8034# hold 0.06056f
C92 sta a_5682_4760# 0
C93 vbp_st vm 0.13119f
C94 spk en 0.04655f
C95 stb vbn_prb 0.00253f
C96 a_3764_10978# sel_adex 0
C97 m1_4306_8930# spk 0
C98 sub1 a_5308_6338# 0.04505f
C99 m1_4970_6412# a_6794_3960# 0.12682f
C100 vbp_syn m1_5010_11806# 0
C101 sel_adex a_2000_6434# 0
C102 vbp_st a_3224_9320# 0.02589f
C103 mreset m1_4970_6412# 0.05602f
C104 sub0 a_4652_12054# 0.00461f
C105 vbp_st m1_1926_10610# 0.1276f
C106 sub1 a_2472_11174# 0
C107 sub1 hold 0.23201f
C108 m1_1926_4740# abus 0.09081f
C109 m1_5964_12420# a_5532_8034# 0.0797f
C110 spk a_2884_11174# 0
C111 vm vbp_syn 0.03752f
C112 spk a_5944_8034# 0.23444f
C113 sta vbn_ref 0.02617f
C114 m1_1926_4740# vbn_prb 0
C115 vm m1_2328_11796# 1.29902f
C116 el a_6794_3960# 0
C117 a_3224_9320# vbp_syn 0.00294f
C118 m1_2438_3470# stb 0.07182f
C119 sub0 m1_4290_5170# 0.02278f
C120 a_6238_4760# a_6794_3960# 0.02106f
C121 m1_2578_10926# a_6794_3960# 0.20915f
C122 mreset el 0.56962f
C123 a_3224_9320# m1_2328_11796# 0.03423f
C124 m1_3242_10926# m1_2978_10750# 0.35607f
C125 vdd m1_2978_10750# 0.30851f
C126 vw sta 0
C127 sub1 spk 0.11653f
C128 stb en 0.71968f
C129 mreset a_6238_4760# 0.02278f
C130 m1_1926_10610# m1_2328_11796# 0.03078f
C131 m1_3152_6276# m1_2328_11796# 0
C132 vm m1_4970_6412# 0.51912f
C133 vsrc a_6794_3960# 0.30681f
C134 mreset vsrc 0.03023f
C135 m1_1350_9910# a_6794_3960# 0.26661f
C136 a_6794_3960# a_3648_6534# 0.06264f
C137 vbp_st sub0 0
C138 stb vbp_w 0.19439f
C139 mreset m1_1350_9910# 0.07684f
C140 mreset a_3648_6534# 0.0028f
C141 m1_2978_10750# hold 0.22256f
C142 stb a_2884_11174# 0.57923f
C143 vw vbn_ref 0
C144 m1_3342_6130# m1_4290_5170# 0
C145 a_3764_10978# m1_5964_12420# 0.12719f
C146 m1_5478_11590# a_5944_8034# 0.18595f
C147 el vm 0.05101f
C148 sta vreset 0.14373f
C149 m1_5964_12420# a_2000_6434# 0.0807f
C150 vm a_6238_4760# 0
C151 sub0 vbp_syn 0.00107f
C152 stb sub1 0.01937f
C153 el a_3224_9320# 0.13992f
C154 sub0 m1_2328_11796# 0.17808f
C155 m1_1926_4740# vbp_w 0.00235f
C156 a_3224_9320# m1_2578_10926# 0
C157 vsrc vm 0.35259f
C158 m1_2578_10926# m1_1926_10610# 0.04843f
C159 m1_4306_8930# a_5532_8034# 0.00618f
C160 vm m1_1350_9910# 0.51688f
C161 vm a_3648_6534# 0.02213f
C162 abus a_2000_6434# 0.26978f
C163 vreset vbn_ref 2.62127f
C164 a_3224_9320# vsrc 0.08238f
C165 sub0 m1_4970_6412# 0.16471f
C166 a_3224_9320# m1_1350_9910# 0.25989f
C167 m1_3242_10926# a_6794_3960# 0.21631f
C168 vbn_prb a_2000_6434# 0
C169 a_3224_9320# a_3648_6534# 0.11479f
C170 a_6794_3960# vbn_leak 0.00628f
C171 vdd a_6794_3960# 1.57047f
C172 m1_4290_5170# a_5682_4760# 0
C173 a_2884_11174# a_5532_8034# 0
C174 m1_1350_9910# m1_3152_6276# 0
C175 mreset vdd 0.0842f
C176 m1_3152_6276# a_3648_6534# 0.07727f
C177 mreset vbn_leak 0.53657f
C178 a_5944_8034# a_5532_8034# 0.19815f
C179 m1_2438_3470# m1_4000_4210# 0.10566f
C180 sel_adex abus 0.04269f
C181 vw vreset 0
C182 a_5308_6338# a_6794_3960# 0.04494f
C183 m1_4046_5170# a_6794_3960# 0.00632f
C184 mreset a_5308_6338# 0
C185 m1_4000_4210# en 0.00413f
C186 vw a_4652_12054# 0.11557f
C187 mreset m1_4046_5170# 0.13015f
C188 stb m1_2978_10750# 0.00113f
C189 vbp_st sta 0.02649f
C190 a_2472_11174# a_6794_3960# 0.00113f
C191 sub1 a_5532_8034# 0.04715f
C192 hold a_6794_3960# 0.01296f
C193 m1_5010_11806# vbn_leak 0
C194 vdd m1_5010_11806# 0.56476f
C195 m1_5870_3330# en 0.04443f
C196 a_6238_4760# sub0 0
C197 m1_3342_6130# m1_4970_6412# 0.1157f
C198 mreset a_2472_11174# 0.00204f
C199 m1_2438_3470# a_2000_6434# 0.16771f
C200 a_3764_10978# en 0.00115f
C201 m1_4306_8930# a_3764_10978# 0.06625f
C202 a_5308_6338# m1_5010_11806# 0.13796f
C203 m1_5918_11806# vbn_leak 0
C204 vsrc sub0 0.05559f
C205 m1_3242_10926# vm 0.00709f
C206 vdd m1_5918_11806# 0.5934f
C207 vm vbn_leak 0.28757f
C208 vdd vm 0.92051f
C209 a_2000_6434# en 0.49094f
C210 sta vbp_syn 0.01365f
C211 sub0 m1_1350_9910# 0.23439f
C212 sub0 a_3648_6534# 1.02357f
C213 vbp_st vbn_ref 2.64503f
C214 spk a_6794_3960# 0.52065f
C215 hold m1_5010_11806# 0
C216 m1_2438_3470# sel_adex 0.04745f
C217 sta m1_2328_11796# 0.23723f
C218 a_5682_4760# m1_2328_11796# 0.00183f
C219 m1_3242_10926# a_3224_9320# 0.00975f
C220 m1_5918_11806# a_5308_6338# 0.0019f
C221 a_3224_9320# vbn_leak 0.47088f
C222 vdd a_3224_9320# 1.43681f
C223 vm a_5308_6338# 0.97631f
C224 a_3764_10978# a_2884_11174# 0.34759f
C225 mreset spk 0.04972f
C226 m1_2438_5766# a_2884_11174# 0
C227 a_3764_10978# a_5944_8034# 0.00297f
C228 vdd m1_1926_10610# 0.38653f
C229 m1_4046_5170# vm 0.05345f
C230 m1_3152_6276# vbn_leak 0.05157f
C231 vbp_w a_2000_6434# 0.05389f
C232 sel_adex en 0.09603f
C233 a_2000_6434# a_2884_11174# 0.00161f
C234 a_5944_8034# a_2000_6434# 0
C235 m1_5918_11806# hold 0.01163f
C236 vm a_2472_11174# 0.09127f
C237 vbp_st vw 0.91242f
C238 vm hold 0.27859f
C239 m1_4046_5170# a_3224_9320# 0.1485f
C240 sta m1_4970_6412# 0.05164f
C241 a_5308_6338# m1_3152_6276# 0
C242 m1_4970_6412# a_5682_4760# 0.00132f
C243 vbp_syn vbn_ref 0.02179f
C244 m1_3342_6130# vsrc 0.06749f
C245 sub1 a_3764_10978# 0.03981f
C246 spk m1_5010_11806# 0.01417f
C247 a_3224_9320# a_2472_11174# 0.05849f
C248 a_3224_9320# hold 0.00355f
C249 vbn_ref m1_2328_11796# 0.03183f
C250 m1_3342_6130# m1_1350_9910# 0.00383f
C251 m1_3342_6130# a_3648_6534# 0.00657f
C252 a_2472_11174# m1_1926_10610# 0.1299f
C253 sel_adex a_2884_11174# 0.00247f
C254 sub1 a_2000_6434# 0.04908f
C255 vw vbp_syn 0.77592f
C256 m1_5918_11806# spk 0.23581f
C257 vm spk 8.05388f
C258 stb a_6794_3960# 0.26616f
C259 vw m1_2328_11796# 0.03518f
C260 el sta 0.04671f
C261 el a_5682_4760# 0.0285f
C262 mreset stb 0.21305f
C263 m1_3242_10926# sub0 0.34981f
C264 sub0 vbn_leak 0.09874f
C265 vdd sub0 0.8635f
C266 sub1 sel_adex 0.24114f
C267 vbp_st vreset 0.05547f
C268 sta a_6238_4760# 0
C269 a_6238_4760# a_5682_4760# 0.00633f
C270 vbn_prb abus 0.02581f
C271 sub0 a_5308_6338# 0.00113f
C272 vbp_st a_4652_12054# 0.29655f
C273 vw m1_4970_6412# 0.00256f
C274 m1_4046_5170# sub0 0.00995f
C275 vsrc sta 0.08836f
C276 m1_1350_9910# a_5682_4760# 0
C277 sta m1_1350_9910# 1.14302f
C278 m1_2978_10750# a_3764_10978# 0.01824f
C279 sub0 a_2472_11174# 0.01257f
C280 vreset vbp_syn 0.03191f
C281 el vbn_ref 0.18218f
C282 m1_5478_11590# m1_5010_11806# 0.01505f
C283 sub0 hold 0.06573f
C284 mreset m1_1926_4740# 0
C285 vreset m1_2328_11796# 0.14697f
C286 m1_3242_10926# m1_3342_6130# 0.01163f
C287 m1_3342_6130# vbn_leak 0.38435f
C288 a_4652_12054# vbp_syn 0.80145f
C289 stb vm 1.37917f
C290 a_4652_12054# m1_2328_11796# 0.10434f
C291 m1_5918_11806# m1_5478_11590# 0.02373f
C292 vm m1_5478_11590# 0.00755f
C293 m1_2438_3470# abus 0
C294 m1_3342_6130# a_5308_6338# 0
C295 vsrc vbn_ref 0.05887f
C296 a_6794_3960# a_5532_8034# 0.07351f
C297 stb a_3224_9320# 0.10892f
C298 m1_5964_12420# vbp_w 0.06951f
C299 vw m1_2578_10926# 0
C300 m1_4046_5170# m1_3342_6130# 0.00521f
C301 m1_1350_9910# vbn_ref 0.29392f
C302 sub0 spk 0.04476f
C303 mreset a_5532_8034# 0
C304 stb m1_1926_10610# 0
C305 m1_5964_12420# a_2884_11174# 0.03083f
C306 m1_2438_3470# vbn_prb -0
C307 m1_5964_12420# a_5944_8034# 0.14956f
C308 abus en 0.12894f
C309 stb m1_3152_6276# 0
C310 vw vsrc 0.26478f
C311 m1_1926_4740# vm 0
C312 m1_4290_5170# m1_2328_11796# 0
C313 vw m1_1350_9910# 0.08151f
C314 vw a_3648_6534# 0.04704f
C315 m1_5010_11806# a_5532_8034# 0.08309f
C316 vbp_w abus 2.62235f
C317 sub1 m1_5964_12420# 0.00294f
C318 abus a_2884_11174# 0
C319 el vreset 0.04904f
C320 vdd a_5682_4760# 0
C321 a_5682_4760# vbn_leak 0.03231f
C322 sta vbn_leak 0.08117f
C323 vdd sta 0.64764f
C324 vbn_prb vbp_w 0.02598f
C325 vbp_st vbp_syn 0.51167f
C326 m1_4970_6412# m1_4290_5170# 0.00423f
C327 m1_5918_11806# a_5532_8034# 0.07188f
C328 m1_5870_3330# a_6794_3960# 0
C329 mreset m1_4000_4210# 0.00108f
C330 vbp_st m1_2328_11796# 0.13645f
C331 vm a_5532_8034# 0.02802f
C332 m1_4046_5170# a_5682_4760# 0.07805f
C333 mreset m1_5870_3330# 0.17268f
C334 stb sub0 0.06011f
C335 sub1 abus 0.00486f
C336 a_3764_10978# a_6794_3960# 0.23771f
C337 m1_2438_3470# en 0.28787f
C338 vsrc vreset 0.0581f
C339 sta a_2472_11174# 0.00319f
C340 mreset m1_2438_5766# 0.08859f
C341 m1_1350_9910# vreset 0.02853f
C342 vbn_ref vbn_leak 0.16386f
C343 a_6794_3960# a_2000_6434# 0.00539f
C344 vdd vbn_ref 0.13156f
C345 vbp_syn m1_2328_11796# -0.01164f
C346 mreset a_2000_6434# 0.62687f
C347 el m1_4290_5170# 0
C348 m1_2438_3470# vbp_w 0
C349 a_4652_12054# a_3648_6534# 0
C350 m1_2438_3470# a_2884_11174# 0
C351 m1_3242_10926# vw 0.18611f
C352 m1_2978_10750# m1_5964_12420# 0.02168f
C353 a_3764_10978# m1_5010_11806# 0.19089f
C354 vw vbn_leak 0.61095f
C355 vdd vw 4.19525f
C356 sel_adex a_6794_3960# 0.0384f
C357 vm m1_4000_4210# 0
C358 sta spk 0.13292f
C359 a_2884_11174# en 0.02292f
C360 mreset sel_adex 0
C361 m1_5010_11806# a_2000_6434# 0.02706f
C362 m1_5870_3330# vm 0.20281f
C363 m1_4306_8930# a_5944_8034# 0
C364 vsrc m1_4290_5170# 0.07286f
C365 vw a_5308_6338# 0.17817f
C366 vbp_st el 0.03178f
C367 a_3224_9320# m1_4000_4210# 0.05423f
C368 m1_4970_6412# m1_2328_11796# 0.31048f
C369 m1_5918_11806# a_3764_10978# 0
C370 m1_2438_3470# sub1 0.00366f
C371 m1_1350_9910# m1_4290_5170# 0.06825f
C372 vm a_3764_10978# 0.04691f
C373 vm m1_2438_5766# 0.00189f
C374 m1_5870_3330# a_3224_9320# 0.08915f
C375 vbp_st m1_2578_10926# 0
C376 vw a_2472_11174# 0
C377 sub0 a_5532_8034# 0
C378 vbp_w a_2884_11174# 0.14723f
C379 vw hold 0.33798f
C380 vm a_2000_6434# 0.79376f
C381 sub1 en 0.0114f
C382 a_3224_9320# a_3764_10978# 0
C383 m1_4306_8930# sub1 0.09237f
C384 vbp_st vsrc 2.65273f
C385 el vbp_syn 0.03031f
C386 vreset vbn_leak 0.05385f
C387 vdd vreset 0.21479f
C388 a_3224_9320# a_2000_6434# 0.05576f
C389 vbp_st a_3648_6534# 0
C390 vbp_st m1_1350_9910# 0.03363f
C391 a_2000_6434# m1_1926_10610# 0.07422f
C392 el m1_2328_11796# 0.0599f
C393 m1_3152_6276# a_2000_6434# 0.00575f
C394 sub1 vbp_w 0.00307f
C395 m1_3242_10926# a_4652_12054# 0.04417f
C396 vm sel_adex 0.0514f
C397 a_4652_12054# vbn_leak 0.00132f
C398 vdd a_4652_12054# 1.43238f
C399 m1_2578_10926# m1_2328_11796# 0
C400 a_6238_4760# m1_2328_11796# 0.08878f
C401 sub1 a_2884_11174# 0.15871f
C402 sub1 a_5944_8034# 0.00174f
C403 stb a_5682_4760# 0
C404 stb sta 0.19564f
C405 vw spk 0.18083f
C406 a_3224_9320# sel_adex 0.04843f
C407 vsrc vbp_syn 0.05949f
C408 a_5308_6338# a_4652_12054# 0.02215f
C409 vsrc m1_2328_11796# 0.02627f
C410 el m1_4970_6412# 0
C411 m1_1350_9910# vbp_syn 0.244f
C412 m1_3152_6276# sel_adex 0.02848f
C413 a_6238_4760# m1_4970_6412# 0.36249f
C414 m1_1350_9910# m1_2328_11796# 0.41866f
C415 m1_4290_5170# vbn_leak 0.50295f
C416 m1_5964_12420# a_6794_3960# 0.00831f
C417 hold a_4652_12054# 0
C418 a_3764_10978# sub0 0.15923f
C419 stb vbn_ref 0.05771f
C420 m1_2438_5766# sub0 0
C421 m1_4306_8930# m1_2978_10750# 0.02754f
C422 m1_1926_4740# sta 0.03432f
C423 vsrc m1_4970_6412# 0.14677f
C424 m1_4290_5170# a_5308_6338# 0.00106f
C425 sub0 a_2000_6434# 0.00807f
C426 m1_4970_6412# m1_1350_9910# 0.06794f
C427 m1_4046_5170# m1_4290_5170# 0.35479f
C428 m1_3242_10926# vbp_st 0.08838f
C429 vdd vbp_st 4.48757f
C430 vbp_st vbn_leak 0.54361f
C431 m1_2978_10750# vbp_w 0.04265f
C432 el a_6238_4760# 0
C433 stb vw 0.01905f
C434 m1_5964_12420# m1_5010_11806# 0.00293f
C435 spk a_4652_12054# 0.31017f
C436 m1_2978_10750# a_2884_11174# 0.0148f
C437 mreset abus 0.0453f
C438 vw m1_5478_11590# 0.12541f
C439 vbp_st a_5308_6338# 0.06343f
C440 m1_1926_4740# vbn_ref 0
C441 sub0 sel_adex 0.63033f
C442 el vsrc 0.03337f
C443 mreset vbn_prb 0
C444 m1_5918_11806# m1_5964_12420# 0.08401f
C445 vm m1_5964_12420# 0.03287f
C446 m1_3242_10926# vbp_syn 0.12739f
C447 el m1_1350_9910# 0.16904f
C448 vbp_syn vbn_leak 0.38942f
C449 vdd vbp_syn 1.96213f
C450 m1_3342_6130# a_2000_6434# 0
C451 vbp_st a_2472_11174# 0.10196f
C452 sub1 m1_2978_10750# 0.14637f
C453 vbp_st hold 0.20218f
C454 vbn_leak m1_2328_11796# 0.10705f
C455 vdd m1_2328_11796# 1.38638f
C456 a_3224_9320# m1_5964_12420# 0
C457 a_5308_6338# vbp_syn 0.04034f
C458 stb vreset 0.00325f
C459 a_5308_6338# m1_2328_11796# 0.00208f
C460 vsrc m1_1350_9910# 0.54243f
C461 m1_3342_6130# sel_adex 0.35877f
C462 m1_4046_5170# m1_2328_11796# 0.0388f
C463 vm abus 0.15431f
C464 m1_4000_4210# a_5682_4760# 0
C465 m1_1350_9910# a_3648_6534# 0
C466 vdd m1_4970_6412# 0.05158f
C467 m1_4970_6412# vbn_leak 0.09248f
C468 hold vbp_syn 0.18932f
C469 mreset m1_2438_3470# 0.08826f
C470 vbp_st spk 0.09999f
C471 m1_5870_3330# a_5682_4760# 0.16396f
C472 a_2472_11174# m1_2328_11796# 0.68656f
C473 m1_5478_11590# a_4652_12054# 0.00255f
C474 vw a_5532_8034# 0.06499f
C475 a_6794_3960# en 0.01896f
C476 vm vbn_prb 0.00306f
C477 a_3224_9320# abus 0.15729f
C478 m1_4306_8930# a_6794_3960# 0.35613f
C479 m1_4970_6412# a_5308_6338# 0.163f
C480 mreset en 0.12387f
C481 m1_3152_6276# abus 0.13251f
C482 m1_4046_5170# m1_4970_6412# 0.06143f
C483 a_3224_9320# vbn_prb 0
C484 m1_1926_4740# vreset 0
C485 sta a_2000_6434# 1.12601f
C486 vbp_w a_6794_3960# 0.33728f
C487 spk vbp_syn 0.06734f
C488 vdd el 2.64779f
C489 el vbn_leak 3.06846f
C490 a_5944_8034# a_6794_3960# 0.01102f
C491 a_6794_3960# a_2884_11174# 0.14956f
C492 mreset vbp_w 0
C493 spk m1_2328_11796# 0.52699f
C494 m1_5964_12420# sub0 0.10405f
C495 vdd a_6238_4760# 0.01906f
C496 a_6238_4760# vbn_leak 0.00568f
C497 vdd m1_2578_10926# 0.19622f
C498 mreset a_2884_11174# 0
C499 m1_2438_3470# vm 0.02859f
C500 sta sel_adex 0
C501 m1_4046_5170# el 0.0018f
C502 m1_3242_10926# vsrc 0
C503 vsrc vbn_leak 4.09016f
C504 vbp_st stb 0.00179f
C505 vbn_ref a_2000_6434# 0.13702f
C506 vdd vsrc 0.19989f
C507 m1_4046_5170# a_6238_4760# 0.01029f
C508 sub1 a_6794_3960# 0.22576f
C509 m1_2438_3470# a_3224_9320# 0.10995f
C510 vm en 0.03989f
C511 m1_4970_6412# spk 0.22186f
C512 m1_4306_8930# vm 0.04316f
C513 a_4652_12054# a_5532_8034# 0.02257f
C514 m1_3242_10926# m1_1350_9910# 0.00253f
C515 m1_3242_10926# a_3648_6534# 0.02654f
C516 vbp_st m1_5478_11590# 0.1906f
C517 m1_1350_9910# vbn_leak 1.03077f
C518 vdd m1_1350_9910# 0.60916f
C519 vbn_leak a_3648_6534# 0.00256f
C520 vdd a_3648_6534# 0.55575f
C521 mreset sub1 0.00254f
C522 sub0 abus 0
C523 vw a_3764_10978# 0.20212f
C524 vw m1_2438_5766# -0.00245f
C525 a_2472_11174# m1_2578_10926# 0.01449f
C526 vsrc a_5308_6338# 0.13127f
C527 a_3224_9320# en 0.08739f
C528 m1_4306_8930# a_3224_9320# 0.00548f
C529 m1_4046_5170# vsrc 0.08453f
C530 m1_1350_9910# a_5308_6338# 0.00376f
C531 vw a_2000_6434# 0.27532f
C532 m1_3152_6276# en 0
C533 vm vbp_w 0.19488f
C534 m1_4046_5170# m1_1350_9910# 0.21107f
C535 stb vbp_syn 0
C536 m1_5918_11806# a_5944_8034# 0.09865f
C537 vm a_5944_8034# 0.00283f
C538 vm a_2884_11174# 0.55503f
C539 vbp_st m1_1926_4740# 0
C540 m1_5478_11590# vbp_syn 0.00148f
C541 stb m1_2328_11796# 0.82567f
C542 m1_4290_5170# a_5532_8034# 0
C543 m1_1350_9910# a_2472_11174# 0.26144f
C544 a_3224_9320# vbp_w 0.55803f
C545 m1_1350_9910# hold 0
C546 hold a_3648_6534# 0.0367f
C547 a_3224_9320# a_2884_11174# 0.13566f
C548 vbp_w m1_1926_10610# 0
C549 a_6238_4760# spk 0.03399f
C550 vw sel_adex 0.05544f
C551 m1_1926_10610# a_2884_11174# 0.06229f
C552 m1_3342_6130# abus 0.18871f
C553 m1_3152_6276# a_2884_11174# 0
C554 sub1 vm 0.14073f
C555 stb m1_4970_6412# 0.04023f
C556 m1_1926_4740# vbp_syn 0.00139f
C557 vsrc spk 0
C558 m1_2978_10750# a_6794_3960# 0.11031f
C559 vbp_st a_5532_8034# 0.04034f
C560 m1_2438_3470# sub0 0.0426f
C561 vreset a_2000_6434# 0.02525f
C562 sub1 a_3224_9320# 0.49741f
C563 a_3764_10978# a_4652_12054# 0.10443f
C564 m1_1926_4740# m1_2328_11796# 0.00227f
C565 spk a_3648_6534# 0
C566 m1_3242_10926# vbn_leak 0.00382f
C567 m1_3242_10926# vdd 0.72412f
C568 vdd vbn_leak 1.26801f
C569 sub1 m1_3152_6276# 0.00322f
C570 sub0 en 0.08487f
C571 m1_4306_8930# sub0 0.11349f
C572 a_4652_12054# a_2000_6434# 0.08528f
C573 m1_3242_10926# a_5308_6338# 0
C574 a_5308_6338# vbn_leak 0.01094f
C575 vdd a_5308_6338# 0.37045f
C576 vbp_syn a_5532_8034# 0.05939f
C577 stb el 0.09628f
C578 m1_4046_5170# vbn_leak 0.35821f
C579 sub0 vbp_w 0
C580 stb a_6238_4760# 0.0012f
C581 m1_2328_11796# a_5532_8034# 0.01583f
C582 stb m1_2578_10926# 0.09378f
C583 m1_2438_3470# m1_3342_6130# 0.11202f
C584 sub0 a_2884_11174# 0.71549f
C585 a_2472_11174# vbn_leak 0
C586 sta abus 0.72261f
C587 vdd a_2472_11174# 0.54435f
C588 m1_3242_10926# hold 0.04992f
C589 vdd hold 1.7834f
C590 hold vbn_leak 0.06388f
C591 m1_4046_5170# a_5308_6338# 0
C592 m1_3342_6130# en 0.11135f
C593 m1_2978_10750# vm 0.06292f
C594 stb vsrc 0.0374f
C595 sta vbn_prb 0.08073f
C596 hold a_5308_6338# 0
C597 m1_4970_6412# a_5532_8034# 0.05908f
C598 stb m1_1350_9910# 0.04655f
C599 stb a_3648_6534# 0
C600 vbp_st a_3764_10978# 0.46478f
C601 m1_1926_4740# el 0
C602 m1_2978_10750# a_3224_9320# 0
C603 sub1 sub0 0.45988f
C604 vw m1_5964_12420# 0.68722f
C605 m1_4290_5170# sel_adex 0.00109f
C606 vbp_st a_2000_6434# 0.0635f
C607 m1_3242_10926# spk 0
C608 vbn_ref abus 0.02284f
C609 spk vbn_leak 0.08107f
C610 vdd spk 2.76144f
C611 m1_3342_6130# a_2884_11174# 0.02772f
C612 vbn_prb vbn_ref 0.41616f
C613 m1_1926_4740# vsrc 0
C614 m1_5870_3330# m1_2328_11796# 0.19909f
C615 spk a_5308_6338# 0.03036f
C616 a_3764_10978# vbp_syn 0.33126f
C617 m1_4046_5170# spk 0
C618 m1_2438_3470# sta 0.00229f
C619 m1_1926_4740# m1_1350_9910# 0.00612f
C620 m1_2438_3470# a_5682_4760# 0
C621 mreset a_6794_3960# 0.02424f
C622 vw abus 0.06851f
C623 m1_2438_5766# m1_2328_11796# 0.0249f
C624 a_3764_10978# m1_2328_11796# 0
C625 vbp_syn a_2000_6434# 0.11789f
C626 m1_3342_6130# sub1 0.01312f
C627 spk hold 0.21612f
C628 sta en 0
C629 a_5682_4760# en 0.02539f
C630 vw vbn_prb 0
C631 a_2000_6434# m1_2328_11796# 1.0158f
C632 m1_5870_3330# m1_4970_6412# 0.02878f
C633 vsrc a_5532_8034# 0.04256f
C634 a_6794_3960# m1_5010_11806# 0.07396f
C635 a_3764_10978# m1_4970_6412# 0
C636 m1_5964_12420# a_4652_12054# 0
C637 m1_1350_9910# a_5532_8034# 0
C638 m1_2978_10750# sub0 0.02593f
C639 m1_2438_3470# vbn_ref 0.3922f
C640 stb vbn_leak 0.10253f
C641 vdd stb 0.54936f
C642 sta vbp_w 0.05753f
C643 sel_adex m1_2328_11796# 0.049f
C644 sta a_2884_11174# 0.00122f
C645 m1_5478_11590# vbn_leak 0
C646 vdd m1_5478_11590# 0.36046f
C647 el m1_4000_4210# 0
C648 vbn_ref en 0.01263f
C649 vreset abus 0.03714f
C650 vm a_6794_3960# 0.61142f
C651 el m1_5870_3330# 0.08696f
C652 mreset vm 1.02358f
C653 m1_2438_3470# vw 0
C654 m1_5478_11590# a_5308_6338# 0.09277f
C655 vbn_prb vreset 2.62402f
C656 m1_5870_3330# a_6238_4760# 0.00569f
C657 a_3224_9320# a_6794_3960# 0.18857f
C658 m1_4970_6412# sel_adex 0.07265f
C659 stb a_2472_11174# 0.00184f
C660 stb hold 0.04831f
C661 a_6794_3960# m1_1926_10610# 0
C662 m1_1926_4740# vbn_leak 0.00486f
C663 vsrc m1_4000_4210# 0.04744f
C664 mreset a_3224_9320# 0.06207f
C665 vw en 0.0147f
C666 vbp_w vbn_ref 0.02153f
C667 m1_4306_8930# vw 0.11145f
C668 a_3764_10978# m1_2578_10926# 0
C669 el a_2000_6434# 0.14966f
C670 m1_5478_11590# hold 0
C671 m1_4000_4210# m1_1350_9910# 0.14245f
C672 mreset m1_3152_6276# 0.01616f
C673 m1_5918_11806# m1_5010_11806# 0
C674 vm m1_5010_11806# 0.16091f
C675 m1_2578_10926# a_2000_6434# 0
C676 vsrc a_3764_10978# 0.00322f
C677 vbp_st m1_5964_12420# 0.29168f
C678 vw vbp_w 0
C679 a_3764_10978# m1_1350_9910# 0.012f
C680 m1_2438_5766# m1_1350_9910# 0
C681 a_3764_10978# a_3648_6534# 0.04296f
C682 vw a_2884_11174# 0.18227f
C683 vw a_5944_8034# 0.3311f
C684 m1_3242_10926# a_5532_8034# 0
C685 stb spk 0.06488f
C686 vsrc a_2000_6434# 0.09391f
C687 m1_5918_11806# vm 0
C688 vbn_leak a_5532_8034# 0.00757f
C689 vdd a_5532_8034# 0.86837f
C690 m1_2438_3470# vreset 0
C691 a_6238_4760# sel_adex 0
C692 m1_1350_9910# a_2000_6434# 0.34202f
C693 a_2000_6434# a_3648_6534# 0
C694 m1_5478_11590# spk 0
C695 a_5308_6338# a_5532_8034# 0.89814f
C696 a_3224_9320# vm 0.20978f
C697 m1_5964_12420# vbp_syn 0.16411f
C698 m1_4046_5170# a_5532_8034# 0
C699 vbp_st abus 0.11457f
C700 sub0 a_6794_3960# 0.18354f
C701 sub1 vw 0.03378f
C702 vsrc sel_adex 0.04511f
C703 vm m1_3152_6276# 0.02125f
C704 m1_4306_8930# a_4652_12054# 0
C705 mreset sub0 0.10197f
C706 m1_1350_9910# sel_adex 0.03338f
C707 sel_adex a_3648_6534# 0.1429f
C708 vbp_st vbn_prb 0.05608f
C709 hold a_5532_8034# 0
C710 a_3224_9320# m1_1926_10610# 0.00423f
C711 a_3224_9320# m1_3152_6276# 0.1623f
C712 vbp_w vreset 0.03158f
C713 m1_2438_3470# m1_4290_5170# 0.02898f
C714 m1_4000_4210# vbn_leak 0.00803f
C715 vbp_syn abus 0.0318f
C716 sub0 m1_5010_11806# 0
C717 vdd m1_5870_3330# 0.05848f
C718 m1_5870_3330# vbn_leak 0.00196f
C719 a_5944_8034# a_4652_12054# 0.11003f
C720 abus m1_2328_11796# 0.03215f
C721 m1_4290_5170# en 0
C722 vbn_prb vbp_syn 2.6174f
C723 m1_3342_6130# a_6794_3960# 0.00172f
C724 m1_3242_10926# a_3764_10978# 0.67983f
C725 m1_2438_5766# vbn_leak 0.0089f
C726 spk a_5532_8034# 0.11328f
C727 a_3764_10978# vbn_leak 0
C728 vdd a_3764_10978# 1.57561f
C729 m1_4046_5170# m1_4000_4210# 0
C730 vbn_prb m1_2328_11796# 0.0454f
C731 mreset m1_3342_6130# 0
C732 m1_3242_10926# a_2000_6434# 0
C733 m1_4046_5170# m1_5870_3330# 0.01373f
C734 vbn_leak a_2000_6434# 0.53493f
C735 vdd a_2000_6434# 1.27527f
C736 vm sub0 0.09597f
C737 a_3764_10978# a_5308_6338# 0.04044f
C738 sub1 a_4652_12054# 0.11579f
C739 m1_2978_10750# vw 0
C740 m1_4306_8930# vbp_st 0.00201f
C741 m1_1926_4740# stb 0.0014f
C742 a_3224_9320# sub0 0.08497f
C743 a_5308_6338# a_2000_6434# 0
C744 m1_5964_12420# m1_2578_10926# -0.01056f
C745 a_3764_10978# a_2472_11174# 0
C746 a_3764_10978# hold 0.00386f
C747 sub0 m1_3152_6276# 0.00582f
C748 m1_3242_10926# sel_adex 0.0189f
C749 vdd sel_adex 0.01227f
C750 sel_adex vbn_leak 0.03728f
C751 m1_2438_3470# vbp_syn 0
C752 a_2472_11174# a_2000_6434# 0.3165f
C753 hold a_2000_6434# 0.42971f
C754 vbp_st vbp_w 0.3059f
C755 m1_2438_3470# m1_2328_11796# 0.0332f
C756 sub1 m1_4290_5170# 0
C757 a_5308_6338# sel_adex 0.00761f
C758 vbp_st a_2884_11174# 0.0154f
C759 el abus 0.03127f
C760 vbp_st a_5944_8034# 0.14544f
C761 m1_4306_8930# vbp_syn 0.62131f
C762 m1_5964_12420# a_3648_6534# 0.01541f
C763 m1_5870_3330# spk 0.00118f
C764 m1_3342_6130# vm 0
C765 sta a_6794_3960# 0
C766 a_6794_3960# a_5682_4760# 0
C767 m1_4046_5170# sel_adex 0.00342f
C768 m1_2328_11796# en 0.0364f
C769 m1_4306_8930# m1_2328_11796# -0.00969f
C770 mreset sta 0.0134f
C771 el vbn_prb 0.06007f
C772 mreset a_5682_4760# 0.35459f
C773 m1_5478_11590# a_5532_8034# 0.22036f
C774 a_3764_10978# spk 0.00391f
C775 a_2472_11174# sel_adex 0
C776 m1_3342_6130# a_3224_9320# 0.08129f
C777 m1_2438_3470# m1_4970_6412# 0.05439f
C778 vbp_w vbp_syn 2.62026f
C779 m1_3342_6130# m1_3152_6276# 0.09722f
C780 vbp_st sub1 0.00269f
C781 vsrc abus 0.22522f
C782 spk a_2000_6434# 0.25944f
C783 m1_2978_10750# a_4652_12054# 0.00136f
C784 vbp_syn a_2884_11174# 0
C785 a_5944_8034# vbp_syn 0.06922f
C786 vbp_w m1_2328_11796# 0.07805f
C787 m1_4970_6412# en 0.04664f
C788 m1_1350_9910# abus 0.59684f
C789 abus a_3648_6534# 0.02815f
C790 a_2884_11174# m1_2328_11796# 0.30928f
C791 vsrc vbn_prb 0.05839f
C792 a_5944_8034# m1_2328_11796# 0.00927f
C793 vbn_prb m1_1350_9910# 0.09f
C794 mreset vbn_ref 0.13805f
C795 spk sel_adex 0.05713f
C796 stb m1_4000_4210# 0
C797 sub1 vbp_syn 0.03373f
C798 m1_2438_3470# el 0.01744f
C799 stb m1_5870_3330# 0.00671f
C800 vm a_5682_4760# 0.03225f
C801 vm sta 0.51194f
C802 vw a_6794_3960# 0.53862f
C803 sub1 m1_2328_11796# 0.05641f
C804 m1_4970_6412# a_2884_11174# 0.01999f
C805 mreset vw 0.00167f
C806 el en 0.1671f
C807 stb a_3764_10978# 0
C808 stb m1_2438_5766# 0.02973f
C809 m1_3242_10926# m1_5964_12420# 0.05669f
C810 a_3224_9320# sta 0
C811 vdd m1_5964_12420# 1.49702f
C812 m1_5964_12420# vbn_leak 0.16725f
C813 a_3224_9320# a_5682_4760# 0.0103f
C814 a_6238_4760# en 0.03565f
C815 m1_3342_6130# sub0 0.1927f
C816 a_3764_10978# m1_5478_11590# 0.15709f
C817 m1_2438_3470# vsrc 0.17501f
C818 sta m1_1926_10610# 0.06406f
C819 stb a_2000_6434# 0.17168f
C820 sub1 m1_4970_6412# 0.0195f
C821 m1_5964_12420# a_5308_6338# 0.01834f
C822 m1_2438_3470# m1_1350_9910# 0.20745f
C823 vbp_st m1_2978_10750# 0.03851f
C824 el vbp_w 0.03028f
C825 vsrc en 0.23131f
C826 vm vbn_ref 0.03686f
C827 vw m1_5010_11806# 0
C828 vbp_w m1_2578_10926# -0.00929f
C829 m1_4306_8930# vss -0.19646f
C830 vdd vss 55.54329f
C831 a_2000_6434# vss 2.31432f
C832 mreset vss 1.53996f
C833 m1_1926_10610# vss -0.08787f
C834 vbp_st vss 1.27997f
C835 a_2472_11174# vss 0.16774f
C836 m1_3242_10926# vss 0.19885f
C837 m1_3342_6130# vss 0.15942f
C838 a_3648_6534# vss 0.85965f
C839 sub1 vss 1.19588f
C840 a_5944_8034# vss 0.26114f
C841 a_5532_8034# vss 0.23843f
C842 a_5308_6338# vss 0.26751f
C843 vsrc vss 2.50138f
C844 m1_4970_6412# vss 1.14833f
C845 spk vss 5.06118f
C846 en vss 1.04478f
C847 hold vss 0.11676f
C848 vm vss 5.89883f
C849 a_3764_10978# vss 0.03652f
C850 m1_5964_12420# vss 0.00427f
C851 vbp_w vss 0.6918f
C852 m1_5918_11806# vss 0.01631f
C853 m1_2328_11796# vss 1.24842f
C854 stb vss 0.6486f
C855 m1_2438_3470# vss 0.5616f
C856 vbn_prb vss 0.94987f
C857 m1_4000_4210# vss -0.00556f
C858 vbn_leak vss 4.40369f
C859 m1_5010_11806# vss -0.09073f
C860 m1_5478_11590# vss -0.07928f
C861 m1_1350_9910# vss 2.18573f
C862 sta vss 1.20425f
C863 a_6238_4760# vss -0.1295f
C864 m1_4046_5170# vss 0.73168f
C865 m1_1926_4740# vss 0.21493f
C866 m1_2438_5766# vss -0.02563f
C867 m1_2578_10926# vss -0.08804f
C868 m1_2978_10750# vss -0.07176f
C869 m1_4290_5170# vss 0.1394f
C870 a_2884_11174# vss 1.29056f
C871 sub0 vss 1.45675f
C872 vw vss 1.4887f
C873 abus vss 1.47997f
C874 vbn_ref vss 0.70784f
C875 vreset vss 0.68601f
C876 m1_3152_6276# vss 0.10835f
C877 sel_adex vss 0.32428f
C878 a_6794_3960# vss 1.58672f
C879 a_4652_12054# vss 0.02482f
C880 vbp_syn vss 0.39885f
C881 a_5682_4760# vss -0.15105f
C882 a_3224_9320# vss 0.6604f
C883 el vss -0.1027f
C884 m1_5870_3330# vss -0.16763f
.ends
