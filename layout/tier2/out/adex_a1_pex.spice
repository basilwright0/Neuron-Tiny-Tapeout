* NGSPICE file created from adex_a1.ext - technology: gf180mcuD

.subckt p_w2_l4 a_400_n200# a_n400_n244# w_n574_n330# a_n488_n200# VSUBS
X0 a_400_n200# a_n400_n244# a_n488_n200# w_n574_n330# pfet_03v3 ad=0.88p pd=4.88u as=0.88p ps=4.88u w=2u l=4u
C0 a_n488_n200# a_n400_n244# 0.07019f
C1 w_n574_n330# a_n488_n200# 0.07409f
C2 a_n488_n200# a_400_n200# 0.01073f
C3 w_n574_n330# a_n400_n244# 0.42229f
C4 a_n400_n244# a_400_n200# 0.07019f
C5 w_n574_n330# a_400_n200# 0.07409f
C6 a_400_n200# VSUBS 0.18936f
C7 a_n488_n200# VSUBS 0.18936f
C8 w_n574_n330# VSUBS 2.27304f
.ends

.subckt n_w2_l4 a_400_n200# a_n400_n244# a_n488_n200# VSUBS
X0 a_400_n200# a_n400_n244# a_n488_n200# VSUBS nfet_03v3 ad=0.88p pd=4.88u as=0.88p ps=4.88u w=2u l=4u
C0 a_400_n200# a_n488_n200# 0.01073f
C1 a_n400_n244# a_400_n200# 0.07019f
C2 a_n400_n244# a_n488_n200# 0.07019f
C3 a_400_n200# VSUBS 0.41684f
C4 a_n488_n200# VSUBS 0.41684f
.ends

.subckt n_w2_l2 a_n288_n200# a_200_n200# a_n200_n244# VSUBS
X0 a_200_n200# a_n200_n244# a_n288_n200# VSUBS nfet_03v3 ad=0.88p pd=4.88u as=0.88p ps=4.88u w=2u l=2u
C0 a_200_n200# a_n288_n200# 0.02133f
C1 a_n200_n244# a_200_n200# 0.0587f
C2 a_n200_n244# a_n288_n200# 0.0587f
C3 a_200_n200# VSUBS 0.2667f
C4 a_n288_n200# VSUBS 0.2667f
.ends

.subckt n_w0p5_l0p28 a_n28_n94# a_n116_n50# a_28_n50# VSUBS
X0 a_28_n50# a_n28_n94# a_n116_n50# VSUBS nfet_03v3 ad=0.22p pd=1.88u as=0.22p ps=1.88u w=0.5u l=0.28u
C0 a_28_n50# a_n116_n50# 0.02085f
C1 a_n28_n94# a_28_n50# 0.00377f
C2 a_n28_n94# a_n116_n50# 0.00377f
C3 a_28_n50# VSUBS 0.07987f
C4 a_n116_n50# VSUBS 0.07987f
.ends

.subckt n_w1_l0p28 a_28_n100# a_n28_n144# a_n116_n100# VSUBS
X0 a_28_n100# a_n28_n144# a_n116_n100# VSUBS nfet_03v3 ad=0.44p pd=2.88u as=0.44p ps=2.88u w=1u l=0.28u
C0 a_28_n100# a_n116_n100# 0.04256f
C1 a_n28_n144# a_28_n100# 0.00769f
C2 a_n28_n144# a_n116_n100# 0.00769f
C3 a_28_n100# VSUBS 0.09911f
C4 a_n116_n100# VSUBS 0.09911f
.ends

.subckt p_w1_l0p5 a_n138_n100# a_50_n100# a_n50_n144# w_n224_n230# VSUBS
X0 a_50_n100# a_n50_n144# a_n138_n100# w_n224_n230# pfet_03v3 ad=0.44p pd=2.88u as=0.44p ps=2.88u w=1u l=0.5u
C0 a_n138_n100# a_n50_n144# 0.01275f
C1 w_n224_n230# a_n138_n100# 0.0205f
C2 a_n138_n100# a_50_n100# 0.03085f
C3 w_n224_n230# a_n50_n144# 0.07993f
C4 a_n50_n144# a_50_n100# 0.01275f
C5 w_n224_n230# a_50_n100# 0.0205f
C6 a_50_n100# VSUBS 0.06546f
C7 a_n138_n100# VSUBS 0.06546f
C8 w_n224_n230# VSUBS 0.61824f
.ends

.subckt n_w0p5_l0p5 a_n138_n50# a_50_n50# a_n50_n94# VSUBS
X0 a_50_n50# a_n50_n94# a_n138_n50# VSUBS nfet_03v3 ad=0.22p pd=1.88u as=0.22p ps=1.88u w=0.5u l=0.5u
C0 a_50_n50# a_n138_n50# 0.01511f
C1 a_n50_n94# a_50_n50# 0.00625f
C2 a_n50_n94# a_n138_n50# 0.00625f
C3 a_50_n50# VSUBS 0.09639f
C4 a_n138_n50# VSUBS 0.09639f
.ends

.subckt p_w1_l0p28 w_n202_n230# a_28_n100# a_n28_n144# a_n116_n100# VSUBS
X0 a_28_n100# a_n28_n144# a_n116_n100# w_n202_n230# pfet_03v3 ad=0.44p pd=2.88u as=0.44p ps=2.88u w=1u l=0.28u
C0 a_n116_n100# a_n28_n144# 0.00769f
C1 w_n202_n230# a_n116_n100# 0.01808f
C2 a_n116_n100# a_28_n100# 0.04256f
C3 w_n202_n230# a_n28_n144# 0.05841f
C4 a_n28_n144# a_28_n100# 0.00769f
C5 w_n202_n230# a_28_n100# 0.01808f
C6 a_28_n100# VSUBS 0.0597f
C7 a_n116_n100# VSUBS 0.0597f
C8 w_n202_n230# VSUBS 0.55752f
.ends

.subckt n_w1_l0p5 a_n138_n100# a_50_n100# a_n50_n144# VSUBS
X0 a_50_n100# a_n50_n144# a_n138_n100# VSUBS nfet_03v3 ad=0.44p pd=2.88u as=0.44p ps=2.88u w=1u l=0.5u
C0 a_50_n100# a_n138_n100# 0.03085f
C1 a_n50_n144# a_50_n100# 0.01275f
C2 a_n50_n144# a_n138_n100# 0.01275f
C3 a_50_n100# VSUBS 0.11563f
C4 a_n138_n100# VSUBS 0.11563f
.ends

.subckt p_w1_l2 w_n374_n230# a_n288_n100# a_200_n100# a_n200_n144# VSUBS
X0 a_200_n100# a_n200_n144# a_n288_n100# w_n374_n230# pfet_03v3 ad=0.44p pd=2.88u as=0.44p ps=2.88u w=1u l=2u
C0 a_n288_n100# a_n200_n144# 0.02905f
C1 w_n374_n230# a_n288_n100# 0.03135f
C2 a_n288_n100# a_200_n100# 0.01056f
C3 w_n374_n230# a_n200_n144# 0.22666f
C4 a_n200_n144# a_200_n100# 0.02905f
C5 w_n374_n230# a_200_n100# 0.03135f
C6 a_200_n100# VSUBS 0.1047f
C7 a_n288_n100# VSUBS 0.1047f
C8 w_n374_n230# VSUBS 1.03224f
.ends

.subckt n_w0p22_l15 a_1500_n22# a_n1500_n66# a_n1592_n36# VSUBS
X0 a_1500_n22# a_n1500_n66# a_n1592_n36# VSUBS nfet_03v3 ad=0.1516p pd=1.64u as=0.1516p ps=1.64u w=0.22u l=15u
C0 a_1500_n22# a_n1500_n66# 0.00918f
C1 a_n1592_n36# a_n1500_n66# 0.00918f
C2 a_1500_n22# VSUBS 1.18476f
C3 a_n1592_n36# VSUBS 1.18476f
.ends

.subckt n_w0p22_l2 a_200_n22# a_n200_n66# a_n292_n36# VSUBS
X0 a_200_n22# a_n200_n66# a_n292_n36# VSUBS nfet_03v3 ad=0.1516p pd=1.64u as=0.1516p ps=1.64u w=0.22u l=2u
C0 a_200_n22# a_n200_n66# 0.00705f
C1 a_n292_n36# a_200_n22# 0.00245f
C2 a_n292_n36# a_n200_n66# 0.00705f
C3 a_200_n22# VSUBS 0.20767f
C4 a_n292_n36# VSUBS 0.20767f
.ends

.subckt n_w0p22_l8 a_800_n22# a_n800_n66# a_n892_n36# VSUBS
X0 a_800_n22# a_n800_n66# a_n892_n36# VSUBS nfet_03v3 ad=0.1516p pd=1.64u as=0.1516p ps=1.64u w=0.22u l=8u
C0 a_800_n22# a_n800_n66# 0.00918f
C1 a_n892_n36# a_n800_n66# 0.00918f
C2 a_800_n22# VSUBS 0.65928f
C3 a_n892_n36# VSUBS 0.65928f
.ends

.subckt p_w2_l0p5 a_50_n200# a_n50_n244# w_n224_n330# a_n138_n200# VSUBS
X0 a_50_n200# a_n50_n244# a_n138_n200# w_n224_n330# pfet_03v3 ad=0.88p pd=4.88u as=0.88p ps=4.88u w=2u l=0.5u
C0 a_n138_n200# a_n50_n244# 0.02577f
C1 w_n224_n330# a_n138_n200# 0.03848f
C2 a_n138_n200# a_50_n200# 0.06232f
C3 w_n224_n330# a_n50_n244# 0.07993f
C4 a_n50_n244# a_50_n200# 0.02577f
C5 w_n224_n330# a_50_n200# 0.03848f
C6 a_50_n200# VSUBS 0.0978f
C7 a_n138_n200# VSUBS 0.0978f
C8 w_n224_n330# VSUBS 0.88704f
.ends

.subckt n_w7p07_l7p07 a_707_n707# a_n795_n707# a_n707_n751# VSUBS
X0 a_707_n707# a_n707_n751# a_n795_n707# VSUBS nfet_03v3 ad=3.1108p pd=15.02u as=3.1108p ps=15.02u w=7.07u l=7.07u
C0 a_707_n707# a_n795_n707# 0.0212f
C1 a_n707_n751# a_707_n707# 0.27012f
C2 a_n707_n751# a_n795_n707# 0.27012f
C3 a_707_n707# VSUBS 0.84237f
C4 a_n795_n707# VSUBS 0.84237f
.ends

.subckt p_w0p22_l8 a_800_n22# a_n800_n66# w_n978_n159# a_n892_n36# VSUBS
X0 a_800_n22# a_n800_n66# a_n892_n36# w_n978_n159# pfet_03v3 ad=0.1516p pd=1.64u as=0.1516p ps=1.64u w=0.22u l=8u
C0 a_n800_n66# a_n892_n36# 0.00918f
C1 w_n978_n159# a_n800_n66# 0.83403f
C2 a_n800_n66# a_800_n22# 0.00918f
C3 w_n978_n159# a_n892_n36# 0.0077f
C4 w_n978_n159# a_800_n22# 0.0077f
C5 a_800_n22# VSUBS 0.23501f
C6 a_n892_n36# VSUBS 0.23501f
C7 w_n978_n159# VSUBS 1.86602f
.ends

.subckt n_w4_l2 a_n288_n400# a_200_n400# a_n200_n444# VSUBS
X0 a_200_n400# a_n200_n444# a_n288_n400# VSUBS nfet_03v3 ad=1.76p pd=8.88u as=1.76p ps=8.88u w=4u l=2u
C0 a_200_n400# a_n288_n400# 0.04287f
C1 a_n200_n444# a_200_n400# 0.11799f
C2 a_n200_n444# a_n288_n400# 0.11799f
C3 a_200_n400# VSUBS 0.34365f
C4 a_n288_n400# VSUBS 0.34365f
.ends

.subckt n_w3p54_l3p54 a_354_n354# a_n354_n398# a_n442_n354# VSUBS
X0 a_354_n354# a_n354_n398# a_n442_n354# VSUBS nfet_03v3 ad=1.5576p pd=7.96u as=1.5576p ps=7.96u w=3.54u l=3.54u
C0 a_354_n354# a_n442_n354# 0.02161f
C1 a_n354_n398# a_354_n354# 0.12189f
C2 a_n354_n398# a_n442_n354# 0.12189f
C3 a_354_n354# VSUBS 0.44156f
C4 a_n442_n354# VSUBS 0.44156f
.ends

.subckt p_w7p07_l7p07 w_n881_n837# a_707_n707# a_n795_n707# a_n707_n751# VSUBS
X0 a_707_n707# a_n707_n751# a_n795_n707# w_n881_n837# pfet_03v3 ad=3.1108p pd=15.02u as=3.1108p ps=15.02u w=7.07u l=7.07u
C0 a_n795_n707# a_n707_n751# 0.27012f
C1 w_n881_n837# a_n795_n707# 0.28802f
C2 a_n795_n707# a_707_n707# 0.0212f
C3 w_n881_n837# a_n707_n751# 0.72259f
C4 a_n707_n751# a_707_n707# 0.27012f
C5 w_n881_n837# a_707_n707# 0.28802f
C6 a_707_n707# VSUBS 0.43364f
C7 a_n795_n707# VSUBS 0.43364f
C8 w_n881_n837# VSUBS 8.84876f
.ends

.subckt p_w0p5_l1 a_100_n50# a_n100_n94# a_n188_n50# w_n274_n180# VSUBS
X0 a_100_n50# a_n100_n94# a_n188_n50# w_n274_n180# pfet_03v3 ad=0.22p pd=1.88u as=0.22p ps=1.88u w=0.5u l=1u
C0 a_n188_n50# a_n100_n94# 0.01026f
C1 w_n274_n180# a_n188_n50# 0.0135f
C2 a_n188_n50# a_100_n50# 0.00935f
C3 w_n274_n180# a_n100_n94# 0.12884f
C4 a_n100_n94# a_100_n50# 0.01026f
C5 w_n274_n180# a_100_n50# 0.0135f
C6 a_100_n50# VSUBS 0.06237f
C7 a_n188_n50# VSUBS 0.06237f
C8 w_n274_n180# VSUBS 0.59184f
.ends

.subckt p_w4_l0p5 a_n138_n400# a_50_n400# a_n50_n444# w_n224_n530# VSUBS
X0 a_50_n400# a_n50_n444# a_n138_n400# w_n224_n530# pfet_03v3 ad=1.76p pd=8.88u as=1.76p ps=8.88u w=4u l=0.5u
C0 a_n138_n400# a_n50_n444# 0.05179f
C1 w_n224_n530# a_n138_n400# 0.07442f
C2 a_n138_n400# a_50_n400# 0.12527f
C3 w_n224_n530# a_n50_n444# 0.07993f
C4 a_n50_n444# a_50_n400# 0.05179f
C5 w_n224_n530# a_50_n400# 0.07442f
C6 a_50_n400# VSUBS 0.16249f
C7 a_n138_n400# VSUBS 0.16249f
C8 w_n224_n530# VSUBS 1.42464f
.ends

.subckt adex_a1 vdd vss el vbn_leak vsrc vbp_st vbn_ref vreset vbn_prb vbp_syn vbp_w
+ abus mreset spk en sta stb hold sel_adex sub0 sub1 vm vw
XXL_XP1 m1_186_2812# m1_186_2812# vdd vdd vss p_w2_l4
XXL_XP2 a_2536_3080# m1_186_2812# vdd vdd vss p_w2_l4
XXL_XMT m1_1704_2490# vbn_leak vss vss n_w2_l4
XXL_XM1 m1_186_2812# a_1024_3080# el vss n_w2_l2
XXS_XWA m1_3872_1730# vbp_syn vdd m1_4242_4630# vss p_w2_l4
XXL_XM2 a_1780_3080# a_2536_3080# a_2536_3080# vss n_w2_l2
XXR_Xi_XN spk vss a_8356_5974# vss n_w0p5_l0p28
XXP_XSA m1_3262_1784# sel_adex m1_4932_8400# vss n_w1_l0p28
XXD_XPI m1_6086_5726# a_7000_3738# vm vdd vss p_w1_l0p5
XXS_XWB m1_4392_1730# vbp_syn vdd m1_4242_4630# vss p_w2_l4
XXR_XSW vreset vm a_480_5974# vss n_w0p5_l0p5
XXR_XNR a_480_5974# vbn_ref vss vss n_w2_l4
XXR_Xi_XP vdd a_8356_5974# spk vdd vss p_w1_l0p28
XXD_XNI vsrc a_7000_3738# vm vss n_w1_l0p5
XXP_XSC m1_4932_8400# a_5492_8534# abus vss n_w1_l0p28
XXP_XPB vdd m1_6290_9150# m1_7186_9150# vbp_st vss p_w1_l2
XXS_XQA vdd vss sta m1_3872_1730# vss p_w1_l0p28
XXA_XT1 vw vbn_leak m1_186_3686# vss n_w0p22_l15
XXP_Xi0_XN sub0 vss a_3332_1974# vss n_w0p5_l0p28
XXS_XQB vdd vss stb m1_4392_1730# vss p_w1_l0p28
XXA_XT2 m1_186_3686# vbn_leak m1_3408_5970# vss n_w0p22_l15
XXP_XPE vdd m1_6290_9150# a_3332_1974# vdd vss p_w1_l0p28
XXA_XR1 vw mreset m1_2516_8340# vss n_w0p22_l2
XXA_XT3 m1_3408_5970# vbn_leak vss vss n_w0p22_l15
XXA_XPS vdd m1_988_5716# a_912_5974# vdd vss p_w1_l0p28
XXA_XW a_2536_3080# vw vss vss n_w0p22_l8
XXL_XD1 a_1024_3080# m1_1704_2490# a_1024_3080# vss n_w2_l2
XXP_XPF vss vw vdd m1_7186_9150# vss p_w2_l0p5
XXP_Xi0_XP vdd a_3332_1974# sub0 vdd vss p_w1_l0p28
XXA_XR2 m1_2516_8340# mreset vss vss n_w0p22_l2
XXL_XD2 m1_1704_2490# a_1780_3080# a_1780_3080# vss n_w2_l2
XXS_XNA sta vm m1_3872_1730# vss n_w0p5_l0p28
XXD_XS2 vdd vdd m1_6552_5730# vbp_st vss p_w1_l2
XXD_XPS vdd vdd m1_6086_5726# vbp_st vss p_w1_l2
XXP_XT0_XMB vss m1_2772_1784# vbn_prb vss n_w2_l2
XXS_XNB stb vm m1_4392_1730# vss n_w0p5_l0p28
XXA_XPW vdd m1_988_5716# m1_1656_4620# vbp_w vss p_w1_l2
XXE_XE1 a_2884_5778# vm vsrc vss n_w0p22_l8
XXC_XC vss vss vm vss n_w7p07_l7p07
XXD_XP2 vdd a_7060_5974# a_7000_3738# m1_6552_5730# vss p_w1_l0p28
XXE_XE2 a_2884_5778# a_2884_5778# vdd vdd vss p_w2_l0p5
XXS_XPH vdd vdd m1_4242_4630# hold vss p_w1_l2
XXP_XT0_XME m1_2916_1640# en m1_2772_1784# vss n_w1_l0p28
XXD_XP3 vdd a_7148_1874# a_7060_5974# vdd vss p_w1_l0p28
XXE_XE3 a_2536_3080# a_2884_5778# vdd vdd vss p_w0p22_l8
XXD_Xi4_XN a_7148_1874# vss spk vss n_w0p5_l0p28
XXP_XT0_XMF m1_2916_1640# vdd vm vss n_w4_l2
XXD_XN2 a_7060_5974# a_7000_3738# vsrc vss n_w0p22_l2
XXR_XCR_XC vss a_480_5974# vss vss n_w3p54_l3p54
XXD_Xi4_XP vdd spk a_7148_1874# vdd vss p_w1_l0p28
XXD_XN3 a_7060_5974# vsrc a_7148_1874# vss n_w0p5_l0p28
XXP_Xi1_XN sub1 vss a_5492_8534# vss n_w0p5_l0p28
XXR_XPC vdd a_480_5974# a_8356_5974# vdd vss p_w1_l0p28
XXP_Xi1_XP vdd a_5492_8534# sub1 vdd vss p_w1_l0p28
XXP_XS1 m1_7186_9150# sub0 m1_3262_1784# vss n_w1_l0p28
XXA_Xi_XN a_480_5974# vss a_912_5974# vss n_w0p5_l0p28
XXA_Xi_XP vdd a_912_5974# a_480_5974# m1_406_5430# vss p_w1_l0p28
XXA_XCW vdd vdd vdd vw vss p_w7p07_l7p07
XXS_XHL vdd vm hold a_2536_3080# vss p_w1_l0p28
XXA_XPA vw vw m1_1656_4620# vdd vss p_w0p5_l1
XXP_XT0_XSW m1_2916_1640# a_3332_1974# m1_3262_1784# vss n_w1_l0p28
XXA_XPB m1_1656_4620# vss vbn_leak vdd vss p_w4_l0p5
XXA_Xi_XS vdd vdd m1_406_5430# vbp_st vss p_w1_l2
XXS_XMR mreset a_480_5974# vdd vss n_w0p5_l0p28
C0 m1_6086_5726# spk 0.00231f
C1 a_3332_1974# mreset 0.0662f
C2 vw sta 0.05989f
C3 m1_3408_5970# sta 0.01802f
C4 vbp_syn m1_4242_4630# 0.39413f
C5 a_7000_3738# vbp_w 0
C6 mreset m1_1704_2490# 0.00378f
C7 vbn_leak m1_4242_4630# 0.0169f
C8 vbp_w a_8356_5974# 0.02085f
C9 vm m1_4242_4630# 0.05363f
C10 mreset a_7060_5974# 0
C11 sub0 el 0
C12 sub1 vbp_st 0.14779f
C13 a_7148_1874# a_7000_3738# 0.082f
C14 a_480_5974# vbp_st 0.23166f
C15 stb vw 0.03281f
C16 m1_3872_1730# sta 0.29875f
C17 stb m1_3408_5970# 0.01955f
C18 m1_186_3686# a_480_5974# 0.05753f
C19 a_7148_1874# a_8356_5974# 0.13564f
C20 a_1780_3080# a_912_5974# 0.03864f
C21 vbp_st m1_6290_9150# 0
C22 m1_4932_8400# a_5492_8534# 0.04966f
C23 hold sel_adex 0.02197f
C24 m1_3872_1730# stb 0.17756f
C25 vbn_ref sta 0
C26 m1_6086_5726# vbp_syn 0.07968f
C27 m1_4392_1730# a_480_5974# 0.02986f
C28 en a_1780_3080# 0.01188f
C29 m1_186_2812# a_2536_3080# 0.33679f
C30 el a_912_5974# 0.04479f
C31 abus el 0.13313f
C32 vbn_leak m1_6086_5726# 0.00266f
C33 m1_4932_8400# mreset 0.00256f
C34 m1_6086_5726# vm 0.07485f
C35 vbp_syn sta 0.07176f
C36 m1_4242_4630# vbp_st 0.00278f
C37 vbn_ref stb 0
C38 a_2536_3080# vw 0.27762f
C39 a_2536_3080# m1_3408_5970# 0.03427f
C40 m1_186_3686# m1_4242_4630# 0
C41 a_2884_5778# mreset 0.27228f
C42 mreset vbp_w 0.17518f
C43 en el 0.03201f
C44 vbn_leak sta 0.07444f
C45 vm sta 0.06249f
C46 a_2536_3080# spk 0.09329f
C47 sub1 vreset 0.00135f
C48 vbn_prb sta 0
C49 sub1 m1_3262_1784# 0
C50 a_480_5974# vreset 0.31265f
C51 vbp_syn stb 0.10063f
C52 a_480_5974# m1_3262_1784# 0.00153f
C53 a_3332_1974# sub1 0.23745f
C54 m1_406_5430# a_912_5974# 0.13088f
C55 m1_3872_1730# a_2536_3080# 0.06331f
C56 a_3332_1974# a_480_5974# 0
C57 a_7148_1874# mreset 0
C58 m1_4392_1730# m1_4242_4630# 0.27477f
C59 m1_6552_5730# spk 0.1889f
C60 vbn_leak stb 0.05159f
C61 hold m1_3408_5970# 0.00379f
C62 hold vw 0.05414f
C63 vm stb 0.10723f
C64 m1_2916_1640# m1_2772_1784# 0.23589f
C65 vbn_prb stb 0.00227f
C66 a_480_5974# m1_1704_2490# 0.09735f
C67 a_3332_1974# m1_6290_9150# 0.15869f
C68 hold spk 0.00125f
C69 a_480_5974# a_7060_5974# 0.06381f
C70 el sel_adex 0
C71 m1_988_5716# el 0
C72 m1_6086_5726# vbp_st 0.09845f
C73 mreset m1_2516_8340# 0.24162f
C74 vsrc abus 0.03072f
C75 hold m1_3872_1730# 0
C76 m1_186_2812# a_1780_3080# 0.16878f
C77 vbp_st sta 0.06137f
C78 vreset m1_4242_4630# 0
C79 vbp_syn a_2536_3080# 0.22853f
C80 m1_3262_1784# m1_4242_4630# 0.01251f
C81 vbn_ref m1_6552_5730# 0
C82 m1_2916_1640# mreset 0
C83 m1_186_3686# sta 0.01752f
C84 vsrc en 0.00116f
C85 a_3332_1974# m1_4242_4630# 0
C86 abus sub0 0.06216f
C87 vbn_leak a_2536_3080# 0.29722f
C88 vm a_2536_3080# 0.1105f
C89 m1_4392_1730# m1_6086_5726# 0.00412f
C90 m1_7186_9150# vdd 0.76081f
C91 vbn_prb a_2536_3080# 0
C92 m1_988_5716# m1_406_5430# 0.12077f
C93 m1_186_2812# el 0.52168f
C94 vbp_syn m1_6552_5730# 0.01006f
C95 stb vbp_st 0.07139f
C96 a_7060_5974# m1_4242_4630# 0
C97 m1_186_3686# stb 0.01759f
C98 hold vbp_syn 0.36086f
C99 m1_4392_1730# sta 0.12821f
C100 vbn_leak m1_6552_5730# 0
C101 sub1 vbp_w 0
C102 el m1_3408_5970# 0.12865f
C103 el vw 0.37985f
C104 vbn_prb m1_6552_5730# 0
C105 a_2884_5778# a_480_5974# 0.02196f
C106 a_480_5974# vbp_w 0.01884f
C107 hold vbn_leak 0.01245f
C108 hold vm 0.17057f
C109 el spk 0.07458f
C110 m1_6086_5726# vreset 0.00149f
C111 m1_186_2812# m1_406_5430# 0
C112 m1_4392_1730# stb 0.67712f
C113 m1_1656_4620# vdd 0.43172f
C114 a_7148_1874# a_480_5974# 0.04931f
C115 sub0 sel_adex 0.52107f
C116 m1_3262_1784# sta 0.13718f
C117 en a_912_5974# 0
C118 m1_406_5430# vw 0
C119 a_2536_3080# vbp_st 0.09065f
C120 a_3332_1974# sta 0.05783f
C121 m1_186_3686# a_2536_3080# 0.05724f
C122 m1_6086_5726# a_7060_5974# 0.03048f
C123 a_7000_3738# vdd 0.50198f
C124 vbn_ref el 0.04164f
C125 a_2884_5778# m1_4242_4630# 0.06621f
C126 m1_1704_2490# sta 0.01803f
C127 vreset stb 0.00245f
C128 vbn_leak a_1780_3080# 0.08915f
C129 vdd a_8356_5974# 0.47756f
C130 m1_6552_5730# vbp_st 0.24748f
C131 m1_3262_1784# stb 0.0245f
C132 a_3332_1974# stb 0.03088f
C133 vsrc vw 0.08808f
C134 hold vbp_st 0.05295f
C135 vbp_syn el 0.15356f
C136 m1_4392_1730# a_2536_3080# 0.00811f
C137 m1_2916_1640# a_480_5974# 0.07451f
C138 hold m1_186_3686# 0
C139 a_7148_1874# m1_4242_4630# 0.01706f
C140 vsrc spk 0.09451f
C141 abus sel_adex 0.22669f
C142 m1_1704_2490# stb 0
C143 m1_988_5716# a_912_5974# 0.15797f
C144 vbn_leak el 2.29495f
C145 vm el 0.05948f
C146 vbn_prb el 0.04369f
C147 m1_2772_1784# vdd 0.1063f
C148 sub0 vw 0.0758f
C149 vsrc m1_3872_1730# 0.18401f
C150 hold m1_4392_1730# 0.04421f
C151 a_5492_8534# vdd 0.45474f
C152 vreset a_2536_3080# 0.0819f
C153 m1_3262_1784# a_2536_3080# 0.25395f
C154 m1_4932_8400# sta 0.00713f
C155 a_3332_1974# a_2536_3080# 0.05538f
C156 m1_7186_9150# a_5492_8534# 0.03856f
C157 vsrc vbn_ref 0.25103f
C158 vbn_leak m1_406_5430# 0.00118f
C159 m1_186_2812# a_912_5974# 0.06102f
C160 a_2884_5778# sta 0.09285f
C161 m1_186_3686# a_1780_3080# 0.00287f
C162 vbp_w sta 0.02159f
C163 mreset vdd 0.54064f
C164 vreset m1_6552_5730# 0
C165 m1_1704_2490# a_2536_3080# 0.0722f
C166 a_7148_1874# m1_6086_5726# 0.02748f
C167 a_7060_5974# a_2536_3080# 0.46309f
C168 a_7000_3738# a_8356_5974# 0.09358f
C169 m1_4932_8400# stb 0.05319f
C170 vsrc vbp_syn 0.02717f
C171 vw a_912_5974# 0.01007f
C172 hold vreset 0
C173 abus m1_3408_5970# 0.03685f
C174 abus vw 0.13408f
C175 m1_186_2812# en 0.07877f
C176 hold m1_3262_1784# 0.00461f
C177 a_1024_3080# a_480_5974# 0.20805f
C178 el vbp_st 0.26854f
C179 a_3332_1974# hold 0.03559f
C180 abus spk 0.09009f
C181 a_2884_5778# stb 0.12923f
C182 stb vbp_w 0.02283f
C183 m1_186_3686# el 0.15986f
C184 vsrc vbn_leak 2.03868f
C185 vsrc vm 0.54255f
C186 vsrc vbn_prb 0.05224f
C187 a_7060_5974# m1_6552_5730# 0.07731f
C188 en m1_3408_5970# 0.05289f
C189 en vw 0.45967f
C190 hold a_7060_5974# 0.01136f
C191 m1_2516_8340# sta 0.00356f
C192 vbn_leak sub0 0
C193 m1_4392_1730# el 0
C194 m1_406_5430# vbp_st 0.06836f
C195 m1_3872_1730# en 0.00235f
C196 m1_988_5716# m1_186_2812# 0
C197 abus vbn_ref 0.03135f
C198 m1_2916_1640# sta 0.00428f
C199 a_3332_1974# a_1780_3080# 0
C200 sel_adex m1_3408_5970# 0.15246f
C201 sel_adex vw 0.08602f
C202 a_2884_5778# a_2536_3080# 0.18869f
C203 a_2536_3080# vbp_w 0.03081f
C204 m1_988_5716# vw 0.00827f
C205 mreset a_7000_3738# 0
C206 abus vbp_syn 0.03226f
C207 vsrc vbp_st 1.85897f
C208 m1_1704_2490# a_1780_3080# 0.1253f
C209 vreset el 0.03463f
C210 mreset a_8356_5974# 0
C211 el m1_3262_1784# 0.02533f
C212 m1_2916_1640# stb 0
C213 vsrc m1_186_3686# 0.07165f
C214 hold m1_4932_8400# 0.00201f
C215 vbn_leak a_912_5974# 0.14705f
C216 vm a_912_5974# 0.09095f
C217 a_7148_1874# a_2536_3080# 0.08729f
C218 vbn_leak abus 0.04845f
C219 a_3332_1974# el 0.04023f
C220 vbn_prb abus 0.03167f
C221 vbp_syn en 0.00546f
C222 sub1 vdd 0.76604f
C223 a_2884_5778# hold 0
C224 a_480_5974# vdd 1.406f
C225 hold vbp_w 0.04941f
C226 sub0 vbp_st 0.01597f
C227 m1_7186_9150# sub1 0.06286f
C228 m1_1704_2490# el 0.0148f
C229 vbn_leak en 0.19607f
C230 en vm 0.00826f
C231 m1_186_2812# vw 0.11378f
C232 a_7060_5974# el 0
C233 m1_186_2812# m1_3408_5970# 0.06483f
C234 a_7148_1874# m1_6552_5730# 0.04932f
C235 vsrc m1_4392_1730# 0.24656f
C236 vdd m1_6290_9150# 0.05219f
C237 a_7148_1874# hold 0.00652f
C238 vw m1_3408_5970# 0.66015f
C239 m1_7186_9150# m1_6290_9150# 0.07498f
C240 mreset a_5492_8534# 0.00445f
C241 m1_2916_1640# a_2536_3080# 0.0025f
C242 vw spk 0.00271f
C243 vbn_leak sel_adex 0.08026f
C244 vbp_st a_912_5974# 0.02018f
C245 m1_3872_1730# vw 0.14401f
C246 vsrc vreset 0.47637f
C247 vdd m1_4242_4630# 1.00373f
C248 abus vbp_st 0.1089f
C249 vsrc m1_3262_1784# 0.00126f
C250 m1_988_5716# vbn_leak 0
C251 m1_186_3686# a_912_5974# 0.04525f
C252 m1_1656_4620# a_480_5974# 0.00192f
C253 a_3332_1974# vsrc 0
C254 en vbp_st 0.02002f
C255 m1_186_3686# en 0.02168f
C256 a_2884_5778# el 0.18953f
C257 vbn_ref vw 0.00163f
C258 el vbp_w 0.69809f
C259 sub0 m1_3262_1784# 0.00321f
C260 a_480_5974# a_7000_3738# 0.13913f
C261 vsrc a_7060_5974# 0.06119f
C262 m1_186_2812# vbp_syn 0.00346f
C263 a_3332_1974# sub0 0.25405f
C264 vbn_ref spk 0.35068f
C265 a_480_5974# a_8356_5974# 0.75746f
C266 vbn_leak m1_186_2812# 0.15984f
C267 m1_186_2812# vm 0.06403f
C268 vbp_syn vw 0.00191f
C269 vbp_syn m1_3408_5970# 0
C270 a_7148_1874# el 0
C271 m1_4392_1730# en 0
C272 m1_6086_5726# vdd 0.92091f
C273 vbp_syn spk 0.15303f
C274 a_1024_3080# a_2536_3080# 0
C275 vbn_leak m1_3408_5970# 0.0447f
C276 vbn_leak vw 0.80832f
C277 vm vw 0.27031f
C278 sel_adex vbp_st 0.12928f
C279 m1_406_5430# vbp_w 0.01895f
C280 vbn_prb vw 0.01645f
C281 m1_988_5716# vbp_st 0.00875f
C282 vbn_leak spk 0.05452f
C283 abus vreset 0.03144f
C284 m1_988_5716# m1_186_3686# 0
C285 m1_3872_1730# vbp_syn 0.16833f
C286 vm spk 7.94886f
C287 vdd sta 0.43573f
C288 m1_2772_1784# a_480_5974# 0.06241f
C289 abus m1_3262_1784# 0.11792f
C290 vbn_prb spk 0.10552f
C291 a_7000_3738# m1_4242_4630# 0.03992f
C292 a_3332_1974# abus 0
C293 m1_7186_9150# sta 0
C294 sub1 a_5492_8534# 0.02457f
C295 m1_3872_1730# vbn_leak 0.05169f
C296 m1_3872_1730# vm 0.25452f
C297 vbn_prb m1_3872_1730# 0.00119f
C298 en m1_3262_1784# 0.02073f
C299 m1_1704_2490# a_912_5974# 0.07023f
C300 a_2884_5778# vsrc 0.23402f
C301 vsrc vbp_w 0.0277f
C302 vdd stb 0.66516f
C303 vbn_ref vbp_syn 0.02726f
C304 a_3332_1974# en 0.07623f
C305 sub1 mreset 0
C306 m1_4932_8400# sub0 0.00402f
C307 m1_7186_9150# stb 0.00211f
C308 a_480_5974# mreset 0.00232f
C309 vbn_leak vbn_ref 0.02664f
C310 m1_186_3686# m1_186_2812# 0.05257f
C311 vbn_ref vm 0.3395f
C312 en m1_1704_2490# 0.10644f
C313 vbn_prb vbn_ref 0.27509f
C314 a_7148_1874# vsrc 0.13724f
C315 sub0 vbp_w 0
C316 vbp_st m1_3408_5970# 0.13878f
C317 vbp_st vw 0.73153f
C318 m1_186_3686# m1_3408_5970# 0.07516f
C319 m1_186_3686# vw 0.24254f
C320 vbn_leak vbp_syn 0.07371f
C321 vbp_syn vm 0.33409f
C322 vbp_st spk 0.1459f
C323 vbn_prb vbp_syn 1.79287f
C324 m1_6086_5726# a_7000_3738# 0.13402f
C325 m1_3262_1784# sel_adex 0.1355f
C326 a_3332_1974# sel_adex 0.02938f
C327 a_1024_3080# a_1780_3080# 0.00806f
C328 vbn_leak vm 0.1546f
C329 m1_6086_5726# a_8356_5974# 0
C330 vbn_prb vbn_leak 0.02808f
C331 vdd a_2536_3080# 1.72208f
C332 vbn_prb vm 0.40986f
C333 abus m1_4932_8400# 0.0725f
C334 m1_3872_1730# m1_186_3686# 0.02989f
C335 m1_4392_1730# vw 0.03067f
C336 mreset m1_4242_4630# 0.04561f
C337 a_2884_5778# a_912_5974# 0
C338 vbp_w a_912_5974# 0.09463f
C339 abus vbp_w 1.79744f
C340 a_1024_3080# el 0.08483f
C341 vdd m1_6552_5730# 0.81083f
C342 vbn_ref vbp_st 1.80088f
C343 a_7000_3738# stb 0.00203f
C344 m1_186_2812# m1_3262_1784# 0.04197f
C345 m1_3872_1730# m1_4392_1730# 0.47036f
C346 hold vdd 1.12837f
C347 a_3332_1974# m1_186_2812# 0.06097f
C348 a_2884_5778# en 0.04904f
C349 en vbp_w 0.13073f
C350 m1_7186_9150# hold 0.07838f
C351 vbp_syn vbp_st 0.02836f
C352 vreset vw 0.13212f
C353 m1_2772_1784# sta 0
C354 m1_3262_1784# vw 0.06389f
C355 m1_3262_1784# m1_3408_5970# 0.26816f
C356 m1_186_3686# vbp_syn 0
C357 m1_186_2812# m1_1704_2490# 0.15614f
C358 a_3332_1974# m1_3408_5970# 0.57058f
C359 a_3332_1974# vw 0.12195f
C360 vreset spk 0.05675f
C361 vbn_leak vbp_st 0.71734f
C362 m1_4392_1730# vbn_ref 0
C363 vm vbp_st 0.003f
C364 a_5492_8534# sta 0
C365 m1_186_3686# vbn_leak 1.82337f
C366 vbn_prb vbp_st 0.02915f
C367 m1_4932_8400# sel_adex 0.10684f
C368 m1_186_3686# vm 0.05701f
C369 m1_1704_2490# vw 0.04436f
C370 m1_2772_1784# stb 0
C371 m1_3872_1730# m1_3262_1784# 0.06042f
C372 a_7060_5974# vw 0.03191f
C373 a_3332_1974# m1_3872_1730# 0
C374 m1_4392_1730# vbp_syn 0.45754f
C375 a_7000_3738# a_2536_3080# 0.08798f
C376 sub1 m1_6290_9150# 0.03483f
C377 m1_2916_1640# a_912_5974# 0.00294f
C378 m1_988_5716# vbp_w 0.01404f
C379 a_7060_5974# spk 0.00763f
C380 mreset sta 0.66134f
C381 en m1_2516_8340# 0.0288f
C382 a_5492_8534# stb 0.02031f
C383 a_2536_3080# a_8356_5974# 0.06316f
C384 m1_4392_1730# vbn_leak 0.06678f
C385 m1_3872_1730# m1_1704_2490# 0.07198f
C386 m1_4392_1730# vm 0.23292f
C387 vbn_ref vreset 1.79698f
C388 vbn_prb m1_4392_1730# 0
C389 a_7000_3738# m1_6552_5730# 0.12274f
C390 m1_2916_1640# en 0.01094f
C391 el vdd 2.14482f
C392 mreset stb 0.20802f
C393 hold a_7000_3738# 0.14198f
C394 m1_6552_5730# a_8356_5974# 0.00544f
C395 vbp_syn vreset 0.02786f
C396 vbp_syn m1_3262_1784# 0.01312f
C397 a_480_5974# m1_4242_4630# 0
C398 a_2884_5778# m1_186_2812# 0.02656f
C399 a_3332_1974# vbp_syn 0
C400 m1_2772_1784# a_2536_3080# 0
C401 vbn_ref a_7060_5974# 0.00254f
C402 m1_186_2812# vbp_w 0.34325f
C403 sel_adex m1_2516_8340# 0
C404 vbn_leak vreset 0.04157f
C405 vreset vm 0.07853f
C406 vbn_leak m1_3262_1784# 0.44856f
C407 vm m1_3262_1784# 0.04372f
C408 vbn_prb vreset 1.83108f
C409 a_3332_1974# vbn_leak 0.19698f
C410 a_3332_1974# vm 0.00127f
C411 a_2884_5778# vw 0.16871f
C412 a_2884_5778# m1_3408_5970# 0.15756f
C413 vbp_w vw 0.33997f
C414 vbp_w m1_3408_5970# 0.25641f
C415 vbp_syn a_7060_5974# 0.05504f
C416 vdd m1_406_5430# 0.40574f
C417 vbp_w spk 0.09471f
C418 vbn_leak m1_1704_2490# 0.28197f
C419 m1_1704_2490# vm 0.0116f
C420 m1_4392_1730# vbp_st 0
C421 vbn_leak a_7060_5974# 0.03153f
C422 vm a_7060_5974# 0.02652f
C423 m1_4392_1730# m1_186_3686# 0.02724f
C424 mreset a_2536_3080# 0.16919f
C425 a_1024_3080# a_912_5974# 0.02599f
C426 vbn_prb a_7060_5974# 0.07705f
C427 a_7148_1874# vw 0.0531f
C428 a_2884_5778# m1_3872_1730# 0.02707f
C429 m1_1656_4620# el 0
C430 m1_3872_1730# vbp_w 0.00244f
C431 hold a_5492_8534# 0.02882f
C432 a_7148_1874# spk 0.10944f
C433 m1_6086_5726# a_480_5974# 0
C434 vsrc vdd 0.11554f
C435 sub1 sta 0
C436 vw m1_2516_8340# 0.08254f
C437 a_7000_3738# el 0.00802f
C438 a_480_5974# sta 0.01929f
C439 vbn_ref vbp_w 0.02771f
C440 vreset vbp_st 0.0341f
C441 hold mreset 0.02113f
C442 m1_3262_1784# vbp_st 0.03404f
C443 m1_186_3686# vreset 0.00195f
C444 a_3332_1974# vbp_st 0.1717f
C445 m1_1656_4620# m1_406_5430# 0
C446 m1_186_3686# m1_3262_1784# 0.0363f
C447 el a_8356_5974# 0.18113f
C448 sub0 vdd 0.60564f
C449 a_3332_1974# m1_186_3686# 0.02933f
C450 vbn_leak m1_4932_8400# 0.00627f
C451 a_2884_5778# vbp_syn 0.16301f
C452 sub1 stb 0.00623f
C453 vbp_syn vbp_w 2.18553f
C454 m1_7186_9150# sub0 0.16038f
C455 a_7148_1874# vbn_ref 0.07745f
C456 a_480_5974# stb 0.05352f
C457 a_7060_5974# vbp_st 0.05013f
C458 m1_186_3686# m1_1704_2490# 0.00483f
C459 a_2884_5778# vbn_leak 0.48893f
C460 a_2884_5778# vm 0.19558f
C461 vbn_leak vbp_w 0.08712f
C462 m1_186_3686# a_7060_5974# 0
C463 vm vbp_w 0.00195f
C464 a_1024_3080# m1_988_5716# 0
C465 m1_6086_5726# m1_4242_4630# 0.14941f
C466 a_2884_5778# vbn_prb 0
C467 m1_4392_1730# m1_3262_1784# 0
C468 vbn_prb vbp_w 0.02857f
C469 m1_2916_1640# m1_3872_1730# 0.00162f
C470 a_7148_1874# vbp_syn 0.00526f
C471 stb m1_6290_9150# 0
C472 a_3332_1974# m1_4392_1730# 0
C473 m1_4242_4630# sta 0.01533f
C474 a_7148_1874# vbn_leak 0.03447f
C475 a_7148_1874# vm 0.0106f
C476 vdd a_912_5974# 0.69589f
C477 m1_4392_1730# m1_1704_2490# 0
C478 abus vdd 0.06459f
C479 a_7148_1874# vbn_prb 0.06433f
C480 m1_4392_1730# a_7060_5974# 0
C481 vsrc a_7000_3738# 0.25167f
C482 m1_7186_9150# abus 0.00303f
C483 a_1024_3080# m1_186_2812# 0.11031f
C484 a_480_5974# a_2536_3080# 0.09038f
C485 stb m1_4242_4630# 0.02715f
C486 vsrc a_8356_5974# 0.03608f
C487 en vdd 0.38363f
C488 mreset el 0.15212f
C489 vbn_leak m1_2516_8340# 0.01787f
C490 a_3332_1974# m1_3262_1784# 0.60618f
C491 a_2884_5778# vbp_st 0.00168f
C492 vbp_w vbp_st 0.08062f
C493 m1_1704_2490# m1_3262_1784# 0.05875f
C494 a_480_5974# m1_6552_5730# 0.06999f
C495 vreset a_7060_5974# 0.03171f
C496 a_2884_5778# m1_186_3686# 0.18856f
C497 m1_2916_1640# vbn_leak 0
C498 m1_2916_1640# vm 0.15263f
C499 sub1 hold 0.02766f
C500 a_3332_1974# m1_1704_2490# 0.07109f
C501 m1_2916_1640# vbn_prb 0
C502 m1_1656_4620# a_912_5974# 0.08779f
C503 a_7148_1874# vbp_st 0.00288f
C504 vdd sel_adex 0.12393f
C505 a_7148_1874# m1_186_3686# 0.00128f
C506 m1_988_5716# vdd 0.16625f
C507 hold m1_6290_9150# 0.00766f
C508 a_2536_3080# m1_4242_4630# 0.0931f
C509 a_2884_5778# m1_4392_1730# 0.25266f
C510 m1_7186_9150# sel_adex 0.00583f
C511 m1_6086_5726# stb 0.00222f
C512 m1_1656_4620# en 0.0032f
C513 vbp_st m1_2516_8340# 0.00178f
C514 vsrc mreset 0.06904f
C515 stb sta 0.70303f
C516 a_5492_8534# sub0 0.1547f
C517 m1_6552_5730# m1_4242_4630# 0.00803f
C518 a_7148_1874# m1_4392_1730# 0
C519 m1_4932_8400# m1_3262_1784# 0.10139f
C520 a_3332_1974# m1_4932_8400# 0.0079f
C521 a_480_5974# a_1780_3080# 0.0085f
C522 hold m1_4242_4630# 0.16714f
C523 m1_186_2812# vdd 1.47033f
C524 a_2884_5778# vreset 0.04276f
C525 vreset vbp_w 0.02796f
C526 a_2884_5778# m1_3262_1784# 0.22531f
C527 m1_3262_1784# vbp_w 0.02777f
C528 mreset sub0 0
C529 a_2884_5778# a_3332_1974# 0.15448f
C530 a_3332_1974# vbp_w 0.11866f
C531 a_1024_3080# vbn_leak 0.00617f
C532 a_1024_3080# vm 0.01262f
C533 m1_988_5716# m1_1656_4620# 0.0248f
C534 sub1 el 0.01811f
C535 m1_2772_1784# a_912_5974# 0.00789f
C536 vdd m1_3408_5970# 0.47995f
C537 vdd vw 2.64357f
C538 m1_6086_5726# a_2536_3080# 0.04733f
C539 a_480_5974# el 0.06166f
C540 a_7148_1874# vreset 0.05028f
C541 a_2884_5778# m1_1704_2490# 0
C542 vdd spk 2.59286f
C543 m1_7186_9150# vw 0.00496f
C544 a_2884_5778# a_7060_5974# 0
C545 a_7060_5974# vbp_w 0
C546 m1_2916_1640# m1_4392_1730# 0
C547 abus a_5492_8534# 0.1764f
C548 a_2536_3080# sta 0.17443f
C549 m1_2772_1784# en 0.03636f
C550 m1_3872_1730# vdd 0.17132f
C551 m1_6086_5726# m1_6552_5730# 0.05615f
C552 hold m1_6086_5726# 0.3195f
C553 a_7148_1874# a_7060_5974# 0.39153f
C554 m1_1656_4620# m1_186_2812# 0
C555 m1_3262_1784# m1_2516_8340# 0
C556 abus mreset 1.85451f
C557 a_480_5974# m1_406_5430# 0.08331f
C558 a_3332_1974# m1_2516_8340# 0.04876f
C559 a_2536_3080# stb 0.14987f
C560 vbn_ref vdd 0.14224f
C561 hold sta 0.00224f
C562 m1_1656_4620# vw 0.19781f
C563 m1_2916_1640# m1_3262_1784# 0.09133f
C564 en mreset 0.04229f
C565 m1_2916_1640# a_3332_1974# 0.03012f
C566 sub1 vsrc 0.00276f
C567 vbp_syn vdd 1.73188f
C568 vsrc a_480_5974# 0.04927f
C569 hold stb 0.15874f
C570 a_5492_8534# sel_adex 0.08155f
C571 m1_2916_1640# m1_1704_2490# 0
C572 a_7000_3738# vw 0.00395f
C573 a_2884_5778# vbp_w 0.10761f
C574 vbn_leak vdd 1.80118f
C575 vm vdd 0.95188f
C576 vbn_prb vdd 0.16878f
C577 vw a_8356_5974# 0.05559f
C578 a_7000_3738# spk 0.00127f
C579 sub1 sub0 0.60486f
C580 mreset sel_adex 0.05623f
C581 a_8356_5974# spk 0.20408f
C582 a_2884_5778# a_7148_1874# 0
C583 a_7148_1874# vbp_w 0
C584 m1_6086_5726# el 0
C585 sub0 m1_6290_9150# 0.00188f
C586 m1_4932_8400# m1_2516_8340# 0.0019f
C587 a_2536_3080# m1_6552_5730# 0.05154f
C588 vsrc m1_4242_4630# 0
C589 hold a_2536_3080# 0.08116f
C590 el sta 0.04812f
C591 vbn_ref a_7000_3738# 0.05299f
C592 m1_1656_4620# vbn_leak 0.3505f
C593 a_5492_8534# vw 0.00408f
C594 sub1 abus 0.00848f
C595 vbn_ref a_8356_5974# 0.00403f
C596 a_480_5974# a_912_5974# 0.53523f
C597 vdd vbp_st 2.96141f
C598 m1_3872_1730# m1_2772_1784# 0.00312f
C599 hold m1_6552_5730# 0.02153f
C600 vbp_syn a_7000_3738# 0.18859f
C601 m1_186_3686# vdd 0.26894f
C602 el stb 0.08699f
C603 a_1024_3080# m1_1704_2490# -0.00845f
C604 m1_7186_9150# vbp_st 0.20724f
C605 mreset m1_3408_5970# 0.13001f
C606 vbp_syn a_8356_5974# 0.06702f
C607 mreset vw 0.83168f
C608 vbn_leak a_7000_3738# 0.53742f
C609 a_480_5974# en 0.00165f
C610 vm a_7000_3738# 0.40367f
C611 vbn_prb a_7000_3738# 0.04989f
C612 mreset spk 1.81917f
C613 vbn_leak a_8356_5974# 0.0323f
C614 m1_2772_1784# vbn_ref 0.00424f
C615 vm a_8356_5974# 0.2479f
C616 vbn_prb a_8356_5974# 0.22607f
C617 a_2536_3080# a_1780_3080# 0.00826f
C618 vsrc m1_6086_5726# 0
C619 m1_4392_1730# vdd 0.36367f
C620 m1_3872_1730# mreset 0.32457f
C621 vsrc sta 0.01583f
C622 sub1 sel_adex 0.10928f
C623 m1_1656_4620# vbp_st 0.01913f
C624 el a_2536_3080# 0.24987f
C625 m1_1656_4620# m1_186_3686# 0
C626 m1_2772_1784# vbn_leak 0
C627 m1_2772_1784# vm 0.23067f
C628 m1_988_5716# a_480_5974# 0.10814f
C629 vbn_ref mreset 0.03331f
C630 vbn_prb m1_2772_1784# 0.28701f
C631 vreset vdd 0.05606f
C632 en m1_4242_4630# 0.00208f
C633 m1_3262_1784# vdd 0.30789f
C634 sub0 sta 0.00363f
C635 sel_adex m1_6290_9150# 0
C636 vsrc stb 0.03362f
C637 vbn_leak a_5492_8534# 0.00233f
C638 a_7000_3738# vbp_st 0.00502f
C639 a_3332_1974# vdd 1.44361f
C640 el m1_6552_5730# 0
C641 vbp_syn mreset 0.13254f
C642 m1_7186_9150# m1_3262_1784# 0.00232f
C643 m1_186_3686# a_7000_3738# 0.08222f
C644 a_3332_1974# m1_7186_9150# 0.04397f
C645 hold el 0.02532f
C646 vbp_st a_8356_5974# 0.03991f
C647 vbn_leak mreset 0.54806f
C648 mreset vm 0.04311f
C649 a_7060_5974# vdd 0.727f
C650 sub0 stb 0.02772f
C651 vbn_prb mreset 0.03597f
C652 m1_186_2812# a_480_5974# 0.23614f
C653 m1_4392_1730# a_7000_3738# 0.0453f
C654 sub1 m1_3408_5970# 0
C655 sub1 vw 0.21855f
C656 a_480_5974# vw 0.35771f
C657 vsrc a_2536_3080# 0.04449f
C658 a_480_5974# spk 0.09234f
C659 a_5492_8534# vbp_st 0.0039f
C660 en sta 0.18106f
C661 el a_1780_3080# 0.01237f
C662 m1_3872_1730# a_480_5974# 0.01243f
C663 abus stb 0.01897f
C664 vsrc m1_6552_5730# 0
C665 vreset a_7000_3738# 0.08198f
C666 m1_4932_8400# vdd 0.04819f
C667 m1_186_2812# m1_4242_4630# 0
C668 hold vsrc 0.00133f
C669 mreset vbp_st 0.85556f
C670 vreset a_8356_5974# 0.03489f
C671 m1_7186_9150# m1_4932_8400# 0
C672 a_2884_5778# vdd 2.00105f
C673 sub1 vbn_ref 0.00167f
C674 m1_186_3686# mreset 0.03648f
C675 vdd vbp_w 2.30763f
C676 vbn_ref a_480_5974# 0.18875f
C677 m1_4242_4630# vw 0
C678 m1_4242_4630# m1_3408_5970# 0
C679 a_7000_3738# a_7060_5974# 0.1138f
C680 sel_adex sta 0.05638f
C681 hold sub0 0.05193f
C682 a_7148_1874# vdd 0.87345f
C683 a_7060_5974# a_8356_5974# 0.04679f
C684 vbp_syn a_480_5974# 0.00549f
C685 m1_4392_1730# mreset 0.11525f
C686 a_2536_3080# a_912_5974# 0
C687 m1_2772_1784# m1_3262_1784# 0.05745f
C688 m1_3872_1730# m1_4242_4630# 0.14855f
C689 sub1 vbn_leak 0.00376f
C690 a_3332_1974# m1_2772_1784# 0.0158f
C691 sub1 vbn_prb 0.00111f
C692 el m1_406_5430# 0
C693 vbn_leak a_480_5974# 0.0873f
C694 a_480_5974# vm 1.09051f
C695 sel_adex stb 0.08845f
C696 vbn_prb a_480_5974# 0.60019f
C697 a_5492_8534# m1_3262_1784# 0.07849f
C698 vdd m1_2516_8340# 0.33495f
C699 m1_2772_1784# m1_1704_2490# 0.00565f
C700 en a_2536_3080# 0.14828f
C701 a_3332_1974# a_5492_8534# 0.12497f
C702 a_2884_5778# m1_1656_4620# 0
C703 m1_1656_4620# vbp_w 0.06808f
C704 m1_186_2812# sta 0.01094f
C705 m1_6086_5726# vw 0
C706 mreset vreset 0.03397f
C707 hold abus 0.02613f
C708 m1_2916_1640# vdd -0
C709 mreset m1_3262_1784# 0.52718f
C710 vsrc el 0.07007f
C711 mreset vss 2.40312f
C712 m1_406_5430# vss -0.00303f
C713 vbp_st vss 2.03918f
C714 m1_3262_1784# vss 0.63237f
C715 a_3332_1974# vss 0.8807f
C716 a_912_5974# vss 0.52768f
C717 m1_7186_9150# vss 0.07407f
C718 sub1 vss 0.94294f
C719 a_7060_5974# vss 0.22204f
C720 a_480_5974# vss 3.43895f
C721 vdd vss 63.02801f
C722 a_7148_1874# vss 0.29578f
C723 m1_2916_1640# vss 0.11849f
C724 m1_2772_1784# vss 0.6591f
C725 en vss 0.79598f
C726 hold vss 0.37526f
C727 m1_6552_5730# vss -0.04892f
C728 vm vss 6.28085f
C729 a_2884_5778# vss -0.15874f
C730 vsrc vss 2.29668f
C731 m1_1656_4620# vss -0.17975f
C732 m1_988_5716# vss -0.07823f
C733 vbp_w vss 0.53598f
C734 m1_4392_1730# vss 0.17892f
C735 stb vss 0.79356f
C736 vbn_prb vss 0.49744f
C737 m1_3872_1730# vss 0.27049f
C738 sta vss 0.56149f
C739 m1_1704_2490# vss 0.49492f
C740 vw vss 4.67729f
C741 m1_2516_8340# vss 0.59941f
C742 m1_6290_9150# vss -0.05246f
C743 m1_3408_5970# vss 0.46223f
C744 sub0 vss 1.04775f
C745 vbn_leak vss 2.95919f
C746 m1_186_3686# vss 0.95993f
C747 abus vss 1.50484f
C748 a_5492_8534# vss 0.54382f
C749 a_7000_3738# vss 0.66411f
C750 vbn_ref vss 1.57938f
C751 vreset vss 0.60015f
C752 m1_6086_5726# vss -0.07811f
C753 m1_4932_8400# vss 0.00654f
C754 sel_adex vss 0.88088f
C755 a_8356_5974# vss 0.47681f
C756 spk vss 4.04689f
C757 a_2536_3080# vss 0.84158f
C758 a_1780_3080# vss 0.07029f
C759 m1_4242_4630# vss -0.17897f
C760 vbp_syn vss -0.96634f
C761 a_1024_3080# vss 0.08085f
C762 el vss 0.89589f
C763 m1_186_2812# vss 0.44916f
.ends
