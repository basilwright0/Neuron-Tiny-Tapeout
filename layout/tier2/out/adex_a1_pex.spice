* NGSPICE file created from adex_a1.ext - technology: gf180mcuD

.subckt p_w0p22_l1 a_100_n22# a_n100_n66# w_n278_n159# a_n192_n36# VSUBS
X0 a_100_n22# a_n100_n66# a_n192_n36# w_n278_n159# pfet_03v3 ad=0.1516p pd=1.64u as=0.1516p ps=1.64u w=0.22u l=1u
C0 a_n192_n36# w_n278_n159# 0.00771f
C1 a_100_n22# a_n192_n36# 0.00453f
C2 a_n100_n66# w_n278_n159# 0.13163f
C3 a_100_n22# a_n100_n66# 0.00509f
C4 a_n100_n66# a_n192_n36# 0.00509f
C5 a_100_n22# w_n278_n159# 0.00771f
C6 a_100_n22# VSUBS 0.05952f
C7 a_n192_n36# VSUBS 0.05952f
C8 w_n278_n159# VSUBS 0.53042f
.ends

.subckt p_w2_l4 a_400_n200# a_n400_n244# w_n574_n330# a_n488_n200# VSUBS
X0 a_400_n200# a_n400_n244# a_n488_n200# w_n574_n330# pfet_03v3 ad=0.88p pd=4.88u as=0.88p ps=4.88u w=2u l=4u
C0 a_n400_n244# w_n574_n330# 0.42229f
C1 a_400_n200# a_n400_n244# 0.07019f
C2 a_n488_n200# w_n574_n330# 0.07409f
C3 a_400_n200# a_n488_n200# 0.01073f
C4 a_n488_n200# a_n400_n244# 0.07019f
C5 a_400_n200# w_n574_n330# 0.07409f
C6 a_400_n200# VSUBS 0.18936f
C7 a_n488_n200# VSUBS 0.18936f
C8 w_n574_n330# VSUBS 2.27304f
.ends

.subckt n_w2_l4 a_400_n200# a_n400_n244# a_n488_n200# VSUBS
X0 a_400_n200# a_n400_n244# a_n488_n200# VSUBS nfet_03v3 ad=0.88p pd=4.88u as=0.88p ps=4.88u w=2u l=4u
C0 a_n488_n200# a_n400_n244# 0.07019f
C1 a_400_n200# a_n400_n244# 0.07019f
C2 a_400_n200# a_n488_n200# 0.01073f
C3 a_400_n200# VSUBS 0.41684f
C4 a_n488_n200# VSUBS 0.41684f
.ends

.subckt n_w4_l1 a_n188_n400# a_100_n400# a_n100_n444# VSUBS
X0 a_100_n400# a_n100_n444# a_n188_n400# VSUBS nfet_03v3 ad=1.76p pd=8.88u as=1.76p ps=8.88u w=4u l=1u
C0 a_n188_n400# a_n100_n444# 0.08505f
C1 a_100_n400# a_n100_n444# 0.08505f
C2 a_100_n400# a_n188_n400# 0.07756f
C3 a_100_n400# VSUBS 0.26859f
C4 a_n188_n400# VSUBS 0.26859f
.ends

.subckt n_w0p5_l0p28 a_n28_n94# a_n116_n50# a_28_n50# VSUBS
X0 a_28_n50# a_n28_n94# a_n116_n50# VSUBS nfet_03v3 ad=0.22p pd=1.88u as=0.22p ps=1.88u w=0.5u l=0.28u
C0 a_n116_n50# a_n28_n94# 0.00377f
C1 a_28_n50# a_n28_n94# 0.00377f
C2 a_28_n50# a_n116_n50# 0.02085f
C3 a_28_n50# VSUBS 0.07987f
C4 a_n116_n50# VSUBS 0.07987f
.ends

.subckt p_w1_l0p5 a_n138_n100# a_50_n100# a_n50_n144# w_n224_n230# VSUBS
X0 a_50_n100# a_n50_n144# a_n138_n100# w_n224_n230# pfet_03v3 ad=0.44p pd=2.88u as=0.44p ps=2.88u w=1u l=0.5u
C0 a_n50_n144# w_n224_n230# 0.07993f
C1 a_50_n100# a_n50_n144# 0.01275f
C2 a_n138_n100# w_n224_n230# 0.0205f
C3 a_50_n100# a_n138_n100# 0.03085f
C4 a_n138_n100# a_n50_n144# 0.01275f
C5 a_50_n100# w_n224_n230# 0.0205f
C6 a_50_n100# VSUBS 0.06546f
C7 a_n138_n100# VSUBS 0.06546f
C8 w_n224_n230# VSUBS 0.61824f
.ends

.subckt n_w1_l0p28 a_28_n100# a_n28_n144# a_n116_n100# VSUBS
X0 a_28_n100# a_n28_n144# a_n116_n100# VSUBS nfet_03v3 ad=0.44p pd=2.88u as=0.44p ps=2.88u w=1u l=0.28u
C0 a_n116_n100# a_n28_n144# 0.00769f
C1 a_28_n100# a_n28_n144# 0.00769f
C2 a_28_n100# a_n116_n100# 0.04256f
C3 a_28_n100# VSUBS 0.09911f
C4 a_n116_n100# VSUBS 0.09911f
.ends

.subckt n_w0p5_l0p5 a_n138_n50# a_50_n50# a_n50_n94# VSUBS
X0 a_50_n50# a_n50_n94# a_n138_n50# VSUBS nfet_03v3 ad=0.22p pd=1.88u as=0.22p ps=1.88u w=0.5u l=0.5u
C0 a_n138_n50# a_n50_n94# 0.00625f
C1 a_50_n50# a_n50_n94# 0.00625f
C2 a_50_n50# a_n138_n50# 0.01511f
C3 a_50_n50# VSUBS 0.09639f
C4 a_n138_n50# VSUBS 0.09639f
.ends

.subckt p_w1_l0p28 w_n202_n230# a_28_n100# a_n28_n144# a_n116_n100# VSUBS
X0 a_28_n100# a_n28_n144# a_n116_n100# w_n202_n230# pfet_03v3 ad=0.44p pd=2.88u as=0.44p ps=2.88u w=1u l=0.28u
C0 a_n28_n144# w_n202_n230# 0.05841f
C1 a_28_n100# a_n28_n144# 0.00769f
C2 a_n116_n100# w_n202_n230# 0.01808f
C3 a_28_n100# a_n116_n100# 0.04256f
C4 a_n116_n100# a_n28_n144# 0.00769f
C5 a_28_n100# w_n202_n230# 0.01808f
C6 a_28_n100# VSUBS 0.0597f
C7 a_n116_n100# VSUBS 0.0597f
C8 w_n202_n230# VSUBS 0.55752f
.ends

.subckt n_w1_l0p5 a_n138_n100# a_50_n100# a_n50_n144# VSUBS
X0 a_50_n100# a_n50_n144# a_n138_n100# VSUBS nfet_03v3 ad=0.44p pd=2.88u as=0.44p ps=2.88u w=1u l=0.5u
C0 a_n138_n100# a_n50_n144# 0.01275f
C1 a_50_n100# a_n50_n144# 0.01275f
C2 a_50_n100# a_n138_n100# 0.03085f
C3 a_50_n100# VSUBS 0.11563f
C4 a_n138_n100# VSUBS 0.11563f
.ends

.subckt p_w1_l2 w_n374_n230# a_n288_n100# a_200_n100# a_n200_n144# VSUBS
X0 a_200_n100# a_n200_n144# a_n288_n100# w_n374_n230# pfet_03v3 ad=0.44p pd=2.88u as=0.44p ps=2.88u w=1u l=2u
C0 a_n200_n144# w_n374_n230# 0.22666f
C1 a_200_n100# a_n200_n144# 0.02905f
C2 a_n288_n100# w_n374_n230# 0.03135f
C3 a_200_n100# a_n288_n100# 0.01056f
C4 a_n288_n100# a_n200_n144# 0.02905f
C5 a_200_n100# w_n374_n230# 0.03135f
C6 a_200_n100# VSUBS 0.1047f
C7 a_n288_n100# VSUBS 0.1047f
C8 w_n374_n230# VSUBS 1.03224f
.ends

.subckt n_w0p22_l15 a_1500_n22# a_n1500_n66# a_n1592_n36# VSUBS
X0 a_1500_n22# a_n1500_n66# a_n1592_n36# VSUBS nfet_03v3 ad=0.1516p pd=1.64u as=0.1516p ps=1.64u w=0.22u l=15u
C0 a_n1500_n66# a_n1592_n36# 0.00918f
C1 a_1500_n22# a_n1500_n66# 0.00918f
C2 a_1500_n22# VSUBS 1.18476f
C3 a_n1592_n36# VSUBS 1.18476f
.ends

.subckt n_w0p22_l8 a_800_n22# a_n800_n66# a_n892_n36# VSUBS
X0 a_800_n22# a_n800_n66# a_n892_n36# VSUBS nfet_03v3 ad=0.1516p pd=1.64u as=0.1516p ps=1.64u w=0.22u l=8u
C0 a_n800_n66# a_n892_n36# 0.00918f
C1 a_800_n22# a_n800_n66# 0.00918f
C2 a_800_n22# VSUBS 0.65928f
C3 a_n892_n36# VSUBS 0.65928f
.ends

.subckt n_w0p22_l2 a_200_n22# a_n200_n66# a_n292_n36# VSUBS
X0 a_200_n22# a_n200_n66# a_n292_n36# VSUBS nfet_03v3 ad=0.1516p pd=1.64u as=0.1516p ps=1.64u w=0.22u l=2u
C0 a_n200_n66# a_n292_n36# 0.00705f
C1 a_200_n22# a_n292_n36# 0.00245f
C2 a_200_n22# a_n200_n66# 0.00705f
C3 a_200_n22# VSUBS 0.20767f
C4 a_n292_n36# VSUBS 0.20767f
.ends

.subckt n_w8_l1 a_100_n800# a_n100_n844# a_n188_n800# VSUBS
X0 a_100_n800# a_n100_n844# a_n188_n800# VSUBS nfet_03v3 ad=3.52p pd=16.88u as=3.52p ps=16.88u w=8u l=1u
C0 a_n188_n800# a_n100_n844# 0.17053f
C1 a_100_n800# a_n100_n844# 0.17053f
C2 a_100_n800# a_n188_n800# 0.1555f
C3 a_100_n800# VSUBS 0.42249f
C4 a_n188_n800# VSUBS 0.42249f
.ends

.subckt p_w2_l0p5 a_50_n200# a_n50_n244# w_n224_n330# a_n138_n200# VSUBS
X0 a_50_n200# a_n50_n244# a_n138_n200# w_n224_n330# pfet_03v3 ad=0.88p pd=4.88u as=0.88p ps=4.88u w=2u l=0.5u
C0 a_n50_n244# w_n224_n330# 0.07993f
C1 a_50_n200# a_n50_n244# 0.02577f
C2 a_n138_n200# w_n224_n330# 0.03848f
C3 a_50_n200# a_n138_n200# 0.06232f
C4 a_n138_n200# a_n50_n244# 0.02577f
C5 a_50_n200# w_n224_n330# 0.03848f
C6 a_50_n200# VSUBS 0.0978f
C7 a_n138_n200# VSUBS 0.0978f
C8 w_n224_n330# VSUBS 0.88704f
.ends

.subckt n_w2_l2 a_n288_n200# a_200_n200# a_n200_n244# VSUBS
X0 a_200_n200# a_n200_n244# a_n288_n200# VSUBS nfet_03v3 ad=0.88p pd=4.88u as=0.88p ps=4.88u w=2u l=2u
C0 a_n288_n200# a_n200_n244# 0.0587f
C1 a_200_n200# a_n200_n244# 0.0587f
C2 a_200_n200# a_n288_n200# 0.02133f
C3 a_200_n200# VSUBS 0.2667f
C4 a_n288_n200# VSUBS 0.2667f
.ends

.subckt n_w7p07_l7p07 a_707_n707# a_n795_n707# a_n707_n751# VSUBS
X0 a_707_n707# a_n707_n751# a_n795_n707# VSUBS nfet_03v3 ad=3.1108p pd=15.02u as=3.1108p ps=15.02u w=7.07u l=7.07u
C0 a_n795_n707# a_n707_n751# 0.27012f
C1 a_707_n707# a_n707_n751# 0.27012f
C2 a_707_n707# a_n795_n707# 0.0212f
C3 a_707_n707# VSUBS 0.84237f
C4 a_n795_n707# VSUBS 0.84237f
.ends

.subckt p_w0p22_l8 a_800_n22# a_n800_n66# w_n978_n159# a_n892_n36# VSUBS
X0 a_800_n22# a_n800_n66# a_n892_n36# w_n978_n159# pfet_03v3 ad=0.1516p pd=1.64u as=0.1516p ps=1.64u w=0.22u l=8u
C0 a_n892_n36# w_n978_n159# 0.0077f
C1 a_n800_n66# w_n978_n159# 0.83403f
C2 a_800_n22# a_n800_n66# 0.00918f
C3 a_n800_n66# a_n892_n36# 0.00918f
C4 a_800_n22# w_n978_n159# 0.0077f
C5 a_800_n22# VSUBS 0.23501f
C6 a_n892_n36# VSUBS 0.23501f
C7 w_n978_n159# VSUBS 1.86602f
.ends

.subckt n_w4_l2 a_n288_n400# a_200_n400# a_n200_n444# VSUBS
X0 a_200_n400# a_n200_n444# a_n288_n400# VSUBS nfet_03v3 ad=1.76p pd=8.88u as=1.76p ps=8.88u w=4u l=2u
C0 a_n288_n400# a_n200_n444# 0.11799f
C1 a_200_n400# a_n200_n444# 0.11799f
C2 a_200_n400# a_n288_n400# 0.04287f
C3 a_200_n400# VSUBS 0.34365f
C4 a_n288_n400# VSUBS 0.34365f
.ends

.subckt n_w3p54_l3p54 a_354_n354# a_n354_n398# a_n442_n354# VSUBS
X0 a_354_n354# a_n354_n398# a_n442_n354# VSUBS nfet_03v3 ad=1.5576p pd=7.96u as=1.5576p ps=7.96u w=3.54u l=3.54u
C0 a_n442_n354# a_n354_n398# 0.12189f
C1 a_354_n354# a_n354_n398# 0.12189f
C2 a_354_n354# a_n442_n354# 0.02161f
C3 a_354_n354# VSUBS 0.44156f
C4 a_n442_n354# VSUBS 0.44156f
.ends

.subckt p_w7p07_l7p07 w_n881_n837# a_707_n707# a_n795_n707# a_n707_n751# VSUBS
X0 a_707_n707# a_n707_n751# a_n795_n707# w_n881_n837# pfet_03v3 ad=3.1108p pd=15.02u as=3.1108p ps=15.02u w=7.07u l=7.07u
C0 a_n707_n751# w_n881_n837# 0.72259f
C1 a_707_n707# a_n707_n751# 0.27012f
C2 a_n795_n707# w_n881_n837# 0.28802f
C3 a_707_n707# a_n795_n707# 0.0212f
C4 a_n795_n707# a_n707_n751# 0.27012f
C5 a_707_n707# w_n881_n837# 0.28802f
C6 a_707_n707# VSUBS 0.43364f
C7 a_n795_n707# VSUBS 0.43364f
C8 w_n881_n837# VSUBS 8.84876f
.ends

.subckt p_w0p5_l1 a_100_n50# a_n100_n94# a_n188_n50# w_n274_n180# VSUBS
X0 a_100_n50# a_n100_n94# a_n188_n50# w_n274_n180# pfet_03v3 ad=0.22p pd=1.88u as=0.22p ps=1.88u w=0.5u l=1u
C0 a_n100_n94# w_n274_n180# 0.12884f
C1 a_100_n50# a_n100_n94# 0.01026f
C2 a_n188_n50# w_n274_n180# 0.0135f
C3 a_100_n50# a_n188_n50# 0.00935f
C4 a_n188_n50# a_n100_n94# 0.01026f
C5 a_100_n50# w_n274_n180# 0.0135f
C6 a_100_n50# VSUBS 0.06237f
C7 a_n188_n50# VSUBS 0.06237f
C8 w_n274_n180# VSUBS 0.59184f
.ends

.subckt p_w4_l0p5 a_n138_n400# a_50_n400# a_n50_n444# w_n224_n530# VSUBS
X0 a_50_n400# a_n50_n444# a_n138_n400# w_n224_n530# pfet_03v3 ad=1.76p pd=8.88u as=1.76p ps=8.88u w=4u l=0.5u
C0 a_n50_n444# w_n224_n530# 0.07993f
C1 a_50_n400# a_n50_n444# 0.05179f
C2 a_n138_n400# w_n224_n530# 0.07442f
C3 a_50_n400# a_n138_n400# 0.12527f
C4 a_n138_n400# a_n50_n444# 0.05179f
C5 a_50_n400# w_n224_n530# 0.07442f
C6 a_50_n400# VSUBS 0.16249f
C7 a_n138_n400# VSUBS 0.16249f
C8 w_n224_n530# VSUBS 1.42464f
.ends

.subckt adex_a1 vdd vss el vbn_leak vsrc vbp_st vbn_ref vreset vbn_prb vbp_syn vbp_w
+ abus sta spk stb en mreset sub0 sel_adex sub1 hold vm vw
XXD_XK a_6424_12054# spk vdd vdd vss p_w0p22_l1
XXL_XP1 a_2068_9320# a_2068_9320# vdd vdd vss p_w2_l4
XXL_XP2 a_6744_3960# a_2068_9320# vdd vdd vss p_w2_l4
XXL_XMT m1_5854_3330# vbn_leak vss vss n_w2_l4
XXL_XM1 a_2068_9320# a_5632_4760# el vss n_w4_l1
XXR_Xi_XN spk vss a_4652_12054# vss n_w0p5_l0p28
XXS_XWA m1_1350_9490# vbp_syn vdd m1_4306_8790# vss p_w2_l4
XXL_XM2 a_6188_4760# a_6744_3960# a_6744_3960# vss n_w4_l1
XXD_XPI m1_5010_11870# a_5308_6338# vm vdd vss p_w1_l0p5
XXS_XWB m1_2328_2920# vbp_syn vdd m1_4306_8790# vss p_w2_l4
XXP_XSA m1_3332_6276# sel_adex m1_3132_6402# vss n_w1_l0p28
XXR_XSW vreset vm a_2000_6434# vss n_w0p5_l0p5
XXR_XNR a_2000_6434# vbn_ref vss vss n_w2_l4
XXR_Xi_XP vdd a_4652_12054# spk vdd vss p_w1_l0p28
XXD_XNI vsrc a_5308_6338# vm vss n_w1_l0p5
XXP_XSC m1_3132_6402# a_3648_6534# abus vss n_w1_l0p28
XXS_XQA vdd vss sta m1_1350_9490# vss p_w1_l0p28
XXP_XPB vdd m1_2970_10926# m1_3242_10610# vbp_st vss p_w1_l2
XXA_XT1 vw vbn_leak m1_1926_4246# vss n_w0p22_l15
XXS_XQB vdd vss stb m1_2328_2920# vss p_w1_l0p28
XXP_Xi0_XN sub0 vss a_2884_11174# vss n_w0p5_l0p28
XXA_XT2 m1_1926_4246# vbn_leak m1_1926_4730# vss n_w0p22_l15
XXA_XPS vdd m1_2558_10610# m1_2086_6300# vdd vss p_w1_l0p28
XXP_XPE vdd m1_2970_10926# a_2884_11174# vdd vss p_w1_l0p28
XXA_XW a_6744_3960# vw vss vss n_w0p22_l8
XXA_XR1 vw mreset m1_5288_4962# vss n_w0p22_l2
XXA_XT3 m1_1926_4730# vbn_leak vss vss n_w0p22_l15
XXL_XD1 m1_5854_3330# a_5632_4760# a_5632_4760# vss n_w8_l1
XXP_Xi0_XP vdd a_2884_11174# sub0 vdd vss p_w1_l0p28
XXP_XPF vss vw vdd m1_3242_10610# vss p_w2_l0p5
XXA_XR2 m1_5288_4962# mreset vss vss n_w0p22_l2
XXL_XD2 a_6188_4760# a_6188_4760# m1_5854_3330# vss n_w8_l1
XXS_XNA sta vm m1_1350_9490# vss n_w0p5_l0p28
XXD_XS2 vdd vdd m1_5486_11870# vbp_st vss p_w1_l2
XXD_XPS vdd vdd m1_5010_11870# vbp_st vss p_w1_l2
XXS_XNB stb vm m1_2328_2920# vss n_w0p5_l0p28
XXP_XT0_XMB vss m1_2438_3470# vbn_prb vss n_w2_l2
XXA_XPW vdd m1_2558_10610# m1_3246_10190# vbp_w vss p_w1_l2
XXD_XS3 vdd vdd m1_5918_11806# vbp_st vss p_w1_l2
XXE_XE1 a_3764_10978# vm vsrc vss n_w0p22_l8
XXC_XC vss vss vm vss n_w7p07_l7p07
XXD_XP2 vdd a_5992_12054# a_5308_6338# m1_5486_11870# vss p_w1_l0p28
XXE_XE2 a_3764_10978# a_3764_10978# vdd vdd vss p_w2_l0p5
XXS_XPH vdd vdd m1_4306_8790# hold vss p_w1_l2
XXP_XT0_XME m1_4890_5290# en m1_2438_3470# vss n_w1_l0p28
XXD_XP3 vdd a_6424_12054# a_5992_12054# m1_5918_11806# vss p_w1_l0p28
XXE_XE3 a_6744_3960# a_3764_10978# vdd vdd vss p_w0p22_l8
XXD_Xi4_XN a_6424_12054# vss spk vss n_w0p5_l0p28
XXP_XT0_XMF m1_4890_5290# vdd vm vss n_w4_l2
XXD_XN2 a_5992_12054# a_5308_6338# vsrc vss n_w0p22_l2
XXR_XCR_XC vss a_2000_6434# vss vss n_w3p54_l3p54
XXD_Xi4_XP vdd spk a_6424_12054# vdd vss p_w1_l0p28
XXD_XN3 a_5992_12054# vsrc a_6424_12054# vss n_w0p5_l0p28
XXP_Xi1_XN sub1 vss a_3648_6534# vss n_w0p5_l0p28
XXR_XPC vdd a_2000_6434# a_4652_12054# vdd vss p_w1_l0p28
XXP_Xi1_XP vdd a_3648_6534# sub1 vdd vss p_w1_l0p28
XXP_XS1 m1_3242_10610# sub0 m1_3332_6276# vss n_w1_l0p28
XXA_Xi_XN a_2000_6434# vss m1_2086_6300# vss n_w0p5_l0p28
XXA_Xi_XP vdd m1_2086_6300# a_2000_6434# m1_2006_10750# vss p_w1_l0p28
XXA_XCW vdd vdd vdd vw vss p_w7p07_l7p07
XXS_XHL vdd vm hold a_6744_3960# vss p_w1_l0p28
XXA_XPA vw vw m1_3246_10190# vdd vss p_w0p5_l1
XXP_XT0_XSW m1_4890_5290# a_2884_11174# m1_3332_6276# vss n_w1_l0p28
XXA_Xi_XS vdd vdd m1_2006_10750# vbp_st vss p_w1_l2
XXA_XPB m1_3246_10190# vss vbn_leak vdd vss p_w4_l0p5
XXS_XMR mreset a_2000_6434# vdd vss n_w0p5_l0p28
C0 vbp_syn vreset 0.02925f
C1 m1_2328_2920# m1_4890_5290# 0.00491f
C2 m1_5918_11806# m1_5486_11870# 0.06553f
C3 m1_2970_10926# a_2068_9320# 0
C4 vw vreset 0
C5 sel_adex a_5992_12054# 0.01106f
C6 el a_6188_4760# 0
C7 vsrc vbn_leak 3.65126f
C8 m1_2006_10750# vbn_ref 0
C9 m1_2558_10610# vbp_st 0
C10 sel_adex m1_5288_4962# 0
C11 m1_5010_11870# a_5308_6338# 0.09168f
C12 stb vsrc 0.02506f
C13 a_2068_9320# vbn_leak 0.33614f
C14 m1_4306_8790# a_3764_10978# 0.17271f
C15 a_3648_6534# vm 0.07344f
C16 vsrc a_5308_6338# 0.26997f
C17 vbn_prb vbn_leak 0.02975f
C18 stb a_2068_9320# 0.13785f
C19 m1_2970_10926# vbp_st 0.00762f
C20 m1_2328_2920# sub1 0.03353f
C21 vbp_syn m1_2006_10750# 0.00133f
C22 m1_1350_9490# vsrc 0.27132f
C23 a_2068_9320# a_5308_6338# 0
C24 stb vbn_prb 0.00261f
C25 sub0 spk 0.03575f
C26 m1_4890_5290# m1_5854_3330# 0.14981f
C27 a_2000_6434# vdd 2.20145f
C28 m1_2970_10926# m1_3242_10610# 0.15574f
C29 vdd a_2884_11174# 0.75323f
C30 a_5632_4760# sta 0
C31 m1_1350_9490# a_2068_9320# 0.36107f
C32 m1_2328_2920# en 0
C33 vbp_st vbn_leak 0.03188f
C34 a_3648_6534# m1_3246_10190# 0.02415f
C35 vbp_w vdd 0.73399f
C36 m1_1350_9490# vbn_prb 0.07153f
C37 m1_4890_5290# spk 0.08246f
C38 a_6744_3960# a_3764_10978# 0.60296f
C39 m1_2086_6300# vbn_ref 0
C40 a_4652_12054# sub1 0
C41 vsrc m1_2438_3470# 0.27503f
C42 vbn_leak m1_3242_10610# 0
C43 a_4652_12054# hold 0.84113f
C44 vbp_st a_5308_6338# 0.10787f
C45 a_2068_9320# m1_2438_3470# 0.20426f
C46 stb m1_3242_10610# 0
C47 vdd el 4.12217f
C48 vbp_syn sub0 0.08397f
C49 m1_1350_9490# vbp_st 0.07019f
C50 a_6744_3960# sta 0
C51 m1_3242_10610# a_5308_6338# 0
C52 m1_2086_6300# vbp_syn 0.12709f
C53 vbn_prb m1_2438_3470# 0.01499f
C54 m1_4306_8790# a_6744_3960# 0.28964f
C55 vw sub0 0.19634f
C56 a_6744_3960# a_5632_4760# 0
C57 a_2884_11174# a_5992_12054# 0
C58 m1_1350_9490# m1_3242_10610# 0.15272f
C59 vw m1_2086_6300# 0
C60 mreset vbn_leak 0.46668f
C61 sub1 spk 0.04904f
C62 en m1_5854_3330# 0.12918f
C63 spk hold 0.48006f
C64 vdd vreset 0.175f
C65 m1_5918_11806# a_4652_12054# 0.00764f
C66 vw m1_4890_5290# 0.15856f
C67 stb mreset 0.06708f
C68 en spk 0.04041f
C69 mreset a_5308_6338# 0.00642f
C70 sub0 a_6188_4760# 0
C71 a_3648_6534# a_2068_9320# 0.39779f
C72 m1_1350_9490# mreset 0
C73 m1_2438_3470# m1_3242_10610# 0.0569f
C74 en vbn_ref 0.01045f
C75 abus vbn_leak 0.32912f
C76 m1_1926_4246# vbn_leak 0.70786f
C77 m1_4890_5290# a_6188_4760# 0.23118f
C78 a_3764_10978# vm 0.08844f
C79 vbp_syn sub1 0.02853f
C80 m1_5918_11806# spk 0.04104f
C81 abus stb 0.02962f
C82 m1_3132_6402# vbn_leak 0.00182f
C83 m1_2006_10750# vdd 0.14549f
C84 stb m1_1926_4246# 0.02805f
C85 vw sub1 0.06599f
C86 sel_adex m1_3332_6276# 0.1441f
C87 vw hold 0.27566f
C88 m1_1926_4730# vbn_leak 0.89139f
C89 a_2000_6434# sel_adex 0.02082f
C90 mreset m1_2438_3470# 0.01398f
C91 a_2884_11174# sel_adex 0.01257f
C92 a_3648_6534# vbp_st 0.16369f
C93 abus m1_1350_9490# 1.11516f
C94 sta vm 0.585f
C95 a_3764_10978# a_6424_12054# 0
C96 m1_5486_11870# a_5308_6338# 0.21681f
C97 m1_1926_4730# stb 0.0285f
C98 m1_1350_9490# m1_1926_4246# 0.02118f
C99 m1_3132_6402# a_5308_6338# 0
C100 vw en 0.00595f
C101 m1_4306_8790# vm 0.25554f
C102 a_5632_4760# vm 0
C103 m1_3246_10190# a_3764_10978# 0.04153f
C104 a_3648_6534# m1_3242_10610# 0.03594f
C105 m1_1350_9490# m1_1926_4730# 0.05417f
C106 m1_2558_10610# m1_2328_2920# 0.0022f
C107 vw m1_5918_11806# 0.09632f
C108 abus m1_2438_3470# 0
C109 m1_4306_8790# a_6424_12054# 0
C110 sub0 vdd 0.64511f
C111 m1_1926_4246# m1_2438_3470# 0.12414f
C112 en a_6188_4760# 0.0307f
C113 m1_4306_8790# m1_3246_10190# 0.22063f
C114 m1_2086_6300# vdd 0.684f
C115 m1_3132_6402# m1_2438_3470# 0.00104f
C116 a_6744_3960# vm 0.62857f
C117 m1_4890_5290# vdd 0.0736f
C118 m1_1926_4730# m1_2438_3470# 0.20793f
C119 m1_5010_11870# a_3764_10978# 0.06695f
C120 m1_2328_2920# vbn_leak 0.11108f
C121 abus a_3648_6534# 0.01997f
C122 a_2068_9320# a_3764_10978# 0.08549f
C123 stb m1_2328_2920# 1.18063f
C124 a_6744_3960# m1_3246_10190# 0.08901f
C125 a_2884_11174# m1_3332_6276# 0.00415f
C126 m1_4306_8790# m1_5010_11870# 0.00485f
C127 sub0 a_5992_12054# 0.00238f
C128 m1_2328_2920# a_5308_6338# 0.1087f
C129 a_2000_6434# a_2884_11174# 0.00332f
C130 a_3648_6534# m1_3132_6402# 0.06957f
C131 sub0 m1_5288_4962# 0.00925f
C132 vsrc sta 0.06619f
C133 vdd sub1 0.48267f
C134 m1_1350_9490# m1_2328_2920# 0.38602f
C135 vdd hold 1.91902f
C136 a_4652_12054# vbn_leak 0.00263f
C137 vsrc a_5632_4760# 0.00135f
C138 vbp_w a_2000_6434# 0.06247f
C139 m1_1926_4730# a_3648_6534# 0.0024f
C140 vbp_w a_2884_11174# 0.03744f
C141 m1_4890_5290# a_5992_12054# 0
C142 a_2068_9320# sta 0
C143 m1_4306_8790# a_2068_9320# 0.02229f
C144 m1_4890_5290# m1_5288_4962# 0.23561f
C145 a_5632_4760# a_2068_9320# -0.07697f
C146 en vdd 0.06334f
C147 vbn_prb sta 0.08494f
C148 vbp_st a_3764_10978# 0.18551f
C149 a_4652_12054# a_5308_6338# 0.02749f
C150 vbn_leak m1_5854_3330# 0.39151f
C151 a_2000_6434# el 0.08865f
C152 m1_5010_11870# a_6744_3960# 0.04955f
C153 m1_2328_2920# m1_2438_3470# 0.03375f
C154 m1_3242_10610# a_3764_10978# 0.40334f
C155 stb m1_5854_3330# 0.01421f
C156 spk vbn_leak 0.34914f
C157 vbp_w el 0.02386f
C158 m1_5918_11806# vdd 0.60597f
C159 vsrc a_6744_3960# 0.16603f
C160 vbp_st sta 0.02871f
C161 m1_4306_8790# vbp_st 0.19678f
C162 vw m1_2558_10610# 0
C163 sub1 a_5992_12054# 0.05356f
C164 a_5992_12054# hold 0.00106f
C165 stb spk 0.06758f
C166 a_2000_6434# vreset 0.25194f
C167 vbn_leak vbn_ref 0.12325f
C168 sub0 sel_adex 0.54123f
C169 a_6744_3960# a_2068_9320# 0.19807f
C170 sub1 m1_5288_4962# 0
C171 a_6424_12054# vm 0.0127f
C172 spk a_5308_6338# 0.00374f
C173 m1_4306_8790# m1_3242_10610# 0.09618f
C174 m1_2086_6300# sel_adex 0
C175 vbp_w vreset 0.02905f
C176 m1_3246_10190# vm 0.48424f
C177 stb vbn_ref 0.10019f
C178 vw m1_2970_10926# 0.00473f
C179 m1_4890_5290# sel_adex 0.04226f
C180 en m1_5288_4962# 0
C181 m1_2328_2920# a_3648_6534# 0.04268f
C182 vbp_syn vbn_leak 0.02726f
C183 m1_1350_9490# vbn_ref 0.04437f
C184 vw vbn_leak 0.0436f
C185 el vreset 0.05022f
C186 mreset sta 0.00247f
C187 a_6744_3960# vbp_st 0.26263f
C188 m1_3246_10190# a_6424_12054# 0.00518f
C189 m1_5918_11806# a_5992_12054# 0.32362f
C190 stb vbp_syn 0.08425f
C191 mreset a_5632_4760# 0.09347f
C192 a_2000_6434# m1_2006_10750# 0.08362f
C193 vbp_syn a_5308_6338# 0.15753f
C194 vw stb 0.00792f
C195 a_6744_3960# m1_3242_10610# 0.54976f
C196 vbp_w m1_2006_10750# 0.03082f
C197 m1_1350_9490# vbp_syn 0.585f
C198 m1_5010_11870# vm 0.10255f
C199 vw a_5308_6338# 0.48982f
C200 m1_5486_11870# a_3764_10978# 0.10663f
C201 m1_3132_6402# a_3764_10978# 0
C202 m1_2438_3470# vbn_ref 0.35284f
C203 sub1 sel_adex 0.26986f
C204 vw m1_1350_9490# 0.14562f
C205 vbn_leak a_6188_4760# 0.3497f
C206 vsrc vm 0.12383f
C207 abus sta 0.64105f
C208 m1_1926_4246# sta 0.04134f
C209 en sel_adex 0.0572f
C210 stb a_6188_4760# 0.00125f
C211 a_2068_9320# vm 0.11817f
C212 m1_2006_10750# el 0
C213 m1_1926_4246# a_5632_4760# 0.00459f
C214 a_6744_3960# mreset 0.0631f
C215 sub0 m1_3332_6276# 0.10098f
C216 vbp_syn m1_2438_3470# 0
C217 m1_5010_11870# m1_3246_10190# 0
C218 sub0 a_2000_6434# 0.01966f
C219 vbn_prb vm 0.00224f
C220 sub0 a_2884_11174# 0.53004f
C221 a_3648_6534# spk 0
C222 m1_1926_4730# sta 0.03356f
C223 vsrc a_6424_12054# 0.00112f
C224 vw m1_2438_3470# 0
C225 m1_2086_6300# a_2000_6434# 0.51668f
C226 m1_2086_6300# a_2884_11174# 0.00692f
C227 m1_2558_10610# vdd 0.22724f
C228 m1_4890_5290# m1_3332_6276# 0.12315f
C229 m1_2006_10750# vreset 0
C230 sub0 vbp_w 0
C231 m1_4890_5290# a_2884_11174# 0.14866f
C232 m1_2086_6300# vbp_w 0.03261f
C233 m1_3246_10190# a_2068_9320# 0.00184f
C234 vbp_st vm 0.12836f
C235 m1_2970_10926# vdd 0.39587f
C236 m1_3242_10610# vm 0.00401f
C237 vbp_syn a_3648_6534# 0.07961f
C238 vdd vbn_leak 0.45139f
C239 m1_2328_2920# a_3764_10978# 0.06147f
C240 vw a_3648_6534# 0.00766f
C241 vbp_st a_6424_12054# 0.1139f
C242 m1_4890_5290# el 0.00466f
C243 sub1 m1_3332_6276# 0.01774f
C244 m1_3246_10190# vbp_st 0.02087f
C245 a_2000_6434# sub1 0.01009f
C246 sub1 a_2884_11174# 0.22542f
C247 a_2000_6434# hold 0.14391f
C248 stb vdd 0.63031f
C249 a_2884_11174# hold 0.17152f
C250 m1_2086_6300# vreset 0
C251 vdd a_5308_6338# 0.80884f
C252 mreset vm 0.08752f
C253 en m1_3332_6276# 0.0751f
C254 m1_3246_10190# m1_3242_10610# 0.52279f
C255 vbp_w hold 0.00379f
C256 en a_2000_6434# 0.17645f
C257 m1_2328_2920# sta 0.23796f
C258 en a_2884_11174# 0.00302f
C259 vsrc a_2068_9320# 0.22114f
C260 m1_4306_8790# m1_2328_2920# -0.00174f
C261 m1_1350_9490# vdd 1.71432f
C262 a_4652_12054# a_3764_10978# 0.00271f
C263 vsrc vbn_prb 0.05329f
C264 vbn_leak a_5992_12054# 0.31899f
C265 a_2068_9320# vbn_prb 0
C266 m1_5010_11870# vbp_st 0.11771f
C267 abus vm 0.17572f
C268 vbn_leak m1_5288_4962# 0.01076f
C269 m1_1926_4246# vm 0.03315f
C270 m1_2086_6300# m1_2006_10750# 0.185f
C271 en el 0.04731f
C272 vsrc vbp_st 2.6502f
C273 m1_5486_11870# vm 0.01345f
C274 spk a_3764_10978# 0
C275 a_5992_12054# a_5308_6338# 0.25776f
C276 m1_3132_6402# vm 0
C277 m1_2328_2920# a_6744_3960# 0.16112f
C278 m1_1926_4730# vm 0.03777f
C279 vbp_st a_2068_9320# 0.00326f
C280 a_5308_6338# m1_5288_4962# 0.00129f
C281 m1_5854_3330# sta 0
C282 a_5632_4760# m1_5854_3330# 0.1086f
C283 vbp_st vbn_prb 0.05736f
C284 en vreset 0.0018f
C285 a_2068_9320# m1_3242_10610# 0.20585f
C286 spk sta 0.13346f
C287 m1_5486_11870# a_6424_12054# 0
C288 m1_3246_10190# m1_5486_11870# 0.06837f
C289 a_4652_12054# a_6744_3960# 0
C290 a_3648_6534# vdd 0.36944f
C291 vbp_syn a_3764_10978# 0.36443f
C292 vbn_ref sta 0.04005f
C293 vsrc mreset 0.01648f
C294 m1_2086_6300# sub0 0.14026f
C295 vbn_leak sel_adex 0.08299f
C296 vw a_3764_10978# 0.06843f
C297 m1_2438_3470# m1_5288_4962# 0
C298 sub0 m1_4890_5290# 0.25829f
C299 mreset a_2068_9320# 0.09143f
C300 a_6744_3960# m1_5854_3330# 0.00211f
C301 vbp_st m1_3242_10610# 0.0795f
C302 stb sel_adex 0
C303 vbp_syn sta 0.02303f
C304 sel_adex a_5308_6338# 0.01161f
C305 m1_4306_8790# vbp_syn 0.36369f
C306 a_6744_3960# spk 0.29633f
C307 vw sta 0
C308 m1_5010_11870# m1_5486_11870# 0.00765f
C309 m1_1350_9490# sel_adex 0
C310 abus vsrc 0.06046f
C311 vw m1_4306_8790# 0.0382f
C312 vsrc m1_1926_4246# 0.21768f
C313 vw a_5632_4760# 0.20706f
C314 m1_2328_2920# vm 0.57987f
C315 abus a_2068_9320# 0.00264f
C316 m1_1926_4246# a_2068_9320# 0.05703f
C317 sub0 sub1 1.16842f
C318 m1_1926_4730# vsrc 0.44161f
C319 m1_2558_10610# a_2884_11174# 0
C320 abus vbn_prb 0.03087f
C321 sub0 hold 0.18162f
C322 m1_1926_4246# vbn_prb 0.00158f
C323 m1_2086_6300# sub1 0
C324 m1_3132_6402# a_2068_9320# 0.00639f
C325 sta a_6188_4760# 0
C326 m1_2558_10610# vbp_w 0.09311f
C327 m1_1926_4730# a_2068_9320# 0.03537f
C328 m1_2438_3470# sel_adex 0.0536f
C329 m1_2328_2920# a_6424_12054# 0.00385f
C330 vbp_syn a_6744_3960# 0.16174f
C331 a_5632_4760# a_6188_4760# 0.00481f
C332 sub0 en 0.10818f
C333 m1_4890_5290# sub1 0.02985f
C334 a_4652_12054# vm 0.06985f
C335 m1_2328_2920# m1_3246_10190# 0.10157f
C336 m1_2970_10926# a_2884_11174# 0.0777f
C337 m1_1926_4730# vbn_prb 0
C338 vw a_6744_3960# 0.19713f
C339 abus vbp_st 0.06464f
C340 m1_2970_10926# vbp_w 0.08931f
C341 m1_1926_4246# vbp_st 0
C342 en m1_4890_5290# 0.12732f
C343 vbn_leak m1_3332_6276# 0.01646f
C344 m1_5854_3330# vm 0.00223f
C345 a_2000_6434# vbn_leak 0.28786f
C346 vbp_st m1_5486_11870# 0.11184f
C347 a_2884_11174# vbn_leak 0.00285f
C348 a_4652_12054# a_6424_12054# 0.21838f
C349 m1_1926_4730# vbp_st 0
C350 spk vm 8.35893f
C351 vbp_w vbn_leak 0.02813f
C352 stb a_2000_6434# 0.17499f
C353 a_6744_3960# a_6188_4760# 0.11321f
C354 stb a_2884_11174# 0.10043f
C355 m1_3132_6402# m1_3242_10610# 0
C356 m1_3332_6276# a_5308_6338# 0
C357 vdd a_3764_10978# 1.77781f
C358 a_3648_6534# sel_adex 0.09897f
C359 a_2000_6434# a_5308_6338# 0
C360 m1_1926_4730# m1_3242_10610# 0
C361 a_2884_11174# a_5308_6338# 0
C362 sub1 hold 0.06387f
C363 stb vbp_w 0.07587f
C364 vbn_ref vm 0.13431f
C365 m1_1350_9490# a_2000_6434# 0.09042f
C366 m1_1350_9490# a_2884_11174# 0.30895f
C367 m1_2328_2920# vsrc 0.06496f
C368 en sub1 0.01533f
C369 m1_1926_4246# mreset 0.14903f
C370 el vbn_leak 2.6973f
C371 spk a_6424_12054# 0.74452f
C372 m1_1350_9490# vbp_w 0.57631f
C373 vdd sta 0.75359f
C374 m1_2328_2920# a_2068_9320# 0.09296f
C375 m1_4306_8790# vdd 0.98109f
C376 stb el 0.05963f
C377 vdd a_5632_4760# 0.01862f
C378 m1_5010_11870# a_4652_12054# 0.00438f
C379 m1_1926_4730# mreset 0.01281f
C380 vbp_syn vm 0.41543f
C381 m1_2438_3470# m1_3332_6276# 0.05929f
C382 m1_2328_2920# vbn_prb 0.05286f
C383 a_2000_6434# m1_2438_3470# 0.13398f
C384 vbn_leak vreset 0.02523f
C385 m1_2438_3470# a_2884_11174# 0
C386 vw vm 0.14327f
C387 m1_2558_10610# m1_2006_10750# 0.06597f
C388 m1_5918_11806# hold 0.00109f
C389 m1_1350_9490# el 0.03536f
C390 a_3764_10978# a_5992_12054# 0.00504f
C391 abus m1_1926_4246# 0.00132f
C392 stb vreset 0.06419f
C393 vbp_w m1_2438_3470# 0
C394 vbp_syn a_6424_12054# 0
C395 m1_2328_2920# vbp_st 0.06069f
C396 abus m1_3132_6402# 0.02716f
C397 vbp_syn m1_3246_10190# 0.36902f
C398 a_6744_3960# vdd 1.64073f
C399 m1_5010_11870# spk 0
C400 abus m1_1926_4730# 0.04289f
C401 vw a_6424_12054# 0.0426f
C402 m1_1350_9490# vreset 0.05954f
C403 m1_1926_4730# m1_1926_4246# 0.28084f
C404 a_6188_4760# vm 0.09185f
C405 vw m1_3246_10190# 0.27665f
C406 m1_2328_2920# m1_3242_10610# 0.04409f
C407 m1_4306_8790# a_5992_12054# 0
C408 a_2068_9320# m1_5854_3330# 0.05596f
C409 a_5632_4760# a_5992_12054# 0
C410 a_3648_6534# m1_3332_6276# 0.03453f
C411 vsrc spk 0
C412 m1_1926_4730# m1_3132_6402# 0
C413 m1_2006_10750# vbn_leak 0
C414 a_5632_4760# m1_5288_4962# 0.10161f
C415 a_3648_6534# a_2000_6434# 0.01118f
C416 a_3648_6534# a_2884_11174# 0.2653f
C417 a_4652_12054# vbp_st 0.36033f
C418 vsrc vbn_ref 0.0541f
C419 stb m1_2006_10750# 0
C420 m1_2558_10610# m1_2086_6300# 0.07276f
C421 m1_2438_3470# vreset 0.03509f
C422 a_4652_12054# m1_3242_10610# 0
C423 m1_2328_2920# mreset 0
C424 a_2068_9320# vbn_ref 0
C425 vbp_syn m1_5010_11870# 0
C426 sel_adex a_3764_10978# 0
C427 m1_2970_10926# sub0 0.04751f
C428 m1_1350_9490# m1_2006_10750# 0.00817f
C429 vbn_prb vbn_ref 0.12056f
C430 a_6744_3960# a_5992_12054# 0.08055f
C431 vw m1_5010_11870# 0
C432 vbp_syn vsrc 0.11717f
C433 a_6744_3960# m1_5288_4962# 0.0794f
C434 vbp_st spk 0.1767f
C435 vw vsrc 0.2864f
C436 sub0 vbn_leak 0.04891f
C437 vbp_syn a_2068_9320# 0.18048f
C438 m1_2086_6300# vbn_leak 0
C439 vbp_syn vbn_prb 2.61727f
C440 vw a_2068_9320# 0.02556f
C441 abus m1_2328_2920# 0.03352f
C442 a_5632_4760# sel_adex 0
C443 vbp_st vbn_ref 2.65096f
C444 m1_2328_2920# m1_1926_4246# 0.04019f
C445 stb sub0 0.09565f
C446 vdd vm 2.07047f
C447 m1_4890_5290# vbn_leak 0.23418f
C448 m1_2086_6300# stb 0.12699f
C449 vw vbn_prb 0
C450 sub0 a_5308_6338# 0.00101f
C451 m1_2328_2920# m1_3132_6402# 0
C452 mreset m1_5854_3330# 0.00887f
C453 stb m1_4890_5290# 0.04195f
C454 m1_1350_9490# sub0 0.11941f
C455 m1_1926_4730# m1_2328_2920# 0.03047f
C456 m1_1350_9490# m1_2086_6300# 0.13958f
C457 m1_4890_5290# a_5308_6338# 0.01618f
C458 vbp_syn vbp_st 0.064f
C459 m1_2970_10926# sub1 0.04286f
C460 m1_2970_10926# hold 0.28325f
C461 mreset spk 0.04482f
C462 vdd a_6424_12054# 1.0295f
C463 m1_3246_10190# vdd 0.99179f
C464 vw vbp_st 0.62506f
C465 a_6744_3960# sel_adex 0.03574f
C466 vbp_syn m1_3242_10610# 0.15225f
C467 a_4652_12054# m1_5486_11870# 0
C468 mreset vbn_ref 0.09759f
C469 sub1 vbn_leak 0.05426f
C470 vw m1_3242_10610# 0.11901f
C471 sub0 m1_2438_3470# 0.00655f
C472 a_3764_10978# m1_3332_6276# 0
C473 a_5992_12054# vm 0.3315f
C474 m1_1926_4246# m1_5854_3330# 0
C475 a_2000_6434# a_3764_10978# 0.00425f
C476 a_2884_11174# a_3764_10978# 0.00134f
C477 m1_5288_4962# vm 0.01348f
C478 stb sub1 0
C479 stb hold 0.0691f
C480 en vbn_leak 0.52733f
C481 m1_4890_5290# m1_2438_3470# 0.00214f
C482 sub1 a_5308_6338# 0.05882f
C483 a_5308_6338# hold 0
C484 stb en 0.7202f
C485 m1_1350_9490# sub1 0.03934f
C486 spk m1_5486_11870# 0
C487 vw mreset 0.44681f
C488 m1_5010_11870# vdd 0.54799f
C489 a_5992_12054# a_6424_12054# 0.2491f
C490 abus vbn_ref 0.03247f
C491 m1_1926_4246# vbn_ref 0.27577f
C492 a_2000_6434# sta 0.93946f
C493 m1_3246_10190# a_5992_12054# 0.4214f
C494 a_2884_11174# sta 0
C495 en a_5308_6338# 0
C496 m1_5918_11806# vbn_leak 0.00406f
C497 vsrc vdd 0.14255f
C498 m1_1350_9490# en 0
C499 sub0 a_3648_6534# 0.25087f
C500 vbp_w sta 0.02795f
C501 m1_1926_4730# vbn_ref 0
C502 vdd a_2068_9320# 1.59037f
C503 abus vbp_syn 0.02285f
C504 vbp_syn m1_1926_4246# 0
C505 sub1 m1_2438_3470# 0.00668f
C506 mreset a_6188_4760# 0.02657f
C507 m1_5918_11806# a_5308_6338# 0.0029f
C508 vdd vbn_prb 0.0802f
C509 vw abus 0.06426f
C510 vw m1_1926_4246# 0.00487f
C511 vbp_syn m1_5486_11870# 0.00115f
C512 sel_adex vm 0.03049f
C513 vbp_syn m1_3132_6402# 0
C514 el sta 0.17005f
C515 m1_2328_2920# a_4652_12054# 0
C516 m1_1926_4730# vbp_syn 0
C517 a_5632_4760# el 0.15669f
C518 en m1_2438_3470# 0.09268f
C519 vw m1_5486_11870# 0.26132f
C520 a_6744_3960# a_2000_6434# 0.007f
C521 a_6744_3960# a_2884_11174# 0.07881f
C522 vw m1_1926_4730# 0.00559f
C523 vbp_st vdd 4.0474f
C524 vsrc a_5992_12054# 0.05121f
C525 vbp_w a_6744_3960# 0.09247f
C526 vreset sta 0.0571f
C527 vsrc m1_5288_4962# 0.0034f
C528 vdd m1_3242_10610# 0.62009f
C529 a_3648_6534# sub1 0.9727f
C530 a_3648_6534# hold 0.07405f
C531 m1_2328_2920# spk 0
C532 a_2068_9320# m1_5288_4962# 0
C533 a_6744_3960# el 0
C534 m1_2328_2920# vbn_ref 0.03035f
C535 m1_2558_10610# m1_2970_10926# 0.02343f
C536 mreset vdd 0.08197f
C537 m1_2006_10750# sta 0.03597f
C538 vbp_st a_5992_12054# 0.00785f
C539 a_4652_12054# spk 0.78939f
C540 vbp_syn m1_2328_2920# 0.35766f
C541 m1_3332_6276# vm 0.00267f
C542 vsrc sel_adex 0.03347f
C543 a_2000_6434# vm 0.75388f
C544 vw m1_2328_2920# 0.41672f
C545 a_2884_11174# vm 0.73657f
C546 sub0 a_3764_10978# 0.0135f
C547 spk m1_5854_3330# 0
C548 m1_2558_10610# stb 0.02484f
C549 m1_2086_6300# a_3764_10978# 0
C550 a_2068_9320# sel_adex 0.10833f
C551 vbp_w vm 0.0802f
C552 abus vdd 0.2467f
C553 vbp_syn a_4652_12054# 0
C554 vdd m1_5486_11870# 0.37073f
C555 a_6744_3960# m1_2006_10750# 0.00122f
C556 m1_2970_10926# stb 0.01006f
C557 mreset a_5992_12054# 0.00541f
C558 sub0 sta 0
C559 m1_3246_10190# a_2884_11174# 0.01643f
C560 m1_4306_8790# sub0 0
C561 vw a_4652_12054# 0.04576f
C562 sub0 a_5632_4760# 0
C563 mreset m1_5288_4962# 0.24371f
C564 m1_2086_6300# sta 0.00855f
C565 el vm 0.68517f
C566 vbp_w m1_3246_10190# 0.02414f
C567 m1_4890_5290# sta 0.04688f
C568 stb vbn_leak 0.10239f
C569 m1_4890_5290# a_5632_4760# 0.02978f
C570 vw m1_5854_3330# 0.05796f
C571 vbn_leak a_5308_6338# 0
C572 vbp_syn spk 0
C573 sel_adex m1_3242_10610# 0.0037f
C574 vreset vm 0.05643f
C575 sub1 a_3764_10978# 0.06056f
C576 m1_1350_9490# vbn_leak 0.04949f
C577 a_3764_10978# hold 0.17956f
C578 vw spk 0.32003f
C579 m1_5486_11870# a_5992_12054# 0.06366f
C580 vbp_syn vbn_ref 0.02825f
C581 sub0 a_6744_3960# 0.06494f
C582 m1_5010_11870# a_2000_6434# 0.02062f
C583 m1_1350_9490# stb 0.05953f
C584 m1_2086_6300# a_6744_3960# 0.15131f
C585 vw vbn_ref 0
C586 m1_5854_3330# a_6188_4760# -0.04998f
C587 vsrc m1_3332_6276# 0.0428f
C588 vsrc a_2000_6434# 0.03918f
C589 m1_4890_5290# a_6744_3960# 0.02467f
C590 m1_1926_4730# m1_5288_4962# 0.15503f
C591 vsrc a_2884_11174# 0.05765f
C592 m1_4306_8790# sub1 0.00248f
C593 mreset sel_adex 0.00469f
C594 m1_4306_8790# hold 0.02641f
C595 m1_2438_3470# vbn_leak 0.46089f
C596 a_2068_9320# m1_3332_6276# 0.09423f
C597 spk a_6188_4760# 0
C598 vsrc vbp_w 0.04933f
C599 a_2000_6434# a_2068_9320# 0.0439f
C600 a_2068_9320# a_2884_11174# 0.08615f
C601 en sta 0
C602 m1_5918_11806# a_3764_10978# 0.00419f
C603 m1_2328_2920# vdd 0.69638f
C604 stb m1_2438_3470# 0.08474f
C605 a_2000_6434# vbn_prb 0
C606 vw vbp_syn 0.33269f
C607 en a_5632_4760# 0.04345f
C608 vbp_w a_2068_9320# 0.00463f
C609 m1_2438_3470# a_5308_6338# 0
C610 m1_2970_10926# a_3648_6534# 0.03543f
C611 vbp_w vbn_prb 0.02631f
C612 m1_1350_9490# m1_2438_3470# 0
C613 vsrc el 0.02538f
C614 abus sel_adex 0.12528f
C615 m1_1926_4246# sel_adex 0.00179f
C616 a_6744_3960# sub1 0.10182f
C617 a_6744_3960# hold 0.11087f
C618 a_2000_6434# vbp_st 0.17679f
C619 vbp_st a_2884_11174# 0
C620 a_2068_9320# el 0.15521f
C621 a_4652_12054# vdd 1.39589f
C622 a_3648_6534# vbn_leak 0.0049f
C623 m1_3132_6402# sel_adex 0.14356f
C624 m1_3242_10610# m1_3332_6276# 0.01785f
C625 vbn_prb el 0.02417f
C626 vw a_6188_4760# 0
C627 m1_1926_4730# sel_adex 0.0056f
C628 vbp_w vbp_st 0.12207f
C629 vsrc vreset 0.05337f
C630 en a_6744_3960# 0.01537f
C631 a_2000_6434# m1_3242_10610# 0.00119f
C632 a_2884_11174# m1_3242_10610# 0.27754f
C633 sub0 vm 0.08605f
C634 m1_2328_2920# a_5992_12054# 0.05078f
C635 vdd m1_5854_3330# 0.03227f
C636 m1_2086_6300# vm 0.09302f
C637 a_2068_9320# vreset 0
C638 vbp_w m1_3242_10610# 0.00261f
C639 m1_4890_5290# vm 0.50146f
C640 m1_1350_9490# a_3648_6534# 0.03554f
C641 vbn_prb vreset 2.69704f
C642 vbp_st el 0.02522f
C643 vdd spk 2.07835f
C644 a_2000_6434# mreset 0.20665f
C645 sub0 m1_3246_10190# 0.02862f
C646 a_4652_12054# a_5992_12054# 0.02387f
C647 vdd vbn_ref 0.09151f
C648 m1_2086_6300# m1_3246_10190# 0
C649 vsrc m1_2006_10750# 0
C650 vbp_st vreset 0.05803f
C651 a_3648_6534# m1_2438_3470# 0
C652 m1_2006_10750# a_2068_9320# 0
C653 m1_5854_3330# a_5992_12054# 0
C654 abus m1_3332_6276# 0.09091f
C655 sub1 vm 0.04339f
C656 m1_2006_10750# vbn_prb 0
C657 m1_2558_10610# a_3764_10978# 0
C658 hold vm 0.13625f
C659 vbp_syn vdd 1.28339f
C660 m1_5854_3330# m1_5288_4962# 0.03829f
C661 abus a_2000_6434# 0.26079f
C662 abus a_2884_11174# 0
C663 m1_1926_4246# a_2000_6434# 0.03154f
C664 mreset el 0.01546f
C665 m1_2328_2920# sel_adex 0
C666 vw vdd 4.32642f
C667 spk a_5992_12054# 0.03802f
C668 m1_3132_6402# m1_3332_6276# 0.179f
C669 a_2000_6434# m1_5486_11870# 0
C670 en vm 0.04219f
C671 abus vbp_w 2.6138f
C672 a_2000_6434# m1_3132_6402# 0.00433f
C673 vbp_w m1_1926_4246# 0
C674 m1_3132_6402# a_2884_11174# 0
C675 m1_1926_4730# m1_3332_6276# 0.00244f
C676 m1_2970_10926# a_3764_10978# 0.00528f
C677 m1_1926_4730# a_2000_6434# 0.08926f
C678 m1_1926_4730# a_2884_11174# 0
C679 sub1 a_6424_12054# 0.00176f
C680 m1_2006_10750# vbp_st 0.14375f
C681 a_6424_12054# hold 0.22895f
C682 mreset vreset 0.09141f
C683 sub0 vsrc 0.06094f
C684 m1_3246_10190# sub1 0.03556f
C685 m1_3246_10190# hold 0.02886f
C686 m1_1926_4730# vbp_w 0
C687 m1_2086_6300# vsrc 0.06342f
C688 abus el 0.02846f
C689 vdd a_6188_4760# 0.0238f
C690 m1_5918_11806# vm 0
C691 sub0 a_2068_9320# 0.20135f
C692 m1_1926_4246# el 0
C693 vsrc m1_4890_5290# 0.28807f
C694 m1_2086_6300# a_2068_9320# 0.36445f
C695 vbp_syn a_5992_12054# 0.00304f
C696 m1_2970_10926# m1_4306_8790# 0.23292f
C697 m1_2086_6300# vbn_prb 0
C698 stb a_3764_10978# 0
C699 m1_4890_5290# a_2068_9320# 0.00277f
C700 vw a_5992_12054# 0.38116f
C701 m1_1926_4730# el 0
C702 a_3764_10978# a_5308_6338# 0.11322f
C703 abus vreset 0.03375f
C704 m1_1926_4246# vreset 0
C705 vw m1_5288_4962# 0.05626f
C706 m1_5918_11806# a_6424_12054# 0.26536f
C707 vbn_leak sta 0.07213f
C708 m1_1350_9490# a_3764_10978# 0.05051f
C709 m1_4306_8790# vbn_leak 0
C710 m1_2558_10610# a_6744_3960# 0.09207f
C711 m1_5918_11806# m1_3246_10190# 0
C712 spk sel_adex 0.03594f
C713 a_5632_4760# vbn_leak 0.17729f
C714 m1_5010_11870# hold 0
C715 m1_2086_6300# vbp_st 0.01607f
C716 stb sta 0.22715f
C717 m1_1926_4730# vreset 0
C718 stb a_5632_4760# 0.00136f
C719 vsrc sub1 0.05214f
C720 sub0 m1_3242_10610# 0.19124f
C721 m1_4306_8790# a_5308_6338# 0.02027f
C722 m1_2970_10926# a_6744_3960# 0.0432f
C723 m1_2328_2920# m1_3332_6276# 0
C724 a_5632_4760# a_5308_6338# 0
C725 m1_2328_2920# a_2000_6434# 0.70411f
C726 a_6188_4760# m1_5288_4962# 0.09203f
C727 m1_2328_2920# a_2884_11174# 0.29771f
C728 m1_1350_9490# sta 1.18025f
C729 a_2068_9320# sub1 0.15659f
C730 m1_1350_9490# m1_4306_8790# 0.21898f
C731 a_2068_9320# hold 0.00448f
C732 m1_2438_3470# a_3764_10978# 0
C733 en vsrc 0.07805f
C734 m1_4890_5290# m1_3242_10610# 0.00674f
C735 abus m1_2006_10750# 0.0036f
C736 m1_2328_2920# vbp_w 0.05086f
C737 a_6744_3960# vbn_leak 0.1105f
C738 en a_2068_9320# 0.37271f
C739 m1_5918_11806# m1_5010_11870# 0
C740 sub0 mreset 0.1382f
C741 vw sel_adex 0.05363f
C742 stb a_6744_3960# 0.42082f
C743 a_4652_12054# a_2000_6434# 0.17915f
C744 m1_2438_3470# sta 0.00464f
C745 m1_2328_2920# el 0
C746 a_6744_3960# a_5308_6338# 0.26432f
C747 vbp_st sub1 0.02032f
C748 m1_4890_5290# mreset 0.28952f
C749 vbp_st hold 0.35438f
C750 m1_1350_9490# a_6744_3960# 0.38219f
C751 a_2000_6434# m1_5854_3330# 0
C752 sub1 m1_3242_10610# 0.06743f
C753 a_3648_6534# a_3764_10978# 0.0552f
C754 m1_2558_10610# vm 0.0029f
C755 m1_3242_10610# hold 0.07683f
C756 abus sub0 0
C757 sel_adex a_6188_4760# 0
C758 m1_2328_2920# vreset 0.14892f
C759 sub0 m1_1926_4246# 0.00108f
C760 abus m1_2086_6300# 0.00188f
C761 vdd a_5992_12054# 0.71971f
C762 a_2000_6434# spk 0.19518f
C763 en m1_3242_10610# 0.03794f
C764 sub0 m1_3132_6402# 0.00109f
C765 m1_2970_10926# vm 0.06263f
C766 m1_1926_4246# m1_4890_5290# 0
C767 m1_1926_4730# sub0 0.00787f
C768 a_2000_6434# vbn_ref 0.11388f
C769 m1_4306_8790# a_3648_6534# 0.03152f
C770 m1_5918_11806# vbp_st 0.1666f
C771 mreset sub1 0
C772 m1_2558_10610# m1_3246_10190# -0.01056f
C773 el m1_5854_3330# 0.07576f
C774 vbp_w vbn_ref 0.02825f
C775 vbn_leak vm 0.32252f
C776 m1_1926_4730# m1_4890_5290# 0.1162f
C777 en mreset 0.15992f
C778 m1_2328_2920# m1_2006_10750# 0.04779f
C779 m1_2970_10926# m1_3246_10190# 0.20756f
C780 vbp_syn a_2000_6434# 0.03221f
C781 stb vm 1.38332f
C782 vbp_syn a_2884_11174# 0.04673f
C783 vw m1_3332_6276# 0
C784 a_5308_6338# vm 0.37706f
C785 vw a_2000_6434# 0.22347f
C786 el vbn_ref 0.02495f
C787 abus sub1 0.00318f
C788 vw a_2884_11174# 0.15959f
C789 vbp_syn vbp_w 2.61267f
C790 vbn_leak a_6424_12054# 0.36752f
C791 a_3648_6534# a_6744_3960# 0.30396f
C792 a_5992_12054# m1_5288_4962# 0
C793 m1_1350_9490# vm 0.28197f
C794 m1_3246_10190# vbn_leak 0.10512f
C795 vw vbp_w 0
C796 m1_5486_11870# hold 0
C797 m1_3132_6402# sub1 0.07348f
C798 abus en 0
C799 en m1_1926_4246# 0.03373f
C800 m1_1926_4730# sub1 0
C801 stb m1_3246_10190# 0
C802 a_6424_12054# a_5308_6338# 0.00703f
C803 vbn_ref vreset 2.70314f
C804 vbp_syn el 0.02387f
C805 m1_3246_10190# a_5308_6338# 0.04535f
C806 vw el 0.01708f
C807 m1_2328_2920# sub0 0.32531f
C808 m1_1926_4730# en 0.06796f
C809 m1_2558_10610# a_2068_9320# 0
C810 m1_1350_9490# m1_3246_10190# 0
C811 m1_2438_3470# vm 0.02775f
C812 m1_2086_6300# m1_2328_2920# 0.6571f
C813 vdd vss 65.30139f
C814 a_2000_6434# vss 3.09496f
C815 mreset vss 1.8764f
C816 m1_3246_10190# vss -0.2094f
C817 m1_2006_10750# vss -0.01557f
C818 vbp_st vss 1.7436f
C819 m1_3242_10610# vss 0.16837f
C820 m1_3332_6276# vss 0.30598f
C821 a_3648_6534# vss 0.49373f
C822 sub1 vss 0.83972f
C823 a_5992_12054# vss 0.45407f
C824 a_5308_6338# vss 0.43916f
C825 vsrc vss 2.73484f
C826 spk vss 4.83827f
C827 a_6424_12054# vss 0.35348f
C828 m1_4890_5290# vss 1.40702f
C829 en vss 1.50796f
C830 hold vss 0.02955f
C831 vm vss 6.33147f
C832 a_3764_10978# vss -0.17116f
C833 m1_5918_11806# vss -0.06503f
C834 m1_2558_10610# vss -0.09115f
C835 vbp_w vss 0.62576f
C836 m1_2438_3470# vss 0.58085f
C837 vbn_prb vss 0.82234f
C838 m1_2328_2920# vss 1.20734f
C839 stb vss 0.50886f
C840 m1_5010_11870# vss -0.08394f
C841 m1_5486_11870# vss -0.07911f
C842 m1_1350_9490# vss 2.21359f
C843 sta vss 1.07134f
C844 a_6188_4760# vss -0.12553f
C845 m1_5288_4962# vss 0.42629f
C846 m1_2970_10926# vss -0.08491f
C847 m1_2086_6300# vss 0.52452f
C848 m1_1926_4730# vss 0.61403f
C849 a_2884_11174# vss 1.18427f
C850 sub0 vss 1.45149f
C851 vw vss 1.88072f
C852 vbn_leak vss 4.13684f
C853 m1_1926_4246# vss 0.56693f
C854 abus vss 1.38313f
C855 vbn_ref vss 1.0987f
C856 vreset vss 0.95015f
C857 m1_3132_6402# vss -0.04671f
C858 sel_adex vss 0.61717f
C859 a_6744_3960# vss 1.24439f
C860 m1_4306_8790# vss -0.20092f
C861 vbp_syn vss 0.74145f
C862 a_4652_12054# vss 0.30065f
C863 a_5632_4760# vss -0.09724f
C864 a_2068_9320# vss -0.20687f
C865 el vss 0.58949f
C866 m1_5854_3330# vss -0.20941f
.ends
