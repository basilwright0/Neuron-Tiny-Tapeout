* NGSPICE file created from scdend_s1.ext - technology: gf180mcuD

.subckt p_w1_l0p28 w_n202_n230# a_28_n100# a_n28_n144# a_n116_n100# VSUBS
X0 a_28_n100# a_n28_n144# a_n116_n100# w_n202_n230# pfet_03v3 ad=0.44p pd=2.88u as=0.44p ps=2.88u w=1u l=0.28u
C0 a_28_n100# a_n28_n144# 0.00769f
C1 a_28_n100# w_n202_n230# 0.01808f
C2 w_n202_n230# a_n28_n144# 0.05841f
C3 a_28_n100# a_n116_n100# 0.04256f
C4 a_n116_n100# a_n28_n144# 0.00769f
C5 w_n202_n230# a_n116_n100# 0.01808f
C6 a_28_n100# VSUBS 0.0597f
C7 a_n116_n100# VSUBS 0.0597f
C8 w_n202_n230# VSUBS 0.55752f
.ends

.subckt n_w2_l4 a_400_n200# a_n400_n244# a_n488_n200# VSUBS
X0 a_400_n200# a_n400_n244# a_n488_n200# VSUBS nfet_03v3 ad=0.88p pd=4.88u as=0.88p ps=4.88u w=2u l=4u
C0 a_n400_n244# a_n488_n200# 0.07019f
C1 a_400_n200# a_n488_n200# 0.01073f
C2 a_n400_n244# a_400_n200# 0.07019f
C3 a_400_n200# VSUBS 0.41684f
C4 a_n488_n200# VSUBS 0.41684f
.ends

.subckt n_w0p5_l0p28 a_n28_n94# a_n116_n50# a_28_n50# VSUBS
X0 a_28_n50# a_n28_n94# a_n116_n50# VSUBS nfet_03v3 ad=0.22p pd=1.88u as=0.22p ps=1.88u w=0.5u l=0.28u
C0 a_n28_n94# a_n116_n50# 0.00377f
C1 a_28_n50# a_n116_n50# 0.02085f
C2 a_n28_n94# a_28_n50# 0.00377f
C3 a_28_n50# VSUBS 0.07987f
C4 a_n116_n50# VSUBS 0.07987f
.ends

.subckt n_w2_l2 a_n288_n200# a_200_n200# a_n200_n244# VSUBS
X0 a_200_n200# a_n200_n244# a_n288_n200# VSUBS nfet_03v3 ad=0.88p pd=4.88u as=0.88p ps=4.88u w=2u l=2u
C0 a_n200_n244# a_n288_n200# 0.0587f
C1 a_200_n200# a_n288_n200# 0.02133f
C2 a_n200_n244# a_200_n200# 0.0587f
C3 a_200_n200# VSUBS 0.2667f
C4 a_n288_n200# VSUBS 0.2667f
.ends

.subckt p_w1_l0p5 a_n138_n100# a_50_n100# a_n50_n144# w_n224_n230# VSUBS
X0 a_50_n100# a_n50_n144# a_n138_n100# w_n224_n230# pfet_03v3 ad=0.44p pd=2.88u as=0.44p ps=2.88u w=1u l=0.5u
C0 a_50_n100# a_n50_n144# 0.01275f
C1 a_50_n100# w_n224_n230# 0.0205f
C2 w_n224_n230# a_n50_n144# 0.07993f
C3 a_50_n100# a_n138_n100# 0.03085f
C4 a_n138_n100# a_n50_n144# 0.01275f
C5 w_n224_n230# a_n138_n100# 0.0205f
C6 a_50_n100# VSUBS 0.06546f
C7 a_n138_n100# VSUBS 0.06546f
C8 w_n224_n230# VSUBS 0.61824f
.ends

.subckt n_w0p5_l0p5 a_n138_n50# a_50_n50# a_n50_n94# VSUBS
X0 a_50_n50# a_n50_n94# a_n138_n50# VSUBS nfet_03v3 ad=0.22p pd=1.88u as=0.22p ps=1.88u w=0.5u l=0.5u
C0 a_n50_n94# a_n138_n50# 0.00625f
C1 a_50_n50# a_n138_n50# 0.01511f
C2 a_n50_n94# a_50_n50# 0.00625f
C3 a_50_n50# VSUBS 0.09639f
C4 a_n138_n50# VSUBS 0.09639f
.ends

.subckt n_w1_l0p28 a_28_n100# a_n28_n144# a_n116_n100# VSUBS
X0 a_28_n100# a_n28_n144# a_n116_n100# VSUBS nfet_03v3 ad=0.44p pd=2.88u as=0.44p ps=2.88u w=1u l=0.28u
C0 a_n28_n144# a_n116_n100# 0.00769f
C1 a_28_n100# a_n116_n100# 0.04256f
C2 a_n28_n144# a_28_n100# 0.00769f
C3 a_28_n100# VSUBS 0.09911f
C4 a_n116_n100# VSUBS 0.09911f
.ends

.subckt n_w1_l0p5 a_n138_n100# a_50_n100# a_n50_n144# VSUBS
X0 a_50_n100# a_n50_n144# a_n138_n100# VSUBS nfet_03v3 ad=0.44p pd=2.88u as=0.44p ps=2.88u w=1u l=0.5u
C0 a_n50_n144# a_n138_n100# 0.01275f
C1 a_50_n100# a_n138_n100# 0.03085f
C2 a_n50_n144# a_50_n100# 0.01275f
C3 a_50_n100# VSUBS 0.11563f
C4 a_n138_n100# VSUBS 0.11563f
.ends

.subckt n_w7p07_l7p07 a_707_n707# a_n795_n707# a_n707_n751# VSUBS
X0 a_707_n707# a_n707_n751# a_n795_n707# VSUBS nfet_03v3 ad=3.1108p pd=15.02u as=3.1108p ps=15.02u w=7.07u l=7.07u
C0 a_n707_n751# a_n795_n707# 0.27012f
C1 a_707_n707# a_n795_n707# 0.0212f
C2 a_n707_n751# a_707_n707# 0.27012f
C3 a_707_n707# VSUBS 0.84237f
C4 a_n795_n707# VSUBS 0.84237f
.ends

.subckt p_w2_l4 a_400_n200# a_n400_n244# w_n574_n330# a_n488_n200# VSUBS
X0 a_400_n200# a_n400_n244# a_n488_n200# w_n574_n330# pfet_03v3 ad=0.88p pd=4.88u as=0.88p ps=4.88u w=2u l=4u
C0 a_400_n200# a_n400_n244# 0.07019f
C1 a_400_n200# w_n574_n330# 0.07409f
C2 w_n574_n330# a_n400_n244# 0.42229f
C3 a_400_n200# a_n488_n200# 0.01073f
C4 a_n488_n200# a_n400_n244# 0.07019f
C5 w_n574_n330# a_n488_n200# 0.07409f
C6 a_400_n200# VSUBS 0.18936f
C7 a_n488_n200# VSUBS 0.18936f
C8 w_n574_n330# VSUBS 2.27304f
.ends

.subckt p_w1_l2 w_n374_n230# a_n288_n100# a_200_n100# a_n200_n144# VSUBS
X0 a_200_n100# a_n200_n144# a_n288_n100# w_n374_n230# pfet_03v3 ad=0.44p pd=2.88u as=0.44p ps=2.88u w=1u l=2u
C0 a_200_n100# a_n200_n144# 0.02905f
C1 a_200_n100# w_n374_n230# 0.03135f
C2 w_n374_n230# a_n200_n144# 0.22666f
C3 a_200_n100# a_n288_n100# 0.01056f
C4 a_n288_n100# a_n200_n144# 0.02905f
C5 w_n374_n230# a_n288_n100# 0.03135f
C6 a_200_n100# VSUBS 0.1047f
C7 a_n288_n100# VSUBS 0.1047f
C8 w_n374_n230# VSUBS 1.03224f
.ends

.subckt n_w0p22_l0p28 a_n120_n36# a_28_n22# a_n28_n66# VSUBS
X0 a_28_n22# a_n28_n66# a_n120_n36# VSUBS nfet_03v3 ad=0.1516p pd=1.64u as=0.1516p ps=1.64u w=0.22u l=0.28u
C0 a_n120_n36# a_n28_n66# 0.00187f
C1 a_28_n22# a_n28_n66# 0.00187f
C2 a_n120_n36# a_28_n22# 0.01112f
C3 a_28_n22# VSUBS 0.07856f
C4 a_n120_n36# VSUBS 0.07856f
.ends

.subckt n_w4_l2 a_n288_n400# a_200_n400# a_n200_n444# VSUBS
X0 a_200_n400# a_n200_n444# a_n288_n400# VSUBS nfet_03v3 ad=1.76p pd=8.88u as=1.76p ps=8.88u w=4u l=2u
C0 a_n200_n444# a_n288_n400# 0.11799f
C1 a_200_n400# a_n288_n400# 0.04287f
C2 a_n200_n444# a_200_n400# 0.11799f
C3 a_200_n400# VSUBS 0.34365f
C4 a_n288_n400# VSUBS 0.34365f
.ends

.subckt n_w0p22_l2 a_200_n22# a_n200_n66# a_n292_n36# VSUBS
X0 a_200_n22# a_n200_n66# a_n292_n36# VSUBS nfet_03v3 ad=0.1516p pd=1.64u as=0.1516p ps=1.64u w=0.22u l=2u
C0 a_n292_n36# a_n200_n66# 0.00705f
C1 a_200_n22# a_n200_n66# 0.00705f
C2 a_n292_n36# a_200_n22# 0.00245f
C3 a_200_n22# VSUBS 0.20767f
C4 a_n292_n36# VSUBS 0.20767f
.ends

.subckt n_w3p54_l3p54 a_354_n354# a_n354_n398# a_n442_n354# VSUBS
X0 a_354_n354# a_n354_n398# a_n442_n354# VSUBS nfet_03v3 ad=1.5576p pd=7.96u as=1.5576p ps=7.96u w=3.54u l=3.54u
C0 a_n354_n398# a_n442_n354# 0.12189f
C1 a_354_n354# a_n442_n354# 0.02161f
C2 a_n354_n398# a_354_n354# 0.12189f
C3 a_354_n354# VSUBS 0.44156f
C4 a_n442_n354# VSUBS 0.44156f
.ends

.subckt scdend_s1 vdd vss el vbn_leak vsrc vbp_st vbn_ref vreset vbn_prb vbp_syn abus
+ sel0 sel2 mreset spk en sta stb hold sc_clk vs d
XXN_Xi0_XP vdd a_4952_4114# sc_clk vdd vss p_w1_l0p28
XXY_XHL vdd d hold m1_4066_5730# vss p_w1_l0p28
XXS_XD_Xi4_XP vdd spk a_1880_6414# vdd vss p_w1_l0p28
XXS_XL_XMT m1_1704_3050# vbn_leak vss vss n_w2_l4
XXY_XMR mreset a_3024_4060# vdd vss n_w0p5_l0p28
XXS_XL_XM2 a_1780_3360# vs vs vss n_w2_l2
XXS_XL_XM1 a_488_5320# m1_702_3050# el vss n_w2_l2
XXS_XD_XPI m1_390_6230# a_788_4018# vs vdd vss p_w1_l0p5
XXS_XR_XSW vreset vs a_3024_4060# vss n_w0p5_l0p5
XXT2_XSW m1_4910_1940# sel2 abus vss n_w1_l0p28
XXS_XR_XNR a_3024_4060# vbn_ref vss vss n_w2_l4
XXS_XD_XNI vsrc a_788_4018# vs vss n_w1_l0p5
XXCD_XC vss vss d vss n_w7p07_l7p07
XXN_Xd2_XN a_6368_4114# vss a_7304_6414# vss n_w0p5_l0p28
XXN_Xd2_XP vdd a_7304_6414# a_6368_4114# vdd vss p_w1_l0p28
XXY_XWA m1_3622_4870# vbp_syn vdd m1_2718_4990# vss p_w2_l4
XXS_XL_XD2 m1_1704_3050# a_1780_3360# a_1780_3360# vss n_w2_l2
XXS_XL_XD1 m1_702_3050# m1_1704_3050# m1_702_3050# vss n_w2_l2
XXT0_XMB vss m1_3716_1916# vbn_prb vss n_w2_l2
XXN_XO2_XP1 vdd m1_6958_6230# sc_clk vdd vss p_w1_l0p28
XXY_XWB m1_3622_5730# vbp_syn vdd m1_2718_4990# vss p_w2_l4
XXN_XO2_XP2 vdd a_7756_6414# a_7304_6414# m1_6958_6230# vss p_w1_l0p28
XXS_XD_XS2 vdd vdd m1_902_6230# vbp_st vss p_w1_l2
XXS_XD_XPS vdd vdd m1_390_6230# vbp_st vss p_w1_l2
XXL1 cl m1_4066_5730# a_7304_6414# vss n_w0p22_l0p28
XXT0_XME m1_3886_1990# en m1_3716_1916# vss n_w1_l0p28
XXN_XO2_XN2 a_7304_6414# vss a_7756_6414# vss n_w0p5_l0p28
XXN_XO2_XN1 sc_clk vss a_7756_6414# vss n_w0p5_l0p28
XXL2 cl el a_5424_4114# vss n_w0p22_l0p28
XXT0_XMF m1_3886_1990# vdd vs vss n_w4_l2
XXS_XD_XP2 vdd a_1428_6414# a_788_4018# m1_902_6230# vss p_w1_l0p28
XXY_XQA vdd vss sta m1_3622_4870# vss p_w1_l0p28
XXS_XD_XP3 vdd a_1880_6414# a_1428_6414# vdd vss p_w1_l0p28
XXY_XQB vdd vss stb m1_3622_5730# vss p_w1_l0p28
XXS_XD_XN2 a_1428_6414# a_788_4018# vsrc vss n_w0p22_l2
XXN_Xd3_XN a_7756_6414# vss a_8208_6414# vss n_w0p5_l0p28
XXS_XD_XN3 a_1428_6414# vsrc a_1880_6414# vss n_w0p5_l0p28
XXY_XNA sta d m1_3622_4870# vss n_w0p5_l0p28
XXN_Xd3_XP vdd a_8208_6414# a_7756_6414# vdd vss p_w1_l0p28
XXY_XNB stb d m1_3622_5730# vss n_w0p5_l0p28
XXS_XR_XPC vdd a_3024_4060# a_2784_6414# vdd vss p_w1_l0p28
XXS_XR_Xi_XN spk vss a_2784_6414# vss n_w0p5_l0p28
XXN_XO1_XP1 vdd m1_5130_6230# a_4952_4114# vdd vss p_w1_l0p28
XXN_XO1_XP2 vdd a_5896_4114# a_5424_4114# m1_5130_6230# vss p_w1_l0p28
XXS_XR_Xi_XP vdd a_2784_6414# spk vdd vss p_w1_l0p28
XXN_XO1_XN1 a_4952_4114# vss a_5896_4114# vss n_w0p5_l0p28
XXY_XPH vdd vdd m1_2718_4990# hold vss p_w1_l2
XXA1 ca d a_7304_6414# vss n_w0p22_l0p28
XXT2_XMB vss m1_4750_1940# vbn_prb vss n_w2_l2
XXN_XO1_XN2 a_5424_4114# vss a_5896_4114# vss n_w0p5_l0p28
XXA2 ca vs a_5424_4114# vss n_w0p22_l0p28
XXT0_XSW m1_3886_1990# sel0 abus vss n_w1_l0p28
XXT2_XME m1_4910_1940# en m1_4750_1940# vss n_w1_l0p28
XXT2_XMF m1_4910_1940# vdd d vss n_w4_l2
XXN_Xd4_XN a_8208_6414# vss a_5424_4114# vss n_w0p5_l0p28
XXN_Xd1_XN a_5896_4114# vss a_6368_4114# vss n_w0p5_l0p28
XXN_Xd1_XP vdd a_6368_4114# a_5896_4114# vdd vss p_w1_l0p28
XXS_XC_XC vss vss vs vss n_w7p07_l7p07
XXN_Xd4_XP vdd a_5424_4114# a_8208_6414# vdd vss p_w1_l0p28
XXS_XD_Xi4_XN a_1880_6414# vss spk vss n_w0p5_l0p28
XXS_XL_XP1 a_488_5320# a_488_5320# vdd vdd vss p_w2_l4
XXN_Xi0_XN sc_clk vss a_4952_4114# vss n_w0p5_l0p28
XXS_XL_XP2 vs a_488_5320# vdd vdd vss p_w2_l4
XXS_XR_XCR_XC vss a_3024_4060# vss vss n_w3p54_l3p54
C0 a_4952_4114# m1_390_6230# 0.00127f
C1 m1_2718_4990# vs 0.05878f
C2 m1_4910_1940# m1_3886_1990# 0.00562f
C3 vbn_ref vdd 1.13671f
C4 vreset m1_902_6230# 0.07073f
C5 m1_3716_1916# m1_4910_1940# 0.04664f
C6 m1_3622_4870# stb 0
C7 m1_5130_6230# m1_902_6230# 0.00128f
C8 m1_2718_4990# vdd 0.70143f
C9 ca vs 0.02469f
C10 a_488_5320# m1_390_6230# 0
C11 vreset a_5896_4114# 0
C12 a_7304_6414# m1_390_6230# 0
C13 ca vdd 0.8292f
C14 sel2 m1_4910_1940# 0.05081f
C15 abus m1_3622_4870# 0.22604f
C16 a_1780_3360# d 0.00115f
C17 m1_5130_6230# a_5896_4114# 0.03177f
C18 en el 0.02268f
C19 vbp_syn m1_1704_3050# 0
C20 spk el 1.81393f
C21 cl spk 0.04173f
C22 m1_4066_5730# m1_4750_1940# 0.00132f
C23 vsrc el 0.48233f
C24 cl vsrc 0.04843f
C25 sc_clk vs 0
C26 m1_4066_5730# d 0.61476f
C27 vbp_syn vs 0.00382f
C28 a_1880_6414# m1_390_6230# 0.02011f
C29 el vbn_ref 0.03145f
C30 cl vbn_ref 0.04463f
C31 m1_3622_5730# a_4952_4114# 0.15434f
C32 sc_clk vdd 1.70129f
C33 vbp_syn vdd 2.36787f
C34 m1_2718_4990# el 0
C35 a_5424_4114# m1_390_6230# 0.28966f
C36 a_7304_6414# vbp_st 0.065f
C37 a_488_5320# a_788_4018# 0.13679f
C38 m1_4750_1940# m1_3622_4870# 0.05742f
C39 ca el 0.39873f
C40 cl ca 0.25452f
C41 m1_3622_5730# a_7304_6414# 0
C42 d m1_3622_4870# 0.53536f
C43 vs mreset 0.01686f
C44 vbn_prb vs 0.18494f
C45 vbp_st a_7756_6414# 0.03518f
C46 m1_6958_6230# m1_902_6230# 0.05081f
C47 vbn_leak sel0 0.44576f
C48 a_8208_6414# vdd 0.57726f
C49 mreset vdd 0.1579f
C50 sel0 a_6368_4114# 0
C51 vbn_prb vdd 0.06023f
C52 m1_1704_3050# sta 0.00133f
C53 a_5424_4114# vbp_st 0.03864f
C54 a_1880_6414# a_788_4018# 0
C55 sc_clk el 0.01736f
C56 vbp_syn el 0.0327f
C57 vbp_syn cl 0.04474f
C58 vbn_leak stb 0.02247f
C59 vs sta 0
C60 m1_3622_5730# a_5424_4114# 0.00141f
C61 a_6368_4114# stb 0.02808f
C62 a_488_5320# a_2784_6414# 0
C63 sta vdd 0.7183f
C64 vreset sel0 0.02752f
C65 m1_4066_5730# m1_390_6230# 0.00162f
C66 vbn_leak abus 0.02707f
C67 abus a_6368_4114# 0
C68 a_4952_4114# hold 0.16199f
C69 a_8208_6414# el 0
C70 a_8208_6414# cl 0.01371f
C71 cl mreset 0.04609f
C72 el mreset 0.0528f
C73 vreset stb 0.01273f
C74 vbn_prb el 0.04518f
C75 vbn_prb cl 0.00181f
C76 vs m1_4910_1940# 0.10189f
C77 a_1880_6414# a_2784_6414# 0.00155f
C78 m1_5130_6230# stb 0.05715f
C79 a_5896_4114# m1_902_6230# 0.00102f
C80 sel2 a_7304_6414# 0.28431f
C81 m1_390_6230# m1_3622_4870# 0
C82 m1_4910_1940# vdd 0.08781f
C83 vreset abus 0.02682f
C84 el sta 0.01301f
C85 spk a_3024_4060# 0.01277f
C86 en a_3024_4060# 0.25057f
C87 m1_3622_5730# m1_4066_5730# 0.21313f
C88 vbn_leak d 0.11417f
C89 sel2 a_7756_6414# 0.0072f
C90 a_3024_4060# vbn_ref 0.23902f
C91 sel2 a_5424_4114# 0.03746f
C92 m1_702_3050# vsrc 0.00154f
C93 m1_2718_4990# a_3024_4060# 0.05981f
C94 a_5424_4114# hold 0.00542f
C95 m1_3622_5730# m1_3622_4870# 0.0949f
C96 vreset d 0.00574f
C97 en spk 0.02881f
C98 m1_6958_6230# stb 0.0011f
C99 en vsrc 0.03731f
C100 vsrc spk 0.54379f
C101 en vbn_ref 0.01095f
C102 sc_clk a_3024_4060# 0.00223f
C103 spk vbn_ref 0.10365f
C104 vbp_syn a_3024_4060# 0.06391f
C105 vsrc vbn_ref 0.02764f
C106 en m1_2718_4990# 0.10482f
C107 m1_2718_4990# spk 0
C108 sel2 m1_4066_5730# 0.11977f
C109 m1_1704_3050# a_488_5320# 0.00215f
C110 a_1428_6414# m1_902_6230# 0.04077f
C111 a_2784_6414# m1_3622_4870# 0.00378f
C112 m1_4066_5730# hold 0.20601f
C113 ca spk 0.06795f
C114 a_4952_4114# vdd 0.79819f
C115 a_6368_4114# m1_390_6230# 0.32041f
C116 m1_3886_1990# m1_3622_4870# 0.00152f
C117 m1_2718_4990# vbn_ref 0
C118 ca vsrc 0.0764f
C119 a_488_5320# vs 0.20012f
C120 m1_902_6230# stb 0.07821f
C121 m1_3716_1916# m1_3622_4870# 0
C122 sel0 a_5896_4114# 0
C123 ca vbn_ref 0.0294f
C124 a_7304_6414# vs 0
C125 a_3024_4060# mreset 0.0255f
C126 a_488_5320# vdd 1.5468f
C127 m1_1704_3050# a_1880_6414# 0.00539f
C128 sel2 m1_3622_4870# 0.01321f
C129 a_7304_6414# vdd 1.09445f
C130 en sc_clk 0.0432f
C131 sc_clk spk 0.16281f
C132 vreset m1_390_6230# 0.09859f
C133 a_5896_4114# stb 0.30821f
C134 vbp_syn en 0.06361f
C135 vbp_syn spk 0.04487f
C136 hold m1_3622_4870# 0.00488f
C137 vbn_leak vbp_st 0.02789f
C138 sc_clk vsrc 0.08455f
C139 a_1880_6414# vs 0.00111f
C140 vbp_st a_6368_4114# 0.05077f
C141 vbp_syn vsrc 0.02769f
C142 sta a_3024_4060# 0.02337f
C143 sc_clk vbn_ref 0.19129f
C144 vbp_syn vbn_ref 0.43534f
C145 vbn_leak m1_3622_5730# 0.12593f
C146 a_1880_6414# vdd 0.85215f
C147 abus a_5896_4114# 0
C148 a_5424_4114# vs 0.00463f
C149 m1_3622_5730# a_6368_4114# 0
C150 a_7756_6414# vdd 0.50628f
C151 m1_2718_4990# sc_clk 0.12651f
C152 vbp_syn m1_2718_4990# 0.29949f
C153 a_5424_4114# vdd 1.66201f
C154 sc_clk ca 0.00159f
C155 vreset vbp_st 0.03199f
C156 a_488_5320# el 0.21638f
C157 a_8208_6414# spk 0.18091f
C158 vbp_syn ca 0.0427f
C159 spk mreset 1.68522f
C160 vbn_prb spk 0.03051f
C161 a_7304_6414# el 0.00264f
C162 a_8208_6414# vsrc 0
C163 a_7304_6414# cl 0.14066f
C164 vsrc mreset 0.03052f
C165 vbn_prb vsrc 0.0305f
C166 d m1_902_6230# 0
C167 a_3024_4060# m1_4910_1940# 0
C168 m1_3622_5730# vreset 0.00516f
C169 a_8208_6414# vbn_ref 0.03398f
C170 mreset vbn_ref 0.03027f
C171 vbn_prb vbn_ref 0.03137f
C172 m1_1704_3050# a_1780_3360# 0.2564f
C173 spk sta 0.09018f
C174 a_1880_6414# el 0.30451f
C175 en sta 0.02371f
C176 d a_5896_4114# 0
C177 vbp_syn sc_clk 0.159f
C178 a_7756_6414# el 0
C179 a_1780_3360# vs 0.05638f
C180 vbn_leak m1_3886_1990# 0
C181 cl a_7756_6414# 0.00329f
C182 vsrc sta 0.11894f
C183 a_8208_6414# ca 0.42225f
C184 ca mreset 0.05447f
C185 vbn_prb ca 0
C186 sta vbn_ref 0.0403f
C187 a_5424_4114# el 0.04034f
C188 vbn_leak m1_3716_1916# 0.00146f
C189 a_1780_3360# vdd 0.00134f
C190 cl a_5424_4114# 0.5137f
C191 m1_4066_5730# vs 0.0361f
C192 m1_2718_4990# sta 0.06971f
C193 vbn_leak sel2 0.49812f
C194 m1_4066_5730# vdd 0.34738f
C195 sel0 stb 0.10658f
C196 sel2 a_6368_4114# 0
C197 vbn_leak hold 0
C198 vreset a_2784_6414# 0.04262f
C199 ca sta 0
C200 en m1_4910_1940# 0
C201 a_6368_4114# hold 0
C202 m1_1704_3050# m1_3622_4870# 0.02697f
C203 vbp_syn a_8208_6414# 0.04707f
C204 vbp_syn mreset 0.03382f
C205 vbp_syn vbn_prb 1.68839f
C206 m1_4910_1940# vbn_ref 0
C207 vs m1_3622_4870# 0.21794f
C208 sel0 abus 2.03518f
C209 vbp_st m1_6958_6230# 0
C210 m1_902_6230# m1_390_6230# 1.08366f
C211 sel2 vreset 0.02846f
C212 a_1780_3360# el 0.01239f
C213 m1_3622_4870# vdd 0.3535f
C214 sc_clk sta 0.33931f
C215 vreset hold 0.02604f
C216 abus stb 0.2706f
C217 vbp_syn sta 0.02296f
C218 m1_5130_6230# hold 0.00819f
C219 m1_4066_5730# el 0.00225f
C220 m1_4066_5730# cl 0.07507f
C221 a_8208_6414# mreset 0
C222 a_5896_4114# m1_390_6230# 0.03664f
C223 vbn_prb mreset 0.04733f
C224 sel0 m1_4750_1940# 0.00191f
C225 vbp_st m1_902_6230# 0.10327f
C226 sel0 d 0.00198f
C227 a_488_5320# a_3024_4060# 0
C228 m1_3622_5730# m1_902_6230# 0
C229 a_7304_6414# a_3024_4060# 0.0205f
C230 m1_4750_1940# stb 0
C231 a_788_4018# m1_902_6230# 0.14452f
C232 m1_702_3050# a_488_5320# 0.13275f
C233 vbp_st a_5896_4114# 0.003f
C234 d stb 0.02932f
C235 abus m1_4750_1940# 0.04052f
C236 m1_3622_5730# a_5896_4114# 0.02467f
C237 abus d 0.04191f
C238 vbn_leak m1_1704_3050# 0.07638f
C239 en a_4952_4114# 0.00134f
C240 m1_4910_1940# mreset 0
C241 vbn_prb m1_4910_1940# 0
C242 a_5424_4114# a_3024_4060# 0
C243 vbn_leak vs 0.01483f
C244 a_4952_4114# vbn_ref 0.00466f
C245 en a_488_5320# 0.00923f
C246 a_488_5320# spk 0.07767f
C247 vbn_leak vdd 0.10285f
C248 a_2784_6414# m1_902_6230# 0.0195f
C249 a_4952_4114# m1_2718_4990# 0.19381f
C250 a_488_5320# vsrc 0.30825f
C251 a_7304_6414# spk 0.06892f
C252 a_6368_4114# vdd 0.73851f
C253 sta m1_4910_1940# 0.00595f
C254 vreset m1_1704_3050# 0
C255 a_7304_6414# vsrc 0
C256 a_7304_6414# vbn_ref 0.0862f
C257 d m1_4750_1940# 0.22728f
C258 m1_2718_4990# a_488_5320# 0
C259 vreset vs 0.06324f
C260 a_1428_6414# m1_390_6230# 0.04049f
C261 en a_1880_6414# 0.00162f
C262 a_1880_6414# spk 0.08974f
C263 spk a_7756_6414# 0.1539f
C264 a_1880_6414# vsrc 0.03542f
C265 vreset vdd 0.80615f
C266 m1_902_6230# hold 0.01745f
C267 a_1780_3360# a_3024_4060# 0
C268 vsrc a_7756_6414# 0.00123f
C269 m1_390_6230# stb 0.07702f
C270 m1_5130_6230# vdd 0.07271f
C271 a_5424_4114# spk 0.2386f
C272 a_7304_6414# ca 0.05286f
C273 a_7756_6414# vbn_ref 0.04643f
C274 a_4952_4114# sc_clk 0.1648f
C275 vbn_leak el 1.68521f
C276 a_5424_4114# vsrc 0.19178f
C277 vbn_leak cl 0.10227f
C278 m1_702_3050# a_1780_3360# 0.02162f
C279 sel2 a_5896_4114# 0
C280 a_1880_6414# m1_2718_4990# 0
C281 vbp_syn a_4952_4114# 0.02921f
C282 m1_4066_5730# a_3024_4060# 0.25013f
C283 a_6368_4114# el 0
C284 a_5896_4114# hold 0.09518f
C285 a_5424_4114# vbn_ref 0.0927f
C286 sel0 vbp_st 0.02733f
C287 m1_2718_4990# a_5424_4114# 0.03856f
C288 vbp_syn a_488_5320# 0.00704f
C289 ca a_7756_6414# 0.31291f
C290 m1_3622_5730# sel0 0.06621f
C291 a_7304_6414# sc_clk 0.23225f
C292 vbp_syn a_7304_6414# 0.04844f
C293 vbp_st stb 0.01684f
C294 a_1428_6414# a_788_4018# 0.03815f
C295 a_5424_4114# ca 0.39946f
C296 vreset el 0.58079f
C297 vreset cl 0.04287f
C298 a_3024_4060# m1_3622_4870# 0.10827f
C299 en a_1780_3360# 0.00732f
C300 a_1780_3360# spk 0.00645f
C301 m1_3622_5730# stb 0.12122f
C302 abus vbp_st 0.02644f
C303 vbp_syn a_1880_6414# 0
C304 sc_clk a_7756_6414# 0.01728f
C305 vbp_syn a_7756_6414# 0.04399f
C306 en m1_4066_5730# 0.00841f
C307 d m1_390_6230# 0.00263f
C308 a_5424_4114# sc_clk 0.14373f
C309 m1_3622_5730# abus 0.1051f
C310 a_7304_6414# a_8208_6414# 0
C311 a_7304_6414# mreset 0.10381f
C312 a_4952_4114# sta 0.21426f
C313 vbp_syn a_5424_4114# 0.09086f
C314 vbn_prb a_7304_6414# 0
C315 m1_6958_6230# vdd 0.06933f
C316 m1_4066_5730# vbn_ref 0.07908f
C317 sel0 m1_3886_1990# 0.02099f
C318 m1_4066_5730# m1_2718_4990# 0.05027f
C319 a_8208_6414# a_7756_6414# 0.11584f
C320 spk m1_3622_4870# 0
C321 en m1_3622_4870# 0.25151f
C322 a_7304_6414# sta 0
C323 a_7756_6414# mreset 0
C324 d vbp_st 0
C325 a_8208_6414# a_5424_4114# 0.1049f
C326 a_5424_4114# mreset 0.10104f
C327 sel2 sel0 1.97038f
C328 m1_3622_4870# vbn_ref 0.01842f
C329 vbn_prb a_5424_4114# 0
C330 m1_3622_5730# m1_4750_1940# 0
C331 vs m1_902_6230# 0.02112f
C332 m1_3716_1916# stb 0
C333 m1_3622_5730# d 0.12915f
C334 m1_2718_4990# m1_3622_4870# 0.31058f
C335 abus m1_3886_1990# 0.19851f
C336 m1_902_6230# vdd 1.63507f
C337 sel2 stb 0.06372f
C338 m1_4066_5730# sc_clk 0.27896f
C339 abus m1_3716_1916# 0
C340 a_5424_4114# sta 0.12071f
C341 hold stb 0.18389f
C342 vbp_syn m1_4066_5730# 0.10662f
C343 a_5896_4114# vdd 0.55103f
C344 vbn_leak a_3024_4060# 0.30686f
C345 sel2 abus 0.07943f
C346 a_6368_4114# a_3024_4060# 0
C347 sc_clk m1_3622_4870# 0.0056f
C348 m1_4750_1940# m1_3886_1990# 0.05974f
C349 vbp_syn m1_3622_4870# 0.14442f
C350 el m1_902_6230# 0.03948f
C351 d m1_3886_1990# 0.10464f
C352 m1_4066_5730# mreset 0.02155f
C353 vbn_prb m1_4066_5730# 0.00343f
C354 m1_3716_1916# m1_4750_1940# 0.14519f
C355 vreset a_3024_4060# 0.34564f
C356 m1_3716_1916# d 0.34593f
C357 vbp_st m1_390_6230# 0.1533f
C358 sel2 m1_4750_1940# 0
C359 vbn_leak spk 0.02882f
C360 sel2 d 0
C361 vbn_leak en 0.04778f
C362 m1_4066_5730# sta 0.02863f
C363 m1_3622_5730# m1_390_6230# 0
C364 a_788_4018# m1_390_6230# 0.08223f
C365 d hold 0.24078f
C366 vbn_leak vsrc 1.68274f
C367 vsrc a_6368_4114# 0
C368 vbn_leak vbn_ref 0.38677f
C369 a_6368_4114# vbn_ref 0.13524f
C370 vbn_leak m1_2718_4990# 0.01029f
C371 m1_1704_3050# a_1428_6414# 0.00917f
C372 vreset en 0.12028f
C373 sel0 vs 0
C374 vreset spk 0.25243f
C375 sta m1_3622_4870# 0.05675f
C376 vbn_leak ca 0.0337f
C377 m1_4066_5730# m1_4910_1940# 0.00191f
C378 m1_3622_5730# vbp_st 0
C379 a_1428_6414# vs 0.00155f
C380 vreset vsrc 0.89379f
C381 sel0 vdd 0.07919f
C382 vreset vbn_ref 1.68927f
C383 a_1428_6414# vdd 0.78673f
C384 a_2784_6414# m1_390_6230# 0.01231f
C385 vs stb 0
C386 vreset m1_2718_4990# 0.11078f
C387 vdd stb 0.83285f
C388 vbn_leak sc_clk 0.00975f
C389 vbn_leak vbp_syn 0.02954f
C390 sc_clk a_6368_4114# 0.11068f
C391 vreset ca 0.11485f
C392 m1_4910_1940# m1_3622_4870# 0.15806f
C393 abus vs 0.01654f
C394 vbp_syn a_6368_4114# 0.03037f
C395 a_4952_4114# a_5424_4114# 0.02548f
C396 abus vdd 0.07736f
C397 a_1880_6414# a_488_5320# 0.10119f
C398 m1_390_6230# hold 0.05808f
C399 sel0 el 0.0283f
C400 a_7304_6414# a_7756_6414# 0.43144f
C401 sel0 cl 0.05881f
C402 a_1428_6414# el 0.07334f
C403 vreset sc_clk 0.02618f
C404 vbp_syn vreset 0.1347f
C405 m1_3622_5730# a_2784_6414# 0
C406 a_2784_6414# a_788_4018# 0
C407 m1_5130_6230# sc_clk 0.00108f
C408 a_7304_6414# a_5424_4114# 0.23186f
C409 vbn_leak a_8208_6414# 0.00454f
C410 vbn_leak mreset 0.03144f
C411 vbn_leak vbn_prb 0.03049f
C412 m1_1704_3050# d 0.04671f
C413 m1_902_6230# a_3024_4060# 0.01003f
C414 m1_5130_6230# vbp_syn 0.00432f
C415 el stb 0.08859f
C416 cl stb 0
C417 sel2 vbp_st 0.02846f
C418 vs m1_4750_1940# 0.26012f
C419 m1_6958_6230# spk 0.00367f
C420 d vs 0.93093f
C421 vbp_st hold 0.00685f
C422 m1_4750_1940# vdd 0.12279f
C423 abus el 0.03209f
C424 abus cl 0.03046f
C425 m1_3622_5730# sel2 0.10854f
C426 a_5424_4114# a_7756_6414# 0.00669f
C427 m1_6958_6230# vbn_ref 0.01892f
C428 d vdd 0.35656f
C429 vbn_leak sta 0.05496f
C430 m1_3622_5730# hold 0.04358f
C431 vreset a_8208_6414# 0
C432 vreset mreset 0.03135f
C433 vbn_prb vreset 1.68844f
C434 m1_4066_5730# a_4952_4114# 0.0524f
C435 a_488_5320# a_1780_3360# 0.00302f
C436 en m1_902_6230# 0.01961f
C437 spk m1_902_6230# 0.15574f
C438 m1_4066_5730# a_7304_6414# 0.01175f
C439 vreset sta 0.04331f
C440 m1_3716_1916# m1_3886_1990# 0.06608f
C441 vsrc m1_902_6230# 0.18936f
C442 m1_5130_6230# sta 0.05725f
C443 el m1_4750_1940# 0.00194f
C444 a_4952_4114# m1_3622_4870# 0
C445 a_1880_6414# a_1780_3360# 0.0077f
C446 cl m1_4750_1940# 0
C447 m1_902_6230# vbn_ref 0.03618f
C448 d el 0.04397f
C449 spk a_5896_4114# 0
C450 cl d 0.00319f
C451 en a_5896_4114# 0
C452 sc_clk m1_6958_6230# 0.02407f
C453 m1_2718_4990# m1_902_6230# 0
C454 vsrc a_5896_4114# 0
C455 sel2 m1_3716_1916# 0
C456 a_5896_4114# vbn_ref 0.03984f
C457 ca m1_902_6230# 0.00497f
C458 a_7304_6414# m1_3622_4870# 0
C459 vs m1_390_6230# 0.15478f
C460 m1_4066_5730# a_5424_4114# 0
C461 m1_2718_4990# a_5896_4114# 0.14786f
C462 m1_390_6230# vdd 1.7696f
C463 sel0 a_3024_4060# 0.30774f
C464 sc_clk m1_902_6230# 0.44649f
C465 vbp_syn m1_902_6230# 0.03909f
C466 vbp_st vs 0.00109f
C467 m1_702_3050# a_1428_6414# 0.00958f
C468 a_3024_4060# stb 0.04378f
C469 sc_clk a_5896_4114# 0
C470 vbp_st vdd 1.56632f
C471 m1_3622_5730# vs 0
C472 vbp_syn a_5896_4114# 0.05153f
C473 a_788_4018# vs 0.32275f
C474 el m1_390_6230# 0.07648f
C475 m1_3622_5730# vdd 0.52994f
C476 abus a_3024_4060# 0.0825f
C477 a_788_4018# vdd 0.44339f
C478 vbn_leak a_4952_4114# 0.0117f
C479 sel0 spk 0.03187f
C480 en sel0 0.22819f
C481 a_1428_6414# spk 0.00205f
C482 sel0 vsrc 0.02729f
C483 m1_1704_3050# a_2784_6414# 0
C484 a_1428_6414# vsrc 0.43537f
C485 sta m1_902_6230# 0.58087f
C486 vbp_st el 0.03196f
C487 sel0 vbn_ref 0.03314f
C488 cl vbp_st 0.04511f
C489 spk stb 0.08863f
C490 m1_4066_5730# m1_3622_4870# 0.09232f
C491 vbn_leak a_7304_6414# 0.19454f
C492 en stb 0.00936f
C493 a_2784_6414# vs 0.2323f
C494 m1_1704_3050# m1_3716_1916# 0
C495 a_7304_6414# a_6368_4114# 0.06846f
C496 vs m1_3886_1990# 0.26561f
C497 vsrc stb 0.00803f
C498 vreset a_4952_4114# 0
C499 m1_4750_1940# a_3024_4060# 0.00217f
C500 m1_3622_5730# el 0
C501 m1_3622_5730# cl 0
C502 a_788_4018# el 0.02051f
C503 m1_5130_6230# a_4952_4114# 0.0361f
C504 vbn_ref stb 0.03433f
C505 a_2784_6414# vdd 0.68185f
C506 m1_3716_1916# vs 0.19044f
C507 d a_3024_4060# 0.3292f
C508 a_5896_4114# sta 0.26359f
C509 m1_3886_1990# vdd 0
C510 abus spk 0.03161f
C511 en abus 0.07911f
C512 sel0 ca 0.02924f
C513 m1_2718_4990# stb 0.00534f
C514 abus vsrc 0.02637f
C515 vbn_leak a_7756_6414# 0.02799f
C516 m1_3716_1916# vdd 0.31653f
C517 sel2 vs 0
C518 vreset a_7304_6414# 0
C519 abus vbn_ref 0.02761f
C520 ca stb 0.02532f
C521 vbn_leak a_5424_4114# 0.05655f
C522 a_5424_4114# a_6368_4114# 0.04444f
C523 sel2 vdd 0.07937f
C524 sel0 sc_clk 0
C525 hold vdd 1.21963f
C526 vbp_syn sel0 0.02838f
C527 abus ca 0.03124f
C528 vreset a_7756_6414# 0
C529 en m1_4750_1940# 0.02073f
C530 a_2784_6414# el 0.01107f
C531 sc_clk stb 0.17977f
C532 en d 0.22536f
C533 vbp_syn stb 0.02083f
C534 vreset a_5424_4114# 0.00861f
C535 d vsrc 0
C536 m1_5130_6230# a_5424_4114# -0.00138f
C537 m1_4750_1940# vbn_ref 0
C538 d vbn_ref 0
C539 abus sc_clk 0
C540 sel0 a_8208_6414# 0
C541 vbp_syn abus 1.68458f
C542 sel2 el 0.03285f
C543 sel0 mreset 0.05368f
C544 sel2 cl 0.1829f
C545 vbn_prb sel0 0.02777f
C546 m1_2718_4990# d 0.12433f
C547 a_3024_4060# m1_390_6230# 0.00352f
C548 el hold 0.01493f
C549 vbn_leak m1_4066_5730# 0.04717f
C550 ca d 0.03908f
C551 mreset stb 0.01453f
C552 vbn_prb stb 0
C553 sel0 sta 0.03337f
C554 a_7304_6414# m1_6958_6230# 0.05273f
C555 a_8208_6414# abus 0
C556 abus mreset 0.72597f
C557 vbn_prb abus 0.02743f
C558 vbn_leak m1_3622_4870# 0.08397f
C559 vreset m1_4066_5730# 0
C560 sc_clk d 0.05806f
C561 sta stb 1.30952f
C562 a_4952_4114# m1_902_6230# 0.00218f
C563 vbp_syn d 0.09358f
C564 m1_1704_3050# vs 0.20076f
C565 m1_6958_6230# a_7756_6414# 0
C566 m1_3622_5730# a_3024_4060# 0.32486f
C567 spk m1_390_6230# 0.07275f
C568 en m1_390_6230# 0.0284f
C569 abus sta 0.15799f
C570 sel0 m1_4910_1940# 0
C571 vsrc m1_390_6230# 0.08791f
C572 a_488_5320# m1_902_6230# 0.0042f
C573 a_4952_4114# a_5896_4114# 0.07587f
C574 m1_702_3050# a_788_4018# 0.00272f
C575 m1_390_6230# vbn_ref 0.00761f
C576 a_7304_6414# m1_902_6230# 0.22655f
C577 vs vdd 1.0097f
C578 vreset m1_3622_4870# 0.1424f
C579 m1_4750_1940# mreset 0
C580 vbn_prb m1_4750_1940# 0.21694f
C581 m1_4910_1940# stb 0
C582 m1_2718_4990# m1_390_6230# 0.00357f
C583 d mreset 0.00786f
C584 vbn_prb d 0.20971f
C585 a_7304_6414# a_5896_4114# 0.00645f
C586 a_1880_6414# m1_902_6230# 0.0101f
C587 vbp_st spk 0.02918f
C588 a_7756_6414# m1_902_6230# 0
C589 abus m1_4910_1940# 0.27046f
C590 vsrc vbp_st 1.68477f
C591 sta m1_4750_1940# 0
C592 a_2784_6414# a_3024_4060# 0.23332f
C593 m1_3622_5730# spk 0
C594 a_5424_4114# m1_902_6230# 0.17382f
C595 m1_1704_3050# el 0.02068f
C596 vbp_st vbn_ref 1.73342f
C597 m1_3622_5730# en 0.0238f
C598 a_3024_4060# m1_3886_1990# 0.1047f
C599 d sta 0.02924f
C600 spk a_788_4018# 0.00482f
C601 m1_3716_1916# a_3024_4060# 0.48967f
C602 m1_2718_4990# vbp_st 0.00114f
C603 vsrc a_788_4018# 0.58492f
C604 vs el 0.42148f
C605 cl vs 0.01751f
C606 m1_3622_5730# vbn_ref 0.12872f
C607 sc_clk m1_390_6230# 0.18827f
C608 vbp_syn m1_390_6230# 0.03726f
C609 a_5424_4114# a_5896_4114# 0.53098f
C610 ca vbp_st 0.02761f
C611 el vdd 0.43684f
C612 sel2 a_3024_4060# 0.17759f
C613 m1_3622_5730# m1_2718_4990# 0.09974f
C614 cl vdd 0.37539f
C615 a_3024_4060# hold 0
C616 m1_4750_1940# m1_4910_1940# 0.15408f
C617 vbn_leak a_6368_4114# 0.00386f
C618 d m1_4910_1940# 0.31758f
C619 a_2784_6414# spk 0.0702f
C620 en a_2784_6414# 0.0105f
C621 sc_clk vbp_st 0.07344f
C622 en m1_3886_1990# 0.0601f
C623 vbp_syn vbp_st 0.35277f
C624 m1_4066_5730# m1_902_6230# 0
C625 en m1_3716_1916# 0.0332f
C626 vbn_leak vreset 0.02535f
C627 m1_3622_5730# sc_clk 0.16696f
C628 m1_3886_1990# vbn_ref 0
C629 vreset a_6368_4114# 0
C630 cl el 0.49113f
C631 vbp_syn m1_3622_5730# 0.46174f
C632 m1_2718_4990# a_2784_6414# 0.05655f
C633 a_4952_4114# stb 0.08307f
C634 sel2 spk 0.06363f
C635 sel2 en 0.00546f
C636 a_1428_6414# a_488_5320# 0.29565f
C637 sta m1_390_6230# 0.02513f
C638 m1_4066_5730# a_5896_4114# 0
C639 sel0 a_7304_6414# 0.13001f
C640 en hold 0.19469f
C641 spk hold 0.0162f
C642 sel2 vsrc 0.02852f
C643 a_8208_6414# vbp_st 0.033f
C644 vsrc hold 0.05089f
C645 vbp_st mreset 0.03062f
C646 sel2 vbn_ref 0.0288f
C647 vbn_prb vbp_st 0.03071f
C648 m1_902_6230# m1_3622_4870# 0.00475f
C649 hold vbn_ref 0
C650 a_7304_6414# stb 0.01086f
C651 m1_3622_5730# mreset 0
C652 sel0 a_7756_6414# 0
C653 a_1880_6414# a_1428_6414# 0.16718f
C654 vbn_prb m1_3622_5730# 0
C655 m1_2718_4990# hold 0.07827f
C656 sel2 ca 0.04876f
C657 a_5896_4114# m1_3622_4870# 0
C658 vbp_st sta 0
C659 sel0 a_5424_4114# 0.06964f
C660 a_7304_6414# abus 0.33428f
C661 vbp_syn a_2784_6414# 0.02102f
C662 a_7756_6414# stb 0
C663 m1_3622_5730# sta 0.08867f
C664 m1_1704_3050# a_3024_4060# 0.23172f
C665 a_5424_4114# stb 0.59783f
C666 a_4952_4114# d 0
C667 sel2 sc_clk 0
C668 abus a_7756_6414# 0
C669 vs a_3024_4060# 0.19486f
C670 vbp_syn sel2 0.02879f
C671 m1_1704_3050# m1_702_3050# 0.01963f
C672 sc_clk hold 0.41798f
C673 vbp_syn hold 0.20036f
C674 abus a_5424_4114# 0.07856f
C675 a_3024_4060# vdd 0.55093f
C676 m1_702_3050# vs 0.11218f
C677 vbn_prb m1_3886_1990# 0
C678 a_7304_6414# d 0.00548f
C679 m1_3622_5730# m1_4910_1940# 0
C680 m1_702_3050# vdd 0.00154f
C681 vbn_prb m1_3716_1916# 0.161f
C682 m1_4066_5730# sel0 0.30861f
C683 sel2 a_8208_6414# 0
C684 a_2784_6414# sta 0.00688f
C685 sel2 mreset 1.68732f
C686 vbn_prb sel2 0.02856f
C687 sta m1_3886_1990# 0
C688 m1_1704_3050# spk 0.00227f
C689 m1_1704_3050# en 0.06862f
C690 m1_1704_3050# vsrc 0
C691 en vs 0.07489f
C692 a_6368_4114# m1_902_6230# 0.0084f
C693 spk vs 8.37959f
C694 m1_4066_5730# stb 0.15325f
C695 m1_1704_3050# vbn_ref 0
C696 cl a_3024_4060# 0
C697 a_5424_4114# d 0.00243f
C698 vsrc vs 0.28395f
C699 en vdd 0.30696f
C700 spk vdd 3.51272f
C701 sel2 sta 0.16203f
C702 vs vbn_ref 0
C703 sel0 m1_3622_4870# 0.1395f
C704 vbn_leak a_5896_4114# 0.01421f
C705 sta hold 0.09489f
C706 vsrc vdd 1.24981f
C707 m1_4066_5730# abus 0.17615f
C708 m1_702_3050# el 0.15588f
C709 a_6368_4114# a_5896_4114# 0.07971f
C710 a_3024_4060# vss 1.70891f
C711 a_4952_4114# vss 0.2407f
C712 sc_clk vss 0.46639f
C713 a_488_5320# vss -0.06919f
C714 spk vss 2.43427f
C715 vs vss 7.77619f
C716 a_6368_4114# vss 0.22798f
C717 m1_4910_1940# vss 0.04639f
C718 m1_4750_1940# vss 0.53178f
C719 abus vss 0.69436f
C720 sel0 vss 0.09463f
C721 ca vss 10.63948f
C722 hold vss 0.10565f
C723 a_5896_4114# vss 0.42854f
C724 m1_5130_6230# vss -0.09115f
C725 a_2784_6414# vss 0.02015f
C726 m1_3622_5730# vss 0.48582f
C727 stb vss 0.92633f
C728 m1_3622_4870# vss 0.91993f
C729 sta vss 0.79311f
C730 a_1880_6414# vss 0.28572f
C731 a_8208_6414# vss 0.23334f
C732 a_1428_6414# vss 0.13858f
C733 vdd vss 58.23761f
C734 el vss 2.31119f
C735 a_5424_4114# vss 0.8175f
C736 a_7756_6414# vss 0.47893f
C737 m1_3886_1990# vss 0.19928f
C738 m1_3716_1916# vss 0.75743f
C739 en vss 1.28945f
C740 m1_4066_5730# vss 0.97575f
C741 a_7304_6414# vss 1.33313f
C742 cl vss 5.73516f
C743 m1_390_6230# vss 0.15895f
C744 vbp_st vss 0.02433f
C745 m1_902_6230# vss 0.00694f
C746 m1_6958_6230# vss -0.09115f
C747 vbn_prb vss 0.89402f
C748 m1_1704_3050# vss 0.7171f
C749 m1_702_3050# vss 0.07195f
C750 a_1780_3360# vss 0.2747f
C751 m1_2718_4990# vss 0.32625f
C752 vbp_syn vss 0
C753 d vss 3.23026f
C754 a_788_4018# vss 0.21517f
C755 vsrc vss 1.29676f
C756 vbn_ref vss 1.20375f
C757 sel2 vss 1.21821f
C758 vreset vss 0.31179f
C759 mreset vss 1.76625f
C760 vbn_leak vss 1.34325f
.ends
