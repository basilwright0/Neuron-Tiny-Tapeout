* NGSPICE file created from scdend_s1w.ext - technology: gf180mcuD

.subckt p_w1_l0p28 w_n202_n230# a_28_n100# a_n28_n144# a_n116_n100# VSUBS
X0 a_28_n100# a_n28_n144# a_n116_n100# w_n202_n230# pfet_03v3 ad=0.44p pd=2.88u as=0.44p ps=2.88u w=1u l=0.28u
C0 w_n202_n230# a_n28_n144# 0.05841f
C1 w_n202_n230# a_n116_n100# 0.01808f
C2 w_n202_n230# a_28_n100# 0.01808f
C3 a_n28_n144# a_n116_n100# 0.00769f
C4 a_n28_n144# a_28_n100# 0.00769f
C5 a_n116_n100# a_28_n100# 0.04256f
C6 a_28_n100# VSUBS 0.0597f
C7 a_n116_n100# VSUBS 0.0597f
C8 w_n202_n230# VSUBS 0.55752f
.ends

.subckt n_w2_l4 a_400_n200# a_n400_n244# a_n488_n200# VSUBS
X0 a_400_n200# a_n400_n244# a_n488_n200# VSUBS nfet_03v3 ad=0.88p pd=4.88u as=0.88p ps=4.88u w=2u l=4u
C0 a_n400_n244# a_n488_n200# 0.07019f
C1 a_n400_n244# a_400_n200# 0.07019f
C2 a_n488_n200# a_400_n200# 0.01073f
C3 a_400_n200# VSUBS 0.41684f
C4 a_n488_n200# VSUBS 0.41684f
.ends

.subckt n_w0p5_l0p28 a_n28_n94# a_n116_n50# a_28_n50# VSUBS
X0 a_28_n50# a_n28_n94# a_n116_n50# VSUBS nfet_03v3 ad=0.22p pd=1.88u as=0.22p ps=1.88u w=0.5u l=0.28u
C0 a_n28_n94# a_n116_n50# 0.00377f
C1 a_n28_n94# a_28_n50# 0.00377f
C2 a_n116_n50# a_28_n50# 0.02085f
C3 a_28_n50# VSUBS 0.07987f
C4 a_n116_n50# VSUBS 0.07987f
.ends

.subckt n_w2_l2 a_n288_n200# a_200_n200# a_n200_n244# VSUBS
X0 a_200_n200# a_n200_n244# a_n288_n200# VSUBS nfet_03v3 ad=0.88p pd=4.88u as=0.88p ps=4.88u w=2u l=2u
C0 a_n200_n244# a_n288_n200# 0.0587f
C1 a_n200_n244# a_200_n200# 0.0587f
C2 a_n288_n200# a_200_n200# 0.02133f
C3 a_200_n200# VSUBS 0.2667f
C4 a_n288_n200# VSUBS 0.2667f
.ends

.subckt p_w1_l0p5 a_n138_n100# a_50_n100# a_n50_n144# w_n224_n230# VSUBS
X0 a_50_n100# a_n50_n144# a_n138_n100# w_n224_n230# pfet_03v3 ad=0.44p pd=2.88u as=0.44p ps=2.88u w=1u l=0.5u
C0 w_n224_n230# a_n50_n144# 0.07993f
C1 w_n224_n230# a_n138_n100# 0.0205f
C2 w_n224_n230# a_50_n100# 0.0205f
C3 a_n50_n144# a_n138_n100# 0.01275f
C4 a_n50_n144# a_50_n100# 0.01275f
C5 a_n138_n100# a_50_n100# 0.03085f
C6 a_50_n100# VSUBS 0.06546f
C7 a_n138_n100# VSUBS 0.06546f
C8 w_n224_n230# VSUBS 0.61824f
.ends

.subckt n_w0p5_l0p5 a_n138_n50# a_50_n50# a_n50_n94# VSUBS
X0 a_50_n50# a_n50_n94# a_n138_n50# VSUBS nfet_03v3 ad=0.22p pd=1.88u as=0.22p ps=1.88u w=0.5u l=0.5u
C0 a_n50_n94# a_n138_n50# 0.00625f
C1 a_n50_n94# a_50_n50# 0.00625f
C2 a_n138_n50# a_50_n50# 0.01511f
C3 a_50_n50# VSUBS 0.09639f
C4 a_n138_n50# VSUBS 0.09639f
.ends

.subckt n_w1_l0p28 a_28_n100# a_n28_n144# a_n116_n100# VSUBS
X0 a_28_n100# a_n28_n144# a_n116_n100# VSUBS nfet_03v3 ad=0.44p pd=2.88u as=0.44p ps=2.88u w=1u l=0.28u
C0 a_n28_n144# a_n116_n100# 0.00769f
C1 a_n28_n144# a_28_n100# 0.00769f
C2 a_n116_n100# a_28_n100# 0.04256f
C3 a_28_n100# VSUBS 0.09911f
C4 a_n116_n100# VSUBS 0.09911f
.ends

.subckt n_w1_l0p5 a_n138_n100# a_50_n100# a_n50_n144# VSUBS
X0 a_50_n100# a_n50_n144# a_n138_n100# VSUBS nfet_03v3 ad=0.44p pd=2.88u as=0.44p ps=2.88u w=1u l=0.5u
C0 a_n50_n144# a_n138_n100# 0.01275f
C1 a_n50_n144# a_50_n100# 0.01275f
C2 a_n138_n100# a_50_n100# 0.03085f
C3 a_50_n100# VSUBS 0.11563f
C4 a_n138_n100# VSUBS 0.11563f
.ends

.subckt n_w7p07_l7p07 a_707_n707# a_n795_n707# a_n707_n751# VSUBS
X0 a_707_n707# a_n707_n751# a_n795_n707# VSUBS nfet_03v3 ad=3.1108p pd=15.02u as=3.1108p ps=15.02u w=7.07u l=7.07u
C0 a_n707_n751# a_n795_n707# 0.27012f
C1 a_n707_n751# a_707_n707# 0.27012f
C2 a_n795_n707# a_707_n707# 0.0212f
C3 a_707_n707# VSUBS 0.84237f
C4 a_n795_n707# VSUBS 0.84237f
.ends

.subckt p_w2_l4 a_400_n200# a_n400_n244# w_n574_n330# a_n488_n200# VSUBS
X0 a_400_n200# a_n400_n244# a_n488_n200# w_n574_n330# pfet_03v3 ad=0.88p pd=4.88u as=0.88p ps=4.88u w=2u l=4u
C0 w_n574_n330# a_n400_n244# 0.42229f
C1 w_n574_n330# a_n488_n200# 0.07409f
C2 w_n574_n330# a_400_n200# 0.07409f
C3 a_n400_n244# a_n488_n200# 0.07019f
C4 a_n400_n244# a_400_n200# 0.07019f
C5 a_n488_n200# a_400_n200# 0.01073f
C6 a_400_n200# VSUBS 0.18936f
C7 a_n488_n200# VSUBS 0.18936f
C8 w_n574_n330# VSUBS 2.27304f
.ends

.subckt p_w1_l2 w_n374_n230# a_n288_n100# a_200_n100# a_n200_n144# VSUBS
X0 a_200_n100# a_n200_n144# a_n288_n100# w_n374_n230# pfet_03v3 ad=0.44p pd=2.88u as=0.44p ps=2.88u w=1u l=2u
C0 w_n374_n230# a_n200_n144# 0.22666f
C1 w_n374_n230# a_n288_n100# 0.03135f
C2 w_n374_n230# a_200_n100# 0.03135f
C3 a_n200_n144# a_n288_n100# 0.02905f
C4 a_n200_n144# a_200_n100# 0.02905f
C5 a_n288_n100# a_200_n100# 0.01056f
C6 a_200_n100# VSUBS 0.1047f
C7 a_n288_n100# VSUBS 0.1047f
C8 w_n374_n230# VSUBS 1.03224f
.ends

.subckt n_w0p22_l0p28 a_n120_n36# a_28_n22# a_n28_n66# VSUBS
X0 a_28_n22# a_n28_n66# a_n120_n36# VSUBS nfet_03v3 ad=0.1516p pd=1.64u as=0.1516p ps=1.64u w=0.22u l=0.28u
C0 a_n120_n36# a_n28_n66# 0.00187f
C1 a_n120_n36# a_28_n22# 0.01112f
C2 a_n28_n66# a_28_n22# 0.00187f
C3 a_28_n22# VSUBS 0.07856f
C4 a_n120_n36# VSUBS 0.07856f
.ends

.subckt n_w4_l2 a_n288_n400# a_200_n400# a_n200_n444# VSUBS
X0 a_200_n400# a_n200_n444# a_n288_n400# VSUBS nfet_03v3 ad=1.76p pd=8.88u as=1.76p ps=8.88u w=4u l=2u
C0 a_n200_n444# a_n288_n400# 0.11799f
C1 a_n200_n444# a_200_n400# 0.11799f
C2 a_n288_n400# a_200_n400# 0.04287f
C3 a_200_n400# VSUBS 0.34365f
C4 a_n288_n400# VSUBS 0.34365f
.ends

.subckt n_w0p22_l2 a_200_n22# a_n200_n66# a_n292_n36# VSUBS
X0 a_200_n22# a_n200_n66# a_n292_n36# VSUBS nfet_03v3 ad=0.1516p pd=1.64u as=0.1516p ps=1.64u w=0.22u l=2u
C0 a_n292_n36# a_n200_n66# 0.00705f
C1 a_n292_n36# a_200_n22# 0.00245f
C2 a_n200_n66# a_200_n22# 0.00705f
C3 a_200_n22# VSUBS 0.20767f
C4 a_n292_n36# VSUBS 0.20767f
.ends

.subckt n_w3p54_l3p54 a_354_n354# a_n354_n398# a_n442_n354# VSUBS
X0 a_354_n354# a_n354_n398# a_n442_n354# VSUBS nfet_03v3 ad=1.5576p pd=7.96u as=1.5576p ps=7.96u w=3.54u l=3.54u
C0 a_n354_n398# a_n442_n354# 0.12189f
C1 a_n354_n398# a_354_n354# 0.12189f
C2 a_n442_n354# a_354_n354# 0.02161f
C3 a_354_n354# VSUBS 0.44156f
C4 a_n442_n354# VSUBS 0.44156f
.ends

.subckt scdend_s1w vdd vss el vbn_leak vsrc vbp_st vbn_ref vreset vbn_prb vbp_syn
+ abus sel0 sel2 mreset spk en sta stb hold sc_clk vs d
XXN_Xi0_XP vdd a_4952_4114# sc_clk vdd vss p_w1_l0p28
XXY_XHL vdd d hold m1_4066_6230# vss p_w1_l0p28
XXS_XD_Xi4_XP vdd spk a_1880_6414# vdd vss p_w1_l0p28
XXS_XL_XMT m1_1446_3050# vbn_leak vss vss n_w2_l4
XXY_XMR mreset a_3024_4060# vdd vss n_w0p5_l0p28
XXS_XL_XM2 a_1780_3360# vs vs vss n_w2_l2
XXS_XL_XM1 a_488_5320# m1_702_3050# el vss n_w2_l2
XXS_XD_XPI m1_176_6220# a_788_4018# vs vdd vss p_w1_l0p5
XXS_XR_XSW vreset vs a_3024_4060# vss n_w0p5_l0p5
XXT2_XSW m1_4910_1940# sel2 abus vss n_w1_l0p28
XXS_XR_XNR a_3024_4060# vbn_ref vss vss n_w2_l4
XXS_XD_XNI vsrc a_788_4018# vs vss n_w1_l0p5
XXCD_XC vss vss d vss n_w7p07_l7p07
XXN_Xd2_XN a_6368_4114# vss a_7304_6414# vss n_w0p5_l0p28
XXN_Xd2_XP vdd a_7304_6414# a_6368_4114# vdd vss p_w1_l0p28
XXY_XWA m1_3612_4340# vbp_syn vdd m1_3886_4870# vss p_w2_l4
XXS_XL_XD2 m1_1446_3050# a_1780_3360# a_1780_3360# vss n_w2_l2
XXS_XL_XD1 m1_702_3050# m1_1446_3050# m1_702_3050# vss n_w2_l2
XXT0_XMB vss m1_3716_1916# vbn_prb vss n_w2_l2
XXN_XO2_XP1 vdd m1_6958_6230# sc_clk vdd vss p_w1_l0p28
XXY_XWB m1_3604_5840# vbp_syn vdd m1_3886_4870# vss p_w2_l4
XXN_XO2_XP2 vdd a_7756_6414# a_7304_6414# m1_6958_6230# vss p_w1_l0p28
XXS_XD_XS2 vdd vdd m1_848_6220# vbp_st vss p_w1_l2
XXS_XD_XPS vdd vdd m1_176_6220# vbp_st vss p_w1_l2
XXL1 cl m1_4066_6230# a_7304_6414# vss n_w0p22_l0p28
XXT0_XME m1_4406_2052# en m1_3716_1916# vss n_w1_l0p28
XXN_XO2_XN2 a_7304_6414# vss a_7756_6414# vss n_w0p5_l0p28
XXN_XO2_XN1 sc_clk vss a_7756_6414# vss n_w0p5_l0p28
XXL2 cl el a_5424_4114# vss n_w0p22_l0p28
XXT0_XMF m1_4406_2052# vdd vs vss n_w4_l2
XXS_XD_XP2 vdd a_1428_6414# a_788_4018# m1_848_6220# vss p_w1_l0p28
XXY_XQA vdd vss sta m1_3612_4340# vss p_w1_l0p28
XXS_XD_XP3 vdd a_1880_6414# a_1428_6414# vdd vss p_w1_l0p28
XXY_XQB vdd vss stb m1_3604_5840# vss p_w1_l0p28
XXS_XD_XN2 a_1428_6414# a_788_4018# vsrc vss n_w0p22_l2
XXN_Xd3_XN a_7756_6414# vss a_8208_6414# vss n_w0p5_l0p28
XXS_XD_XN3 a_1428_6414# vsrc a_1880_6414# vss n_w0p5_l0p28
XXY_XNA sta d m1_3612_4340# vss n_w0p5_l0p28
XXN_Xd3_XP vdd a_8208_6414# a_7756_6414# vdd vss p_w1_l0p28
XXY_XNB stb d m1_3604_5840# vss n_w0p5_l0p28
XXS_XR_XPC vdd a_3024_4060# a_2784_6414# vdd vss p_w1_l0p28
XXS_XR_Xi_XN spk vss a_2784_6414# vss n_w0p5_l0p28
XXN_XO1_XP1 vdd m1_5130_6230# a_4952_4114# vdd vss p_w1_l0p28
XXN_XO1_XP2 vdd a_5896_4114# a_5424_4114# m1_5130_6230# vss p_w1_l0p28
XXS_XR_Xi_XP vdd a_2784_6414# spk vdd vss p_w1_l0p28
XXN_XO1_XN1 a_4952_4114# vss a_5896_4114# vss n_w0p5_l0p28
XXY_XPH vdd vdd m1_3886_4870# hold vss p_w1_l2
XXA1 ca d a_7304_6414# vss n_w0p22_l0p28
XXT2_XMB vss m1_4750_1926# vbn_prb vss n_w2_l2
XXN_XO1_XN2 a_5424_4114# vss a_5896_4114# vss n_w0p5_l0p28
XXA2 ca vs a_5424_4114# vss n_w0p22_l0p28
XXT0_XSW m1_4406_2052# sel0 abus vss n_w1_l0p28
XXT2_XME m1_4910_1940# en m1_4750_1926# vss n_w1_l0p28
XXT2_XMF m1_4910_1940# vdd d vss n_w4_l2
XXN_Xd4_XN a_8208_6414# vss a_5424_4114# vss n_w0p5_l0p28
XXN_Xd1_XN a_5896_4114# vss a_6368_4114# vss n_w0p5_l0p28
XXN_Xd1_XP vdd a_6368_4114# a_5896_4114# vdd vss p_w1_l0p28
XXS_XC_XC vss vss vs vss n_w7p07_l7p07
XXN_Xd4_XP vdd a_5424_4114# a_8208_6414# vdd vss p_w1_l0p28
XXS_XD_Xi4_XN a_1880_6414# vss spk vss n_w0p5_l0p28
XXS_XL_XP1 a_488_5320# a_488_5320# vdd vdd vss p_w2_l4
XXN_Xi0_XN sc_clk vss a_4952_4114# vss n_w0p5_l0p28
XXS_XL_XP2 vs a_488_5320# vdd vdd vss p_w2_l4
XXS_XR_XCR_XC vss a_3024_4060# vss vss n_w3p54_l3p54
C0 m1_4066_6230# a_6368_4114# 0.00218f
C1 a_5424_4114# sta 0.22804f
C2 vsrc el 1.09981f
C3 vbp_st sta 0
C4 vbn_leak vbn_ref 0.58983f
C5 m1_1446_3050# vsrc 0.00978f
C6 m1_848_6220# spk 0.09033f
C7 en m1_4910_1940# 0.00135f
C8 el m1_4406_2052# 0.04018f
C9 sta m1_5130_6230# 0.03616f
C10 a_7304_6414# spk 0.00547f
C11 a_8208_6414# spk 0.00283f
C12 vbn_prb m1_4910_1940# 0
C13 a_6368_4114# stb 0.03686f
C14 vdd spk 3.69129f
C15 el m1_848_6220# 0.65921f
C16 a_7756_6414# stb 0.00102f
C17 m1_4910_1940# m1_3716_1916# 0.00973f
C18 el a_7304_6414# 0.02782f
C19 m1_3612_4340# a_2784_6414# 0
C20 a_8208_6414# el 0.00436f
C21 vdd el 2.04575f
C22 a_788_4018# spk 0
C23 m1_4750_1926# sel2 0.00131f
C24 m1_1446_3050# vdd 0.00141f
C25 a_5424_4114# spk 0.08689f
C26 vbp_st spk 0.05517f
C27 m1_4750_1926# sel0 0
C28 vs m1_3886_4870# 0.04426f
C29 vbp_syn m1_3886_4870# 0.42085f
C30 mreset vs 0.00183f
C31 m1_3612_4340# sel2 0.0203f
C32 mreset vbp_syn 0.02704f
C33 sc_clk m1_3604_5840# 0.08172f
C34 a_5896_4114# sel2 0
C35 a_788_4018# el 0.26173f
C36 m1_5130_6230# spk 0
C37 d m1_3886_4870# 0.03285f
C38 m1_3612_4340# sel0 0.16964f
C39 abus m1_4910_1940# 0.24368f
C40 m1_4066_6230# stb 0.05118f
C41 a_5424_4114# el 0.12526f
C42 d mreset 0.01239f
C43 sel0 a_5896_4114# 0
C44 vbp_st el 0.0442f
C45 m1_4066_6230# en 0.00482f
C46 cl vbn_leak 0.08248f
C47 vs a_1780_3360# 0.06358f
C48 a_4952_4114# m1_3604_5840# 0.20531f
C49 vbn_ref m1_3886_4870# 0
C50 m1_4066_6230# vbn_prb 0.0342f
C51 abus a_6368_4114# 0
C52 mreset vbn_ref 0.08439f
C53 a_7304_6414# ca 0.02786f
C54 d a_1780_3360# 0.03324f
C55 m1_4750_1926# sta 0.00107f
C56 hold a_6368_4114# 0
C57 m1_4910_1940# a_3024_4060# 0.03155f
C58 a_7756_6414# abus 0.05375f
C59 en stb 0.00868f
C60 vdd ca 0
C61 vreset a_6368_4114# 0
C62 m1_3612_4340# sta 0.07393f
C63 vbn_prb stb 0
C64 sta a_5896_4114# 0.02608f
C65 vbn_leak m1_3604_5840# 0.04702f
C66 vreset a_7756_6414# 0
C67 a_6368_4114# a_3024_4060# 0
C68 vsrc sc_clk 0.04101f
C69 a_5424_4114# ca 0.01652f
C70 m1_3716_1916# stb 0
C71 en m1_3716_1916# 0.01453f
C72 m1_4066_6230# abus 0.37843f
C73 vbn_prb m1_3716_1916# 0.11133f
C74 m1_4750_1926# spk 0.09276f
C75 m1_4066_6230# hold 0.2196f
C76 sc_clk m1_848_6220# 0.67143f
C77 vreset m1_4066_6230# 0
C78 m1_3612_4340# spk 0.0089f
C79 sc_clk a_7304_6414# 0.25953f
C80 abus stb 0.13958f
C81 cl mreset 0.55585f
C82 a_5896_4114# spk 0
C83 a_4952_4114# m1_848_6220# 0
C84 m1_4750_1926# el 0.14573f
C85 m1_4066_6230# a_3024_4060# 0.04812f
C86 en abus 0.16179f
C87 hold stb 0.16269f
C88 sc_clk vdd 1.6055f
C89 vsrc vbn_leak 1.43492f
C90 en hold 0.12218f
C91 vreset stb 0.01178f
C92 vbn_prb abus 0.02836f
C93 m1_4910_1940# sel2 0.04966f
C94 m1_3612_4340# el 0
C95 vs vbp_syn 0.00679f
C96 m1_1446_3050# m1_3612_4340# 0.00276f
C97 el a_5896_4114# 0
C98 vreset en 0.07739f
C99 vbn_leak m1_4406_2052# 0
C100 en a_488_5320# 0.00754f
C101 a_4952_4114# vdd 0.62408f
C102 stb a_3024_4060# 0.12162f
C103 d vs 1.79424f
C104 m1_3604_5840# m1_3886_4870# 0.25477f
C105 vreset vbn_prb 1.43266f
C106 a_5424_4114# sc_clk 0.24144f
C107 m1_6958_6230# el 0
C108 a_6368_4114# sel2 0
C109 d vbp_syn 0.13244f
C110 en a_3024_4060# 0.33876f
C111 mreset m1_3604_5840# 0
C112 sc_clk vbp_st 0.07188f
C113 sel0 a_6368_4114# 0
C114 m1_702_3050# a_488_5320# 0.00114f
C115 vs vbn_ref 0
C116 a_1780_3360# a_1880_6414# 0.00973f
C117 vbn_prb a_3024_4060# 0
C118 a_7756_6414# sel2 0
C119 vbn_leak a_7304_6414# 0.13322f
C120 a_8208_6414# vbn_leak 0.02004f
C121 vbn_ref vbp_syn 0.02787f
C122 a_5424_4114# a_4952_4114# 0.01489f
C123 sc_clk m1_5130_6230# 0.00262f
C124 a_7756_6414# sel0 0
C125 vdd vbn_leak 0.08095f
C126 m1_176_6220# vs 0.07394f
C127 m1_4910_1940# sta 0.02738f
C128 m1_176_6220# vbp_syn 0.03509f
C129 m1_3716_1916# a_3024_4060# 0.29635f
C130 a_4952_4114# m1_5130_6230# 0
C131 m1_176_6220# d 0.00325f
C132 sta a_6368_4114# 0
C133 a_5424_4114# vbn_leak 0.17694f
C134 vreset abus 0.02775f
C135 m1_4066_6230# sel2 0.0267f
C136 vbp_st vbn_leak 0.03691f
C137 en a_2784_6414# 0.01222f
C138 vreset hold 0.03467f
C139 m1_4066_6230# sel0 0.39153f
C140 vsrc mreset 0.02269f
C141 abus a_3024_4060# 0.39953f
C142 vreset a_488_5320# 0
C143 hold a_3024_4060# 0
C144 stb sel2 0.16546f
C145 a_488_5320# a_3024_4060# 0
C146 vsrc a_1780_3360# 0
C147 vreset a_3024_4060# 0.30918f
C148 en sel2 0.00216f
C149 sel0 stb 0.02104f
C150 cl vs 0.01718f
C151 cl vbp_syn 0.00122f
C152 en sel0 0.15449f
C153 a_7304_6414# m1_3886_4870# 0.00106f
C154 vbn_prb sel2 0.2195f
C155 m1_4066_6230# sta 0.07409f
C156 a_6368_4114# spk 0
C157 cl d 0.00476f
C158 mreset a_7304_6414# 0.15596f
C159 vbn_prb sel0 0.02854f
C160 a_8208_6414# mreset 0
C161 m1_4910_1940# el 0.03656f
C162 vdd m1_3886_4870# 0.80305f
C163 mreset vdd 0.15271f
C164 sc_clk m1_3612_4340# 0.01678f
C165 a_7756_6414# spk 0
C166 m1_3716_1916# sel2 0
C167 cl vbn_ref 0.00256f
C168 vs a_1880_6414# 0.0636f
C169 sc_clk a_5896_4114# 0
C170 el a_6368_4114# 0
C171 sta stb 0.92516f
C172 vs m1_3604_5840# 0
C173 m1_6958_6230# sc_clk 0.0113f
C174 m1_3604_5840# vbp_syn 0.4298f
C175 m1_3612_4340# a_4952_4114# 0.00282f
C176 d a_1880_6414# 0
C177 a_1780_3360# vdd 0.00133f
C178 en sta 0.1029f
C179 a_5424_4114# m1_3886_4870# 0.09836f
C180 a_4952_4114# a_5896_4114# 0.00425f
C181 a_7756_6414# el 0.00359f
C182 a_5424_4114# mreset 0.05244f
C183 d m1_3604_5840# 0.14772f
C184 a_488_5320# a_2784_6414# 0
C185 vreset a_2784_6414# 0.42439f
C186 mreset vbp_st 0.02326f
C187 m1_4750_1926# vbn_leak 0
C188 abus sel2 0.12161f
C189 vs a_1428_6414# 0.05366f
C190 vbn_ref m1_3604_5840# 0.04861f
C191 a_2784_6414# a_3024_4060# 0.02555f
C192 abus sel0 1.56614f
C193 m1_176_6220# a_1880_6414# 0.01643f
C194 d a_1428_6414# 0
C195 m1_3612_4340# vbn_leak 0.1256f
C196 vreset sel2 0.02211f
C197 vbn_leak a_5896_4114# 0
C198 m1_176_6220# m1_3604_5840# 0.00382f
C199 vreset sel0 0.02823f
C200 m1_4066_6230# el 0.07319f
C201 stb spk 0.14539f
C202 sel2 a_3024_4060# 0.06891f
C203 sel0 a_3024_4060# 0.53141f
C204 en spk 0.02438f
C205 vsrc vs 0.13641f
C206 vsrc vbp_syn 0.03557f
C207 m1_176_6220# a_1428_6414# 0.02324f
C208 abus sta 0.08068f
C209 vbn_prb spk 0.35896f
C210 vs m1_4406_2052# 0.13547f
C211 vsrc d 0
C212 el stb 0.01723f
C213 hold sta 0.11753f
C214 en el 0.02252f
C215 m1_1446_3050# en 0.08408f
C216 vreset sta 0.22051f
C217 d m1_4406_2052# 0.20076f
C218 vsrc vbn_ref 0.03088f
C219 vs m1_848_6220# 0.02724f
C220 m1_3716_1916# spk 0.00122f
C221 vbn_prb el 0.3677f
C222 m1_848_6220# vbp_syn 0.03448f
C223 vs a_7304_6414# 0.00966f
C224 sta a_3024_4060# 0.04309f
C225 m1_702_3050# el 0.224f
C226 vbn_ref m1_4406_2052# 0
C227 a_7304_6414# vbp_syn 0.03211f
C228 m1_1446_3050# m1_702_3050# 0.0091f
C229 a_8208_6414# vbp_syn 0.06245f
C230 cl m1_3604_5840# -0
C231 m1_176_6220# vsrc 0.04299f
C232 m1_4066_6230# ca 0
C233 vs vdd 1.34783f
C234 m1_3716_1916# el 0.49869f
C235 d a_7304_6414# 0.00861f
C236 m1_4750_1926# mreset 0
C237 vdd vbp_syn 2.33995f
C238 m1_1446_3050# m1_3716_1916# 0.00108f
C239 vbn_ref m1_848_6220# 0
C240 m1_3612_4340# m1_3886_4870# 0.27068f
C241 d vdd 1.11494f
C242 abus spk 0.06186f
C243 vbn_ref a_7304_6414# 0.03721f
C244 a_5896_4114# m1_3886_4870# 0.00585f
C245 sc_clk a_6368_4114# 0.04323f
C246 a_8208_6414# vbn_ref 0
C247 a_788_4018# vs 0.17742f
C248 m1_176_6220# m1_848_6220# 0.74923f
C249 hold spk 0.08741f
C250 a_5424_4114# vs 0.01135f
C251 vdd vbn_ref 0.07782f
C252 a_5424_4114# vbp_syn 0.25973f
C253 a_7756_6414# sc_clk 0.02873f
C254 vreset spk 0.73702f
C255 a_488_5320# spk 0.08003f
C256 m1_176_6220# a_7304_6414# 0.06115f
C257 a_4952_4114# a_6368_4114# 0
C258 vbp_st vbp_syn 0.48383f
C259 sel0 sel2 1.84333f
C260 abus el 0.03409f
C261 a_5424_4114# d 0
C262 vbn_prb ca 0.21096f
C263 m1_176_6220# vdd 1.76238f
C264 hold el 0.01324f
C265 m1_5130_6230# vbp_syn 0.00447f
C266 a_2784_6414# sta 0.0069f
C267 spk a_3024_4060# 0.0259f
C268 a_1880_6414# a_1428_6414# 0.23101f
C269 m1_4910_1940# vbn_leak 0
C270 vreset el 0.2497f
C271 a_5424_4114# vbn_ref 0.04142f
C272 a_488_5320# el 0.19941f
C273 m1_1446_3050# a_488_5320# 0
C274 vsrc cl 0.00504f
C275 vbp_st vbn_ref 1.43904f
C276 m1_176_6220# a_788_4018# 0.03372f
C277 el a_3024_4060# 0.44315f
C278 vbn_leak a_6368_4114# 0
C279 m1_176_6220# a_5424_4114# 0.1793f
C280 m1_1446_3050# a_3024_4060# 0.11195f
C281 m1_4066_6230# sc_clk 0.32755f
C282 sta sel2 0.22007f
C283 m1_176_6220# vbp_st 0.06206f
C284 sel0 sta 0.05434f
C285 a_7756_6414# vbn_leak 0
C286 vsrc a_1880_6414# 0.26375f
C287 m1_176_6220# m1_5130_6230# 0.00296f
C288 m1_4066_6230# a_4952_4114# 0.05471f
C289 cl a_7304_6414# 0.28733f
C290 sc_clk stb 0.1667f
C291 cl a_8208_6414# 0
C292 en sc_clk 0.0434f
C293 a_2784_6414# spk 0.11534f
C294 cl vdd 0.00687f
C295 a_4952_4114# stb 0.14332f
C296 a_1880_6414# m1_848_6220# 0
C297 en a_4952_4114# 0.00143f
C298 m1_4066_6230# vbn_leak 0.04017f
C299 vsrc a_1428_6414# 0.27257f
C300 a_2784_6414# el 0
C301 m1_4750_1926# vs 0.22258f
C302 m1_1446_3050# a_2784_6414# 0
C303 spk sel2 0.11159f
C304 cl a_5424_4114# 0.1589f
C305 m1_3604_5840# a_7304_6414# 0.05744f
C306 vdd a_1880_6414# 0.72291f
C307 cl vbp_st 0.00348f
C308 sel0 spk 0.06219f
C309 d m1_4750_1926# 0.22967f
C310 m1_3612_4340# vs 0.00538f
C311 m1_3612_4340# vbp_syn 0.24166f
C312 vdd m1_3604_5840# 0.81777f
C313 vbn_leak stb 0.13846f
C314 m1_848_6220# a_1428_6414# 0.00341f
C315 a_5896_4114# vbp_syn 0.03887f
C316 el sel2 0.03754f
C317 a_6368_4114# m1_3886_4870# 0
C318 en vbn_leak 0.07069f
C319 m1_4750_1926# vbn_ref 0
C320 d m1_3612_4340# 0.20994f
C321 a_788_4018# a_1880_6414# 0.00221f
C322 sel0 el 0.0378f
C323 m1_6958_6230# vbp_syn 0.00991f
C324 m1_1446_3050# sel0 0
C325 vbn_prb vbn_leak 0.02808f
C326 m1_3612_4340# vbn_ref 0.16976f
C327 abus sc_clk 0
C328 vdd a_1428_6414# 0.62251f
C329 a_5424_4114# m1_3604_5840# 0.1201f
C330 a_7756_6414# mreset 0
C331 vbn_ref a_5896_4114# 0.04475f
C332 vbp_st m1_3604_5840# 0.00589f
C333 hold sc_clk 0.42688f
C334 sta spk 0.36757f
C335 vbn_leak m1_3716_1916# 0
C336 vreset sc_clk 0.01754f
C337 vsrc m1_848_6220# 0.04719f
C338 a_788_4018# a_1428_6414# 0.02105f
C339 m1_176_6220# a_5896_4114# 0.07647f
C340 hold a_4952_4114# 0.04432f
C341 vsrc a_7304_6414# 0
C342 sta el 0.34806f
C343 vsrc a_8208_6414# 0
C344 sc_clk a_3024_4060# 0
C345 vreset a_4952_4114# 0
C346 m1_1446_3050# sta 0.00104f
C347 m1_4066_6230# m1_3886_4870# 0.10258f
C348 vsrc vdd 0.9489f
C349 sel2 ca 0.00376f
C350 m1_4066_6230# mreset 0.10905f
C351 sel0 ca 0.00123f
C352 abus vbn_leak 0.40068f
C353 vdd m1_4406_2052# -0.02942f
C354 m1_848_6220# a_7304_6414# 0.13435f
C355 a_8208_6414# m1_848_6220# 0
C356 vsrc a_788_4018# 0.13097f
C357 stb m1_3886_4870# 0.0046f
C358 vsrc a_5424_4114# 0.00909f
C359 a_8208_6414# a_7304_6414# 0.02158f
C360 vreset vbn_leak 0.02808f
C361 vdd m1_848_6220# 1.54956f
C362 mreset stb 0.0061f
C363 en m1_3886_4870# 0.09045f
C364 vsrc vbp_st 1.43524f
C365 vdd a_7304_6414# 1.17829f
C366 a_8208_6414# vdd 0.75181f
C367 vbn_leak a_3024_4060# 0.53568f
C368 vbn_prb mreset 0.1675f
C369 el spk 0.89589f
C370 a_788_4018# m1_848_6220# 0.11246f
C371 m1_1446_3050# spk 0
C372 en a_1780_3360# 0.00717f
C373 a_5424_4114# m1_848_6220# 0.18113f
C374 vs m1_4910_1940# 0.07574f
C375 vbp_st m1_848_6220# 0.06764f
C376 a_5424_4114# a_7304_6414# 0.29451f
C377 a_8208_6414# a_5424_4114# 0.37041f
C378 vbp_st a_7304_6414# 0.0291f
C379 d m1_4910_1940# 0.17613f
C380 a_788_4018# vdd 0.42144f
C381 a_8208_6414# vbp_st 0.06868f
C382 m1_1446_3050# el 0.09874f
C383 m1_702_3050# a_1780_3360# 0.00796f
C384 a_5424_4114# vdd 1.59846f
C385 sc_clk sel2 0
C386 m1_3612_4340# m1_3604_5840# 0.04386f
C387 a_6368_4114# vbp_syn 0.03076f
C388 vbp_st vdd 1.56284f
C389 sc_clk sel0 0
C390 a_5896_4114# m1_3604_5840# 0.10228f
C391 m1_4910_1940# vbn_ref 0
C392 a_7756_6414# vbp_syn 0.05212f
C393 vdd m1_5130_6230# 0.06163f
C394 a_4952_4114# sel0 0
C395 abus mreset 0.03129f
C396 vbn_ref a_6368_4114# 0.00919f
C397 hold m1_3886_4870# 0.10308f
C398 a_5424_4114# vbp_st 0.04811f
C399 spk ca 0.37463f
C400 a_488_5320# m1_3886_4870# 0
C401 vreset m1_3886_4870# 0.04f
C402 a_7756_6414# vbn_ref 0
C403 a_5424_4114# m1_5130_6230# 0.05424f
C404 vreset mreset 0.02405f
C405 m1_176_6220# a_6368_4114# 0.28398f
C406 sc_clk sta 0.44454f
C407 vbn_leak sel2 0.58306f
C408 a_3024_4060# m1_3886_4870# 0.10218f
C409 el ca 0.02431f
C410 m1_4066_6230# vs 0.00154f
C411 mreset a_3024_4060# 0.00165f
C412 m1_4066_6230# vbp_syn 0.13709f
C413 m1_176_6220# a_7756_6414# 0
C414 sel0 vbn_leak 0.30833f
C415 a_488_5320# a_1780_3360# 0.0014f
C416 a_4952_4114# sta 0.10717f
C417 m1_4750_1926# m1_4406_2052# 0.06714f
C418 m1_4066_6230# d 0.15839f
C419 vsrc a_5896_4114# 0
C420 vs stb 0.0036f
C421 m1_4066_6230# vbn_ref 0.2649f
C422 stb vbp_syn 0.03322f
C423 en vs 0.09836f
C424 en vbp_syn 0.0582f
C425 d stb 0.12501f
C426 vbn_prb vs 0.09408f
C427 vbn_leak sta 0.07355f
C428 d en 0.04831f
C429 vbn_prb vbp_syn 1.433f
C430 a_5896_4114# m1_848_6220# 0
C431 m1_4750_1926# vdd 0.16962f
C432 sc_clk spk 0.10377f
C433 m1_3612_4340# a_7304_6414# 0
C434 m1_702_3050# vs 0.01714f
C435 vbn_ref stb 0.04658f
C436 a_5896_4114# a_7304_6414# 0.00185f
C437 a_2784_6414# m1_3886_4870# 0.05401f
C438 m1_6958_6230# m1_848_6220# 0.04711f
C439 d vbn_prb 0.23018f
C440 en vbn_ref 0.01055f
C441 vs m1_3716_1916# 0.28821f
C442 m1_3612_4340# vdd 0.33137f
C443 m1_6958_6230# a_7304_6414# 0.07388f
C444 a_7756_6414# cl 0
C445 vdd a_5896_4114# 0.50051f
C446 a_4952_4114# spk 0
C447 m1_176_6220# stb 0.22664f
C448 vbn_prb vbn_ref 0.02718f
C449 sc_clk el 0.29998f
C450 d m1_3716_1916# 0.24591f
C451 m1_176_6220# en 0.01522f
C452 m1_6958_6230# vdd 0.07836f
C453 mreset sel2 2.6457f
C454 a_4952_4114# el 0
C455 a_6368_4114# m1_3604_5840# 0.128f
C456 a_5424_4114# a_5896_4114# 0.33033f
C457 mreset sel0 0.31129f
C458 abus vs 0.00688f
C459 vbp_st a_5896_4114# 0.02375f
C460 vbn_leak spk 0.05351f
C461 abus vbp_syn 1.43405f
C462 m1_6958_6230# a_5424_4114# 0.0051f
C463 a_7756_6414# m1_3604_5840# 0
C464 m1_4066_6230# cl 0.10154f
C465 m1_6958_6230# vbp_st 0
C466 hold vbp_syn 0.246f
C467 a_5896_4114# m1_5130_6230# 0.00427f
C468 d abus 0.05025f
C469 vreset vs 0.0201f
C470 a_488_5320# vs 0.56387f
C471 a_488_5320# vbp_syn 0.00338f
C472 vreset vbp_syn 0.07011f
C473 d hold 0.28462f
C474 vbn_leak el 1.44079f
C475 m1_1446_3050# vbn_leak 0.34283f
C476 abus vbn_ref 0.32458f
C477 vs a_3024_4060# 0.39765f
C478 d a_488_5320# 0
C479 sta m1_3886_4870# 0.0751f
C480 vreset d 0.09824f
C481 vbp_syn a_3024_4060# 0.07023f
C482 hold vbn_ref 0
C483 vreset vbn_ref 1.43505f
C484 d a_3024_4060# 0.61108f
C485 m1_4066_6230# m1_3604_5840# 0.16418f
C486 m1_4910_1940# m1_4406_2052# 0.00635f
C487 cl vbn_prb 0.26346f
C488 m1_176_6220# hold 0.031f
C489 vsrc a_6368_4114# 0
C490 vbn_ref a_3024_4060# 0.06993f
C491 vreset m1_176_6220# 0.03702f
C492 m1_176_6220# a_488_5320# 0.00143f
C493 a_7756_6414# vsrc 0
C494 en a_1880_6414# 0.00136f
C495 m1_3604_5840# stb 0.03444f
C496 m1_176_6220# a_3024_4060# 0
C497 en m1_3604_5840# 0.02928f
C498 vbn_leak ca 0
C499 a_6368_4114# m1_848_6220# 0
C500 vdd m1_4910_1940# 0.18269f
C501 vs a_2784_6414# 0.02818f
C502 vbn_prb m1_3604_5840# 0
C503 m1_4750_1926# m1_3612_4340# 0.28587f
C504 a_2784_6414# vbp_syn 0.00906f
C505 mreset spk 1.47394f
C506 a_6368_4114# a_7304_6414# 0.03718f
C507 a_7756_6414# m1_848_6220# 0.0865f
C508 d a_2784_6414# 0.34621f
C509 vdd a_6368_4114# 0.54216f
C510 cl abus 0.00101f
C511 a_7756_6414# a_7304_6414# 0.69275f
C512 a_7756_6414# a_8208_6414# 0.06134f
C513 a_1780_3360# spk 0.00642f
C514 vs sel2 0.00207f
C515 mreset el 0.03493f
C516 sel2 vbp_syn 0.02468f
C517 a_7756_6414# vdd 0.81825f
C518 sc_clk a_4952_4114# 0.44542f
C519 vs sel0 0.00165f
C520 vreset cl 0.00193f
C521 m1_702_3050# a_1428_6414# 0.00662f
C522 sel0 vbp_syn 0.02908f
C523 d sel2 0.0013f
C524 a_5424_4114# a_6368_4114# 0.01541f
C525 m1_176_6220# a_2784_6414# 0.0013f
C526 a_1780_3360# el 0.00874f
C527 d sel0 0
C528 vbp_st a_6368_4114# 0.06813f
C529 vsrc stb 0.04769f
C530 m1_1446_3050# a_1780_3360# 0.23906f
C531 vsrc en 0.01958f
C532 vbn_ref sel2 0.02363f
C533 a_7756_6414# a_5424_4114# 0.10785f
C534 abus m1_3604_5840# 0.05284f
C535 m1_4066_6230# a_7304_6414# 0.09175f
C536 a_6368_4114# m1_5130_6230# 0
C537 sel0 vbn_ref 0.48755f
C538 a_7756_6414# vbp_st 0.03821f
C539 a_488_5320# a_1880_6414# 0.09399f
C540 vsrc vbn_prb 0.0263f
C541 hold m1_3604_5840# 0.05036f
C542 en m1_4406_2052# 0.09719f
C543 sc_clk vbn_leak 0
C544 m1_4066_6230# vdd 0.56393f
C545 vs sta 0
C546 vsrc m1_702_3050# 0.032f
C547 m1_848_6220# stb 0.01385f
C548 vbn_prb m1_4406_2052# 0
C549 sta vbp_syn 0.03112f
C550 en m1_848_6220# 0.01814f
C551 a_4952_4114# vbn_leak 0.00374f
C552 mreset ca 0.00273f
C553 a_7304_6414# stb 0.00817f
C554 m1_3604_5840# a_3024_4060# 0.2426f
C555 d sta 0.06615f
C556 m1_3716_1916# m1_4406_2052# 0.07311f
C557 m1_4066_6230# a_5424_4114# 0.00252f
C558 vdd stb 0.91443f
C559 a_488_5320# a_1428_6414# 0.10946f
C560 sta vbn_ref 0.03679f
C561 m1_4066_6230# vbp_st 0
C562 vbn_prb a_7304_6414# 0.01876f
C563 en vdd 0.29847f
C564 vbn_prb vdd 0.06807f
C565 m1_176_6220# sta 0.11376f
C566 vsrc abus 0.02681f
C567 a_5424_4114# stb 0.57553f
C568 m1_702_3050# vdd 0.00306f
C569 m1_4750_1926# m1_4910_1940# 0.11657f
C570 vbp_st stb 0.01863f
C571 vsrc hold 0.03863f
C572 vs spk 8.28977f
C573 vdd m1_3716_1916# 0.03057f
C574 abus m1_4406_2052# 0.10081f
C575 cl sel2 0.18582f
C576 spk vbp_syn 0.72357f
C577 a_2784_6414# a_1880_6414# 0.00217f
C578 vreset vsrc 0.77945f
C579 vsrc a_488_5320# 0.23511f
C580 a_5424_4114# vbn_prb 0.12141f
C581 m1_5130_6230# stb 0.08268f
C582 cl sel0 0
C583 m1_3612_4340# m1_4910_1940# 0.21572f
C584 vbn_prb vbp_st 0.02656f
C585 a_788_4018# m1_702_3050# 0.00784f
C586 d spk 0.03616f
C587 vs el 0.755f
C588 vsrc a_3024_4060# 0
C589 sc_clk m1_3886_4870# 0.06759f
C590 el vbp_syn 0.04362f
C591 m1_1446_3050# vs 0.14368f
C592 hold m1_848_6220# 0.01336f
C593 abus a_7304_6414# 0.17555f
C594 vbn_ref spk 0.05515f
C595 m1_1446_3050# vbp_syn 0
C596 a_8208_6414# abus 0.13388f
C597 a_3024_4060# m1_4406_2052# 0.40361f
C598 a_6368_4114# a_5896_4114# 0.38813f
C599 vreset m1_848_6220# 0.04056f
C600 d el 0.81475f
C601 a_488_5320# m1_848_6220# 0.00249f
C602 abus vdd 0.86468f
C603 m1_1446_3050# d 0.05506f
C604 a_4952_4114# m1_3886_4870# 0.07734f
C605 m1_3604_5840# sel2 0.03264f
C606 m1_6958_6230# a_6368_4114# 0
C607 vreset a_7304_6414# 0
C608 vreset a_8208_6414# 0
C609 m1_176_6220# spk 0.25864f
C610 hold vdd 1.07785f
C611 sel0 m1_3604_5840# 0.03726f
C612 el vbn_ref 0.03822f
C613 m1_848_6220# a_3024_4060# 0
C614 a_488_5320# vdd 1.52641f
C615 m1_6958_6230# a_7756_6414# 0.00286f
C616 vreset vdd 0.63964f
C617 a_7304_6414# a_3024_4060# 0
C618 a_5424_4114# abus 0.09471f
C619 m1_176_6220# el 0.05568f
C620 abus vbp_st 0.04426f
C621 vdd a_3024_4060# 0.32052f
C622 vbn_leak m1_3886_4870# 0
C623 a_5424_4114# hold 0.06694f
C624 a_788_4018# a_488_5320# 0.34794f
C625 hold vbp_st 0.00685f
C626 vsrc a_2784_6414# 0.00238f
C627 mreset vbn_leak 0.27301f
C628 vs ca 0.29833f
C629 vreset a_5424_4114# 0.00993f
C630 m1_4066_6230# m1_3612_4340# 0.04827f
C631 vreset vbp_st 0.02955f
C632 m1_4066_6230# a_5896_4114# 0.06079f
C633 sta m1_3604_5840# 0.02904f
C634 hold m1_5130_6230# 0
C635 m1_4750_1926# stb 0.00204f
C636 d ca 0.19604f
C637 a_5424_4114# a_3024_4060# 0
C638 en m1_4750_1926# 0.04049f
C639 vsrc sel2 0.02206f
C640 a_2784_6414# m1_848_6220# 0
C641 cl spk 0.16669f
C642 m1_3612_4340# stb 0.00685f
C643 vbn_prb m1_4750_1926# 0.33387f
C644 vsrc sel0 0.02699f
C645 a_5896_4114# stb 0.20238f
C646 en m1_3612_4340# 0.12326f
C647 en a_5896_4114# 0
C648 m1_6958_6230# stb 0.00127f
C649 sel0 m1_4406_2052# 0.04012f
C650 a_2784_6414# vdd 0.57849f
C651 cl el 0.1565f
C652 m1_4750_1926# m1_3716_1916# 0.11617f
C653 a_1880_6414# spk 0.16518f
C654 a_7304_6414# sel2 0.03725f
C655 m1_3612_4340# m1_3716_1916# 0
C656 a_8208_6414# sel2 0
C657 m1_3604_5840# spk 0.00795f
C658 a_788_4018# a_2784_6414# 0
C659 sel0 a_7304_6414# 0.03853f
C660 a_8208_6414# sel0 0
C661 vsrc sta 0.04226f
C662 vdd sel2 0.07527f
C663 sc_clk vs 0
C664 sc_clk vbp_syn 0.1499f
C665 el a_1880_6414# 0.0033f
C666 sel0 vdd 0.07864f
C667 m1_1446_3050# a_1880_6414# 0.00498f
C668 sta m1_4406_2052# 0
C669 el m1_3604_5840# 0.00132f
C670 m1_4750_1926# abus 0.01516f
C671 d sc_clk 0.02025f
C672 spk a_1428_6414# 0
C673 a_4952_4114# vbp_syn 0.04203f
C674 a_5424_4114# sel2 0.06953f
C675 sta m1_848_6220# 0.09122f
C676 abus m1_3612_4340# 0.08413f
C677 sc_clk vbn_ref 0.00227f
C678 d a_4952_4114# 0
C679 a_7756_6414# a_6368_4114# 0
C680 vbp_st sel2 0.02204f
C681 a_5424_4114# sel0 0.05026f
C682 abus a_5896_4114# 0
C683 cl ca 0.12111f
C684 sta a_7304_6414# 0
C685 hold m1_3612_4340# 0.00258f
C686 el a_1428_6414# 0.42051f
C687 sel0 vbp_st 0.02701f
C688 hold a_5896_4114# 0
C689 m1_1446_3050# a_1428_6414# 0.0025f
C690 m1_4750_1926# a_3024_4060# 0.13849f
C691 a_4952_4114# vbn_ref 0.01149f
C692 a_488_5320# m1_3612_4340# 0
C693 m1_176_6220# sc_clk 0.10764f
C694 vreset m1_3612_4340# 0.01865f
C695 vdd sta 0.89281f
C696 vreset a_5896_4114# 0
C697 vs vbn_leak 0.0081f
C698 m1_4066_6230# m1_4910_1940# 0
C699 vbn_leak vbp_syn 0.02874f
C700 vsrc spk 0.8931f
C701 m1_3612_4340# a_3024_4060# 0.39883f
C702 m1_176_6220# a_4952_4114# 0.00137f
C703 a_5896_4114# a_3024_4060# 0.00472f
C704 d vbn_leak 0.02074f
C705 a_3024_4060# vss 1.64352f
C706 a_4952_4114# vss 0.18866f
C707 sc_clk vss 0.35319f
C708 spk vss 5.23193f
C709 vs vss 6.09453f
C710 a_6368_4114# vss 0.2113f
C711 m1_4910_1940# vss 0.00207f
C712 m1_4750_1926# vss 0.92901f
C713 abus vss 1.75567f
C714 sel0 vss 1.78502f
C715 ca vss 11.59966f
C716 hold vss -0.02263f
C717 a_5896_4114# vss 0.52589f
C718 m1_5130_6230# vss -0.09115f
C719 a_2784_6414# vss -0.01715f
C720 m1_3604_5840# vss 0.70567f
C721 stb vss 0.6057f
C722 m1_3612_4340# vss 1.03718f
C723 sta vss 0.76925f
C724 a_1880_6414# vss 0.17363f
C725 a_8208_6414# vss 0.21812f
C726 a_1428_6414# vss 0.14952f
C727 vdd vss 58.5788f
C728 m1_4406_2052# vss 0.1662f
C729 el vss 4.52287f
C730 a_5424_4114# vss 1.15557f
C731 a_7756_6414# vss 0.42508f
C732 m1_3716_1916# vss 1.10068f
C733 en vss 1.18749f
C734 m1_4066_6230# vss 0.92976f
C735 a_7304_6414# vss 1.05157f
C736 cl vss 5.42135f
C737 m1_176_6220# vss 0.30532f
C738 vbp_st vss 0.91284f
C739 m1_848_6220# vss 0.04718f
C740 m1_6958_6230# vss -0.09115f
C741 vbn_prb vss 1.95894f
C742 m1_1446_3050# vss 0.66034f
C743 m1_702_3050# vss 0.14641f
C744 a_1780_3360# vss 0.28496f
C745 m1_3886_4870# vss 0.07027f
C746 vbp_syn vss 0.71267f
C747 d vss 3.08078f
C748 a_788_4018# vss 0.24149f
C749 vsrc vss 2.64027f
C750 vbn_ref vss 1.89683f
C751 sel2 vss 1.40777f
C752 vreset vss 1.97702f
C753 a_488_5320# vss 0.09816f
C754 mreset vss 2.1153f
C755 vbn_leak vss 1.73465f
.ends
