* LVS reference for adex_a1: flattened from its cell file by layout/tier2/flatten.py
* MOM capacitors (Cfb, SC caps; values from PEX) omitted: XD.CFB
.subckt adex_a1 vm vw spk sel_adex sub0 sub1 sta stb hold mreset vbp_syn el vsrc vreset vbn_leak vbp_st vbn_ref vbn_prb vbp_w en abus vdd vss
XXC_XC vss vm vss vss nfet_03v3 W=7.07u L=7.07u
XXL_XMT XL.t vbn_leak vss vss nfet_03v3 W=2u L=4u
XXL_XM1 XL.a el XL.s1 vss nfet_03v3 W=4u L=0.5u
XXL_XD1 XL.s1 XL.s1 XL.t vss nfet_03v3 W=8u L=0.5u
XXL_XM2 vl vl XL.s2 vss nfet_03v3 W=4u L=0.5u
XXL_XD2 XL.s2 XL.s2 XL.t vss nfet_03v3 W=8u L=0.5u
XXL_XP1 XL.a XL.a vdd vdd pfet_03v3 W=2u L=4u
XXL_XP2 vl XL.a vdd vdd pfet_03v3 W=2u L=4u
XXD_XPS XD.s vbp_st vdd vdd pfet_03v3 W=1u L=2u
XXD_XPI XD.n1 vm XD.s vdd pfet_03v3 W=1u L=0.5u
XXD_XNI XD.n1 vm vsrc vss nfet_03v3 W=1u L=0.5u
XXD_XS2 XD.s2 vbp_st vdd vdd pfet_03v3 W=1u L=2u
XXD_XP2 XD.p XD.n1 XD.s2 vdd pfet_03v3 W=1u L=0.28u
XXD_XN2 XD.p XD.n1 vsrc vss nfet_03v3 W=0.22u L=2u
XXD_XS3 XD.s3 vbp_st vdd vdd pfet_03v3 W=1u L=2u
XXD_XP3 XD.pb XD.p XD.s3 vdd pfet_03v3 W=1u L=0.28u
XXD_XN3 XD.pb XD.p vsrc vss nfet_03v3 W=0.5u L=0.28u
XXD_XK XD.pb spk vdd vdd pfet_03v3 W=0.22u L=1u
XXD_Xi4_XN spk XD.pb vss vss nfet_03v3 W=0.5u L=0.28u
XXD_Xi4_XP spk XD.pb vdd vdd pfet_03v3 W=1u L=0.28u
XXR_Xi_XN XR.spkb spk vss vss nfet_03v3 W=0.5u L=0.28u
XXR_Xi_XP XR.spkb spk vdd vdd pfet_03v3 W=1u L=0.28u
XXR_XPC vr XR.spkb vdd vdd pfet_03v3 W=1u L=0.28u
XXR_XNR vr vbn_ref vss vss nfet_03v3 W=2u L=4u
XXR_XCR_XC vss vr vss vss nfet_03v3 W=3.54u L=3.54u
XXR_XSW vm vr vreset vss nfet_03v3 W=0.5u L=0.5u
XXS_XPH XS.h hold vdd vdd pfet_03v3 W=1u L=2u
XXS_XWA XS.da vbp_syn XS.h vdd pfet_03v3 W=2u L=4u
XXS_XWB XS.db vbp_syn XS.h vdd pfet_03v3 W=2u L=4u
XXS_XNA XS.da sta vm vss nfet_03v3 W=0.5u L=0.28u
XXS_XNB XS.db stb vm vss nfet_03v3 W=0.5u L=0.28u
XXS_XQA vss sta XS.da vdd pfet_03v3 W=1u L=0.28u
XXS_XQB vss stb XS.db vdd pfet_03v3 W=1u L=0.28u
XXS_XHL vm hold vl vdd pfet_03v3 W=1u L=0.28u
XXS_XMR vdd mreset vr vss nfet_03v3 W=0.5u L=0.28u
XXA_Xi_XS XA.Xi.s vbp_st vdd vdd pfet_03v3 W=1u L=2u
XXA_Xi_XP XA.vrb vr XA.Xi.s vdd pfet_03v3 W=1u L=0.28u
XXA_Xi_XN XA.vrb vr vss vss nfet_03v3 W=0.5u L=0.28u
XXA_XPS XA.t XA.vrb vdd vdd pfet_03v3 W=1u L=0.28u
XXA_XPW XA.s vbp_w XA.t vdd pfet_03v3 W=1u L=2u
XXA_XPA vw vw XA.s vdd pfet_03v3 W=0.5u L=2u
XXA_XPB vss vbn_leak XA.s vdd pfet_03v3 W=32u L=0.5u
XXA_XT1 vw vbn_leak XA.m1 vss nfet_03v3 W=0.5u L=10u
XXA_XT2 XA.m1 vbn_leak XA.m2 vss nfet_03v3 W=0.5u L=10u
XXA_XT3 XA.m2 vbn_leak XA.m3 vss nfet_03v3 W=0.5u L=10u
XXA_XT4 XA.m3 vbn_leak XA.m4 vss nfet_03v3 W=0.5u L=10u
XXA_XT5 XA.m4 vbn_leak vss vss nfet_03v3 W=0.5u L=10u
XXA_XCW vdd vw vdd vdd pfet_03v3 W=7.07u L=7.07u
XXA_XW vl vw vss vss nfet_03v3 W=4u L=1u
XXA_XR1 vw mreset XA.r vss nfet_03v3 W=0.22u L=2u
XXA_XR2 XA.r mreset vss vss nfet_03v3 W=0.22u L=2u
XXE_XE1 XE.e vm vsrc vss nfet_03v3 W=0.22u L=8u
XXE_XE2 XE.e XE.e vdd vdd pfet_03v3 W=2u L=0.5u
XXE_XE3 vl XE.e vdd vdd pfet_03v3 W=0.22u L=8u
XXP_Xi0_XN XP.s0b sub0 vss vss nfet_03v3 W=0.5u L=0.28u
XXP_Xi0_XP XP.s0b sub0 vdd vdd pfet_03v3 W=1u L=0.28u
XXP_Xi1_XN XP.s1b sub1 vss vss nfet_03v3 W=0.5u L=0.28u
XXP_Xi1_XP XP.s1b sub1 vdd vdd pfet_03v3 W=1u L=0.28u
XXP_XT0_XMF vdd vm XP.XT0.prb vss nfet_03v3 W=4u L=2u
XXP_XT0_XME XP.XT0.prb en XP.XT0.s vss nfet_03v3 W=1u L=0.28u
XXP_XT0_XMB XP.XT0.s vbn_prb vss vss nfet_03v3 W=2u L=2u
XXP_XT0_XSW XP.XT0.prb XP.s0b XP.m vss nfet_03v3 W=1u L=0.28u
XXP_XPE XP.t1 XP.s0b vdd vdd pfet_03v3 W=1u L=0.28u
XXP_XPB XP.p1 vbp_st XP.t1 vdd pfet_03v3 W=1u L=2u
XXP_XPF vss vw XP.p1 vdd pfet_03v3 W=2u L=0.5u
XXP_XS1 XP.p1 sub0 XP.m vss nfet_03v3 W=1u L=0.28u
XXP_XSA XP.m sel_adex XP.n vss nfet_03v3 W=1u L=0.28u
XXP_XSC XP.n XP.s1b abus vss nfet_03v3 W=1u L=0.28u
.ends adex_a1
