* LVS reference for slot_cmp_h: flattened from cells/neuron/slot.spice by layout/slot/flatten.py
* Cfb (MOM capacitor, value from PEX) omitted:
.subckt slot_cmp_h vm spk rsel sub sub_b el vsrc vreset vbn_leak vbp_st vbn_ref vbn_prb en abus vdd vss aux vbp_syn sta stb hold mreset
XXC_XC vss vm vss vss nfet_03v3 W=7.07u L=7.07u
XXL_XMT XL.t vbn_leak vss vss nfet_03v3 W=2u L=4u
XXL_XM1 la el XL.s1 vss nfet_03v3 W=4u L=1u
XXL_XD1 XL.s1 XL.s1 XL.t vss nfet_03v3 W=8u L=1u
XXL_XM2 vl vl XL.s2 vss nfet_03v3 W=4u L=1u
XXL_XD2 XL.s2 XL.s2 XL.t vss nfet_03v3 W=8u L=1u
XXL_XP1 la la vdd vdd pfet_03v3 W=2u L=4u
XXL_XP2 vl la vdd vdd pfet_03v3 W=2u L=4u
XXD_XPT XD.t vbp_st vdd vdd pfet_03v3 W=1u L=2u
XXD_XM1 XD.x vm XD.t vdd pfet_03v3 W=2u L=1u
XXD_XM2 XD.o aux XD.t vdd pfet_03v3 W=2u L=1u
XXD_XN1 XD.x XD.x vss vss nfet_03v3 W=1u L=2u
XXD_XN2 XD.o XD.x vss vss nfet_03v3 W=1u L=2u
XXD_XH2 XD.h vbp_st vdd vdd pfet_03v3 W=1u L=6u
XXD_XH1 XD.o XD.ob XD.h vdd pfet_03v3 W=1u L=0.28u
XXD_Xi1_XS XD.Xi1.s vbp_st vdd vdd pfet_03v3 W=1u L=2u
XXD_Xi1_XP XD.ob XD.o XD.Xi1.s vdd pfet_03v3 W=1u L=0.28u
XXD_Xi1_XN XD.ob XD.o vss vss nfet_03v3 W=0.5u L=0.28u
XXD_Xi2_XN spk XD.ob vss vss nfet_03v3 W=0.5u L=0.28u
XXD_Xi2_XP spk XD.ob vdd vdd pfet_03v3 W=1u L=0.28u
XXR_Xi_XN XR.spkb spk vss vss nfet_03v3 W=0.5u L=0.28u
XXR_Xi_XP XR.spkb spk vdd vdd pfet_03v3 W=1u L=0.28u
XXR_XPC vr XR.spkb vdd vdd pfet_03v3 W=1u L=0.28u
XXR_XNR vr vbn_ref vss vss nfet_03v3 W=2u L=4u
XXR_XCR_XC vss vr vss vss nfet_03v3 W=3.54u L=3.54u
XXR_XSW vm vr vreset vss nfet_03v3 W=0.5u L=0.5u
XXPM_XMF vdd vm XPM.prb vss nfet_03v3 W=4u L=2u
XXPM_XME XPM.prb en XPM.s vss nfet_03v3 W=1u L=0.28u
XXPM_XMB XPM.s vbn_prb vss vss nfet_03v3 W=2u L=2u
XXPM_XSC XPM.prb en XPM.mc vss nfet_03v3 W=1u L=0.28u
XXPM_XSW XPM.mc rsel XPM.m vss nfet_03v3 W=1u L=0.28u
XXPM_XSB XPM.m sub_b abus vss nfet_03v3 W=1u L=0.28u
XXPR_XMF vdd vr XPR.prb vss nfet_03v3 W=4u L=2u
XXPR_XME XPR.prb en XPR.s vss nfet_03v3 W=1u L=0.28u
XXPR_XMB XPR.s vbn_prb vss vss nfet_03v3 W=2u L=2u
XXPR_XSC XPR.prb en XPR.mc vss nfet_03v3 W=1u L=0.28u
XXPR_XSW XPR.mc rsel XPR.m vss nfet_03v3 W=1u L=0.28u
XXPR_XSB XPR.m sub abus vss nfet_03v3 W=1u L=0.28u
XXS_XPH XS.h hold vdd vdd pfet_03v3 W=1u L=2u
XXS_XWA XS.da vbp_syn XS.h vdd pfet_03v3 W=2u L=4u
XXS_XWB XS.db vbp_syn XS.h vdd pfet_03v3 W=2u L=4u
XXS_XNA XS.da sta vm vss nfet_03v3 W=0.5u L=0.28u
XXS_XNB XS.db stb vm vss nfet_03v3 W=0.5u L=0.28u
XXS_XQA vss sta XS.da vdd pfet_03v3 W=1u L=0.28u
XXS_XQB vss stb XS.db vdd pfet_03v3 W=1u L=0.28u
XXS_XHL vm hold vl vdd pfet_03v3 W=1u L=0.28u
XXS_XMR vdd mreset vr vss nfet_03v3 W=0.5u L=0.28u
.ends slot_cmp_h
