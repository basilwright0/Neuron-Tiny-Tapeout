* NGSPICE file created from slot_cmp_h.ext - technology: gf180mcuD

.subckt p_w2_l4 a_400_n200# a_n400_n244# w_n574_n330# a_n488_n200# VSUBS
X0 a_400_n200# a_n400_n244# a_n488_n200# w_n574_n330# pfet_03v3 ad=0.88p pd=4.88u as=0.88p ps=4.88u w=2u l=4u
C0 w_n574_n330# a_400_n200# 0.07409f
C1 a_400_n200# a_n400_n244# 0.07019f
C2 w_n574_n330# a_n488_n200# 0.07409f
C3 a_n488_n200# a_n400_n244# 0.07019f
C4 a_n488_n200# a_400_n200# 0.01073f
C5 w_n574_n330# a_n400_n244# 0.42229f
C6 a_400_n200# VSUBS 0.18936f
C7 a_n488_n200# VSUBS 0.18936f
C8 w_n574_n330# VSUBS 2.27304f
.ends

.subckt n_w1_l0p28 a_28_n100# a_n28_n144# a_n116_n100# VSUBS
X0 a_28_n100# a_n28_n144# a_n116_n100# VSUBS nfet_03v3 ad=0.44p pd=2.88u as=0.44p ps=2.88u w=1u l=0.28u
C0 a_n28_n144# a_28_n100# 0.00769f
C1 a_28_n100# a_n116_n100# 0.04256f
C2 a_n28_n144# a_n116_n100# 0.00769f
C3 a_28_n100# VSUBS 0.09911f
C4 a_n116_n100# VSUBS 0.09911f
.ends

.subckt n_w2_l2 a_n288_n200# a_200_n200# a_n200_n244# VSUBS
X0 a_200_n200# a_n200_n244# a_n288_n200# VSUBS nfet_03v3 ad=0.88p pd=4.88u as=0.88p ps=4.88u w=2u l=2u
C0 a_n200_n244# a_200_n200# 0.0587f
C1 a_200_n200# a_n288_n200# 0.02133f
C2 a_n200_n244# a_n288_n200# 0.0587f
C3 a_200_n200# VSUBS 0.2667f
C4 a_n288_n200# VSUBS 0.2667f
.ends

.subckt n_w2_l4 a_400_n200# a_n400_n244# a_n488_n200# VSUBS
X0 a_400_n200# a_n400_n244# a_n488_n200# VSUBS nfet_03v3 ad=0.88p pd=4.88u as=0.88p ps=4.88u w=2u l=4u
C0 a_n400_n244# a_400_n200# 0.07019f
C1 a_400_n200# a_n488_n200# 0.01073f
C2 a_n400_n244# a_n488_n200# 0.07019f
C3 a_400_n200# VSUBS 0.41684f
C4 a_n488_n200# VSUBS 0.41684f
.ends

.subckt n_w4_l0p5_k1 a_n188_n400# a_50_n400# a_n50_n444# VSUBS
X0 a_50_n400# a_n50_n444# a_n188_n400# VSUBS nfet_03v3 ad=2.76p pd=9.38u as=2.76p ps=9.38u w=4u l=0.5u
C0 a_n50_n444# a_50_n400# 0.04238f
C1 a_50_n400# a_n188_n400# 0.10174f
C2 a_n50_n444# a_n188_n400# 0.04238f
C3 a_50_n400# VSUBS 0.23105f
C4 a_n188_n400# VSUBS 0.23105f
.ends

.subckt n_w0p5_l0p28 a_n28_n94# a_n116_n50# a_28_n50# VSUBS
X0 a_28_n50# a_n28_n94# a_n116_n50# VSUBS nfet_03v3 ad=0.22p pd=1.88u as=0.22p ps=1.88u w=0.5u l=0.28u
C0 a_n28_n94# a_28_n50# 0.00377f
C1 a_28_n50# a_n116_n50# 0.02085f
C2 a_n28_n94# a_n116_n50# 0.00377f
C3 a_28_n50# VSUBS 0.07987f
C4 a_n116_n50# VSUBS 0.07987f
.ends

.subckt n_w1_l0p5 a_n138_n100# a_50_n100# a_n50_n144# VSUBS
X0 a_50_n100# a_n50_n144# a_n138_n100# VSUBS nfet_03v3 ad=0.44p pd=2.88u as=0.44p ps=2.88u w=1u l=0.5u
C0 a_n50_n144# a_50_n100# 0.01275f
C1 a_50_n100# a_n138_n100# 0.03085f
C2 a_n50_n144# a_n138_n100# 0.01275f
C3 a_50_n100# VSUBS 0.11563f
C4 a_n138_n100# VSUBS 0.11563f
.ends

.subckt p_w1_l0p28 w_n202_n230# a_28_n100# a_n28_n144# a_n116_n100# VSUBS
X0 a_28_n100# a_n28_n144# a_n116_n100# w_n202_n230# pfet_03v3 ad=0.44p pd=2.88u as=0.44p ps=2.88u w=1u l=0.28u
C0 w_n202_n230# a_28_n100# 0.01808f
C1 a_28_n100# a_n28_n144# 0.00769f
C2 w_n202_n230# a_n116_n100# 0.01808f
C3 a_n116_n100# a_n28_n144# 0.00769f
C4 a_n116_n100# a_28_n100# 0.04256f
C5 w_n202_n230# a_n28_n144# 0.05841f
C6 a_28_n100# VSUBS 0.0597f
C7 a_n116_n100# VSUBS 0.0597f
C8 w_n202_n230# VSUBS 0.55752f
.ends

.subckt n_w4_l2 a_n288_n400# a_200_n400# a_n200_n444# VSUBS
X0 a_200_n400# a_n200_n444# a_n288_n400# VSUBS nfet_03v3 ad=1.76p pd=8.88u as=1.76p ps=8.88u w=4u l=2u
C0 a_n200_n444# a_200_n400# 0.11799f
C1 a_200_n400# a_n288_n400# 0.04287f
C2 a_n200_n444# a_n288_n400# 0.11799f
C3 a_200_n400# VSUBS 0.34365f
C4 a_n288_n400# VSUBS 0.34365f
.ends

.subckt p_w1_l2 w_n374_n230# a_n288_n100# a_200_n100# a_n200_n144# VSUBS
X0 a_200_n100# a_n200_n144# a_n288_n100# w_n374_n230# pfet_03v3 ad=0.44p pd=2.88u as=0.44p ps=2.88u w=1u l=2u
C0 w_n374_n230# a_200_n100# 0.03135f
C1 a_200_n100# a_n200_n144# 0.02905f
C2 w_n374_n230# a_n288_n100# 0.03135f
C3 a_n288_n100# a_n200_n144# 0.02905f
C4 a_n288_n100# a_200_n100# 0.01056f
C5 w_n374_n230# a_n200_n144# 0.22666f
C6 a_200_n100# VSUBS 0.1047f
C7 a_n288_n100# VSUBS 0.1047f
C8 w_n374_n230# VSUBS 1.03224f
.ends

.subckt n_w7p07_l7p07 a_707_n707# a_n795_n707# a_n707_n751# VSUBS
X0 a_707_n707# a_n707_n751# a_n795_n707# VSUBS nfet_03v3 ad=3.1108p pd=15.02u as=3.1108p ps=15.02u w=7.07u l=7.07u
C0 a_n707_n751# a_707_n707# 0.27012f
C1 a_707_n707# a_n795_n707# 0.0212f
C2 a_n707_n751# a_n795_n707# 0.27012f
C3 a_707_n707# VSUBS 0.84237f
C4 a_n795_n707# VSUBS 0.84237f
.ends

.subckt n_w0p5_l1p5 a_150_n50# a_n238_n50# a_n150_n94# VSUBS
X0 a_150_n50# a_n150_n94# a_n238_n50# VSUBS nfet_03v3 ad=0.22p pd=1.88u as=0.22p ps=1.88u w=0.5u l=1.5u
C0 a_n150_n94# a_150_n50# 0.01269f
C1 a_150_n50# a_n238_n50# 0.00671f
C2 a_n150_n94# a_n238_n50# 0.01269f
C3 a_150_n50# VSUBS 0.17146f
C4 a_n238_n50# VSUBS 0.17146f
.ends

.subckt n_w1_l2 a_n288_n100# a_200_n100# a_n200_n144# VSUBS
X0 a_200_n100# a_n200_n144# a_n288_n100# VSUBS nfet_03v3 ad=0.44p pd=2.88u as=0.44p ps=2.88u w=1u l=2u
C0 a_n200_n144# a_200_n100# 0.02905f
C1 a_200_n100# a_n288_n100# 0.01056f
C2 a_n200_n144# a_n288_n100# 0.02905f
C3 a_200_n100# VSUBS 0.22823f
C4 a_n288_n100# VSUBS 0.22823f
.ends

.subckt n_w3p54_l3p54 a_354_n354# a_n354_n398# a_n442_n354# VSUBS
X0 a_354_n354# a_n354_n398# a_n442_n354# VSUBS nfet_03v3 ad=1.5576p pd=7.96u as=1.5576p ps=7.96u w=3.54u l=3.54u
C0 a_n354_n398# a_354_n354# 0.12189f
C1 a_354_n354# a_n442_n354# 0.02161f
C2 a_n354_n398# a_n442_n354# 0.12189f
C3 a_354_n354# VSUBS 0.44156f
C4 a_n442_n354# VSUBS 0.44156f
.ends

.subckt p_w2_l1 a_100_n200# a_n100_n244# w_n274_n330# a_n188_n200# VSUBS
X0 a_100_n200# a_n100_n244# a_n188_n200# w_n274_n330# pfet_03v3 ad=0.88p pd=4.88u as=0.88p ps=4.88u w=2u l=1u
C0 w_n274_n330# a_100_n200# 0.04851f
C1 a_100_n200# a_n100_n244# 0.04231f
C2 w_n274_n330# a_n188_n200# 0.04851f
C3 a_n188_n200# a_n100_n244# 0.04231f
C4 a_n188_n200# a_100_n200# 0.03858f
C5 w_n274_n330# a_n100_n244# 0.12884f
C6 a_100_n200# VSUBS 0.11088f
C7 a_n188_n200# VSUBS 0.11088f
C8 w_n274_n330# VSUBS 1.08504f
.ends

.subckt n_w0p5_l3 a_n388_n50# a_300_n50# a_n300_n94# VSUBS
X0 a_300_n50# a_n300_n94# a_n388_n50# VSUBS nfet_03v3 ad=0.22p pd=1.88u as=0.22p ps=1.88u w=0.5u l=3u
C0 a_n300_n94# a_300_n50# 0.01602f
C1 a_300_n50# a_n388_n50# 0.00348f
C2 a_n300_n94# a_n388_n50# 0.01602f
C3 a_300_n50# VSUBS 0.28406f
C4 a_n388_n50# VSUBS 0.28406f
.ends

.subckt p_w1_l6 w_n774_n230# a_n688_n100# a_600_n100# a_n600_n144# VSUBS
X0 a_600_n100# a_n600_n144# a_n688_n100# w_n774_n230# pfet_03v3 ad=0.44p pd=2.88u as=0.44p ps=2.88u w=1u l=6u
C0 w_n774_n230# a_600_n100# 0.03955f
C1 a_600_n100# a_n600_n144# 0.03688f
C2 w_n774_n230# a_n688_n100# 0.03955f
C3 a_n688_n100# a_n600_n144# 0.03688f
C4 a_n688_n100# a_600_n100# 0.00349f
C5 w_n774_n230# a_n600_n144# 0.61793f
C6 a_600_n100# VSUBS 0.20933f
C7 a_n688_n100# VSUBS 0.20933f
C8 w_n774_n230# VSUBS 2.13624f
.ends

.subckt n_w0p5_l4 a_n488_n50# a_400_n50# a_n400_n94# VSUBS
X0 a_400_n50# a_n400_n94# a_n488_n50# VSUBS nfet_03v3 ad=0.22p pd=1.88u as=0.22p ps=1.88u w=0.5u l=4u
C0 a_n400_n94# a_400_n50# 0.01702f
C1 a_400_n50# a_n488_n50# 0.0026f
C2 a_n400_n94# a_n488_n50# 0.01702f
C3 a_400_n50# VSUBS 0.35913f
C4 a_n488_n50# VSUBS 0.35913f
.ends

.subckt slot_cmp_h vss vbp_syn vdd el aux vbn_leak vsrc vbp_st vbn_prb vbn_ref en
+ vreset abus spk t3 t2 t1 t0 sta stb hold mreset rsel sub sub_b vm
XXL_XP1 a_480_5620# a_480_5620# vdd vdd vss p_w2_l4
XXPM_XSW m1_4052_1572# rsel m1_3704_1572# vss n_w1_l0p28
XXL_XP2 a_1682_2940# a_480_5620# vdd vdd vss p_w2_l4
XXPR_XMB vss m1_4802_1762# vbn_prb vss n_w2_l2
XXL_XMT m1_644_2570# vbn_leak vss vss n_w2_l4
XXL_XM1 a_338_2940# a_480_5620# el vss n_w4_l0p5_k1
XXS_XWA m1_4902_6422# vbp_syn vdd m1_3600_6548# vss p_w2_l4
XXR_Xi_XN spk vss a_2784_4734# vss n_w0p5_l0p28
XXL_XM2 a_2130_2940# a_1682_2940# a_1682_2940# vss n_w4_l0p5_k1
XXS_XWB m1_4902_6422# vbp_syn vdd m1_3188_6220# vss p_w2_l4
XXR_XNR vss vbn_ref a_2510_1740# vss n_w2_l4
XXPR_XME m1_2448_868# en m1_4802_1762# vss n_w1_l0p28
XXR_XSW vreset vm a_2510_1740# vss n_w1_l0p5
XXR_Xi_XP vdd a_2784_4734# spk vdd vss p_w1_l0p28
XXPR_XMF m1_2448_868# vdd a_2510_1740# vss n_w4_l2
XXS_XQA vdd m1_3600_6548# sta vss vss p_w1_l0p28
XXS_XQB vdd m1_3188_6220# stb vss vss p_w1_l0p28
XXS_XNA sta vm m1_3600_6548# vss n_w0p5_l0p28
XXS_XNB stb vm m1_3188_6220# vss n_w0p5_l0p28
XXD_XPT vdd vdd m1_3052_4742# a_368_4070# vss p_w1_l2
XXL_XD2a m1_644_2570# a_2130_2940# a_2130_2940# vss n_w4_l0p5_k1
XXPM_XSB abus sub_b m1_4052_1572# vss n_w1_l0p28
XXL_XD2b m1_644_2570# a_2130_2940# a_2130_2940# vss n_w4_l0p5_k1
XXL_XD1a m1_644_2570# a_338_2940# a_338_2940# vss n_w4_l0p5_k1
XXPM_XSC m1_3704_1572# en m1_3360_172# vss n_w1_l0p28
XXC_XC vss vss vm vss n_w7p07_l7p07
XXT_XR1 m1_2020_9600# m1_1540_9160# vbn_leak vss n_w0p5_l1p5
XXS_XPH vdd m1_4902_6422# vdd hold vss p_w1_l2
XXD_Xi1_XN a_1684_3624# vss a_1424_4734# vss n_w0p5_l0p28
XXL_XD1b m1_644_2570# a_338_2940# a_338_2940# vss n_w4_l0p5_k1
XXPR_XSW m1_2972_1572# rsel m1_2280_960# vss n_w1_l0p28
XXT_XR2 m1_208_9160# m1_2020_9600# vbn_leak vss n_w0p5_l1p5
XXT_XP0 vdd m1_2436_8920# t0 vm vss p_w1_l0p28
XXD_XN1 a_2720_3620# vss a_2720_3620# vss n_w1_l2
XXT_XR3 m1_236_9612# m1_208_9160# vbn_leak vss n_w0p5_l1p5
XXT_XP1 vdd m1_1960_6220# t1 vm vss p_w1_l0p28
XXR_XCR_XC vss a_2510_1740# vss vss n_w3p54_l3p54
XXD_XN2 vss a_1684_3624# a_2720_3620# vss n_w1_l2
XXD_XM1 a_2720_3620# vm vdd m1_3052_4742# vss p_w2_l1
XXD_Xi1_XP vdd a_1424_4734# a_1684_3624# m1_1092_4130# vss p_w1_l0p28
XXT_XN0 t0 a_480_5620# m1_2436_8920# vss n_w0p5_l0p28
XXT_XP2 vdd m1_1400_6220# t2 vm vss p_w1_l0p28
XXD_XM2 a_1684_3624# aux vdd m1_3052_4742# vss p_w2_l1
XXPM_XMB vss m1_4822_412# vbn_prb vss n_w2_l2
XXT_XN1 t1 a_480_5620# m1_1960_6220# vss n_w0p5_l0p28
XXT_XP3 vdd m1_841_6220# t3 vm vss p_w1_l0p28
XXT_XL0 m1_2436_8920# m1_236_9612# vbn_leak vss n_w0p5_l3
XXT_XLT m1_236_9612# vdd vbn_leak vss n_w0p5_l3
XXT_XN2 t2 a_480_5620# m1_1400_6220# vss n_w0p5_l0p28
XXD_Xi1_XS vdd vdd m1_1092_4130# a_368_4070# vss p_w1_l2
XXT_XL1 m1_1960_6220# m1_208_9160# vbn_leak vss n_w0p5_l3
XXT_XN3 t3 a_480_5620# m1_841_6220# vss n_w0p5_l0p28
XXR_XPC vdd a_2510_1740# a_2784_4734# vdd vss p_w1_l0p28
XXD_XH1 vdd a_1684_3624# a_1424_4734# m1_1244_4440# vss p_w1_l0p28
XXPM_XME m1_3360_172# en m1_4822_412# vss n_w1_l0p28
XXT_XL2 m1_1400_6220# m1_2020_9600# vbn_leak vss n_w0p5_l3
XXT_XL3 m1_841_6220# m1_1540_9160# vbn_leak vss n_w0p5_l3
XXD_XH2 vdd vdd m1_1244_4440# a_368_4070# vss p_w1_l6
XXPM_XMF m1_3360_172# vdd vm vss n_w4_l2
XXPC vdd vdd a_368_4070# a_368_4070# vss p_w1_l2
XXNC a_368_4070# vss vbn_prb vss n_w2_l2
XXS_XHL vdd vm hold a_1682_2940# vss p_w1_l0p28
XXD_Xi2_XN a_1424_4734# vss spk vss n_w0p5_l0p28
XXS_XMR mreset a_2510_1740# vdd vss n_w0p5_l0p28
XXD_Xi2_XP vdd spk a_1424_4734# vdd vss p_w1_l0p28
XXPR_XSB abus sub m1_2972_1572# vss n_w1_l0p28
XXPR_XSC m1_2448_868# en m1_2280_960# vss n_w1_l0p28
XXT_XRB m1_1104_10052# m1_1540_9160# vbn_leak vss n_w0p5_l4
XXT_XRA vss m1_1104_10052# vbn_leak vss n_w0p5_l4
C0 a_1684_3624# vbp_st 0
C1 m1_1104_10052# m1_2020_9600# 0.00135f
C2 vbn_prb a_2510_1740# 0.10968f
C3 el vbp_st 0
C4 m1_2448_868# m1_4052_1572# 0.01864f
C5 a_2720_3620# vm 0.06151f
C6 m1_208_9160# m1_2020_9600# 0.0066f
C7 m1_3704_1572# vm 0.00228f
C8 m1_2280_960# vm 0.20694f
C9 m1_2448_868# a_2130_2940# 0
C10 m1_644_2570# a_2720_3620# 0.00377f
C11 a_368_4070# a_480_5620# 0.36744f
C12 m1_3600_6548# t0 0
C13 hold m1_841_6220# 0.03667f
C14 m1_3704_1572# m1_644_2570# 0
C15 sub en 0.02611f
C16 m1_2280_960# m1_644_2570# 0.00243f
C17 a_2130_2940# a_1682_2940# 0.11573f
C18 m1_1960_6220# m1_236_9612# 0.00262f
C19 stb hold 0.00185f
C20 spk m1_1400_6220# 0
C21 vdd t0 0.10654f
C22 sub_b sta 0.0244f
C23 m1_208_9160# m1_841_6220# 0.04681f
C24 a_368_4070# vbn_ref 0
C25 hold m1_1960_6220# 0.03609f
C26 m1_3188_6220# sub_b 0.05477f
C27 rsel a_2720_3620# 0.1f
C28 vm sta 0.05544f
C29 rsel m1_3704_1572# 0.0208f
C30 abus a_1684_3624# 0
C31 a_2720_3620# vbn_leak 0.01103f
C32 mreset vbn_prb 0
C33 rsel m1_2280_960# 0.00355f
C34 m1_3704_1572# vbn_leak 0
C35 m1_2280_960# vbn_leak 0
C36 abus el 0.03394f
C37 m1_3360_172# sub_b 0.00256f
C38 m1_2436_8920# m1_3600_6548# 0.00104f
C39 vm m1_3188_6220# 0.04184f
C40 a_480_5620# m1_841_6220# 0.24585f
C41 m1_1400_6220# t1 0.00121f
C42 m1_208_9160# m1_1960_6220# 0.10334f
C43 a_2720_3620# vreset 0
C44 m1_3704_1572# vreset 0.00107f
C45 m1_2448_868# vsrc 0.04105f
C46 m1_2280_960# vreset 0.16931f
C47 sub_b a_2510_1740# 0.05238f
C48 m1_3360_172# vm 0.23882f
C49 stb a_480_5620# 0
C50 t0 m1_236_9612# 0.00103f
C51 m1_3360_172# m1_644_2570# 0
C52 a_2720_3620# sub 0.07481f
C53 vm a_2510_1740# 0.17879f
C54 m1_2280_960# sub 0
C55 vdd m1_2436_8920# 0.03679f
C56 m1_644_2570# a_2510_1740# 0.07629f
C57 a_480_5620# m1_1960_6220# 0.11283f
C58 vbp_syn a_1684_3624# 0.2086f
C59 a_480_5620# a_338_2940# -0.03481f
C60 vbn_leak sta 0
C61 vbp_syn el 0.11642f
C62 a_1684_3624# spk 0.11825f
C63 t0 hold 0.06366f
C64 m1_1540_9160# vdd 0.01627f
C65 el spk 0
C66 m1_2448_868# vdd 0.23336f
C67 a_2720_3620# en 0
C68 vm m1_1092_4130# 0.01117f
C69 m1_3052_4742# vbp_syn 0.04305f
C70 m1_3704_1572# en 0.00127f
C71 m1_4822_412# vbn_prb 0.07062f
C72 m1_2280_960# en 0.11659f
C73 vdd a_1682_2940# 0.6863f
C74 vreset sta 0
C75 m1_644_2570# m1_1092_4130# 0
C76 m1_2448_868# aux 0.03231f
C77 rsel m1_3360_172# 0.00595f
C78 m1_3052_4742# spk 0.00151f
C79 m1_3360_172# vbn_leak 0.03045f
C80 abus m1_4052_1572# 0.00965f
C81 a_368_4070# stb 0.0011f
C82 mreset sub_b 0.00222f
C83 m1_208_9160# t0 0.04172f
C84 a_2784_4734# sub_b 0
C85 rsel a_2510_1740# 0.20649f
C86 sub sta 0
C87 m1_2436_8920# m1_236_9612# 0.02764f
C88 vbn_leak a_2510_1740# 0.28356f
C89 vbp_st vsrc 3.28878f
C90 m1_3360_172# vreset 0.03486f
C91 a_368_4070# m1_1960_6220# 0
C92 m1_1244_4440# a_1682_2940# 0.00573f
C93 vm a_2784_4734# 0.0128f
C94 m1_1540_9160# m1_236_9612# 0.04408f
C95 m1_3188_6220# sub 0
C96 a_368_4070# a_338_2940# 0.01045f
C97 m1_644_2570# a_2784_4734# 0.00166f
C98 vreset a_2510_1740# 0.0694f
C99 a_1424_4734# spk 0.24309f
C100 a_480_5620# t0 0.06179f
C101 m1_2436_8920# hold 0.27015f
C102 m1_3360_172# sub 0.00189f
C103 rsel m1_1092_4130# 0.19318f
C104 sta en 0
C105 m1_2020_9600# m1_1960_6220# 0.00275f
C106 m1_1400_6220# t2 0.27577f
C107 m1_1540_9160# hold 0
C108 sub a_2510_1740# 0.29089f
C109 vbp_syn a_2130_2940# 0
C110 m1_1400_6220# sub_b 0
C111 vdd vbp_st 0.19972f
C112 a_1684_3624# vbn_prb 0.00734f
C113 a_2130_2940# spk 0.01604f
C114 a_1682_2940# hold 0.03072f
C115 m1_3360_172# en 0.14838f
C116 el vbn_prb 0.02832f
C117 m1_208_9160# m1_2436_8920# 0.11451f
C118 vbp_st aux 0
C119 m1_4902_6422# vbp_st 0.07319f
C120 vm m1_1400_6220# 0.0616f
C121 mreset vbn_leak 0.02825f
C122 rsel a_2784_4734# 0.02728f
C123 m1_1540_9160# m1_1104_10052# 0.00844f
C124 abus vsrc 0.09648f
C125 m1_3704_1572# m1_2280_960# 0
C126 vbn_leak a_2784_4734# 0
C127 sub m1_1092_4130# 0
C128 a_2510_1740# en 0.08714f
C129 m1_1540_9160# m1_208_9160# 0.01189f
C130 m1_841_6220# m1_1960_6220# 0
C131 vm m1_4822_412# 0
C132 a_368_4070# t0 0.00159f
C133 mreset vreset 0
C134 stb m1_1960_6220# 0
C135 m1_2436_8920# a_480_5620# 0.01379f
C136 vbp_st m1_236_9612# 0
C137 sub a_2784_4734# 0.25103f
C138 abus vdd 0.19176f
C139 rsel m1_1400_6220# 0.51159f
C140 a_480_5620# a_1682_2940# 0.95109f
C141 vbp_syn vsrc 0.22096f
C142 vbn_leak m1_1400_6220# 0.06934f
C143 abus m1_4902_6422# 0
C144 m1_2448_868# m1_2972_1572# 0.01408f
C145 abus aux 0.03464f
C146 vbp_st hold 0.03353f
C147 vbp_syn m1_3600_6548# 0.10055f
C148 mreset en 0
C149 vbn_leak m1_4822_412# 0.00239f
C150 m1_4052_1572# vbn_prb 0
C151 a_1684_3624# sub_b 0.0081f
C152 el sub_b 0.32639f
C153 a_2130_2940# vbn_prb 0
C154 a_368_4070# m1_2436_8920# 0.00161f
C155 m1_3704_1572# m1_3360_172# 0.01037f
C156 m1_2448_868# vbn_ref 0.03511f
C157 m1_3360_172# m1_2280_960# 0.00125f
C158 vm a_1684_3624# 0.02298f
C159 vreset m1_4822_412# 0.02237f
C160 a_2720_3620# a_2510_1740# 0.49003f
C161 el vm 0.63007f
C162 m1_3052_4742# sub_b 0.00768f
C163 m1_208_9160# vbp_st 0
C164 m1_3704_1572# a_2510_1740# 0
C165 m1_644_2570# a_1684_3624# 0.01137f
C166 stb t0 0.00219f
C167 m1_2280_960# a_2510_1740# 0.13552f
C168 vdd vbp_syn 5.0366f
C169 m1_644_2570# el 0.12834f
C170 m1_2436_8920# m1_2020_9600# 0.0059f
C171 vdd spk 0.70269f
C172 vbp_syn m1_4902_6422# 0.36896f
C173 a_368_4070# a_1682_2940# 0.34825f
C174 vbp_syn aux 0.12461f
C175 m1_3052_4742# vm 0.15293f
C176 t0 m1_1960_6220# 0.09391f
C177 spk aux 0
C178 m1_1540_9160# m1_2020_9600# 0.08003f
C179 m1_3188_6220# sta 0.20875f
C180 a_2720_3620# m1_1092_4130# 0
C181 abus hold 0
C182 vdd t3 0.12018f
C183 m1_1244_4440# spk 0.00326f
C184 m1_2436_8920# m1_841_6220# 0
C185 m1_4822_412# en 0.08642f
C186 rsel a_1684_3624# 0.36345f
C187 vbn_leak a_1684_3624# 0.00455f
C188 rsel el 0.00858f
C189 sta a_2510_1740# 0
C190 vbp_syn m1_236_9612# 0.00373f
C191 vsrc vbn_prb 0.05121f
C192 a_1424_4734# vm 0.00562f
C193 el vbn_leak 0.06175f
C194 m1_1540_9160# m1_841_6220# -0
C195 m1_4052_1572# sub_b 0.00909f
C196 a_1424_4734# m1_644_2570# 0.00852f
C197 a_2720_3620# a_2784_4734# 0.02135f
C198 vdd t1 0.1194f
C199 m1_2436_8920# stb 0.00869f
C200 vbn_ref vbp_st 0.04128f
C201 m1_3188_6220# a_2510_1740# 0.05905f
C202 a_2130_2940# sub_b 0.00676f
C203 a_1684_3624# vreset 0
C204 m1_3052_4742# vbn_leak 0
C205 el vreset 0.35481f
C206 vm m1_4052_1572# 0
C207 a_1682_2940# m1_841_6220# 0.00164f
C208 m1_3360_172# a_2510_1740# 0.01314f
C209 vbp_syn hold 0.55871f
C210 m1_2436_8920# m1_1960_6220# 0.00178f
C211 a_2130_2940# vm 0.03399f
C212 a_368_4070# vbp_st 0
C213 spk hold 0.09606f
C214 t3 m1_236_9612# 0.00386f
C215 sub a_1684_3624# 0.05092f
C216 m1_644_2570# a_2130_2940# 0.46888f
C217 el sub 0
C218 m1_1540_9160# m1_1960_6220# 0.0011f
C219 vdd vbn_prb 0.2328f
C220 abus m1_2972_1572# 0.00853f
C221 m1_4902_6422# vbn_prb 0.10591f
C222 rsel a_1424_4734# 0.1635f
C223 vbn_prb aux 0.06354f
C224 t1 m1_236_9612# 0.00103f
C225 m1_3052_4742# sub 0.01444f
C226 vbp_syn m1_208_9160# 0.04668f
C227 hold t3 0.19131f
C228 mreset sta 0.01573f
C229 m1_208_9160# spk 0.00166f
C230 a_1682_2940# a_338_2940# 0.01529f
C231 a_1684_3624# en 0
C232 m1_1092_4130# a_2510_1740# 0
C233 el en 0.18647f
C234 abus vbn_ref 0.07643f
C235 mreset m1_3188_6220# 0.05939f
C236 rsel m1_4052_1572# 0
C237 vbn_leak m1_4052_1572# 0.00484f
C238 hold t1 0.03581f
C239 rsel a_2130_2940# 0.00884f
C240 vsrc sub_b 0.02771f
C241 a_2130_2940# vbn_leak 0.01792f
C242 vbp_syn a_480_5620# 0
C243 m1_208_9160# t3 0.05548f
C244 a_480_5620# spk 0.13757f
C245 vbn_prb m1_236_9612# 0
C246 a_1424_4734# sub 0
C247 vbp_syn m1_2972_1572# 0
C248 m1_3600_6548# sub_b 0.046f
C249 m1_4052_1572# vreset 0.001f
C250 m1_2436_8920# t0 0.45617f
C251 vm vsrc 0
C252 mreset a_2510_1740# 0.05899f
C253 a_2130_2940# vreset 0
C254 a_2784_4734# a_2510_1740# 0.0043f
C255 m1_644_2570# vsrc 0.00106f
C256 vm m1_3600_6548# 0.02386f
C257 m1_208_9160# t1 0.028f
C258 vsrc m1_4802_1762# 0.00103f
C259 vdd t2 0.13013f
C260 hold vbn_prb 0.05309f
C261 a_480_5620# t3 0.16917f
C262 vbp_syn vbn_ref 0.09319f
C263 a_2130_2940# sub 0.02978f
C264 a_1682_2940# t0 0
C265 vdd sub_b 0.76053f
C266 a_2784_4734# m1_1092_4130# 0
C267 m1_4902_6422# sub_b 0
C268 aux sub_b 0.15595f
C269 a_368_4070# vbp_syn 0.35953f
C270 a_480_5620# t1 0.19229f
C271 vdd vm 2.28415f
C272 m1_4052_1572# en 0.00116f
C273 a_368_4070# spk 0.08043f
C274 a_2720_3620# a_1684_3624# 0.38477f
C275 m1_1244_4440# t2 0
C276 m1_208_9160# vbn_prb 0
C277 rsel vsrc 0
C278 vdd m1_644_2570# 0.03552f
C279 a_2130_2940# en 0.00619f
C280 a_2720_3620# el 0
C281 vm aux 0.0064f
C282 vbn_leak vsrc 3.29215f
C283 m1_3360_172# m1_4822_412# 0.05008f
C284 m1_2280_960# el 0.01386f
C285 m1_644_2570# aux 0.00316f
C286 vbp_syn m1_2020_9600# 0
C287 t2 m1_236_9612# 0.00103f
C288 m1_3052_4742# a_2720_3620# 0.16899f
C289 m1_1244_4440# vm 0.00133f
C290 m1_1540_9160# m1_2436_8920# 0
C291 vreset vsrc 0.03535f
C292 m1_1244_4440# m1_644_2570# 0.0048f
C293 hold t2 0.03581f
C294 rsel vdd 0.89436f
C295 vdd vbn_leak 0.42925f
C296 hold sub_b 0.0409f
C297 rsel aux 0.00389f
C298 sub m1_3600_6548# 0
C299 a_1424_4734# a_2720_3620# 0.00284f
C300 el sta 0
C301 vbn_leak m1_4902_6422# 0.0032f
C302 vbn_leak aux 3.35487f
C303 spk m1_841_6220# 0
C304 vbn_ref vbn_prb 3.45615f
C305 vbp_syn stb 0.00106f
C306 vm hold 0.02231f
C307 m1_1104_10052# t2 0
C308 vdd vreset 0.26306f
C309 el m1_3188_6220# 0.02368f
C310 vsrc en 0.06535f
C311 m1_208_9160# t2 0.03144f
C312 m1_1244_4440# rsel 0.12214f
C313 stb spk 0
C314 m1_4902_6422# vreset 0
C315 vreset aux 0.03533f
C316 m1_3704_1572# m1_4052_1572# 0
C317 a_368_4070# vbn_prb 0
C318 m1_3360_172# el 0.0484f
C319 m1_2280_960# m1_4052_1572# 0
C320 a_2130_2940# a_2720_3620# 0.01131f
C321 m1_841_6220# t3 0.27267f
C322 vdd sub 0.35439f
C323 m1_2280_960# a_2130_2940# 0.005f
C324 a_1684_3624# a_2510_1740# 0.21836f
C325 spk m1_1960_6220# 0.25688f
C326 rsel m1_236_9612# 0.04112f
C327 sub aux 0.00125f
C328 vbn_leak m1_236_9612# 0.83992f
C329 el a_2510_1740# 0.15529f
C330 a_480_5620# t2 0.23204f
C331 m1_3052_4742# a_2510_1740# 0.17913f
C332 vdd en 0.2981f
C333 rsel hold 0.02756f
C334 a_1684_3624# m1_1092_4130# 0.19226f
C335 vbn_leak hold 0.03595f
C336 stb t1 0
C337 m1_4902_6422# en 0.00861f
C338 aux en 0.06544f
C339 el m1_1092_4130# 0
C340 a_480_5620# vm 0.45397f
C341 m1_2448_868# vbp_st 0.03217f
C342 m1_644_2570# a_480_5620# 0.02804f
C343 m1_2972_1572# vm 0.00417f
C344 vreset hold 0.02317f
C345 t1 m1_1960_6220# 0.27252f
C346 rsel m1_1104_10052# 0
C347 m1_2972_1572# m1_644_2570# 0.00144f
C348 vbn_ref sub_b 0.02617f
C349 vbn_leak m1_1104_10052# 0.0079f
C350 rsel m1_208_9160# 0.05303f
C351 a_1424_4734# a_2510_1740# 0
C352 m1_208_9160# vbn_leak 0.35843f
C353 a_2720_3620# vsrc 0
C354 a_2784_4734# a_1684_3624# 0.04876f
C355 vbp_syn t0 0
C356 a_368_4070# t2 0
C357 mreset el 0.05943f
C358 sub hold 0.09874f
C359 el a_2784_4734# 0
C360 vbn_ref vm 0
C361 t0 spk 0.24512f
C362 a_368_4070# sub_b 0.42383f
C363 m1_644_2570# vbn_ref 0
C364 m1_4052_1572# a_2510_1740# 0
C365 vbn_ref m1_4802_1762# 0.07727f
C366 m1_3052_4742# a_2784_4734# 0.02255f
C367 a_2130_2940# a_2510_1740# 0.19304f
C368 rsel a_480_5620# 0.25711f
C369 a_368_4070# vm 0.6154f
C370 a_1424_4734# m1_1092_4130# 0.12332f
C371 a_480_5620# vbn_leak 0
C372 a_368_4070# m1_644_2570# 0.00621f
C373 abus m1_2448_868# 0.06404f
C374 hold en 0.17277f
C375 rsel m1_2972_1572# 0.01326f
C376 m1_2972_1572# vbn_leak 0
C377 vdd a_2720_3620# 0.14673f
C378 m1_3704_1572# vdd 0.03441f
C379 vdd m1_2280_960# 0.00138f
C380 a_2720_3620# aux 0.00232f
C381 vsrc sta 0
C382 m1_2972_1572# vreset 0.0031f
C383 t0 t1 0.0144f
C384 m1_2280_960# aux 0
C385 rsel vbn_ref 0
C386 a_1424_4734# a_2784_4734# 0.03005f
C387 vbp_syn m1_2436_8920# 0
C388 vbn_ref vbn_leak 0.0143f
C389 m1_841_6220# t2 0.20943f
C390 a_480_5620# sub 0
C391 m1_3600_6548# sta 0.13964f
C392 m1_2436_8920# spk 0.0424f
C393 el m1_4822_412# 0.00123f
C394 m1_2972_1572# sub 0.01112f
C395 a_368_4070# rsel 0.15386f
C396 m1_3188_6220# m1_3600_6548# 0.04544f
C397 m1_3360_172# vsrc 0.02779f
C398 vbn_ref vreset 0.04923f
C399 a_368_4070# vbn_leak 0.05484f
C400 m1_2448_868# vbp_syn 0.03995f
C401 a_2130_2940# a_2784_4734# 0.01119f
C402 stb sub_b 0.1259f
C403 vm m1_841_6220# 0.03544f
C404 vbp_syn a_1682_2940# 0
C405 vsrc a_2510_1740# 0.11605f
C406 t2 m1_1960_6220# 0
C407 a_1682_2940# spk 0.09451f
C408 a_368_4070# vreset 0
C409 vdd sta 0.20151f
C410 stb vm 0.04439f
C411 rsel m1_2020_9600# 0.09894f
C412 sub_b m1_1960_6220# 0
C413 vbn_leak m1_2020_9600# 0.28886f
C414 m1_3600_6548# a_2510_1740# 0.04909f
C415 m1_4902_6422# sta 0
C416 aux sta 0
C417 abus vbp_st 0.1108f
C418 a_1424_4734# m1_1400_6220# 0.00125f
C419 vdd m1_3188_6220# 0.22381f
C420 m1_2436_8920# t1 0
C421 a_368_4070# sub 0.15685f
C422 m1_3188_6220# m1_4902_6422# -0.01073f
C423 m1_3188_6220# aux 0.00155f
C424 vm m1_1960_6220# 0.07636f
C425 a_1682_2940# t3 0.00526f
C426 vdd m1_3360_172# 0.31893f
C427 vm a_338_2940# 0.21631f
C428 vbn_ref en 3.44676f
C429 m1_3360_172# aux 0.02978f
C430 m1_644_2570# a_338_2940# 0.39381f
C431 vdd a_2510_1740# 1.24379f
C432 el a_1684_3624# 0.0081f
C433 vbn_leak m1_841_6220# 0.03737f
C434 a_1682_2940# t1 0.00125f
C435 m1_4902_6422# a_2510_1740# 0.0283f
C436 a_368_4070# en 0.00111f
C437 aux a_2510_1740# 0.34915f
C438 mreset vsrc 0.01081f
C439 rsel stb 0
C440 m1_3052_4742# a_1684_3624# 0.11374f
C441 vbp_syn vbp_st 0.16809f
C442 m1_3052_4742# el 0
C443 mreset m1_3600_6548# 0.03296f
C444 t0 t2 0
C445 vdd m1_1092_4130# 0.54338f
C446 hold sta 0
C447 rsel m1_1960_6220# 0.04269f
C448 m1_2448_868# vbn_prb 0.11982f
C449 t0 sub_b 0.01099f
C450 vbn_leak m1_1960_6220# 0.01622f
C451 a_2720_3620# a_480_5620# 0
C452 m1_3188_6220# hold 0
C453 vm t0 0.04559f
C454 m1_2280_960# m1_2972_1572# 0
C455 m1_1244_4440# m1_1092_4130# 0.21259f
C456 stb sub 0.15303f
C457 mreset vdd 0.15856f
C458 a_1424_4734# a_1684_3624# 0.44856f
C459 vdd a_2784_4734# 0.41972f
C460 a_1424_4734# el 0
C461 mreset aux 0.03786f
C462 a_2784_4734# aux 0
C463 a_2720_3620# vbn_ref 0
C464 hold a_2510_1740# 0.00163f
C465 m1_3052_4742# a_1424_4734# 0.00147f
C466 abus vbp_syn 0.22941f
C467 vsrc m1_4822_412# 0.00459f
C468 a_2130_2940# a_1684_3624# 0.00396f
C469 el m1_4052_1572# 0.04158f
C470 m1_2436_8920# t2 0
C471 a_2130_2940# el 0.1323f
C472 a_368_4070# a_2720_3620# 0.05471f
C473 m1_2436_8920# sub_b 0.00595f
C474 rsel t0 0
C475 vbn_leak t0 0.00273f
C476 vbp_st vbn_prb 3.38211f
C477 vdd m1_1400_6220# 0.05976f
C478 m1_2436_8920# vm 0.03258f
C479 a_1682_2940# t2 0
C480 m1_2448_868# sub_b 0.00939f
C481 a_1682_2940# sub_b 0
C482 vbn_ref sta 0
C483 vdd m1_4822_412# 0.01221f
C484 m1_3360_172# m1_2972_1572# 0.00276f
C485 mreset hold 0.00927f
C486 a_480_5620# a_2510_1740# 0
C487 m1_2448_868# vm 0.11006f
C488 vbp_syn spk 0
C489 m1_4822_412# aux 0.00143f
C490 m1_2448_868# m1_644_2570# 0
C491 vm a_1682_2940# 0.54801f
C492 m1_2972_1572# a_2510_1740# 0.0195f
C493 sub t0 0.0095f
C494 a_1424_4734# a_2130_2940# 0.00393f
C495 a_368_4070# sta 0.00166f
C496 m1_2448_868# m1_4802_1762# 0.01907f
C497 m1_644_2570# a_1682_2940# 0.25286f
C498 m1_3360_172# vbn_ref 0.03533f
C499 a_1684_3624# vsrc 0
C500 a_368_4070# m1_3188_6220# 0
C501 m1_1400_6220# m1_236_9612# 0.0151f
C502 el vsrc 0
C503 a_480_5620# m1_1092_4130# 0.08352f
C504 rsel m1_2436_8920# 0.0047f
C505 vbn_ref a_2510_1740# 0.07568f
C506 m1_2436_8920# vbn_leak 0.11776f
C507 spk t3 0
C508 abus vbn_prb 0.34843f
C509 el m1_3600_6548# 0.02141f
C510 m1_1540_9160# rsel 0.15368f
C511 m1_1540_9160# vbn_leak 0.42134f
C512 hold m1_1400_6220# 0.03f
C513 rsel m1_2448_868# 0.01397f
C514 a_368_4070# a_2510_1740# 0.2827f
C515 m1_2448_868# vbn_leak 0.04602f
C516 m1_3052_4742# m1_3600_6548# 0
C517 spk t1 0.00466f
C518 rsel a_1682_2940# 0.04943f
C519 vbp_st sub_b 0.01435f
C520 a_480_5620# a_2784_4734# 0
C521 vbn_leak a_1682_2940# 0
C522 vdd a_1684_3624# 0.58984f
C523 m1_2436_8920# sub 0.10073f
C524 vdd el 3.89788f
C525 m1_2448_868# vreset 0.12242f
C526 vm vbp_st 0
C527 a_1684_3624# aux 0.11897f
C528 a_368_4070# m1_1092_4130# 0.25462f
C529 el aux 3.32203f
C530 m1_208_9160# m1_1400_6220# 0.03315f
C531 m1_644_2570# vbp_st 0
C532 m1_3052_4742# vdd 0.1921f
C533 vbp_syn vbn_prb 0.13401f
C534 vbp_st m1_4802_1762# 0.00793f
C535 stb sta 0.02411f
C536 mreset vbn_ref 0
C537 m1_2448_868# sub 0.0169f
C538 m1_1244_4440# a_1684_3624# 0.00641f
C539 m1_3052_4742# aux 0.01914f
C540 m1_1244_4440# el 0.0018f
C541 a_1682_2940# sub 0.00385f
C542 stb m1_3188_6220# 0.13166f
C543 a_368_4070# mreset 0
C544 a_480_5620# m1_1400_6220# 0.06602f
C545 a_368_4070# a_2784_4734# 0.03214f
C546 m1_3188_6220# m1_1960_6220# 0
C547 el m1_236_9612# 0
C548 abus sub_b 0.11032f
C549 m1_2448_868# en 0.09092f
C550 rsel vbp_st 0
C551 vdd a_1424_4734# 0.68688f
C552 stb a_2510_1740# 0.00165f
C553 vbn_leak vbp_st 0.00117f
C554 abus vm 0.0129f
C555 abus m1_644_2570# 0.00799f
C556 el hold 0.02603f
C557 vdd m1_4052_1572# 0.01699f
C558 vreset vbp_st 0.03539f
C559 abus m1_4802_1762# 0.19654f
C560 vdd a_2130_2940# 0.00164f
C561 m1_1244_4440# a_1424_4734# 0.01428f
C562 a_338_2940# a_2510_1740# 0
C563 m1_4052_1572# aux 0.03689f
C564 vbn_ref m1_4822_412# 0.07762f
C565 a_2130_2940# aux 0
C566 a_368_4070# m1_1400_6220# 0
C567 spk t2 0
C568 vbp_syn sub_b 0.23882f
C569 m1_208_9160# el 0
C570 spk sub_b 0.00712f
C571 t0 sta 0
C572 m1_1244_4440# a_2130_2940# 0
C573 m1_1092_4130# a_338_2940# 0
C574 vbp_syn vm 0.24602f
C575 rsel abus 0.01567f
C576 m1_3188_6220# t0 0
C577 m1_2020_9600# m1_1400_6220# 0
C578 vbp_syn m1_644_2570# 0.08293f
C579 abus vbn_leak 0.07484f
C580 vm spk 0.12f
C581 t3 t2 0.00505f
C582 vbp_st en 0.06588f
C583 m1_644_2570# spk 0
C584 a_480_5620# a_1684_3624# 0.03274f
C585 el a_480_5620# 0.1572f
C586 m1_3704_1572# m1_2448_868# 0.02667f
C587 m1_2448_868# m1_2280_960# 0.03098f
C588 abus vreset 3.44218f
C589 a_2720_3620# a_1682_2940# 0
C590 m1_2972_1572# el 0
C591 t2 t1 0.0102f
C592 vm t3 0.05788f
C593 m1_3052_4742# a_480_5620# 0
C594 vdd vsrc 0.18634f
C595 t1 sub_b 0
C596 m1_841_6220# m1_1400_6220# 0.0156f
C597 abus sub 0.00227f
C598 vsrc aux 0
C599 m1_4902_6422# vsrc 0.00963f
C600 vbn_ref a_1684_3624# 0.00152f
C601 vdd m1_3600_6548# 0.20299f
C602 rsel vbp_syn 0.08509f
C603 m1_2436_8920# sta 0
C604 el vbn_ref 0
C605 vbp_syn vbn_leak 0.24976f
C606 vm t1 0.07289f
C607 rsel spk 0.13138f
C608 m1_3600_6548# m1_4902_6422# -0.01073f
C609 m1_3600_6548# aux 0.00217f
C610 vbn_leak spk 0
C611 m1_2436_8920# m1_3188_6220# 0
C612 a_368_4070# a_1684_3624# 0.16472f
C613 abus en 0.23162f
C614 a_368_4070# el 0.0376f
C615 vbp_syn vreset 0.32699f
C616 m1_1400_6220# m1_1960_6220# 0
C617 a_1424_4734# a_480_5620# 0.08338f
C618 vbn_prb sub_b 0.02944f
C619 rsel t3 0
C620 vsrc m1_236_9612# 0
C621 a_368_4070# m1_3052_4742# 0.22776f
C622 vbn_leak t3 0.00392f
C623 mreset t0 0
C624 vdd m1_4902_6422# 0.14962f
C625 vdd aux 0.5856f
C626 vbp_syn sub 0.00933f
C627 vm vbn_prb 0
C628 a_2720_3620# vbp_st 0
C629 el m1_2020_9600# 0
C630 m1_2448_868# m1_3360_172# 0.11628f
C631 m1_644_2570# vbn_prb 0.0022f
C632 sub spk 0.04431f
C633 a_2130_2940# a_480_5620# 0.20809f
C634 vbn_prb m1_4802_1762# 0.14693f
C635 rsel t1 0.41821f
C636 m1_1244_4440# vdd 0.18659f
C637 vsrc hold 0.02827f
C638 vbn_leak t1 0
C639 m1_2448_868# a_2510_1740# 0.14081f
C640 a_1682_2940# a_2510_1740# 0.0037f
C641 vbp_syn en 0.30406f
C642 a_368_4070# a_1424_4734# 0.10633f
C643 vdd m1_236_9612# 0.03961f
C644 aux m1_236_9612# 0
C645 m1_208_9160# vsrc 0
C646 t0 m1_1400_6220# 0
C647 rsel vbn_prb 0
C648 vbn_leak vbn_prb 0.12098f
C649 stb el 0
C650 vbp_st sta 0
C651 a_1682_2940# m1_1092_4130# 0.01358f
C652 t2 sub_b 0
C653 a_368_4070# a_2130_2940# 0.0049f
C654 vdd hold 0.62882f
C655 abus a_2720_3620# 0
C656 abus m1_3704_1572# 0.01102f
C657 abus m1_2280_960# 0.00128f
C658 m1_4902_6422# hold -0.01665f
C659 hold aux 0.02669f
C660 vreset vbn_prb 0.04855f
C661 vm t2 0.04871f
C662 m1_3360_172# vbp_st 0.02939f
C663 el a_338_2940# 0.09107f
C664 vm sub_b 0.1686f
C665 vdd m1_1104_10052# 0.01066f
C666 m1_644_2570# sub_b 0.17137f
C667 a_1682_2940# a_2784_4734# 0
C668 sub vbn_prb 0
C669 vdd m1_208_9160# 0.00417f
C670 sub_b m1_4802_1762# 0
C671 vbp_st a_2510_1740# 0.09704f
C672 m1_208_9160# aux 0
C673 m1_644_2570# vm 0.18587f
C674 hold m1_236_9612# 0.00124f
C675 vbp_syn a_2720_3620# 0.04524f
C676 m1_2436_8920# m1_1400_6220# 0
C677 vbn_ref vsrc 0.0395f
C678 m1_3704_1572# vbp_syn 0.04136f
C679 m1_644_2570# m1_4802_1762# 0
C680 m1_2280_960# vbp_syn 0
C681 a_2720_3620# spk 0.03774f
C682 vbn_prb en 0.09975f
C683 vdd a_480_5620# 1.80147f
C684 rsel t2 0.00468f
C685 m1_1540_9160# m1_1400_6220# 0.08454f
C686 vbn_leak t2 0.00761f
C687 a_368_4070# vsrc 0
C688 vdd m1_2972_1572# 0.0038f
C689 m1_1104_10052# m1_236_9612# 0.005f
C690 rsel sub_b 0.20759f
C691 vbn_leak sub_b 0.31248f
C692 a_1682_2940# m1_1400_6220# 0
C693 m1_208_9160# m1_236_9612# 0.14518f
C694 abus m1_3360_172# 0.09898f
C695 a_368_4070# m1_3600_6548# 0.00141f
C696 el t0 0
C697 m1_1244_4440# a_480_5620# 0.14495f
C698 rsel vm 0.10234f
C699 vbn_leak vm 0.00248f
C700 vreset sub_b 0.00461f
C701 mreset vbp_st 0
C702 rsel m1_644_2570# 0.06789f
C703 abus a_2510_1740# 0.00643f
C704 vdd vbn_ref 0.3761f
C705 m1_644_2570# vbn_leak 0.21421f
C706 a_2130_2940# a_338_2940# 0.00151f
C707 vbn_ref m1_4902_6422# 0.09993f
C708 vbn_leak m1_4802_1762# 0
C709 vbn_ref aux 0
C710 vbp_syn sta 0.00659f
C711 m1_208_9160# hold 0.05114f
C712 vm vreset 0.15354f
C713 spk sta 0
C714 sub sub_b 0.1422f
C715 a_368_4070# vdd 2.5819f
C716 m1_644_2570# vreset 0.00801f
C717 vbp_syn m1_3188_6220# 0.02832f
C718 vreset m1_4802_1762# 0.00845f
C719 a_368_4070# aux 0.01646f
C720 m1_3188_6220# spk 0.02683f
C721 vm sub 0.17979f
C722 m1_208_9160# m1_1104_10052# 0.00298f
C723 m1_3360_172# vbp_syn 0.06893f
C724 a_480_5620# hold 0.02439f
C725 m1_644_2570# sub 0.09799f
C726 vdd m1_2020_9600# 0
C727 m1_1244_4440# a_368_4070# 0.06582f
C728 sub_b en 0.04123f
C729 a_2720_3620# vbn_prb 0.00227f
C730 rsel vbn_leak 0.38568f
C731 vbp_syn a_2510_1740# 0.82785f
C732 m1_2436_8920# el 0
C733 m1_2020_9600# aux 0
C734 spk a_2510_1740# 0.01205f
C735 abus mreset 0
C736 vm en 0.40632f
C737 stb m1_3600_6548# 0.00109f
C738 rsel vreset 0.00275f
C739 vbp_st m1_4822_412# 0.01159f
C740 m1_644_2570# en 0.01378f
C741 vbn_leak vreset 0.03653f
C742 m1_2448_868# el 0.04811f
C743 a_1682_2940# a_1684_3624# 0.01548f
C744 vbn_ref hold 0.17517f
C745 m1_4802_1762# en 0.11313f
C746 m1_3188_6220# t1 0
C747 el a_1682_2940# 0.13779f
C748 vdd m1_841_6220# 0.03399f
C749 rsel sub 0.36688f
C750 m1_1092_4130# spk 0
C751 vbn_leak sub 0.06844f
C752 m1_2020_9600# m1_236_9612# 0.116f
C753 a_368_4070# hold 0.00112f
C754 vdd stb 0.16074f
C755 vbn_prb sta 0
C756 m1_208_9160# vbn_ref 0
C757 stb aux 0
C758 sub vreset 0.00197f
C759 mreset vbp_syn 0.2264f
C760 vbp_syn a_2784_4734# 0
C761 vdd m1_1960_6220# 0.02837f
C762 mreset spk 0.00703f
C763 rsel en 0.04725f
C764 vbn_leak en 0.07411f
C765 a_2784_4734# spk 0.31883f
C766 vdd a_338_2940# 0.00807f
C767 m1_3360_172# vbn_prb 0.03469f
C768 m1_841_6220# m1_236_9612# 0.02532f
C769 abus m1_4822_412# 0.00649f
C770 a_2720_3620# sub_b 0.00728f
C771 a_1424_4734# a_1682_2940# 0.022f
C772 m1_3704_1572# sub_b 0
C773 m1_2280_960# sub_b 0
C774 vreset en 3.43598f
C775 vbp_st vss 0.98967f
C776 vsrc vss 1.06767f
C777 m1_3360_172# vss 0.88392f
C778 m1_1104_10052# vss 0.01565f
C779 m1_2280_960# vss 0.12636f
C780 en vss 2.13985f
C781 abus vss 4.58192f
C782 sub vss 0.42571f
C783 mreset vss 0.68178f
C784 spk vss 0.56929f
C785 hold vss 2.95913f
C786 vdd vss 20.51163f
C787 m1_1244_4440# vss -0.03848f
C788 a_368_4070# vss -0.11374f
C789 m1_1540_9160# vss 0.21701f
C790 m1_2020_9600# vss 0.16954f
C791 m1_4822_412# vss 0.28416f
C792 m1_1092_4130# vss -0.02612f
C793 m1_841_6220# vss 0.18723f
C794 t3 vss 0.46814f
C795 vbn_prb vss 1.47282f
C796 aux vss 0.59079f
C797 m1_1400_6220# vss 0.16941f
C798 t2 vss 0.32767f
C799 m1_3052_4742# vss -0.19389f
C800 m1_1960_6220# vss 0.17983f
C801 t1 vss 0.28524f
C802 m1_236_9612# vss 0.65308f
C803 m1_208_9160# vss 1.22651f
C804 a_2720_3620# vss 0.5563f
C805 m1_2436_8920# vss 0.46977f
C806 t0 vss 0.29546f
C807 m1_2972_1572# vss -0.04045f
C808 rsel vss 2.82428f
C809 a_1424_4734# vss 0.24957f
C810 a_1684_3624# vss 0.29029f
C811 vm vss 2.38008f
C812 m1_3704_1572# vss -0.05326f
C813 m1_644_2570# vss 0.24702f
C814 a_338_2940# vss -0.05305f
C815 sub_b vss 0.783f
C816 m1_3188_6220# vss 0.2805f
C817 stb vss 0.37375f
C818 sta vss 0.25919f
C819 m1_2448_868# vss 0.70763f
C820 vreset vss 0.97822f
C821 a_2510_1740# vss 1.90106f
C822 m1_4802_1762# vss -0.00625f
C823 vbn_ref vss 1.05896f
C824 a_2130_2940# vss 0.36735f
C825 a_1682_2940# vss 0.8809f
C826 a_2784_4734# vss -0.0161f
C827 m1_4902_6422# vss -0.1955f
C828 m1_3600_6548# vss -0.04329f
C829 vbp_syn vss 2.13185f
C830 a_480_5620# vss 0.12517f
C831 el vss 0.89399f
C832 vbn_leak vss 4.34989f
C833 m1_4052_1572# vss -0.03695f
.ends
