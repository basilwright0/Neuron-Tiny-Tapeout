* NGSPICE file created from slot_cmp_h.ext - technology: gf180mcuD

.subckt p_w2_l4 a_400_n200# a_n400_n244# w_n574_n330# a_n488_n200# VSUBS
X0 a_400_n200# a_n400_n244# a_n488_n200# w_n574_n330# pfet_03v3 ad=0.88p pd=4.88u as=0.88p ps=4.88u w=2u l=4u
C0 a_n488_n200# w_n574_n330# 0.07409f
C1 a_n400_n244# a_n488_n200# 0.07019f
C2 a_400_n200# w_n574_n330# 0.07409f
C3 a_n400_n244# a_400_n200# 0.07019f
C4 a_n400_n244# w_n574_n330# 0.42229f
C5 a_n488_n200# a_400_n200# 0.01073f
C6 a_400_n200# VSUBS 0.18936f
C7 a_n488_n200# VSUBS 0.18936f
C8 w_n574_n330# VSUBS 2.27304f
.ends

.subckt n_w1_l0p28 a_28_n100# a_n28_n144# a_n116_n100# VSUBS
X0 a_28_n100# a_n28_n144# a_n116_n100# VSUBS nfet_03v3 ad=0.44p pd=2.88u as=0.44p ps=2.88u w=1u l=0.28u
C0 a_28_n100# a_n28_n144# 0.00769f
C1 a_n116_n100# a_28_n100# 0.04256f
C2 a_n116_n100# a_n28_n144# 0.00769f
C3 a_28_n100# VSUBS 0.09911f
C4 a_n116_n100# VSUBS 0.09911f
.ends

.subckt n_w2_l2 a_n288_n200# a_200_n200# a_n200_n244# VSUBS
X0 a_200_n200# a_n200_n244# a_n288_n200# VSUBS nfet_03v3 ad=0.88p pd=4.88u as=0.88p ps=4.88u w=2u l=2u
C0 a_200_n200# a_n200_n244# 0.0587f
C1 a_n288_n200# a_200_n200# 0.02133f
C2 a_n288_n200# a_n200_n244# 0.0587f
C3 a_200_n200# VSUBS 0.2667f
C4 a_n288_n200# VSUBS 0.2667f
.ends

.subckt n_w2_l4 a_400_n200# a_n400_n244# a_n488_n200# VSUBS
X0 a_400_n200# a_n400_n244# a_n488_n200# VSUBS nfet_03v3 ad=0.88p pd=4.88u as=0.88p ps=4.88u w=2u l=4u
C0 a_400_n200# a_n400_n244# 0.07019f
C1 a_n488_n200# a_400_n200# 0.01073f
C2 a_n488_n200# a_n400_n244# 0.07019f
C3 a_400_n200# VSUBS 0.41684f
C4 a_n488_n200# VSUBS 0.41684f
.ends

.subckt n_w4_l1 a_n188_n400# a_100_n400# a_n100_n444# VSUBS
X0 a_100_n400# a_n100_n444# a_n188_n400# VSUBS nfet_03v3 ad=1.76p pd=8.88u as=1.76p ps=8.88u w=4u l=1u
C0 a_100_n400# a_n100_n444# 0.08505f
C1 a_n188_n400# a_100_n400# 0.07756f
C2 a_n188_n400# a_n100_n444# 0.08505f
C3 a_100_n400# VSUBS 0.26859f
C4 a_n188_n400# VSUBS 0.26859f
.ends

.subckt n_w0p5_l0p28 a_n28_n94# a_n116_n50# a_28_n50# VSUBS
X0 a_28_n50# a_n28_n94# a_n116_n50# VSUBS nfet_03v3 ad=0.22p pd=1.88u as=0.22p ps=1.88u w=0.5u l=0.28u
C0 a_28_n50# a_n28_n94# 0.00377f
C1 a_n116_n50# a_28_n50# 0.02085f
C2 a_n116_n50# a_n28_n94# 0.00377f
C3 a_28_n50# VSUBS 0.07987f
C4 a_n116_n50# VSUBS 0.07987f
.ends

.subckt n_w0p5_l0p5 a_n138_n50# a_50_n50# a_n50_n94# VSUBS
X0 a_50_n50# a_n50_n94# a_n138_n50# VSUBS nfet_03v3 ad=0.22p pd=1.88u as=0.22p ps=1.88u w=0.5u l=0.5u
C0 a_50_n50# a_n50_n94# 0.00625f
C1 a_n138_n50# a_50_n50# 0.01511f
C2 a_n138_n50# a_n50_n94# 0.00625f
C3 a_50_n50# VSUBS 0.09639f
C4 a_n138_n50# VSUBS 0.09639f
.ends

.subckt p_w1_l0p28 w_n202_n230# a_28_n100# a_n28_n144# a_n116_n100# VSUBS
X0 a_28_n100# a_n28_n144# a_n116_n100# w_n202_n230# pfet_03v3 ad=0.44p pd=2.88u as=0.44p ps=2.88u w=1u l=0.28u
C0 a_n116_n100# w_n202_n230# 0.01808f
C1 a_n28_n144# a_n116_n100# 0.00769f
C2 a_28_n100# w_n202_n230# 0.01808f
C3 a_n28_n144# a_28_n100# 0.00769f
C4 a_n28_n144# w_n202_n230# 0.05841f
C5 a_n116_n100# a_28_n100# 0.04256f
C6 a_28_n100# VSUBS 0.0597f
C7 a_n116_n100# VSUBS 0.0597f
C8 w_n202_n230# VSUBS 0.55752f
.ends

.subckt n_w4_l2 a_n288_n400# a_200_n400# a_n200_n444# VSUBS
X0 a_200_n400# a_n200_n444# a_n288_n400# VSUBS nfet_03v3 ad=1.76p pd=8.88u as=1.76p ps=8.88u w=4u l=2u
C0 a_200_n400# a_n200_n444# 0.11799f
C1 a_n288_n400# a_200_n400# 0.04287f
C2 a_n288_n400# a_n200_n444# 0.11799f
C3 a_200_n400# VSUBS 0.34365f
C4 a_n288_n400# VSUBS 0.34365f
.ends

.subckt p_w1_l2 w_n374_n230# a_n288_n100# a_200_n100# a_n200_n144# VSUBS
X0 a_200_n100# a_n200_n144# a_n288_n100# w_n374_n230# pfet_03v3 ad=0.44p pd=2.88u as=0.44p ps=2.88u w=1u l=2u
C0 a_n288_n100# w_n374_n230# 0.03135f
C1 a_n200_n144# a_n288_n100# 0.02905f
C2 a_200_n100# w_n374_n230# 0.03135f
C3 a_n200_n144# a_200_n100# 0.02905f
C4 a_n200_n144# w_n374_n230# 0.22666f
C5 a_n288_n100# a_200_n100# 0.01056f
C6 a_200_n100# VSUBS 0.1047f
C7 a_n288_n100# VSUBS 0.1047f
C8 w_n374_n230# VSUBS 1.03224f
.ends

.subckt n_w7p07_l7p07 a_707_n707# a_n795_n707# a_n707_n751# VSUBS
X0 a_707_n707# a_n707_n751# a_n795_n707# VSUBS nfet_03v3 ad=3.1108p pd=15.02u as=3.1108p ps=15.02u w=7.07u l=7.07u
C0 a_707_n707# a_n707_n751# 0.27012f
C1 a_n795_n707# a_707_n707# 0.0212f
C2 a_n795_n707# a_n707_n751# 0.27012f
C3 a_707_n707# VSUBS 0.84237f
C4 a_n795_n707# VSUBS 0.84237f
.ends

.subckt n_w0p5_l1p5 a_150_n50# a_n238_n50# a_n150_n94# VSUBS
X0 a_150_n50# a_n150_n94# a_n238_n50# VSUBS nfet_03v3 ad=0.22p pd=1.88u as=0.22p ps=1.88u w=0.5u l=1.5u
C0 a_150_n50# a_n150_n94# 0.01269f
C1 a_n238_n50# a_150_n50# 0.00671f
C2 a_n238_n50# a_n150_n94# 0.01269f
C3 a_150_n50# VSUBS 0.17146f
C4 a_n238_n50# VSUBS 0.17146f
.ends

.subckt n_w1_l2 a_n288_n100# a_200_n100# a_n200_n144# VSUBS
X0 a_200_n100# a_n200_n144# a_n288_n100# VSUBS nfet_03v3 ad=0.44p pd=2.88u as=0.44p ps=2.88u w=1u l=2u
C0 a_200_n100# a_n200_n144# 0.02905f
C1 a_n288_n100# a_200_n100# 0.01056f
C2 a_n288_n100# a_n200_n144# 0.02905f
C3 a_200_n100# VSUBS 0.22823f
C4 a_n288_n100# VSUBS 0.22823f
.ends

.subckt n_w3p54_l3p54 a_354_n354# a_n354_n398# a_n442_n354# VSUBS
X0 a_354_n354# a_n354_n398# a_n442_n354# VSUBS nfet_03v3 ad=1.5576p pd=7.96u as=1.5576p ps=7.96u w=3.54u l=3.54u
C0 a_354_n354# a_n354_n398# 0.12189f
C1 a_n442_n354# a_354_n354# 0.02161f
C2 a_n442_n354# a_n354_n398# 0.12189f
C3 a_354_n354# VSUBS 0.44156f
C4 a_n442_n354# VSUBS 0.44156f
.ends

.subckt p_w2_l1 a_100_n200# a_n100_n244# w_n274_n330# a_n188_n200# VSUBS
X0 a_100_n200# a_n100_n244# a_n188_n200# w_n274_n330# pfet_03v3 ad=0.88p pd=4.88u as=0.88p ps=4.88u w=2u l=1u
C0 a_n188_n200# w_n274_n330# 0.04851f
C1 a_n100_n244# a_n188_n200# 0.04231f
C2 a_100_n200# w_n274_n330# 0.04851f
C3 a_n100_n244# a_100_n200# 0.04231f
C4 a_n100_n244# w_n274_n330# 0.12884f
C5 a_n188_n200# a_100_n200# 0.03858f
C6 a_100_n200# VSUBS 0.11088f
C7 a_n188_n200# VSUBS 0.11088f
C8 w_n274_n330# VSUBS 1.08504f
.ends

.subckt n_w0p5_l3 a_n388_n50# a_300_n50# a_n300_n94# VSUBS
X0 a_300_n50# a_n300_n94# a_n388_n50# VSUBS nfet_03v3 ad=0.22p pd=1.88u as=0.22p ps=1.88u w=0.5u l=3u
C0 a_300_n50# a_n300_n94# 0.01602f
C1 a_n388_n50# a_300_n50# 0.00348f
C2 a_n388_n50# a_n300_n94# 0.01602f
C3 a_300_n50# VSUBS 0.28406f
C4 a_n388_n50# VSUBS 0.28406f
.ends

.subckt p_w1_l6 w_n774_n230# a_n688_n100# a_600_n100# a_n600_n144# VSUBS
X0 a_600_n100# a_n600_n144# a_n688_n100# w_n774_n230# pfet_03v3 ad=0.44p pd=2.88u as=0.44p ps=2.88u w=1u l=6u
C0 a_n688_n100# w_n774_n230# 0.03955f
C1 a_n600_n144# a_n688_n100# 0.03688f
C2 a_600_n100# w_n774_n230# 0.03955f
C3 a_n600_n144# a_600_n100# 0.03688f
C4 a_n600_n144# w_n774_n230# 0.61793f
C5 a_n688_n100# a_600_n100# 0.00349f
C6 a_600_n100# VSUBS 0.20933f
C7 a_n688_n100# VSUBS 0.20933f
C8 w_n774_n230# VSUBS 2.13624f
.ends

.subckt n_w0p5_l4 a_n488_n50# a_400_n50# a_n400_n94# VSUBS
X0 a_400_n50# a_n400_n94# a_n488_n50# VSUBS nfet_03v3 ad=0.22p pd=1.88u as=0.22p ps=1.88u w=0.5u l=4u
C0 a_400_n50# a_n400_n94# 0.01702f
C1 a_n488_n50# a_400_n50# 0.0026f
C2 a_n488_n50# a_n400_n94# 0.01702f
C3 a_400_n50# VSUBS 0.35913f
C4 a_n488_n50# VSUBS 0.35913f
.ends

.subckt slot_cmp_h vss vbp_syn vdd el aux vbn_leak vsrc vbp_st vbn_prb vbn_ref en
+ vreset abus spk t3 t2 t1 t0 sta stb hold mreset rsel sub sub_b vm
XXL_XP1 a_480_5620# a_480_5620# vdd vdd vss p_w2_l4
XXPM_XSW m1_4052_1572# rsel m1_3704_1572# vss n_w1_l0p28
XXL_XP2 a_1632_2940# a_480_5620# vdd vdd vss p_w2_l4
XXPR_XMB vss m1_4822_1769# vbn_prb vss n_w2_l2
XXL_XMT m1_644_2570# vbn_leak vss vss n_w2_l4
XXL_XM1 a_288_2940# a_480_5620# el vss n_w4_l1
XXS_XWA m1_4902_6422# vbp_syn vdd m1_3620_6220# vss p_w2_l4
XXR_Xi_XN spk vss a_2784_4734# vss n_w0p5_l0p28
XXL_XM2 a_2080_2940# a_1632_2940# a_1632_2940# vss n_w4_l1
XXS_XWB m1_4902_6422# vbp_syn vdd m1_3212_6232# vss p_w2_l4
XXR_XNR vss vbn_ref a_2510_1690# vss n_w2_l4
XXPR_XME m1_2640_532# en m1_4822_1769# vss n_w1_l0p28
XXR_XSW vreset vm a_2510_1690# vss n_w0p5_l0p5
XXR_Xi_XP vdd a_2784_4734# spk vdd vss p_w1_l0p28
XXPR_XMF m1_2640_532# vdd a_2510_1690# vss n_w4_l2
XXS_XQA vdd m1_3620_6220# sta vss vss p_w1_l0p28
XXS_XQB vdd m1_3212_6232# stb vss vss p_w1_l0p28
XXS_XNA sta vm m1_3620_6220# vss n_w0p5_l0p28
XXS_XNB stb vm m1_3212_6232# vss n_w0p5_l0p28
XXD_XPT vdd vdd m1_3040_4730# vbp_st vss p_w1_l2
XXL_XD2a m1_644_2570# a_2080_2940# a_2080_2940# vss n_w4_l1
XXPM_XSB abus sub_b m1_4052_1572# vss n_w1_l0p28
XXL_XD2b m1_644_2570# a_2080_2940# a_2080_2940# vss n_w4_l1
XXL_XD1a m1_644_2570# a_288_2940# a_288_2940# vss n_w4_l1
XXPM_XSC m1_3704_1572# en m1_3360_868# vss n_w1_l0p28
XXC_XC vss vss vm vss n_w7p07_l7p07
XXT_XR1 m1_2020_9600# m1_1545_9160# vbn_leak vss n_w0p5_l1p5
XXS_XPH vdd m1_4902_6422# vdd hold vss p_w1_l2
XXD_Xi1_XN a_1684_3624# vss a_1424_4734# vss n_w0p5_l0p28
XXL_XD1b m1_644_2570# a_288_2940# a_288_2940# vss n_w4_l1
XXPR_XSW m1_2972_1572# rsel m1_2292_960# vss n_w1_l0p28
XXT_XR2 m1_208_9160# m1_2020_9600# vbn_leak vss n_w0p5_l1p5
XXT_XP0 vdd m1_2532_9492# t0 vm vss p_w1_l0p28
XXD_XN1 a_2720_3620# vss a_2720_3620# vss n_w1_l2
XXT_XR3 m1_224_9600# m1_208_9160# vbn_leak vss n_w0p5_l1p5
XXT_XP1 vdd m1_1960_6220# t1 vm vss p_w1_l0p28
XXR_XCR_XC vss a_2510_1690# vss vss n_w3p54_l3p54
XXD_XN2 vss a_1684_3624# a_2720_3620# vss n_w1_l2
XXD_XM1 a_2720_3620# vm vdd m1_3040_4730# vss p_w2_l1
XXD_Xi1_XP vdd a_1424_4734# a_1684_3624# m1_1700_4540# vss p_w1_l0p28
XXT_XN0 t0 a_480_5620# m1_2532_9492# vss n_w0p5_l0p28
XXT_XP2 vdd m1_1400_6220# t2 vm vss p_w1_l0p28
XXD_XM2 a_1684_3624# aux vdd m1_3040_4730# vss p_w2_l1
XXPM_XMB vss m1_4822_412# vbn_prb vss n_w2_l2
XXT_XN1 t1 a_480_5620# m1_1960_6220# vss n_w0p5_l0p28
XXT_XP3 vdd m1_796_6220# t3 vm vss p_w1_l0p28
XXT_XL0 m1_2532_9492# m1_224_9600# vbn_leak vss n_w0p5_l3
XXT_XLT m1_224_9600# vdd vbn_leak vss n_w0p5_l3
XXT_XN2 t2 a_480_5620# m1_1400_6220# vss n_w0p5_l0p28
XXD_Xi1_XS vdd vdd m1_1700_4540# vbp_st vss p_w1_l2
XXT_XL1 m1_1960_6220# m1_208_9160# vbn_leak vss n_w0p5_l3
XXT_XN3 t3 a_480_5620# m1_796_6220# vss n_w0p5_l0p28
XXR_XPC vdd a_2510_1690# a_2784_4734# vdd vss p_w1_l0p28
XXD_XH1 vdd a_1684_3624# a_1424_4734# m1_1320_4540# vss p_w1_l0p28
XXPM_XME m1_3360_868# en m1_4822_412# vss n_w1_l0p28
XXT_XL2 m1_1400_6220# m1_2020_9600# vbn_leak vss n_w0p5_l3
XXT_XL3 m1_796_6220# m1_1545_9160# vbn_leak vss n_w0p5_l3
XXD_XH2 vdd vdd m1_1320_4540# vbp_st vss p_w1_l6
XXPM_XMF m1_3360_868# vdd vm vss n_w4_l2
XXS_XHL vdd vm hold a_1632_2940# vss p_w1_l0p28
XXD_Xi2_XN a_1424_4734# vss spk vss n_w0p5_l0p28
XXS_XMR mreset a_2510_1690# vdd vss n_w0p5_l0p28
XXD_Xi2_XP vdd spk a_1424_4734# vdd vss p_w1_l0p28
XXPR_XSB abus sub m1_2972_1572# vss n_w1_l0p28
XXPR_XSC m1_2640_532# en m1_2292_960# vss n_w1_l0p28
XXT_XRB m1_1104_10052# m1_1545_9160# vbn_leak vss n_w0p5_l4
XXT_XRA vss m1_1104_10052# vbn_leak vss n_w0p5_l4
C0 a_1684_3624# vbn_leak 0.01365f
C1 vbn_prb a_2720_3620# 0
C2 m1_2532_9492# vbn_leak 0.13885f
C3 m1_4822_1769# vbn_ref 0.07576f
C4 m1_1320_4540# a_1684_3624# 0.197f
C5 a_480_5620# sub 0.01757f
C6 a_1632_2940# vbn_leak 0
C7 vbp_syn m1_2292_960# 0
C8 m1_1320_4540# a_1632_2940# 0.02822f
C9 sub_b m1_2640_532# 0.45109f
C10 a_2784_4734# a_2510_1690# 0.00991f
C11 vdd t3 0.11554f
C12 m1_1400_6220# vbn_leak 0.11177f
C13 m1_1320_4540# m1_1400_6220# 0
C14 stb sta 0.00598f
C15 m1_208_9160# t0 0.00451f
C16 a_1424_4734# a_2720_3620# 0
C17 vbn_prb a_2510_1690# 0.12049f
C18 vbp_st rsel 0.17458f
C19 m1_644_2570# m1_2292_960# 0
C20 m1_3704_1572# rsel 0.05093f
C21 vm a_2080_2940# 0.04362f
C22 m1_4052_1572# en 0.00464f
C23 a_480_5620# vdd 2.17171f
C24 m1_2292_960# abus 0
C25 m1_4902_6422# en 0
C26 m1_4822_412# aux 0.00149f
C27 vbp_syn a_2784_4734# 0
C28 vbp_st m1_3212_6232# 0.00191f
C29 el a_2080_2940# 0.12146f
C30 a_1424_4734# a_2510_1690# 0
C31 m1_2292_960# vbn_leak 0
C32 mreset sta 0.0392f
C33 aux en 0.03434f
C34 t1 vbn_leak 0
C35 m1_2532_9492# m1_2020_9600# 0
C36 vbp_syn vbn_prb 0.05883f
C37 vreset mreset 0
C38 hold a_2510_1690# 0.40948f
C39 sub_b a_2080_2940# 0
C40 stb spk 0.01043f
C41 vbp_syn m1_224_9600# 0
C42 sub vbn_ref 0
C43 sub m1_4822_1769# 0
C44 m1_644_2570# a_2784_4734# 0.00413f
C45 vbp_st vsrc 3.16814f
C46 t2 m1_2532_9492# 0
C47 m1_208_9160# rsel 0.04122f
C48 a_1684_3624# aux 0.09156f
C49 m1_1400_6220# m1_2020_9600# 0.00371f
C50 aux m1_2532_9492# 0
C51 t2 a_1632_2940# 0
C52 m1_1320_4540# m1_1700_4540# 0.00664f
C53 vm sta 0.07982f
C54 a_1632_2940# aux 0
C55 vreset vm 0.3457f
C56 m1_644_2570# vbn_prb 0
C57 vdd m1_1960_6220# 0.04338f
C58 t2 m1_1400_6220# 0.22388f
C59 m1_3360_868# vbn_ref 0.03698f
C60 m1_4822_1769# m1_3360_868# 0
C61 a_2784_4734# vbn_leak 0
C62 vbp_syn hold 0.08668f
C63 vbn_prb abus 0.13587f
C64 sta el 0.00274f
C65 vreset el 0.10176f
C66 m1_3040_4730# spk 0.00951f
C67 vdd vbn_ref 0.3563f
C68 mreset spk 0.00569f
C69 vdd m1_4822_1769# 0
C70 vdd m1_796_6220# 0.04859f
C71 vbn_prb vbn_leak 0.00619f
C72 sub_b sta 0
C73 m1_224_9600# vbn_leak 0.44717f
C74 m1_644_2570# a_1424_4734# 0.00278f
C75 m1_208_9160# vsrc 0
C76 vreset sub_b 0.00278f
C77 m1_2640_532# rsel 0.09165f
C78 vm spk 0.21705f
C79 m1_2292_960# aux 0
C80 t2 t1 0.01497f
C81 hold abus 0
C82 a_1632_2940# t3 0
C83 m1_1320_4540# a_1424_4734# 0.03235f
C84 vdd m1_3620_6220# 0.18133f
C85 hold vbn_leak 0.02634f
C86 m1_3040_4730# a_2720_3620# 0.10822f
C87 sub m1_3360_868# 0
C88 a_480_5620# a_1684_3624# 0.02786f
C89 a_480_5620# m1_2532_9492# 0.0285f
C90 vbp_st m1_208_9160# 0
C91 sub_b spk 0.23868f
C92 m1_2640_532# vsrc 0.04106f
C93 a_480_5620# a_1632_2940# 0.13891f
C94 a_288_2940# a_2510_1690# 0
C95 sta t0 0
C96 a_2784_4734# aux 0
C97 a_480_5620# m1_1400_6220# 0.18925f
C98 sub vdd 0.2357f
C99 vbn_prb m1_4902_6422# 0.11621f
C100 m1_224_9600# m1_2020_9600# 0.09736f
C101 vbp_syn stb 0
C102 vm a_2720_3620# 0.04661f
C103 rsel a_2080_2940# 0.07995f
C104 m1_3040_4730# a_2510_1690# 0.26239f
C105 a_2510_1690# mreset 0.12196f
C106 t2 m1_224_9600# 0
C107 vbn_prb aux 0
C108 m1_224_9600# aux 0
C109 m1_4822_412# vbn_ref 0.08626f
C110 vdd m1_3360_868# 0.21934f
C111 a_2720_3620# el 0
C112 m1_2532_9492# m1_1960_6220# 0.01077f
C113 a_2510_1690# vm 0.22487f
C114 vbp_st m1_2640_532# 0.05971f
C115 vbn_ref en 3.24535f
C116 sub_b a_2720_3620# 0.04556f
C117 hold m1_4902_6422# 0.03201f
C118 m1_3704_1572# m1_2640_532# 0.00775f
C119 m1_4822_1769# en 0.0933f
C120 m1_1545_9160# m1_2532_9492# 0.0243f
C121 vbp_syn m1_3040_4730# 0.05311f
C122 vbp_syn mreset 0.21791f
C123 t2 hold 0.05488f
C124 spk t0 0
C125 a_480_5620# t1 0.15703f
C126 m1_1400_6220# m1_1960_6220# 0.02526f
C127 a_1684_3624# vbn_ref 0
C128 hold aux 0.02272f
C129 m1_2972_1572# vm 0
C130 a_288_2940# m1_644_2570# 0.40629f
C131 a_2510_1690# el 0.09353f
C132 m1_1545_9160# m1_1400_6220# 0.02874f
C133 vreset rsel 0.00115f
C134 a_480_5620# m1_1700_4540# 0.06753f
C135 sub_b a_2510_1690# 0.1634f
C136 m1_2972_1572# el 0
C137 vbp_syn vm 0.14777f
C138 m1_1400_6220# m1_796_6220# 0
C139 m1_3212_6232# sta 0.16203f
C140 m1_224_9600# t3 0.00235f
C141 a_480_5620# a_2784_4734# 0
C142 mreset abus 0
C143 vbp_syn el 0.13457f
C144 vbp_st a_2080_2940# 0
C145 m1_3040_4730# vbn_leak 0
C146 sta vsrc 0
C147 m1_644_2570# vm 0.2068f
C148 t1 m1_1960_6220# 0.2325f
C149 mreset vbn_leak 0.03323f
C150 vreset vsrc 0.0362f
C151 sub_b vbp_syn 0.35567f
C152 t1 m1_1545_9160# 0.00203f
C153 spk rsel 0.05016f
C154 sub en 0.02503f
C155 vm abus 0.0046f
C156 hold t3 0.12938f
C157 m1_4822_412# m1_3360_868# 0.02941f
C158 m1_644_2570# el 0.12566f
C159 vm vbn_leak 0.00365f
C160 sub a_1684_3624# 0.03793f
C161 sub m1_2532_9492# 0.06076f
C162 m1_1320_4540# vm 0
C163 m1_3212_6232# spk 0.15744f
C164 m1_3360_868# en 0.10917f
C165 sub_b m1_644_2570# 0.06513f
C166 a_480_5620# a_1424_4734# 0.07372f
C167 vdd m1_4822_412# 0.01309f
C168 abus el 0.03172f
C169 a_1632_2940# sub 0.01805f
C170 a_480_5620# hold 0.2404f
C171 el vbn_leak 0.0758f
C172 sub_b abus 0.00747f
C173 vbp_st sta 0.0027f
C174 m1_1320_4540# el 0
C175 vdd en 0.25136f
C176 vreset vbp_st 0.03671f
C177 vreset m1_3704_1572# 0.00154f
C178 sub_b vbn_leak 0.09396f
C179 m1_224_9600# m1_1960_6220# 0.00198f
C180 a_2720_3620# rsel 0.06566f
C181 vdd a_1684_3624# 0.74093f
C182 m1_224_9600# m1_1545_9160# 0.04895f
C183 vdd m1_2532_9492# 0.06749f
C184 m1_4902_6422# mreset 0
C185 vbp_syn t0 0
C186 a_1632_2940# vdd 0.94503f
C187 vbn_prb vbn_ref 3.22545f
C188 vbn_prb m1_4822_1769# 0.07747f
C189 m1_3040_4730# aux 0.00159f
C190 m1_224_9600# m1_796_6220# 0.03795f
C191 vdd m1_1400_6220# 0.05245f
C192 m1_1104_10052# vbn_leak 0.11902f
C193 mreset aux 0.05326f
C194 m1_2292_960# sub 0
C195 hold m1_1960_6220# 0.04077f
C196 a_2510_1690# rsel 0.29334f
C197 m1_4902_6422# vm 0
C198 m1_2640_532# a_2080_2940# 0
C199 vbp_st spk 0.06028f
C200 m1_4052_1572# el 0.03937f
C201 a_2720_3620# vsrc 0
C202 t2 vm 0.07606f
C203 vm aux 0.01419f
C204 m1_2972_1572# rsel 0.02791f
C205 m1_2292_960# m1_3360_868# 0.00301f
C206 sub m1_1700_4540# 0.05304f
C207 hold vbn_ref 0.05684f
C208 vbn_prb m1_3620_6220# 0
C209 m1_4902_6422# el 0.00136f
C210 hold m1_796_6220# 0.0277f
C211 m1_4052_1572# sub_b 0.05306f
C212 t0 vbn_leak 0.00216f
C213 a_480_5620# stb 0
C214 m1_2292_960# vdd 0
C215 aux el 3.16097f
C216 vbp_syn rsel 0.05277f
C217 a_2784_4734# sub 0.0084f
C218 vdd t1 0.12154f
C219 a_2510_1690# vsrc 0.11276f
C220 sub_b aux 0.07304f
C221 m1_4822_412# en 0.08592f
C222 vbn_prb sub 0
C223 m1_1104_10052# m1_2020_9600# 0.00154f
C224 vreset m1_2640_532# 0.17336f
C225 vbp_st a_2720_3620# 0.00467f
C226 vdd m1_1700_4540# 0.33813f
C227 vbp_syn m1_3212_6232# 0.1436f
C228 a_480_5620# a_288_2940# -0.0214f
C229 m1_644_2570# rsel 0.13355f
C230 t2 m1_1104_10052# 0
C231 vbn_prb m1_3360_868# 0.02672f
C232 a_480_5620# m1_3040_4730# 0
C233 vm t3 0.06549f
C234 abus rsel 0.1501f
C235 a_2784_4734# vdd 0.40118f
C236 vbp_syn vsrc 0.13034f
C237 a_1684_3624# en 0
C238 stb m1_1960_6220# 0
C239 vbp_st a_2510_1690# 0.14425f
C240 rsel vbn_leak 0.38249f
C241 sub hold 0.06951f
C242 a_2510_1690# m1_3704_1572# 0
C243 m1_1320_4540# rsel 0.07085f
C244 vbn_prb vdd 0.14891f
C245 t0 m1_2020_9600# 0
C246 vdd m1_224_9600# 0.03449f
C247 a_480_5620# vm 0.46622f
C248 a_1632_2940# a_1684_3624# 0.07967f
C249 m1_3212_6232# vbn_leak 0.00306f
C250 vreset a_2080_2940# 0
C251 m1_1400_6220# m1_2532_9492# 0.00105f
C252 vsrc abus 0.06987f
C253 a_1424_4734# vdd 0.58425f
C254 a_480_5620# el 0.13213f
C255 vbp_syn vbp_st 0.17084f
C256 vbp_syn m1_3704_1572# 0.04166f
C257 mreset m1_1960_6220# 0
C258 vdd hold 0.41042f
C259 vsrc vbn_leak 3.13453f
C260 a_480_5620# sub_b 0
C261 stb m1_3620_6220# 0
C262 m1_2292_960# en 0.0829f
C263 m1_3040_4730# vbn_ref 0
C264 m1_4052_1572# rsel 0
C265 mreset vbn_ref 0
C266 m1_644_2570# vbp_st 0.00245f
C267 vm m1_1960_6220# 0.06598f
C268 m1_2020_9600# rsel 0
C269 m1_2640_532# a_2720_3620# 0.01538f
C270 spk a_2080_2940# 0.01663f
C271 vbp_st abus 0.06668f
C272 t1 m1_2532_9492# 0
C273 vreset sta 0
C274 t2 rsel 0.26719f
C275 m1_3704_1572# abus 0
C276 aux rsel 0
C277 vbp_syn m1_208_9160# 0.08009f
C278 vm vbn_ref 0
C279 a_1632_2940# t1 0
C280 vm m1_796_6220# 0.09524f
C281 sub stb 0.1326f
C282 m1_4902_6422# m1_3212_6232# -0.01073f
C283 vbp_st vbn_leak 0.04244f
C284 m1_3704_1572# vbn_leak 0
C285 m1_1320_4540# vbp_st 0.07952f
C286 t1 m1_1400_6220# 0.14585f
C287 m1_1700_4540# a_1684_3624# 0.18597f
C288 m1_1700_4540# m1_2532_9492# 0
C289 m1_3040_4730# m1_3620_6220# 0
C290 sub_b m1_1960_6220# 0
C291 vbn_prb m1_4822_412# 0.11236f
C292 a_2510_1690# m1_2640_532# 0.29315f
C293 mreset m1_3620_6220# 0.03135f
C294 a_1632_2940# m1_1700_4540# 0.08166f
C295 vbn_ref el 0
C296 aux m1_3212_6232# 0.00636f
C297 m1_4822_1769# el 0
C298 a_480_5620# t0 0.15687f
C299 m1_4902_6422# vsrc 0.01875f
C300 vbn_prb en 0.05491f
C301 a_2784_4734# a_1684_3624# 0.03113f
C302 m1_2972_1572# m1_2640_532# 0.02667f
C303 sub_b vbn_ref 0.01715f
C304 sub_b m1_4822_1769# 0.00923f
C305 a_1632_2940# a_2784_4734# 0.11328f
C306 vm m1_3620_6220# 0.0371f
C307 spk sta 0.03529f
C308 a_2720_3620# a_2080_2940# 0.01142f
C309 aux vsrc 0
C310 vdd stb 0.11638f
C311 m1_3040_4730# sub 0.08159f
C312 vbn_prb a_1684_3624# 0
C313 m1_1545_9160# m1_1104_10052# -0
C314 m1_224_9600# m1_2532_9492# 0.02365f
C315 m1_208_9160# vbn_leak 0.2167f
C316 vbp_syn m1_2640_532# 0.20524f
C317 m1_3620_6220# el 0.0208f
C318 t3 rsel 0.00322f
C319 m1_4052_1572# m1_3704_1572# 0
C320 m1_224_9600# m1_1400_6220# 0.03725f
C321 a_288_2940# vdd 0.01069f
C322 hold en 0.01154f
C323 sub_b m1_3620_6220# 0
C324 vbp_st m1_4902_6422# 0.07204f
C325 a_2510_1690# a_2080_2940# 0.29113f
C326 sub vm 0.25861f
C327 a_1424_4734# a_1684_3624# 0.28821f
C328 m1_644_2570# m1_2640_532# 0.13227f
C329 t0 m1_1960_6220# 0.15519f
C330 a_1632_2940# a_1424_4734# 0.15323f
C331 t2 vbp_st 0
C332 m1_1545_9160# t0 0
C333 m1_3040_4730# vdd 0.17976f
C334 hold m1_2532_9492# 0.27826f
C335 a_480_5620# rsel 0.45221f
C336 vbp_st aux 0.04147f
C337 vdd mreset 0.09495f
C338 a_1424_4734# m1_1400_6220# 0
C339 a_1632_2940# hold 0.00618f
C340 m1_2640_532# abus 0.28961f
C341 sub el 0
C342 vm m1_3360_868# 0.43533f
C343 vreset a_2720_3620# 0
C344 hold m1_1400_6220# 0.04025f
C345 m1_2640_532# vbn_leak 0.35303f
C346 sub_b sub 0.06144f
C347 vbp_syn a_2080_2940# 0
C348 vdd vm 1.72904f
C349 m1_3360_868# el 0.04723f
C350 a_2784_4734# m1_1700_4540# 0.00595f
C351 m1_208_9160# m1_2020_9600# 0
C352 a_2510_1690# sta 0
C353 sub_b m1_3360_868# 0.00182f
C354 vreset a_2510_1690# 0.15126f
C355 t2 m1_208_9160# 0.00451f
C356 vdd el 3.83027f
C357 m1_208_9160# aux 0
C358 t0 m1_3620_6220# 0
C359 m1_644_2570# a_2080_2940# 0.45135f
C360 m1_1960_6220# rsel 0
C361 m1_1545_9160# rsel 0
C362 spk a_2720_3620# 0.01949f
C363 sub_b vdd 0.51598f
C364 vreset m1_2972_1572# 0.00216f
C365 t1 hold 0.05862f
C366 abus a_2080_2940# 0.00273f
C367 m1_4822_1769# rsel 0
C368 a_1424_4734# m1_1700_4540# 0.11932f
C369 vbp_syn sta 0.10294f
C370 m1_796_6220# rsel 0.62137f
C371 m1_4052_1572# m1_2640_532# 0.00159f
C372 a_2080_2940# vbn_leak 0.00598f
C373 vreset vbp_syn 0.03667f
C374 m1_1320_4540# a_2080_2940# 0
C375 hold m1_1700_4540# 0
C376 sub t0 0.01967f
C377 stb m1_2532_9492# 0.00738f
C378 vbn_prb m1_224_9600# 0
C379 vdd m1_1104_10052# 0.00631f
C380 a_480_5620# vbp_st 0.48416f
C381 a_2510_1690# spk 0.00745f
C382 a_1424_4734# a_2784_4734# 0.00569f
C383 aux m1_2640_532# 0.08311f
C384 vreset m1_644_2570# 0.00714f
C385 m1_208_9160# t3 0.00451f
C386 vsrc vbn_ref 0.03528f
C387 mreset en 0
C388 m1_4822_1769# vsrc 0.00316f
C389 a_288_2940# a_1632_2940# 0.00768f
C390 vbn_prb hold 0.05296f
C391 m1_4822_412# vm 0
C392 vreset abus 3.20116f
C393 vdd t0 0.11575f
C394 m1_3040_4730# a_1684_3624# 0.01861f
C395 sta vbn_leak 0
C396 mreset m1_2532_9492# 0
C397 vbp_syn spk 0.0221f
C398 m1_3212_6232# m1_3620_6220# 0.02287f
C399 vreset vbn_leak 0.03668f
C400 a_1632_2940# m1_3040_4730# 0
C401 vm en 0.20274f
C402 vbp_st m1_1960_6220# 0
C403 m1_4822_412# el 0
C404 a_2510_1690# a_2720_3620# 0.34258f
C405 sub rsel 0.26967f
C406 t1 stb 0
C407 vsrc m1_3620_6220# 0.00149f
C408 vm a_1684_3624# 0.00174f
C409 m1_644_2570# spk 0
C410 vm m1_2532_9492# 0.0221f
C411 el en 0.04105f
C412 aux a_2080_2940# 0
C413 a_1632_2940# vm 0.26897f
C414 vbp_st vbn_ref 0.04024f
C415 vbp_st m1_4822_1769# 0.00698f
C416 m1_3704_1572# m1_4822_1769# 0
C417 sub m1_3212_6232# 0.00227f
C418 m1_3360_868# rsel 0.00571f
C419 m1_1700_4540# stb 0
C420 sub_b en 0.01155f
C421 vm m1_1400_6220# 0.06276f
C422 a_1684_3624# el 0.01179f
C423 m1_2532_9492# el 0
C424 vbp_syn a_2720_3620# 0.06421f
C425 a_1632_2940# el 0.11115f
C426 vdd rsel 1.38723f
C427 sub_b a_1684_3624# 0.0619f
C428 sub_b m1_2532_9492# 0.00362f
C429 m1_208_9160# m1_1960_6220# 0.06468f
C430 m1_2972_1572# a_2510_1690# 0.01701f
C431 vreset m1_4052_1572# 0.00149f
C432 sub_b a_1632_2940# 0.00154f
C433 m1_4902_6422# sta 0.00115f
C434 m1_208_9160# m1_1545_9160# 0.02003f
C435 vbp_st m1_3620_6220# 0.00704f
C436 vdd m1_3212_6232# 0.24695f
C437 m1_644_2570# a_2720_3620# 0.00353f
C438 m1_208_9160# vbn_ref 0
C439 m1_3360_868# vsrc 0.02315f
C440 m1_3040_4730# m1_1700_4540# 0.00469f
C441 aux sta 0.0016f
C442 vbp_syn a_2510_1690# 0.23431f
C443 m1_208_9160# m1_796_6220# 0.05379f
C444 vreset aux 0.03619f
C445 m1_2292_960# vm 0.1009f
C446 a_2720_3620# abus 0
C447 t1 vm 0.07529f
C448 vdd vsrc 0.18976f
C449 m1_2972_1572# vbp_syn 0
C450 a_2720_3620# vbn_leak 0.01514f
C451 m1_3040_4730# a_2784_4734# 0.01832f
C452 vbp_st sub 0.0683f
C453 m1_2292_960# el 0.00289f
C454 m1_644_2570# a_2510_1690# 0.14106f
C455 m1_1700_4540# vm 0.01979f
C456 hold stb 0.00142f
C457 m1_3040_4730# vbn_prb 0
C458 a_480_5620# a_2080_2940# 0.21028f
C459 vbn_prb mreset 0
C460 t0 m1_2532_9492# 0.12633f
C461 a_2510_1690# abus 0.02694f
C462 sub_b t1 0
C463 vbp_st m1_3360_868# 0.02367f
C464 m1_644_2570# m1_2972_1572# 0
C465 a_1632_2940# t0 0.00123f
C466 m1_3704_1572# m1_3360_868# 0.02574f
C467 a_2784_4734# vm 0.00112f
C468 m1_2640_532# vbn_ref 0.06082f
C469 m1_4822_1769# m1_2640_532# 0.27195f
C470 a_2510_1690# vbn_leak 0.12441f
C471 aux spk 0
C472 m1_1320_4540# a_2510_1690# 0
C473 m1_2972_1572# abus 0.00944f
C474 sub_b m1_1700_4540# 0
C475 vbp_st vdd 2.13557f
C476 vdd m1_3704_1572# 0.03893f
C477 vbn_prb vm 0
C478 m1_644_2570# vbp_syn 0.05318f
C479 a_2784_4734# el 0
C480 m1_2972_1572# vbn_leak 0.00149f
C481 hold mreset 0.29977f
C482 vbp_syn abus 0.0399f
C483 sub_b a_2784_4734# 0
C484 rsel en 0.17452f
C485 vbn_prb el 0
C486 m1_224_9600# el 0
C487 vbp_syn vbn_leak 0.26595f
C488 a_1424_4734# vm 0
C489 sub_b vbn_prb 0.00497f
C490 a_1684_3624# rsel 0.366f
C491 m1_2532_9492# rsel 0
C492 hold vm 0.02896f
C493 m1_644_2570# abus 0.03521f
C494 aux a_2720_3620# 0.00514f
C495 a_1632_2940# rsel 0.13673f
C496 t1 t0 0.01505f
C497 vdd m1_208_9160# 0.00176f
C498 m1_4822_412# vsrc 0.00473f
C499 m1_4052_1572# a_2510_1690# 0
C500 m1_1400_6220# rsel 0.04341f
C501 m1_644_2570# vbn_leak 0.17686f
C502 m1_644_2570# m1_1320_4540# 0
C503 m1_4902_6422# a_2510_1690# 0.25275f
C504 hold el 0.02268f
C505 m1_3212_6232# m1_2532_9492# 0.00909f
C506 sub m1_2640_532# 0.01526f
C507 m1_1700_4540# t0 0
C508 m1_224_9600# m1_1104_10052# 0.00329f
C509 vsrc en 0.03451f
C510 abus vbn_leak 0.16763f
C511 sub_b hold 0.00163f
C512 a_2510_1690# aux 0.19019f
C513 a_480_5620# spk 0.00834f
C514 a_1684_3624# vsrc 0
C515 m1_3360_868# m1_2640_532# 0.06255f
C516 vbp_st m1_4822_412# 0.01302f
C517 vbp_syn m1_4902_6422# 0.17139f
C518 sta vbn_ref 0
C519 vdd m1_2640_532# 0.17556f
C520 m1_224_9600# t0 0
C521 m1_2292_960# rsel 0.00409f
C522 vreset vbn_ref 0.04976f
C523 vreset m1_4822_1769# 0
C524 vbp_st en 0.03559f
C525 vbp_syn aux 0.17848f
C526 m1_3704_1572# en 0.02036f
C527 sub a_2080_2940# 0.01412f
C528 m1_1700_4540# rsel 0.01222f
C529 stb vm 0.04177f
C530 vbp_st m1_2532_9492# 0.00102f
C531 vbp_st a_1684_3624# 0.03104f
C532 m1_4052_1572# abus 0
C533 a_480_5620# a_2720_3620# 0
C534 a_1632_2940# vbp_st 0.1604f
C535 hold t0 0.17918f
C536 sta m1_3620_6220# 0.25027f
C537 m1_644_2570# aux 0
C538 m1_4052_1572# vbn_leak 0.00493f
C539 a_2784_4734# rsel 0.16091f
C540 vbp_st m1_1400_6220# 0.00184f
C541 m1_4902_6422# vbn_leak 0.00588f
C542 m1_2020_9600# vbn_leak 0.32183f
C543 a_288_2940# vm 0.32306f
C544 aux abus 0.03131f
C545 m1_208_9160# en 0
C546 vbn_prb rsel 0
C547 vdd a_2080_2940# 0.00479f
C548 sub_b stb 0.20271f
C549 t2 vbn_leak 0.00244f
C550 a_480_5620# a_2510_1690# 0
C551 m1_224_9600# rsel 0.05305f
C552 m1_1320_4540# t2 0
C553 aux vbn_leak 3.20997f
C554 m1_3040_4730# vm 0.17084f
C555 a_288_2940# el 0.07037f
C556 vm mreset 0
C557 m1_208_9160# m1_2532_9492# 0.12354f
C558 vreset sub 0
C559 a_1424_4734# rsel 0.22089f
C560 m1_3040_4730# el 0
C561 spk m1_3620_6220# 0.01582f
C562 mreset el 0.03155f
C563 m1_208_9160# m1_1400_6220# 0.04533f
C564 vbp_st t1 0.00304f
C565 vreset m1_3360_868# 0.04247f
C566 hold rsel 0.02943f
C567 a_480_5620# vbp_syn 0
C568 vbn_prb vsrc 0.01173f
C569 a_2720_3620# vbn_ref 0
C570 sub_b m1_3040_4730# 0.06901f
C571 m1_224_9600# vsrc 0
C572 vdd sta 0.27127f
C573 m1_2640_532# en 0.31555f
C574 vbp_st m1_1700_4540# 0.36583f
C575 vreset vdd 0.50878f
C576 vm el 0.48139f
C577 hold m1_3212_6232# 0.02089f
C578 stb t0 0.00196f
C579 m1_4052_1572# aux 0.03364f
C580 sub spk 0.23649f
C581 t3 vbn_leak 0
C582 a_480_5620# m1_644_2570# 0.01903f
C583 a_1684_3624# m1_2640_532# 0.01087f
C584 sub_b vm 0.24493f
C585 vbp_st a_2784_4734# 0.00589f
C586 m1_4902_6422# aux 0.00216f
C587 a_2510_1690# vbn_ref 0.1999f
C588 hold vsrc 0.02503f
C589 t1 m1_208_9160# 0.00451f
C590 sub_b el 0.13398f
C591 vbp_st vbn_prb 3.19892f
C592 a_480_5620# vbn_leak 0
C593 vbp_st m1_224_9600# 0
C594 a_480_5620# m1_1320_4540# 0.10376f
C595 vdd spk 0.64647f
C596 mreset t0 0
C597 a_2080_2940# en 0.0055f
C598 vbp_syn vbn_ref 0.00566f
C599 vbp_syn m1_4822_1769# 0
C600 a_2510_1690# m1_3620_6220# 0.0012f
C601 sub a_2720_3620# 0.14188f
C602 vbp_st a_1424_4734# 0.03419f
C603 a_1684_3624# a_2080_2940# 0.00891f
C604 vbp_st hold 0.0284f
C605 m1_2292_960# m1_2640_532# 0.10875f
C606 vm t0 0.06212f
C607 a_1632_2940# a_2080_2940# 0.10805f
C608 vbn_prb m1_208_9160# 0
C609 m1_224_9600# m1_208_9160# 0.17833f
C610 stb m1_3212_6232# 0.08691f
C611 m1_1960_6220# vbn_leak 0.01676f
C612 t2 t3 0.01011f
C613 a_288_2940# rsel 0
C614 sub a_2510_1690# 0.39585f
C615 vreset m1_4822_412# 0.02053f
C616 vbp_syn m1_3620_6220# 0.10744f
C617 abus vbn_ref 0.06176f
C618 m1_1545_9160# vbn_leak 0.2214f
C619 t0 el 0
C620 m1_4822_1769# abus 0.03698f
C621 vdd a_2720_3620# 0.15367f
C622 sta en 0
C623 vbn_ref vbn_leak 0.01525f
C624 m1_4822_1769# vbn_leak 0.00178f
C625 m1_2972_1572# sub 0.0388f
C626 vreset en 3.35664f
C627 sub_b t0 0
C628 m1_796_6220# vbn_leak 0.01244f
C629 a_2510_1690# m1_3360_868# 0.00139f
C630 hold m1_208_9160# 0.01049f
C631 a_480_5620# t2 0.17845f
C632 vreset a_1684_3624# 0
C633 vbp_syn sub 0.0092f
C634 vdd a_2510_1690# 1.50333f
C635 m1_2972_1572# m1_3360_868# 0
C636 vbn_prb m1_2640_532# 0.30158f
C637 mreset m1_3212_6232# 0.04542f
C638 m1_2292_960# a_2080_2940# 0.00225f
C639 vm rsel 0.12176f
C640 m1_3620_6220# vbn_leak 0.00263f
C641 m1_2972_1572# vdd 0.00475f
C642 vbp_syn m1_3360_868# 0.12654f
C643 m1_3040_4730# vsrc 0
C644 mreset vsrc 0.01062f
C645 m1_2020_9600# m1_1960_6220# 0.00152f
C646 m1_644_2570# sub 0.03474f
C647 el rsel 0.00285f
C648 vbp_st stb 0
C649 vm m1_3212_6232# 0.02568f
C650 m1_1545_9160# m1_2020_9600# 0.13778f
C651 vbp_syn vdd 4.51093f
C652 m1_4052_1572# m1_4822_1769# 0
C653 sub_b rsel 0.06613f
C654 sub abus 0.01459f
C655 spk m1_2532_9492# 0.00557f
C656 a_1684_3624# spk 0.05608f
C657 m1_4902_6422# vbn_ref 0.10461f
C658 a_2784_4734# a_2080_2940# 0.0054f
C659 m1_644_2570# m1_3360_868# 0
C660 m1_3212_6232# el 0.02802f
C661 sub vbn_leak 0.07579f
C662 vm vsrc 0
C663 a_288_2940# vbp_st 0.01059f
C664 a_1632_2940# spk 0.32419f
C665 a_480_5620# t3 0.23364f
C666 vreset m1_2292_960# 0.0684f
C667 aux vbn_ref 0
C668 sub_b m1_3212_6232# 0.08355f
C669 m1_4822_1769# aux 0
C670 m1_3360_868# abus 0.03771f
C671 t2 m1_796_6220# 0.00138f
C672 m1_644_2570# vdd 0.02417f
C673 m1_1104_10052# rsel 0
C674 vsrc el 0
C675 vbp_st m1_3040_4730# 0.11383f
C676 vbp_st mreset 0
C677 m1_3360_868# vbn_leak 0.02568f
C678 a_2720_3620# en 0
C679 vdd abus 0.24796f
C680 sub_b vsrc 0.01041f
C681 m1_4902_6422# m1_3620_6220# -0
C682 vdd vbn_leak 0.4352f
C683 a_1424_4734# a_2080_2940# 0.006f
C684 m1_1320_4540# vdd 0.16902f
C685 a_1684_3624# a_2720_3620# 0.26748f
C686 vbp_st vm 0.35289f
C687 vm m1_3704_1572# 0.00909f
C688 aux m1_3620_6220# 0.00548f
C689 a_1632_2940# a_2720_3620# 0.00642f
C690 a_2510_1690# en 0.37357f
C691 vbn_prb sta 0
C692 vbp_st el 0.04174f
C693 vreset vbn_prb 0.04725f
C694 m1_3212_6232# t0 0
C695 t3 m1_796_6220# 0.31721f
C696 a_2510_1690# a_1684_3624# 0.3701f
C697 m1_2972_1572# en 0.0103f
C698 a_480_5620# m1_1960_6220# 0.10367f
C699 m1_1700_4540# spk 0.08747f
C700 sub_b vbp_st 0.11787f
C701 m1_4052_1572# m1_3360_868# 0.00423f
C702 a_1632_2940# a_2510_1690# 0.02314f
C703 sub aux 0.00239f
C704 a_2784_4734# spk 0.1862f
C705 vbp_syn en 0.05637f
C706 hold sta 0
C707 m1_4052_1572# vdd 0.01699f
C708 a_480_5620# m1_796_6220# 0.11184f
C709 vreset hold 0.00193f
C710 aux m1_3360_868# 0.02321f
C711 vdd m1_4902_6422# 0.06513f
C712 vdd m1_2020_9600# 0
C713 m1_208_9160# el 0
C714 vbp_syn a_1684_3624# 0.22692f
C715 vbp_syn m1_2532_9492# 0.01682f
C716 t2 vdd 0.1236f
C717 a_1632_2940# vbp_syn 0
C718 vdd aux 0.58454f
C719 m1_4822_412# abus 0.00377f
C720 m1_644_2570# en 0.02086f
C721 m1_1700_4540# a_2720_3620# 0
C722 m1_4822_412# vbn_leak 0.00248f
C723 m1_1545_9160# m1_1960_6220# 0.04574f
C724 abus en 0.25635f
C725 m1_2292_960# a_2510_1690# 0.17033f
C726 m1_644_2570# a_1684_3624# 0.0034f
C727 vbp_st t0 0.00216f
C728 a_1424_4734# spk 0.17799f
C729 vm m1_2640_532# 0.24029f
C730 m1_644_2570# a_1632_2940# 0.26444f
C731 vbn_leak en 0.03953f
C732 a_2784_4734# a_2720_3620# 0.02112f
C733 m1_208_9160# m1_1104_10052# 0
C734 hold spk 0.00141f
C735 m1_1960_6220# m1_796_6220# 0
C736 vsrc rsel 0
C737 a_1684_3624# abus 0
C738 m1_2972_1572# m1_2292_960# 0.00162f
C739 a_288_2940# a_2080_2940# 0
C740 m1_1700_4540# a_2510_1690# 0.00244f
C741 m1_1545_9160# m1_796_6220# -0
C742 a_1632_2940# abus 0
C743 m1_2640_532# el 0.0584f
C744 vsrc vss 1.03985f
C745 m1_3360_868# vss 0.94934f
C746 m1_2640_532# vss 1.32597f
C747 m1_1104_10052# vss -0.01965f
C748 m1_2292_960# vss 0.1617f
C749 en vss 1.31422f
C750 abus vss 4.3048f
C751 sub vss 0.64368f
C752 mreset vss 0.64751f
C753 spk vss 0.45036f
C754 hold vss 2.19355f
C755 vdd vss 20.99833f
C756 m1_1320_4540# vss -0.09979f
C757 vbp_st vss 0.6313f
C758 m1_1545_9160# vss 0.23798f
C759 m1_2020_9600# vss 0.15387f
C760 m1_4822_412# vss 0.1597f
C761 m1_796_6220# vss 0.18725f
C762 t3 vss 0.4576f
C763 vbn_prb vss 1.0371f
C764 aux vss 0.54897f
C765 m1_1400_6220# vss 0.26438f
C766 t2 vss 0.2686f
C767 m1_1700_4540# vss -0.07273f
C768 m1_3040_4730# vss -0.19548f
C769 m1_1960_6220# vss 0.26559f
C770 t1 vss 0.30116f
C771 m1_224_9600# vss 0.69494f
C772 m1_208_9160# vss 1.2785f
C773 a_2720_3620# vss 0.50447f
C774 m1_2532_9492# vss 0.50585f
C775 t0 vss 0.32481f
C776 m1_2972_1572# vss -0.04459f
C777 rsel vss 2.90274f
C778 a_1424_4734# vss 0.16852f
C779 a_1684_3624# vss 0.4478f
C780 vm vss 2.44515f
C781 m1_3704_1572# vss -0.05714f
C782 m1_644_2570# vss 0.01278f
C783 a_288_2940# vss -0.05532f
C784 sub_b vss 0.68924f
C785 m1_3212_6232# vss 0.33802f
C786 stb vss 0.21437f
C787 sta vss 0.14597f
C788 vreset vss 0.94457f
C789 a_2510_1690# vss 1.86085f
C790 m1_4822_1769# vss -0.03939f
C791 vbn_ref vss 1.08049f
C792 a_2080_2940# vss 0.18279f
C793 a_1632_2940# vss 1.0705f
C794 a_2784_4734# vss -0.00391f
C795 m1_4902_6422# vss -0.19058f
C796 m1_3620_6220# vss -0.07791f
C797 vbp_syn vss 1.49329f
C798 el vss 0.91981f
C799 vbn_leak vss 4.34494f
C800 m1_4052_1572# vss -0.0389f
C801 a_480_5620# vss 0.15815f
.ends
