* NGSPICE file created from slot_cmp_h.ext - technology: gf180mcuD

.subckt p_w2_l4 a_400_n200# a_n400_n244# w_n574_n330# a_n488_n200# VSUBS
X0 a_400_n200# a_n400_n244# a_n488_n200# w_n574_n330# pfet_03v3 ad=0.88p pd=4.88u as=0.88p ps=4.88u w=2u l=4u
C0 a_n400_n244# a_400_n200# 0.07019f
C1 a_n488_n200# a_400_n200# 0.01073f
C2 a_400_n200# w_n574_n330# 0.07409f
C3 a_n400_n244# a_n488_n200# 0.07019f
C4 a_n400_n244# w_n574_n330# 0.42229f
C5 a_n488_n200# w_n574_n330# 0.07409f
C6 a_400_n200# VSUBS 0.18936f
C7 a_n488_n200# VSUBS 0.18936f
C8 w_n574_n330# VSUBS 2.27304f
.ends

.subckt n_w1_l0p28 a_28_n100# a_n28_n144# a_n116_n100# VSUBS
X0 a_28_n100# a_n28_n144# a_n116_n100# VSUBS nfet_03v3 ad=0.44p pd=2.88u as=0.44p ps=2.88u w=1u l=0.28u
C0 a_n116_n100# a_28_n100# 0.04256f
C1 a_n116_n100# a_n28_n144# 0.00769f
C2 a_28_n100# a_n28_n144# 0.00769f
C3 a_28_n100# VSUBS 0.09911f
C4 a_n116_n100# VSUBS 0.09911f
.ends

.subckt n_w2_l2 a_n288_n200# a_200_n200# a_n200_n244# VSUBS
X0 a_200_n200# a_n200_n244# a_n288_n200# VSUBS nfet_03v3 ad=0.88p pd=4.88u as=0.88p ps=4.88u w=2u l=2u
C0 a_n288_n200# a_200_n200# 0.02133f
C1 a_n288_n200# a_n200_n244# 0.0587f
C2 a_200_n200# a_n200_n244# 0.0587f
C3 a_200_n200# VSUBS 0.2667f
C4 a_n288_n200# VSUBS 0.2667f
.ends

.subckt n_w2_l4 a_400_n200# a_n400_n244# a_n488_n200# VSUBS
X0 a_400_n200# a_n400_n244# a_n488_n200# VSUBS nfet_03v3 ad=0.88p pd=4.88u as=0.88p ps=4.88u w=2u l=4u
C0 a_n488_n200# a_400_n200# 0.01073f
C1 a_n488_n200# a_n400_n244# 0.07019f
C2 a_400_n200# a_n400_n244# 0.07019f
C3 a_400_n200# VSUBS 0.41684f
C4 a_n488_n200# VSUBS 0.41684f
.ends

.subckt n_w4_l1 a_n188_n400# a_100_n400# a_n100_n444# VSUBS
X0 a_100_n400# a_n100_n444# a_n188_n400# VSUBS nfet_03v3 ad=1.76p pd=8.88u as=1.76p ps=8.88u w=4u l=1u
C0 a_n188_n400# a_100_n400# 0.07756f
C1 a_n188_n400# a_n100_n444# 0.08505f
C2 a_100_n400# a_n100_n444# 0.08505f
C3 a_100_n400# VSUBS 0.26859f
C4 a_n188_n400# VSUBS 0.26859f
.ends

.subckt n_w0p5_l0p28 a_n28_n94# a_n116_n50# a_28_n50# VSUBS
X0 a_28_n50# a_n28_n94# a_n116_n50# VSUBS nfet_03v3 ad=0.22p pd=1.88u as=0.22p ps=1.88u w=0.5u l=0.28u
C0 a_n116_n50# a_28_n50# 0.02085f
C1 a_n116_n50# a_n28_n94# 0.00377f
C2 a_28_n50# a_n28_n94# 0.00377f
C3 a_28_n50# VSUBS 0.07987f
C4 a_n116_n50# VSUBS 0.07987f
.ends

.subckt n_w1_l0p5 a_n138_n100# a_50_n100# a_n50_n144# VSUBS
X0 a_50_n100# a_n50_n144# a_n138_n100# VSUBS nfet_03v3 ad=0.44p pd=2.88u as=0.44p ps=2.88u w=1u l=0.5u
C0 a_n138_n100# a_50_n100# 0.03085f
C1 a_n138_n100# a_n50_n144# 0.01275f
C2 a_50_n100# a_n50_n144# 0.01275f
C3 a_50_n100# VSUBS 0.11563f
C4 a_n138_n100# VSUBS 0.11563f
.ends

.subckt p_w1_l0p28 w_n202_n230# a_28_n100# a_n28_n144# a_n116_n100# VSUBS
X0 a_28_n100# a_n28_n144# a_n116_n100# w_n202_n230# pfet_03v3 ad=0.44p pd=2.88u as=0.44p ps=2.88u w=1u l=0.28u
C0 a_n28_n144# a_28_n100# 0.00769f
C1 a_n116_n100# a_28_n100# 0.04256f
C2 a_28_n100# w_n202_n230# 0.01808f
C3 a_n28_n144# a_n116_n100# 0.00769f
C4 a_n28_n144# w_n202_n230# 0.05841f
C5 a_n116_n100# w_n202_n230# 0.01808f
C6 a_28_n100# VSUBS 0.0597f
C7 a_n116_n100# VSUBS 0.0597f
C8 w_n202_n230# VSUBS 0.55752f
.ends

.subckt n_w4_l2 a_n288_n400# a_200_n400# a_n200_n444# VSUBS
X0 a_200_n400# a_n200_n444# a_n288_n400# VSUBS nfet_03v3 ad=1.76p pd=8.88u as=1.76p ps=8.88u w=4u l=2u
C0 a_n288_n400# a_200_n400# 0.04287f
C1 a_n288_n400# a_n200_n444# 0.11799f
C2 a_200_n400# a_n200_n444# 0.11799f
C3 a_200_n400# VSUBS 0.34365f
C4 a_n288_n400# VSUBS 0.34365f
.ends

.subckt p_w1_l2 w_n374_n230# a_n288_n100# a_200_n100# a_n200_n144# VSUBS
X0 a_200_n100# a_n200_n144# a_n288_n100# w_n374_n230# pfet_03v3 ad=0.44p pd=2.88u as=0.44p ps=2.88u w=1u l=2u
C0 a_n200_n144# a_200_n100# 0.02905f
C1 a_n288_n100# a_200_n100# 0.01056f
C2 a_200_n100# w_n374_n230# 0.03135f
C3 a_n200_n144# a_n288_n100# 0.02905f
C4 a_n200_n144# w_n374_n230# 0.22666f
C5 a_n288_n100# w_n374_n230# 0.03135f
C6 a_200_n100# VSUBS 0.1047f
C7 a_n288_n100# VSUBS 0.1047f
C8 w_n374_n230# VSUBS 1.03224f
.ends

.subckt n_w7p07_l7p07 a_707_n707# a_n795_n707# a_n707_n751# VSUBS
X0 a_707_n707# a_n707_n751# a_n795_n707# VSUBS nfet_03v3 ad=3.1108p pd=15.02u as=3.1108p ps=15.02u w=7.07u l=7.07u
C0 a_n795_n707# a_707_n707# 0.0212f
C1 a_n795_n707# a_n707_n751# 0.27012f
C2 a_707_n707# a_n707_n751# 0.27012f
C3 a_707_n707# VSUBS 0.84237f
C4 a_n795_n707# VSUBS 0.84237f
.ends

.subckt n_w0p5_l1p5 a_150_n50# a_n238_n50# a_n150_n94# VSUBS
X0 a_150_n50# a_n150_n94# a_n238_n50# VSUBS nfet_03v3 ad=0.22p pd=1.88u as=0.22p ps=1.88u w=0.5u l=1.5u
C0 a_n238_n50# a_150_n50# 0.00671f
C1 a_n238_n50# a_n150_n94# 0.01269f
C2 a_150_n50# a_n150_n94# 0.01269f
C3 a_150_n50# VSUBS 0.17146f
C4 a_n238_n50# VSUBS 0.17146f
.ends

.subckt n_w1_l2 a_n288_n100# a_200_n100# a_n200_n144# VSUBS
X0 a_200_n100# a_n200_n144# a_n288_n100# VSUBS nfet_03v3 ad=0.44p pd=2.88u as=0.44p ps=2.88u w=1u l=2u
C0 a_n288_n100# a_200_n100# 0.01056f
C1 a_n288_n100# a_n200_n144# 0.02905f
C2 a_200_n100# a_n200_n144# 0.02905f
C3 a_200_n100# VSUBS 0.22823f
C4 a_n288_n100# VSUBS 0.22823f
.ends

.subckt n_w3p54_l3p54 a_354_n354# a_n354_n398# a_n442_n354# VSUBS
X0 a_354_n354# a_n354_n398# a_n442_n354# VSUBS nfet_03v3 ad=1.5576p pd=7.96u as=1.5576p ps=7.96u w=3.54u l=3.54u
C0 a_n442_n354# a_354_n354# 0.02161f
C1 a_n442_n354# a_n354_n398# 0.12189f
C2 a_354_n354# a_n354_n398# 0.12189f
C3 a_354_n354# VSUBS 0.44156f
C4 a_n442_n354# VSUBS 0.44156f
.ends

.subckt p_w2_l1 a_100_n200# a_n100_n244# w_n274_n330# a_n188_n200# VSUBS
X0 a_100_n200# a_n100_n244# a_n188_n200# w_n274_n330# pfet_03v3 ad=0.88p pd=4.88u as=0.88p ps=4.88u w=2u l=1u
C0 a_n100_n244# a_100_n200# 0.04231f
C1 a_n188_n200# a_100_n200# 0.03858f
C2 a_100_n200# w_n274_n330# 0.04851f
C3 a_n100_n244# a_n188_n200# 0.04231f
C4 a_n100_n244# w_n274_n330# 0.12884f
C5 a_n188_n200# w_n274_n330# 0.04851f
C6 a_100_n200# VSUBS 0.11088f
C7 a_n188_n200# VSUBS 0.11088f
C8 w_n274_n330# VSUBS 1.08504f
.ends

.subckt n_w0p5_l3 a_n388_n50# a_300_n50# a_n300_n94# VSUBS
X0 a_300_n50# a_n300_n94# a_n388_n50# VSUBS nfet_03v3 ad=0.22p pd=1.88u as=0.22p ps=1.88u w=0.5u l=3u
C0 a_n388_n50# a_300_n50# 0.00348f
C1 a_n388_n50# a_n300_n94# 0.01602f
C2 a_300_n50# a_n300_n94# 0.01602f
C3 a_300_n50# VSUBS 0.28406f
C4 a_n388_n50# VSUBS 0.28406f
.ends

.subckt p_w1_l6 w_n774_n230# a_n688_n100# a_600_n100# a_n600_n144# VSUBS
X0 a_600_n100# a_n600_n144# a_n688_n100# w_n774_n230# pfet_03v3 ad=0.44p pd=2.88u as=0.44p ps=2.88u w=1u l=6u
C0 a_n600_n144# a_600_n100# 0.03688f
C1 a_n688_n100# a_600_n100# 0.00349f
C2 a_600_n100# w_n774_n230# 0.03955f
C3 a_n600_n144# a_n688_n100# 0.03688f
C4 a_n600_n144# w_n774_n230# 0.61793f
C5 a_n688_n100# w_n774_n230# 0.03955f
C6 a_600_n100# VSUBS 0.20933f
C7 a_n688_n100# VSUBS 0.20933f
C8 w_n774_n230# VSUBS 2.13624f
.ends

.subckt n_w0p5_l4 a_n488_n50# a_400_n50# a_n400_n94# VSUBS
X0 a_400_n50# a_n400_n94# a_n488_n50# VSUBS nfet_03v3 ad=0.22p pd=1.88u as=0.22p ps=1.88u w=0.5u l=4u
C0 a_n488_n50# a_400_n50# 0.0026f
C1 a_n488_n50# a_n400_n94# 0.01702f
C2 a_400_n50# a_n400_n94# 0.01702f
C3 a_400_n50# VSUBS 0.35913f
C4 a_n488_n50# VSUBS 0.35913f
.ends

.subckt slot_cmp_h vss vbp_syn vdd el aux vbn_leak vsrc vbp_st vbn_prb vbn_ref en
+ vreset abus spk t3 t2 t1 t0 sta stb hold mreset rsel sub sub_b vm
XXL_XP1 a_480_5620# a_480_5620# vdd vdd vss p_w2_l4
XXPM_XSW m1_4052_1572# rsel m1_3704_1572# vss n_w1_l0p28
XXL_XP2 a_1632_2940# a_480_5620# vdd vdd vss p_w2_l4
XXPR_XMB vss m1_4822_1769# vbn_prb vss n_w2_l2
XXL_XMT m1_218_2312# vbn_leak vss vss n_w2_l4
XXL_XM1 a_288_2940# a_480_5620# el vss n_w4_l1
XXS_XWA m1_4902_6422# vbp_syn vdd m1_3620_6220# vss p_w2_l4
XXR_Xi_XN spk vss a_2784_4734# vss n_w0p5_l0p28
XXL_XM2 a_2080_2940# a_1632_2940# a_1632_2940# vss n_w4_l1
XXS_XWB m1_4902_6422# vbp_syn vdd m1_3200_6220# vss p_w2_l4
XXR_XNR vss vbn_ref a_2510_1740# vss n_w2_l4
XXPR_XME m1_2440_960# en m1_4822_1769# vss n_w1_l0p28
XXR_XSW vreset vm a_2510_1740# vss n_w1_l0p5
XXR_Xi_XP vdd a_2784_4734# spk vdd vss p_w1_l0p28
XXPR_XMF m1_2440_960# vdd a_2510_1740# vss n_w4_l2
XXS_XQA vdd m1_3620_6220# sta vss vss p_w1_l0p28
XXS_XQB vdd m1_3200_6220# stb vss vss p_w1_l0p28
XXS_XNA sta vm m1_3620_6220# vss n_w0p5_l0p28
XXS_XNB stb vm m1_3200_6220# vss n_w0p5_l0p28
XXD_XPT vdd vdd m1_3040_4730# vbp_st vss p_w1_l2
XXL_XD2a m1_218_2312# a_2080_2940# a_2080_2940# vss n_w4_l1
XXPM_XSB abus sub_b m1_4052_1572# vss n_w1_l0p28
XXL_XD2b m1_218_2312# a_2080_2940# a_2080_2940# vss n_w4_l1
XXL_XD1a m1_218_2312# a_288_2940# a_288_2940# vss n_w4_l1
XXPM_XSC m1_3704_1572# en m1_3348_296# vss n_w1_l0p28
XXC_XC vss vss vm vss n_w7p07_l7p07
XXT_XR1 m1_2020_9600# m1_1545_9160# vbn_leak vss n_w0p5_l1p5
XXS_XPH vdd m1_4902_6422# vdd hold vss p_w1_l2
XXD_Xi1_XN a_1684_3624# vss a_1424_4734# vss n_w0p5_l0p28
XXL_XD1b m1_218_2312# a_288_2940# a_288_2940# vss n_w4_l1
XXPR_XSW m1_2972_1572# rsel m1_2260_960# vss n_w1_l0p28
XXT_XR2 m1_208_9160# m1_2020_9600# vbn_leak vss n_w0p5_l1p5
XXT_XP0 vdd m1_2440_6996# t0 vm vss p_w1_l0p28
XXD_XN1 a_2720_3620# vss a_2720_3620# vss n_w1_l2
XXT_XR3 m1_236_9612# m1_208_9160# vbn_leak vss n_w0p5_l1p5
XXT_XP1 vdd m1_1960_6220# t1 vm vss p_w1_l0p28
XXR_XCR_XC vss a_2510_1740# vss vss n_w3p54_l3p54
XXD_XN2 vss a_1684_3624# a_2720_3620# vss n_w1_l2
XXD_XM1 a_2720_3620# vm vdd m1_3040_4730# vss p_w2_l1
XXD_Xi1_XP vdd a_1424_4734# a_1684_3624# m1_1680_4540# vss p_w1_l0p28
XXT_XN0 t0 a_480_5620# m1_2440_6996# vss n_w0p5_l0p28
XXT_XP2 vdd m1_1400_6220# t2 vm vss p_w1_l0p28
XXD_XM2 a_1684_3624# aux vdd m1_3040_4730# vss p_w2_l1
XXPM_XMB vss m1_4822_412# vbn_prb vss n_w2_l2
XXT_XN1 t1 a_480_5620# m1_1960_6220# vss n_w0p5_l0p28
XXT_XP3 vdd m1_760_8360# t3 vm vss p_w1_l0p28
XXT_XL0 m1_2440_6996# m1_236_9612# vbn_leak vss n_w0p5_l3
XXT_XLT m1_236_9612# vdd vbn_leak vss n_w0p5_l3
XXT_XN2 t2 a_480_5620# m1_1400_6220# vss n_w0p5_l0p28
XXD_Xi1_XS vdd vdd m1_1680_4540# vbp_st vss p_w1_l2
XXT_XL1 m1_1960_6220# m1_208_9160# vbn_leak vss n_w0p5_l3
XXT_XN3 t3 a_480_5620# m1_760_8360# vss n_w0p5_l0p28
XXR_XPC vdd a_2510_1740# a_2784_4734# vdd vss p_w1_l0p28
XXD_XH1 vdd a_1684_3624# a_1424_4734# m1_1276_3992# vss p_w1_l0p28
XXPM_XME m1_3348_296# en m1_4822_412# vss n_w1_l0p28
XXT_XL2 m1_1400_6220# m1_2020_9600# vbn_leak vss n_w0p5_l3
XXT_XL3 m1_760_8360# m1_1545_9160# vbn_leak vss n_w0p5_l3
XXD_XH2 vdd vdd m1_1276_3992# vbp_st vss p_w1_l6
XXPM_XMF m1_3348_296# vdd vm vss n_w4_l2
XXS_XHL vdd vm hold a_1632_2940# vss p_w1_l0p28
XXD_Xi2_XN a_1424_4734# vss spk vss n_w0p5_l0p28
XXS_XMR mreset a_2510_1740# vdd vss n_w0p5_l0p28
XXD_Xi2_XP vdd spk a_1424_4734# vdd vss p_w1_l0p28
XXPR_XSB abus sub m1_2972_1572# vss n_w1_l0p28
XXPR_XSC m1_2440_960# en m1_2260_960# vss n_w1_l0p28
XXT_XRB m1_1104_10052# m1_1545_9160# vbn_leak vss n_w0p5_l4
XXT_XRA vss m1_1104_10052# vbn_leak vss n_w0p5_l4
C0 vbp_syn vbn_ref 0.0057f
C1 vm a_1632_2940# 0.06186f
C2 stb vbp_syn 0
C3 a_1632_2940# t2 0
C4 rsel vsrc 0
C5 sub_b t1 0.03178f
C6 abus vsrc 0.092f
C7 a_2784_4734# a_2080_2940# 0.00881f
C8 a_2510_1740# vbn_leak 0.15352f
C9 vm m1_2260_960# 0.21634f
C10 m1_1276_3992# a_2080_2940# 0
C11 a_1684_3624# vbn_ref 0.00209f
C12 aux vbn_leak 3.37296f
C13 m1_2260_960# vreset 0.07887f
C14 a_1632_2940# hold 0.04854f
C15 m1_1680_4540# m1_2440_6996# 0
C16 sub_b vdd 0.35915f
C17 m1_218_2312# vbn_prb 0
C18 vdd m1_3620_6220# 0.18868f
C19 m1_1545_9160# spk 0.00383f
C20 a_480_5620# stb 0
C21 m1_4822_1769# vsrc 0
C22 vdd en 0.25536f
C23 m1_218_2312# a_2784_4734# 0
C24 m1_2972_1572# vbn_leak 0
C25 spk m1_2440_6996# 0.02745f
C26 t0 m1_1960_6220# 0.1099f
C27 vbn_leak t3 0.00396f
C28 a_2080_2940# a_1632_2940# 0.14371f
C29 sub_b m1_1400_6220# 0.03313f
C30 m1_236_9612# m1_1545_9160# 0.04852f
C31 a_1424_4734# sub 0
C32 vm m1_2440_6996# 0.02334f
C33 t2 m1_2440_6996# 0
C34 m1_236_9612# m1_2440_6996# 0.04264f
C35 vbn_leak vsrc 3.29536f
C36 a_2080_2940# m1_2260_960# 0.00484f
C37 vbp_syn rsel 0.23578f
C38 t1 m1_208_9160# 0.03033f
C39 abus vbp_syn 0.05527f
C40 m1_218_2312# a_1632_2940# 0.26511f
C41 hold m1_2440_6996# 0.22108f
C42 m1_3200_6220# vbp_syn 0.11049f
C43 a_1684_3624# rsel 0.07571f
C44 sta sub 0.00519f
C45 vdd m1_208_9160# 0
C46 vbp_st sub 0.06688f
C47 m1_218_2312# m1_2260_960# 0
C48 abus a_1684_3624# 0
C49 a_480_5620# rsel 0
C50 m1_4052_1572# rsel 0
C51 vdd a_1424_4734# 0.48042f
C52 m1_4902_6422# vdd 0.06177f
C53 vm m1_4822_412# 0
C54 abus m1_4052_1572# 0
C55 m1_4822_412# vreset 0.01403f
C56 sub_b vbn_prb 0
C57 m1_760_8360# vbn_ref 0.0785f
C58 vbn_prb m1_3620_6220# 0
C59 a_288_2940# a_480_5620# 0.00327f
C60 spk m1_1960_6220# 0.03516f
C61 stb m1_760_8360# 0
C62 m1_1400_6220# m1_208_9160# 0.02899f
C63 vbn_prb en 0.04466f
C64 sub_b a_2784_4734# 0
C65 m1_1680_4540# m1_3040_4730# 0.02631f
C66 vm m1_1960_6220# 0.06442f
C67 m1_1400_6220# a_1424_4734# 0
C68 sub_b m1_1276_3992# 0.00873f
C69 a_2720_3620# m1_3040_4730# 0.09878f
C70 vbn_leak vbp_syn 0.25912f
C71 m1_236_9612# m1_1960_6220# 0.00218f
C72 vdd sta 0.21319f
C73 spk m1_3040_4730# 0.00279f
C74 vbp_st vdd 2.23212f
C75 t0 m1_1680_4540# 0
C76 m1_3348_296# sub 0.00182f
C77 m1_2440_960# sub 0.00829f
C78 el vbn_ref 0
C79 m1_1960_6220# hold 0.02869f
C80 vbn_leak a_1684_3624# 0.00209f
C81 vm m1_3040_4730# 0.21683f
C82 sub_b a_1632_2940# 0.11212f
C83 a_480_5620# vbn_leak 0
C84 vbn_leak m1_4052_1572# 0.00484f
C85 t0 spk 0.0225f
C86 a_2510_1740# sub 0.4495f
C87 vm t0 0.06996f
C88 vbn_prb m1_208_9160# 0
C89 sub_b m1_2260_960# 0.00286f
C90 m1_760_8360# rsel 0.18923f
C91 rsel m1_2020_9600# 0.00444f
C92 aux sub 0
C93 m1_4902_6422# vbn_prb 0.11453f
C94 t0 m1_236_9612# 0.00103f
C95 abus m1_760_8360# 0.19175f
C96 t0 mreset 0
C97 m1_2260_960# en 0.10323f
C98 vdd m1_3348_296# 0.23273f
C99 vdd m1_2440_960# 0.14025f
C100 a_2784_4734# a_1424_4734# 0.0059f
C101 sub_b m1_1545_9160# 0
C102 m1_1276_3992# a_1424_4734# 0.006f
C103 m1_1680_4540# a_2720_3620# 0.00151f
C104 t0 hold 0.06206f
C105 m1_2972_1572# sub 0
C106 m1_1680_4540# spk 0.15096f
C107 sub_b m1_2440_6996# 0.02687f
C108 vbn_prb sta 0
C109 a_2510_1740# vdd 1.67059f
C110 el rsel 0.03406f
C111 a_2720_3620# spk 0.02167f
C112 vbp_st vbn_prb 3.35825f
C113 m1_3704_1572# rsel 0.04574f
C114 vm m1_1680_4540# 0.03856f
C115 abus el 0.03285f
C116 aux vdd 0.59142f
C117 abus m1_3704_1572# 0
C118 a_288_2940# el 0.01438f
C119 vm a_2720_3620# 0.20548f
C120 a_1424_4734# a_1632_2940# 0.16263f
C121 a_2720_3620# vreset 0
C122 vbp_st a_2784_4734# 0.00841f
C123 m1_3200_6220# el 0.02698f
C124 vbn_leak m1_2020_9600# 0.39355f
C125 vbn_leak m1_760_8360# 0.10787f
C126 m1_1276_3992# vbp_st 0.12957f
C127 vm spk 0.2432f
C128 spk t2 0.48945f
C129 m1_2972_1572# vdd 0.0042f
C130 vdd t3 0.1055f
C131 m1_236_9612# spk 0.00453f
C132 mreset spk 0.00566f
C133 vm vreset 0.1433f
C134 vm t2 0.06211f
C135 vm mreset 0
C136 m1_236_9612# t2 0.00103f
C137 spk hold 0.36419f
C138 m1_1545_9160# m1_208_9160# 0.06063f
C139 mreset vreset 0
C140 vdd vsrc 0.1861f
C141 vbn_prb m1_3348_296# 0.02673f
C142 vbp_st a_1632_2940# 0.27753f
C143 m1_4822_412# en 0.08345f
C144 vbn_prb m1_2440_960# 0.13367f
C145 m1_1680_4540# a_2080_2940# 0
C146 vm hold 0.01031f
C147 vbn_leak el 0.1234f
C148 sub_b m1_1960_6220# 0.02657f
C149 t2 hold 0.02753f
C150 a_2080_2940# a_2720_3620# 0.01135f
C151 m1_208_9160# m1_2440_6996# 0.07574f
C152 m1_3704_1572# vbn_leak 0
C153 hold vreset 0.00201f
C154 vbp_syn sub 0.00134f
C155 m1_236_9612# hold 0
C156 mreset hold 0.08809f
C157 a_2080_2940# spk 0.00878f
C158 vbn_prb a_2510_1740# 0.13028f
C159 vm a_2080_2940# 0.13336f
C160 aux vbn_prb 0
C161 a_2080_2940# vreset 0
C162 m1_218_2312# a_2720_3620# 0.0024f
C163 a_1684_3624# sub 0.05719f
C164 a_2510_1740# a_2784_4734# 0.0098f
C165 m1_1276_3992# a_2510_1740# 0
C166 a_480_5620# sub 0.00537f
C167 aux a_2784_4734# 0
C168 en m1_3040_4730# 0
C169 m1_218_2312# spk 0
C170 m1_1104_10052# m1_2020_9600# 0.00175f
C171 vbp_st m1_2440_6996# 0.00126f
C172 vm m1_218_2312# 0.31173f
C173 vdd vbp_syn 4.60452f
C174 sub_b t0 0.02632f
C175 t0 m1_3620_6220# 0
C176 m1_218_2312# vreset 0.00483f
C177 m1_2440_960# m1_2260_960# 0.03491f
C178 t1 a_480_5620# 0.2916f
C179 vbn_prb vsrc 0.01018f
C180 a_2510_1740# a_1632_2940# 0
C181 m1_1960_6220# m1_208_9160# 0.10108f
C182 vdd a_1684_3624# 0.52987f
C183 a_480_5620# vdd 1.79929f
C184 vdd m1_4052_1572# 0.01699f
C185 a_2510_1740# m1_2260_960# 0.12749f
C186 vbp_st m1_4822_412# 0.01316f
C187 a_1632_2940# t3 0.00306f
C188 m1_218_2312# a_2080_2940# 0.4538f
C189 a_1424_4734# m1_3040_4730# 0
C190 a_480_5620# m1_1400_6220# 0.30654f
C191 sub_b a_2720_3620# 0.00127f
C192 rsel vbn_ref 0
C193 m1_760_8360# sub 0.05634f
C194 m1_2972_1572# m1_2260_960# 0
C195 t0 m1_208_9160# 0.04172f
C196 a_2720_3620# en 0
C197 sub_b spk 0.32106f
C198 abus vbn_ref 0.09022f
C199 stb rsel 0.10296f
C200 vm sub_b 0.34882f
C201 vm m1_3620_6220# 0.02993f
C202 vbn_prb vbp_syn 0.05778f
C203 sub_b t2 0.03172f
C204 sub_b vreset 0.00258f
C205 sub_b m1_236_9612# 0
C206 vm en 0.15238f
C207 stb m1_3200_6220# 0.12534f
C208 t1 m1_760_8360# 0.04148f
C209 vbp_st m1_3040_4730# 0.10937f
C210 mreset m1_3620_6220# 0.03275f
C211 m1_4822_412# m1_3348_296# 0.02942f
C212 en vreset 3.64762f
C213 m1_4822_1769# vbn_ref 0.06833f
C214 a_2784_4734# vbp_syn 0
C215 vbn_prb a_1684_3624# 0
C216 mreset en 0
C217 sub_b hold 0.27972f
C218 el sub 0.03045f
C219 vdd m1_2020_9600# 0
C220 t0 sta 0
C221 vdd m1_760_8360# 1.60273f
C222 vbp_st t0 0.00294f
C223 en hold 0.01349f
C224 a_2784_4734# a_1684_3624# 0.0384f
C225 m1_1276_3992# a_1684_3624# 0.09165f
C226 m1_1680_4540# a_1424_4734# 0.12367f
C227 vbn_leak vbn_ref 0.01475f
C228 aux m1_4822_412# 0.00149f
C229 a_2720_3620# a_1424_4734# 0
C230 sub_b a_2080_2940# 0.13689f
C231 vbp_syn a_1632_2940# 0
C232 m1_1276_3992# a_480_5620# 0.15605f
C233 spk m1_208_9160# 0.10557f
C234 m1_1400_6220# m1_760_8360# 0.03992f
C235 m1_1400_6220# m1_2020_9600# 0
C236 abus rsel 0.05518f
C237 a_2080_2940# en 0.01034f
C238 m1_4902_6422# spk 0
C239 a_1424_4734# spk 0.30686f
C240 t2 m1_208_9160# 0.02447f
C241 vdd el 3.88472f
C242 vm m1_4902_6422# 0
C243 vm a_1424_4734# 0.00102f
C244 m1_3704_1572# vdd 0.03292f
C245 a_1684_3624# a_1632_2940# 0.11888f
C246 m1_236_9612# m1_208_9160# 0.10509f
C247 m1_3200_6220# rsel 0.00948f
C248 m1_218_2312# sub_b 0.17128f
C249 a_480_5620# a_1632_2940# 0.3164f
C250 vbp_st m1_1680_4540# 0.07033f
C251 mreset m1_4902_6422# 0
C252 a_2510_1740# m1_3040_4730# 0.31488f
C253 m1_218_2312# en 0.0231f
C254 hold m1_208_9160# 0.00227f
C255 m1_4822_412# vsrc 0.00473f
C256 abus m1_4822_1769# 0.37626f
C257 vbp_st a_2720_3620# 0.00316f
C258 aux m1_3040_4730# 0.0035f
C259 sta spk 0.00147f
C260 m1_4902_6422# hold 0.05525f
C261 vbp_st spk 0.29828f
C262 vbp_syn m1_2440_6996# 0
C263 vm sta 0.06583f
C264 vbn_prb m1_760_8360# 0.0893f
C265 vm vbp_st 0.30992f
C266 sta vreset 0
C267 vbp_st t2 0
C268 vbn_leak rsel 0.33089f
C269 vbp_st vreset 0.03554f
C270 abus vbn_leak 0.14652f
C271 mreset sta 0.02275f
C272 vbp_st m1_236_9612# 0
C273 a_2080_2940# a_1424_4734# 0.00535f
C274 a_2784_4734# m1_760_8360# 0.00277f
C275 vbp_st mreset 0.00103f
C276 sta hold 0
C277 m1_3200_6220# vbn_leak 0.00223f
C278 a_480_5620# m1_2440_6996# 0.01223f
C279 vbp_st hold 0.0269f
C280 vsrc m1_3040_4730# 0
C281 m1_4822_1769# vbn_leak 0
C282 vbn_prb el 0
C283 m1_218_2312# a_1424_4734# 0
C284 m1_1680_4540# a_2510_1740# 0.07473f
C285 a_1632_2940# m1_760_8360# 0.26216f
C286 vm m1_3348_296# 0.19722f
C287 vbp_st a_2080_2940# 0
C288 vm m1_2440_960# 0.35692f
C289 a_2784_4734# el 0.00219f
C290 m1_3348_296# vreset 0.07971f
C291 a_2510_1740# a_2720_3620# 0.16103f
C292 m1_2440_960# vreset 0.09485f
C293 sub_b en 0.02425f
C294 m1_1276_3992# el 0.0065f
C295 aux a_2720_3620# 0.00475f
C296 a_2510_1740# spk 0.00471f
C297 aux spk 0
C298 vm a_2510_1740# 0.37881f
C299 m1_218_2312# vbp_st 0.0017f
C300 a_2510_1740# vreset 0.14399f
C301 vm aux 0.01129f
C302 aux vreset 0.03544f
C303 a_1632_2940# el 0.10481f
C304 mreset a_2510_1740# 0.03721f
C305 vbp_syn m1_3040_4730# 0.03625f
C306 m1_1545_9160# m1_760_8360# 0.00132f
C307 m1_1545_9160# m1_2020_9600# 0.13746f
C308 a_480_5620# m1_1960_6220# 0.14057f
C309 aux m1_236_9612# 0
C310 spk t3 0.13296f
C311 stb sub 0.01589f
C312 mreset aux 0.02791f
C313 m1_2440_960# a_2080_2940# 0
C314 a_2510_1740# hold 0.36053f
C315 m1_760_8360# m1_2440_6996# 0.03241f
C316 m1_2020_9600# m1_2440_6996# 0.0068f
C317 vm m1_2972_1572# 0
C318 a_2720_3620# vsrc 0
C319 vm t3 0.02715f
C320 m1_2260_960# el 0
C321 aux hold 0.03219f
C322 m1_2972_1572# vreset 0.05467f
C323 t2 t3 0.00819f
C324 sub_b m1_208_9160# 0.01244f
C325 a_1684_3624# m1_3040_4730# 0.1044f
C326 t0 vbp_syn 0
C327 spk vsrc 0
C328 m1_236_9612# t3 0.00424f
C329 m1_4902_6422# m1_3620_6220# 0
C330 sub_b m1_4902_6422# 0
C331 sub_b a_1424_4734# 0
C332 a_480_5620# m1_3040_4730# 0
C333 t1 stb 0
C334 a_2510_1740# a_2080_2940# 0.07313f
C335 vm vsrc 0
C336 m1_218_2312# m1_3348_296# 0
C337 vsrc vreset 0.03541f
C338 m1_218_2312# m1_2440_960# 0
C339 hold t3 0.15862f
C340 aux a_2080_2940# 0
C341 vdd vbn_ref 0.34516f
C342 m1_236_9612# vsrc 0
C343 stb vdd 0.12022f
C344 mreset vsrc 0.01048f
C345 t0 a_480_5620# 0.13767f
C346 m1_1104_10052# vbn_leak 0.01238f
C347 vsrc hold 0.02531f
C348 sta m1_3620_6220# 0.08896f
C349 m1_218_2312# a_2510_1740# 0.03316f
C350 sub_b vbp_st 0.25222f
C351 vbp_st m1_3620_6220# 0.00926f
C352 rsel sub 0.56026f
C353 m1_218_2312# aux 0.00219f
C354 sta en 0
C355 abus sub 0.09586f
C356 vbp_st en 0.03314f
C357 vbp_syn a_2720_3620# 0.01929f
C358 m1_760_8360# m1_1960_6220# 0.03579f
C359 a_288_2940# sub 0
C360 vbp_syn spk 0.00145f
C361 m1_3200_6220# sub 0.00268f
C362 m1_1680_4540# a_1684_3624# 0.12294f
C363 m1_218_2312# m1_2972_1572# 0
C364 m1_4822_412# el 0
C365 a_2720_3620# a_1684_3624# 0.27063f
C366 a_480_5620# m1_1680_4540# 0.00345f
C367 vm vbp_syn 0.17497f
C368 vbp_syn vreset 0.03374f
C369 a_480_5620# a_2720_3620# 0
C370 m1_760_8360# m1_3040_4730# 0.11636f
C371 m1_236_9612# vbp_syn 0
C372 a_1684_3624# spk 0.2045f
C373 mreset vbp_syn 0.26938f
C374 m1_218_2312# vsrc 0
C375 vdd rsel 0.41474f
C376 sub_b m1_3348_296# 0.001f
C377 sub_b m1_2440_960# 0.00915f
C378 a_480_5620# spk 0.50528f
C379 abus vdd 0.19277f
C380 vm a_1684_3624# 0.06522f
C381 vbn_prb vbn_ref 3.38876f
C382 a_288_2940# vdd 0.00864f
C383 vbp_syn hold 0.06983f
C384 a_1684_3624# vreset 0
C385 en m1_3348_296# 0.13529f
C386 m1_2440_960# en 0.10672f
C387 vm a_480_5620# 0.14569f
C388 vm m1_4052_1572# 0
C389 t0 m1_760_8360# 0.03255f
C390 vbn_leak sub 0.01161f
C391 vbp_st m1_208_9160# 0
C392 a_480_5620# t2 0.2257f
C393 m1_3200_6220# vdd 0.21344f
C394 m1_4052_1572# vreset 0.00494f
C395 m1_4902_6422# sta 0
C396 vbp_st a_1424_4734# 0.03039f
C397 vbp_st m1_4902_6422# 0.07016f
C398 sub_b a_2510_1740# 0.02416f
C399 a_2510_1740# m1_3620_6220# 0.00218f
C400 el m1_3040_4730# 0
C401 a_2080_2940# vbp_syn 0
C402 sub_b aux 0.03434f
C403 aux m1_3620_6220# 0.00565f
C404 a_2510_1740# en 0.2926f
C405 a_480_5620# hold 0.13333f
C406 t1 vbn_leak 0.00104f
C407 aux en 0.03186f
C408 t0 el 0
C409 a_2080_2940# a_1684_3624# 0.00278f
C410 sub_b t3 0.16043f
C411 vdd vbn_leak 0.44038f
C412 vbp_st sta 0.00526f
C413 m1_218_2312# vbp_syn 0.05561f
C414 m1_1680_4540# m1_760_8360# 0.08443f
C415 a_480_5620# a_2080_2940# 0.22733f
C416 m1_2972_1572# en 0.00519f
C417 a_2720_3620# m1_760_8360# 0.00796f
C418 sub_b vsrc 0.00149f
C419 vbn_prb rsel 0
C420 m1_3620_6220# vsrc 0.00149f
C421 spk m1_760_8360# 0.56361f
C422 m1_1400_6220# vbn_leak 0.1407f
C423 abus vbn_prb 0.32865f
C424 m1_218_2312# a_1684_3624# 0
C425 en vsrc 0.03194f
C426 m1_218_2312# a_480_5620# 0.03727f
C427 vm m1_760_8360# 0.21566f
C428 a_2784_4734# rsel 0.01351f
C429 m1_760_8360# t2 0.08544f
C430 m1_760_8360# vreset 0.23732f
C431 a_2510_1740# a_1424_4734# 0
C432 m1_4902_6422# a_2510_1740# 0.32482f
C433 aux m1_208_9160# 0
C434 m1_236_9612# m1_760_8360# 0.04875f
C435 m1_236_9612# m1_2020_9600# 0.12051f
C436 mreset m1_760_8360# 0.01276f
C437 aux m1_4902_6422# 0.00323f
C438 m1_4822_1769# vbn_prb 0.04923f
C439 a_2720_3620# el 0.02362f
C440 vbp_st m1_3348_296# 0.02362f
C441 vbp_st m1_2440_960# 0.03505f
C442 m1_760_8360# hold 0.01233f
C443 stb m1_2440_6996# 0
C444 spk el 0.00412f
C445 t3 m1_208_9160# 0.05438f
C446 a_1632_2940# rsel 0.00213f
C447 vm el 0.05554f
C448 el vreset 0.03523f
C449 vm m1_3704_1572# 0
C450 a_2510_1740# sta 0
C451 vbn_prb vbn_leak 0.00248f
C452 a_288_2940# a_1632_2940# 0.00161f
C453 vbp_st a_2510_1740# 0.22934f
C454 sub_b vbp_syn 0.14637f
C455 m1_3704_1572# vreset 0.00545f
C456 vbp_syn m1_3620_6220# 0.1788f
C457 aux sta 0
C458 m1_236_9612# el 0
C459 m1_1104_10052# vdd 0.01066f
C460 vsrc m1_208_9160# 0
C461 mreset el 0.02729f
C462 vbp_st aux 0.04265f
C463 m1_2260_960# rsel 0.00101f
C464 m1_4902_6422# vsrc 0.01875f
C465 abus m1_2260_960# 0
C466 vbp_syn en 0.04982f
C467 vbn_leak a_2784_4734# 0
C468 el hold 0.03485f
C469 m1_4822_412# vbn_ref 0.0877f
C470 m1_2440_960# m1_3348_296# 0.20264f
C471 sub_b a_1684_3624# 0
C472 sub_b a_480_5620# 0.22463f
C473 sub_b m1_4052_1572# 0.05199f
C474 a_1684_3624# en 0
C475 m1_4052_1572# en 0.00456f
C476 a_2080_2940# el 0.12118f
C477 rsel m1_2440_6996# 0.03393f
C478 stb m1_1960_6220# 0
C479 sta vsrc 0
C480 a_2510_1740# m1_3348_296# 0.00965f
C481 vbn_leak a_1632_2940# 0
C482 a_2510_1740# m1_2440_960# 0.13473f
C483 vbp_st vsrc 3.32919f
C484 aux m1_3348_296# 0.02314f
C485 t1 sub 0
C486 aux m1_2440_960# 0.03247f
C487 vbp_syn m1_208_9160# 0.04614f
C488 vbn_ref m1_3040_4730# 0
C489 m1_218_2312# el 0.0494f
C490 m1_4902_6422# vbp_syn 0.15646f
C491 vdd sub 0.38471f
C492 m1_2972_1572# m1_3348_296# 0.00154f
C493 m1_2972_1572# m1_2440_960# 0.00654f
C494 aux a_2510_1740# 0.09927f
C495 m1_1545_9160# vbn_leak 0.22041f
C496 abus m1_4822_412# 0.00377f
C497 a_1424_4734# a_1684_3624# 0.30197f
C498 t0 stb 0.00192f
C499 m1_3348_296# vsrc 0.023f
C500 t1 vdd 0.11037f
C501 m1_2440_960# vsrc 0.03403f
C502 a_480_5620# a_1424_4734# 0.03911f
C503 vbn_leak m1_2440_6996# 0.04181f
C504 a_2510_1740# m1_2972_1572# 0.02593f
C505 sub_b m1_760_8360# 0.08264f
C506 vbp_syn sta 0.009f
C507 rsel m1_1960_6220# 0.00282f
C508 vbp_st vbp_syn 0.17082f
C509 m1_760_8360# en 0.10392f
C510 t1 m1_1400_6220# 0.10294f
C511 a_2510_1740# vsrc 0.11731f
C512 aux vsrc 0
C513 vbp_st a_1684_3624# 0.02432f
C514 rsel m1_3040_4730# 0.01778f
C515 m1_1400_6220# vdd 0.04935f
C516 vbp_st a_480_5620# 0.4175f
C517 stb m1_1680_4540# 0
C518 a_2720_3620# vbn_ref 0
C519 sub_b el 0.4625f
C520 m1_4822_412# vbn_leak 0.00248f
C521 m1_3620_6220# el 0.02107f
C522 sub_b m1_3704_1572# 0
C523 vbn_prb sub 0
C524 el en 0.03151f
C525 t0 rsel 0.01763f
C526 vbp_syn m1_3348_296# 0.0978f
C527 stb spk 0
C528 m1_2440_960# vbp_syn 0.0596f
C529 m1_3704_1572# en 0.00442f
C530 vm vbn_ref 0
C531 a_2784_4734# sub 0.11906f
C532 vbn_leak m1_1960_6220# 0.02019f
C533 vbn_ref vreset 0.05016f
C534 m1_1276_3992# sub 0
C535 vm stb 0.05481f
C536 m1_1104_10052# m1_1545_9160# -0
C537 m1_760_8360# m1_208_9160# 0.17216f
C538 m1_2020_9600# m1_208_9160# 0.00169f
C539 mreset vbn_ref 0
C540 t0 m1_3200_6220# 0
C541 a_1424_4734# m1_760_8360# 0.02098f
C542 a_2510_1740# vbp_syn 0.24073f
C543 hold vbn_ref 0.05285f
C544 m1_2440_960# m1_4052_1572# 0.01752f
C545 aux vbp_syn 0.16412f
C546 vbn_leak m1_3040_4730# 0
C547 stb hold 0
C548 vbn_prb vdd 0.13941f
C549 a_1632_2940# sub 0.30074f
C550 m1_1680_4540# rsel 0.10215f
C551 a_2510_1740# a_1684_3624# 0.1016f
C552 vdd a_2784_4734# 0.42839f
C553 el m1_208_9160# 0
C554 sta m1_760_8360# 0
C555 m1_1276_3992# vdd 0.17097f
C556 aux a_1684_3624# 0.12989f
C557 a_2720_3620# rsel 0.061f
C558 a_480_5620# a_2510_1740# 0
C559 a_2510_1740# m1_4052_1572# 0
C560 vbp_st m1_760_8360# 0.28817f
C561 abus a_2720_3620# 0
C562 a_1424_4734# el 0.00101f
C563 m1_4902_6422# el 0.00202f
C564 t0 vbn_leak 0.00308f
C565 m1_2260_960# sub 0.00375f
C566 aux m1_4052_1572# 0.03176f
C567 spk rsel 0.02706f
C568 t1 a_1632_2940# 0
C569 vm rsel 0.40357f
C570 vbp_syn vsrc 0.11604f
C571 rsel vreset 0.01361f
C572 vm abus 0
C573 m1_218_2312# vbn_ref 0
C574 m1_3200_6220# spk 0.0172f
C575 abus vreset 3.38764f
C576 a_288_2940# vm 0.03386f
C577 vdd a_1632_2940# 0.56864f
C578 m1_236_9612# rsel 0.04872f
C579 a_480_5620# t3 0.15506f
C580 mreset rsel 0
C581 abus mreset 0
C582 vm m1_3200_6220# 0.04019f
C583 sta el 0
C584 vbp_st el 0.04436f
C585 a_1684_3624# vsrc 0
C586 m1_2440_6996# sub 0.17854f
C587 rsel hold 0.15956f
C588 vdd m1_2260_960# 0
C589 abus hold 0
C590 mreset m1_3200_6220# 0.03148f
C591 t1 m1_1545_9160# 0.00579f
C592 m1_4822_1769# vreset 0.01045f
C593 m1_1400_6220# a_1632_2940# 0
C594 vbn_leak a_2720_3620# 0.01281f
C595 m1_3200_6220# hold 0.02074f
C596 t1 m1_2440_6996# 0
C597 vbn_leak spk 0.03637f
C598 a_2080_2940# rsel 0.00545f
C599 abus a_2080_2940# 0
C600 vm vbn_leak 0.10494f
C601 a_2510_1740# m1_760_8360# 0.99754f
C602 a_288_2940# a_2080_2940# 0
C603 vbn_leak vreset 0.03658f
C604 vbn_leak t2 0.00196f
C605 aux m1_760_8360# 0.11842f
C606 vdd m1_2440_6996# 0.03749f
C607 m1_236_9612# vbn_leak 0.66948f
C608 el m1_3348_296# 0.02284f
C609 mreset vbn_leak 0.02638f
C610 m1_1276_3992# a_2784_4734# 0
C611 m1_2440_960# el 0.03098f
C612 m1_1545_9160# m1_1400_6220# 0.01966f
C613 m1_3704_1572# m1_3348_296# 0.03813f
C614 m1_218_2312# rsel 0.06613f
C615 m1_3704_1572# m1_2440_960# 0.02905f
C616 m1_218_2312# abus 0.007f
C617 vbn_leak hold 0.02751f
C618 sub_b vbn_ref 0
C619 vbp_syn a_1684_3624# 0.27445f
C620 a_288_2940# m1_218_2312# 0.44471f
C621 m1_760_8360# t3 0.13759f
C622 m1_1960_6220# sub 0
C623 m1_1400_6220# m1_2440_6996# 0
C624 stb m1_3620_6220# 0
C625 sub_b stb 0.01967f
C626 a_480_5620# vbp_syn 0
C627 en vbn_ref 3.40721f
C628 a_2510_1740# el 0.08362f
C629 a_2510_1740# m1_3704_1572# 0
C630 a_2784_4734# a_1632_2940# 0.09312f
C631 aux el 3.32277f
C632 m1_218_2312# m1_4822_1769# 0
C633 m1_1276_3992# a_1632_2940# 0.00188f
C634 m1_760_8360# vsrc 0.0517f
C635 vbn_leak a_2080_2940# 0.00597f
C636 m1_4822_412# vdd 0.01289f
C637 t1 m1_1960_6220# 0.27404f
C638 m1_3040_4730# sub 0
C639 a_480_5620# a_1684_3624# 0.0931f
C640 vdd m1_1960_6220# 0.03992f
C641 m1_1104_10052# spk 0
C642 m1_218_2312# vbn_leak 0.2111f
C643 t0 sub 0.00301f
C644 el vsrc 0
C645 m1_208_9160# vbn_ref 0
C646 m1_1104_10052# m1_236_9612# 0.005f
C647 m1_1400_6220# m1_1960_6220# 0.00636f
C648 sub_b rsel 0.40545f
C649 m1_4902_6422# vbn_ref 0.10322f
C650 vdd m1_3040_4730# 0.1375f
C651 sub_b abus 0.08221f
C652 t1 t0 0.01505f
C653 rsel en 0.10818f
C654 a_288_2940# sub_b 0.15521f
C655 abus en 0.29812f
C656 vbp_syn m1_760_8360# 0.10252f
C657 sub_b m1_3200_6220# 0.00625f
C658 m1_3200_6220# m1_3620_6220# 0.02699f
C659 t0 vdd 0.11552f
C660 sub_b m1_4822_1769# 0
C661 m1_1680_4540# sub 0.04454f
C662 m1_4822_412# vbn_prb 0.11717f
C663 a_2720_3620# sub 0.07398f
C664 a_1684_3624# m1_760_8360# 0.00638f
C665 sta vbn_ref 0
C666 m1_4822_1769# en 0.09223f
C667 vbp_st vbn_ref 0.04314f
C668 stb sta 0.019f
C669 a_480_5620# m1_760_8360# 0.3479f
C670 vbp_st stb 0
C671 spk sub 0.05877f
C672 vbp_syn el 0.12993f
C673 vm sub 0.20446f
C674 m1_3704_1572# vbp_syn 0.03875f
C675 sub_b vbn_leak 0.24909f
C676 vbn_leak m1_3620_6220# 0.00269f
C677 vreset sub 0.00581f
C678 rsel m1_208_9160# 0.13368f
C679 vbn_leak en 0.03504f
C680 a_1424_4734# rsel 0
C681 m1_1680_4540# vdd 0.3482f
C682 t1 spk 0.1407f
C683 a_1684_3624# el 0.05903f
C684 vdd a_2720_3620# 0.13288f
C685 m1_1545_9160# m1_2440_6996# 0.03193f
C686 vbn_prb m1_3040_4730# 0
C687 hold sub 0.08911f
C688 vm t1 0.0792f
C689 m1_4052_1572# el 0.03762f
C690 a_480_5620# el 0.06776f
C691 t1 t2 0.01505f
C692 m1_3348_296# vbn_ref 0.03697f
C693 m1_3704_1572# m1_4052_1572# 0
C694 m1_3200_6220# m1_4902_6422# -0.01073f
C695 m1_2440_960# vbn_ref 0.03805f
C696 vdd spk 1.4523f
C697 t1 m1_236_9612# 0.00103f
C698 a_2784_4734# m1_3040_4730# 0.01481f
C699 vm vdd 1.51774f
C700 a_1632_2940# m1_1960_6220# 0
C701 vdd t2 0.11294f
C702 sta rsel 0.0012f
C703 vdd vreset 0.28871f
C704 t1 hold 0.03034f
C705 a_2080_2940# sub 0.13852f
C706 vbp_st rsel 0.13374f
C707 m1_236_9612# vdd 0.04299f
C708 mreset vdd 0.10608f
C709 abus vbp_st 0.10262f
C710 m1_1400_6220# spk 0.25205f
C711 a_2510_1740# vbn_ref 0.25047f
C712 a_288_2940# vbp_st 0.00946f
C713 m1_760_8360# m1_2020_9600# 0
C714 aux vbn_ref 0
C715 stb a_2510_1740# 0
C716 vbn_leak m1_208_9160# 0.31423f
C717 vm m1_1400_6220# 0.07427f
C718 m1_3200_6220# sta 0.3236f
C719 vdd hold 0.48154f
C720 m1_1400_6220# t2 0.22862f
C721 vbp_st m1_3200_6220# 0.00173f
C722 m1_4902_6422# vbn_leak 0.00588f
C723 a_1632_2940# m1_3040_4730# 0
C724 m1_218_2312# sub 0.09237f
C725 m1_236_9612# m1_1400_6220# 0.017f
C726 m1_4822_1769# vbp_st 0.00457f
C727 m1_1545_9160# m1_1960_6220# 0.04574f
C728 m1_1400_6220# hold 0.02863f
C729 vdd a_2080_2940# 0.00696f
C730 t0 a_1632_2940# 0
C731 rsel m1_3348_296# 0.01013f
C732 vbn_prb a_2720_3620# 0
C733 m1_1960_6220# m1_2440_6996# 0.00259f
C734 m1_2440_960# rsel 0.01375f
C735 m1_760_8360# el 0.05792f
C736 abus m1_3348_296# 0.09167f
C737 m1_1680_4540# a_2784_4734# 0.06879f
C738 vsrc vbn_ref 0.03993f
C739 vbn_leak sta 0
C740 abus m1_2440_960# 0.04301f
C741 vbp_st vbn_leak 0.04228f
C742 a_2784_4734# a_2720_3620# 0.02962f
C743 m1_218_2312# vdd 0.02835f
C744 vm vbn_prb 0
C745 vbn_prb vreset 0.05198f
C746 a_2784_4734# spk 0.14702f
C747 a_2510_1740# rsel 0.578f
C748 m1_1276_3992# spk 0.09756f
C749 m1_4822_1769# m1_2440_960# 0.01949f
C750 vbn_prb m1_236_9612# 0
C751 aux rsel 0.00152f
C752 abus a_2510_1740# 0.00595f
C753 mreset vbn_prb 0
C754 vm a_2784_4734# 0.00267f
C755 abus aux 0.03509f
C756 m1_1680_4540# a_1632_2940# 0.12969f
C757 m1_1276_3992# t2 0
C758 m1_3200_6220# a_2510_1740# 0
C759 vbn_prb hold 0.05298f
C760 a_2720_3620# a_1632_2940# 0
C761 t0 m1_2440_6996# 0.38305f
C762 aux m1_3200_6220# 0.0071f
C763 sub_b sub 0.02831f
C764 m1_3620_6220# sub 0.00251f
C765 m1_2972_1572# rsel 0.0373f
C766 vbn_leak m1_3348_296# 0.02543f
C767 spk a_1632_2940# 0.35989f
C768 abus m1_2972_1572# 0.00522f
C769 m1_2440_960# vbn_leak 0.04489f
C770 en sub 0.09416f
C771 vsrc vss 1.0363f
C772 m1_3348_296# vss 0.94892f
C773 m1_1104_10052# vss 0.01317f
C774 m1_2260_960# vss 0.18719f
C775 en vss 1.32981f
C776 abus vss 4.54549f
C777 sub vss 0.39785f
C778 mreset vss 0.59944f
C779 spk vss 1.12622f
C780 hold vss 2.20818f
C781 vdd vss 21.36157f
C782 m1_1276_3992# vss -0.01041f
C783 vbp_st vss 0.66901f
C784 m1_1545_9160# vss 0.18079f
C785 m1_2020_9600# vss 0.06253f
C786 m1_4822_412# vss 0.14609f
C787 m1_760_8360# vss 1.81455f
C788 t3 vss 0.44919f
C789 vbn_prb vss 1.08798f
C790 aux vss 0.63069f
C791 m1_1400_6220# vss 0.16632f
C792 t2 vss 0.2502f
C793 m1_1680_4540# vss -0.05319f
C794 m1_3040_4730# vss -0.19252f
C795 m1_1960_6220# vss 0.29509f
C796 t1 vss 0.28283f
C797 m1_236_9612# vss 0.80842f
C798 m1_208_9160# vss 1.18212f
C799 a_2720_3620# vss 0.49455f
C800 m1_2440_6996# vss 0.42943f
C801 t0 vss 0.42704f
C802 m1_2972_1572# vss -0.04607f
C803 rsel vss 2.17463f
C804 a_1424_4734# vss 0.19649f
C805 a_1684_3624# vss 0.36204f
C806 vm vss 1.58363f
C807 m1_3704_1572# vss -0.06278f
C808 m1_218_2312# vss -0.04138f
C809 a_288_2940# vss -0.06616f
C810 sub_b vss 1.43495f
C811 m1_3200_6220# vss 0.14328f
C812 stb vss 0.18813f
C813 sta vss 0.25427f
C814 m1_2440_960# vss 0.82003f
C815 vreset vss 0.88219f
C816 a_2510_1740# vss 1.62665f
C817 m1_4822_1769# vss 0.00271f
C818 vbn_ref vss 0.92018f
C819 a_2080_2940# vss 0.13616f
C820 a_1632_2940# vss 0.72453f
C821 a_2784_4734# vss 0.02823f
C822 m1_4902_6422# vss -0.17539f
C823 m1_3620_6220# vss -0.054f
C824 vbp_syn vss 1.23118f
C825 el vss 0.69912f
C826 vbn_leak vss 4.17193f
C827 m1_4052_1572# vss -0.05911f
C828 a_480_5620# vss 0.32032f
.ends
