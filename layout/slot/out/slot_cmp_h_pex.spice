* NGSPICE file created from slot_cmp_h.ext - technology: gf180mcuD

.subckt p_w2_l4 a_400_n200# a_n400_n244# w_n574_n330# a_n488_n200# VSUBS
X0 a_400_n200# a_n400_n244# a_n488_n200# w_n574_n330# pfet_03v3 ad=0.88p pd=4.88u as=0.88p ps=4.88u w=2u l=4u
C0 a_n400_n244# a_n488_n200# 0.07019f
C1 a_n400_n244# w_n574_n330# 0.42229f
C2 w_n574_n330# a_n488_n200# 0.07409f
C3 a_n400_n244# a_400_n200# 0.07019f
C4 a_n488_n200# a_400_n200# 0.01073f
C5 w_n574_n330# a_400_n200# 0.07409f
C6 a_400_n200# VSUBS 0.18936f
C7 a_n488_n200# VSUBS 0.18936f
C8 w_n574_n330# VSUBS 2.27304f
.ends

.subckt n_w1_l0p28 a_28_n100# a_n28_n144# a_n116_n100# VSUBS
X0 a_28_n100# a_n28_n144# a_n116_n100# VSUBS nfet_03v3 ad=0.44p pd=2.88u as=0.44p ps=2.88u w=1u l=0.28u
C0 a_n116_n100# a_28_n100# 0.04256f
C1 a_n116_n100# a_n28_n144# 0.00769f
C2 a_n28_n144# a_28_n100# 0.00769f
C3 a_28_n100# VSUBS 0.09911f
C4 a_n116_n100# VSUBS 0.09911f
.ends

.subckt n_w2_l2 a_n288_n200# a_200_n200# a_n200_n244# VSUBS
X0 a_200_n200# a_n200_n244# a_n288_n200# VSUBS nfet_03v3 ad=0.88p pd=4.88u as=0.88p ps=4.88u w=2u l=2u
C0 a_n288_n200# a_200_n200# 0.02133f
C1 a_n288_n200# a_n200_n244# 0.0587f
C2 a_n200_n244# a_200_n200# 0.0587f
C3 a_200_n200# VSUBS 0.2667f
C4 a_n288_n200# VSUBS 0.2667f
.ends

.subckt n_w2_l4 a_400_n200# a_n400_n244# a_n488_n200# VSUBS
X0 a_400_n200# a_n400_n244# a_n488_n200# VSUBS nfet_03v3 ad=0.88p pd=4.88u as=0.88p ps=4.88u w=2u l=4u
C0 a_n488_n200# a_400_n200# 0.01073f
C1 a_n488_n200# a_n400_n244# 0.07019f
C2 a_n400_n244# a_400_n200# 0.07019f
C3 a_400_n200# VSUBS 0.41684f
C4 a_n488_n200# VSUBS 0.41684f
.ends

.subckt n_w4_l0p5_k1 a_n188_n400# a_50_n400# a_n50_n444# VSUBS
X0 a_50_n400# a_n50_n444# a_n188_n400# VSUBS nfet_03v3 ad=2.76p pd=9.38u as=2.76p ps=9.38u w=4u l=0.5u
C0 a_n188_n400# a_50_n400# 0.10174f
C1 a_n188_n400# a_n50_n444# 0.04238f
C2 a_n50_n444# a_50_n400# 0.04238f
C3 a_50_n400# VSUBS 0.23105f
C4 a_n188_n400# VSUBS 0.23105f
.ends

.subckt n_w0p5_l0p28 a_n28_n94# a_n116_n50# a_28_n50# VSUBS
X0 a_28_n50# a_n28_n94# a_n116_n50# VSUBS nfet_03v3 ad=0.22p pd=1.88u as=0.22p ps=1.88u w=0.5u l=0.28u
C0 a_n116_n50# a_28_n50# 0.02085f
C1 a_n116_n50# a_n28_n94# 0.00377f
C2 a_n28_n94# a_28_n50# 0.00377f
C3 a_28_n50# VSUBS 0.07987f
C4 a_n116_n50# VSUBS 0.07987f
.ends

.subckt n_w1_l0p5 a_n138_n100# a_50_n100# a_n50_n144# VSUBS
X0 a_50_n100# a_n50_n144# a_n138_n100# VSUBS nfet_03v3 ad=0.44p pd=2.88u as=0.44p ps=2.88u w=1u l=0.5u
C0 a_n138_n100# a_50_n100# 0.03085f
C1 a_n138_n100# a_n50_n144# 0.01275f
C2 a_n50_n144# a_50_n100# 0.01275f
C3 a_50_n100# VSUBS 0.11563f
C4 a_n138_n100# VSUBS 0.11563f
.ends

.subckt p_w1_l0p28 w_n202_n230# a_28_n100# a_n28_n144# a_n116_n100# VSUBS
X0 a_28_n100# a_n28_n144# a_n116_n100# w_n202_n230# pfet_03v3 ad=0.44p pd=2.88u as=0.44p ps=2.88u w=1u l=0.28u
C0 a_n28_n144# a_n116_n100# 0.00769f
C1 a_n28_n144# w_n202_n230# 0.05841f
C2 w_n202_n230# a_n116_n100# 0.01808f
C3 a_n28_n144# a_28_n100# 0.00769f
C4 a_n116_n100# a_28_n100# 0.04256f
C5 w_n202_n230# a_28_n100# 0.01808f
C6 a_28_n100# VSUBS 0.0597f
C7 a_n116_n100# VSUBS 0.0597f
C8 w_n202_n230# VSUBS 0.55752f
.ends

.subckt n_w4_l2 a_n288_n400# a_200_n400# a_n200_n444# VSUBS
X0 a_200_n400# a_n200_n444# a_n288_n400# VSUBS nfet_03v3 ad=1.76p pd=8.88u as=1.76p ps=8.88u w=4u l=2u
C0 a_n288_n400# a_200_n400# 0.04287f
C1 a_n288_n400# a_n200_n444# 0.11799f
C2 a_n200_n444# a_200_n400# 0.11799f
C3 a_200_n400# VSUBS 0.34365f
C4 a_n288_n400# VSUBS 0.34365f
.ends

.subckt p_w1_l2 w_n374_n230# a_n288_n100# a_200_n100# a_n200_n144# VSUBS
X0 a_200_n100# a_n200_n144# a_n288_n100# w_n374_n230# pfet_03v3 ad=0.44p pd=2.88u as=0.44p ps=2.88u w=1u l=2u
C0 a_n200_n144# a_n288_n100# 0.02905f
C1 a_n200_n144# w_n374_n230# 0.22666f
C2 w_n374_n230# a_n288_n100# 0.03135f
C3 a_n200_n144# a_200_n100# 0.02905f
C4 a_n288_n100# a_200_n100# 0.01056f
C5 w_n374_n230# a_200_n100# 0.03135f
C6 a_200_n100# VSUBS 0.1047f
C7 a_n288_n100# VSUBS 0.1047f
C8 w_n374_n230# VSUBS 1.03224f
.ends

.subckt n_w7p07_l7p07 a_707_n707# a_n795_n707# a_n707_n751# VSUBS
X0 a_707_n707# a_n707_n751# a_n795_n707# VSUBS nfet_03v3 ad=3.1108p pd=15.02u as=3.1108p ps=15.02u w=7.07u l=7.07u
C0 a_n795_n707# a_707_n707# 0.0212f
C1 a_n795_n707# a_n707_n751# 0.27012f
C2 a_n707_n751# a_707_n707# 0.27012f
C3 a_707_n707# VSUBS 0.84237f
C4 a_n795_n707# VSUBS 0.84237f
.ends

.subckt n_w0p5_l1p5 a_150_n50# a_n238_n50# a_n150_n94# VSUBS
X0 a_150_n50# a_n150_n94# a_n238_n50# VSUBS nfet_03v3 ad=0.22p pd=1.88u as=0.22p ps=1.88u w=0.5u l=1.5u
C0 a_n238_n50# a_150_n50# 0.00671f
C1 a_n238_n50# a_n150_n94# 0.01269f
C2 a_n150_n94# a_150_n50# 0.01269f
C3 a_150_n50# VSUBS 0.17146f
C4 a_n238_n50# VSUBS 0.17146f
.ends

.subckt n_w1_l2 a_n288_n100# a_200_n100# a_n200_n144# VSUBS
X0 a_200_n100# a_n200_n144# a_n288_n100# VSUBS nfet_03v3 ad=0.44p pd=2.88u as=0.44p ps=2.88u w=1u l=2u
C0 a_n288_n100# a_200_n100# 0.01056f
C1 a_n288_n100# a_n200_n144# 0.02905f
C2 a_n200_n144# a_200_n100# 0.02905f
C3 a_200_n100# VSUBS 0.22823f
C4 a_n288_n100# VSUBS 0.22823f
.ends

.subckt n_w3p54_l3p54 a_354_n354# a_n354_n398# a_n442_n354# VSUBS
X0 a_354_n354# a_n354_n398# a_n442_n354# VSUBS nfet_03v3 ad=1.5576p pd=7.96u as=1.5576p ps=7.96u w=3.54u l=3.54u
C0 a_n442_n354# a_354_n354# 0.02161f
C1 a_n442_n354# a_n354_n398# 0.12189f
C2 a_n354_n398# a_354_n354# 0.12189f
C3 a_354_n354# VSUBS 0.44156f
C4 a_n442_n354# VSUBS 0.44156f
.ends

.subckt p_w2_l1 a_100_n200# a_n100_n244# w_n274_n330# a_n188_n200# VSUBS
X0 a_100_n200# a_n100_n244# a_n188_n200# w_n274_n330# pfet_03v3 ad=0.88p pd=4.88u as=0.88p ps=4.88u w=2u l=1u
C0 a_n100_n244# a_n188_n200# 0.04231f
C1 a_n100_n244# w_n274_n330# 0.12884f
C2 w_n274_n330# a_n188_n200# 0.04851f
C3 a_n100_n244# a_100_n200# 0.04231f
C4 a_n188_n200# a_100_n200# 0.03858f
C5 w_n274_n330# a_100_n200# 0.04851f
C6 a_100_n200# VSUBS 0.11088f
C7 a_n188_n200# VSUBS 0.11088f
C8 w_n274_n330# VSUBS 1.08504f
.ends

.subckt n_w0p5_l3 a_n388_n50# a_300_n50# a_n300_n94# VSUBS
X0 a_300_n50# a_n300_n94# a_n388_n50# VSUBS nfet_03v3 ad=0.22p pd=1.88u as=0.22p ps=1.88u w=0.5u l=3u
C0 a_n388_n50# a_300_n50# 0.00348f
C1 a_n388_n50# a_n300_n94# 0.01602f
C2 a_n300_n94# a_300_n50# 0.01602f
C3 a_300_n50# VSUBS 0.28406f
C4 a_n388_n50# VSUBS 0.28406f
.ends

.subckt p_w1_l6 w_n774_n230# a_n688_n100# a_600_n100# a_n600_n144# VSUBS
X0 a_600_n100# a_n600_n144# a_n688_n100# w_n774_n230# pfet_03v3 ad=0.44p pd=2.88u as=0.44p ps=2.88u w=1u l=6u
C0 a_n600_n144# a_n688_n100# 0.03688f
C1 a_n600_n144# w_n774_n230# 0.61793f
C2 w_n774_n230# a_n688_n100# 0.03955f
C3 a_n600_n144# a_600_n100# 0.03688f
C4 a_n688_n100# a_600_n100# 0.00349f
C5 w_n774_n230# a_600_n100# 0.03955f
C6 a_600_n100# VSUBS 0.20933f
C7 a_n688_n100# VSUBS 0.20933f
C8 w_n774_n230# VSUBS 2.13624f
.ends

.subckt n_w0p5_l4 a_n488_n50# a_400_n50# a_n400_n94# VSUBS
X0 a_400_n50# a_n400_n94# a_n488_n50# VSUBS nfet_03v3 ad=0.22p pd=1.88u as=0.22p ps=1.88u w=0.5u l=4u
C0 a_n488_n50# a_400_n50# 0.0026f
C1 a_n488_n50# a_n400_n94# 0.01702f
C2 a_n400_n94# a_400_n50# 0.01702f
C3 a_400_n50# VSUBS 0.35913f
C4 a_n488_n50# VSUBS 0.35913f
.ends

.subckt slot_cmp_h vss vbp_syn vdd el aux vbn_leak vsrc vbp_st vbn_prb vbn_ref en
+ vreset abus spk t3 t2 t1 t0 sta stb hold mreset rsel sub sub_b vm
XXL_XP1 a_480_5620# a_480_5620# vdd vdd vss p_w2_l4
XXPM_XSW m1_4052_1572# rsel m1_3704_1572# vss n_w1_l0p28
XXL_XP2 a_1682_2940# a_480_5620# vdd vdd vss p_w2_l4
XXPR_XMB vss m1_4802_1762# vbn_prb vss n_w2_l2
XXL_XMT m1_644_2570# vbn_leak vss vss n_w2_l4
XXL_XM1 a_338_2940# a_480_5620# el vss n_w4_l0p5_k1
XXS_XWA m1_4902_6422# vbp_syn vdd m1_3600_6548# vss p_w2_l4
XXR_Xi_XN spk vss a_2784_4734# vss n_w0p5_l0p28
XXL_XM2 a_2130_2940# a_1682_2940# a_1682_2940# vss n_w4_l0p5_k1
XXS_XWB m1_4902_6422# vbp_syn vdd m1_3188_6220# vss p_w2_l4
XXR_XNR vss vbn_ref a_2510_1740# vss n_w2_l4
XXPR_XME m1_2448_868# en m1_4802_1762# vss n_w1_l0p28
XXR_XSW vreset vm a_2510_1740# vss n_w1_l0p5
XXR_Xi_XP vdd a_2784_4734# spk vdd vss p_w1_l0p28
XXPR_XMF m1_2448_868# vdd a_2510_1740# vss n_w4_l2
XXS_XQA vdd m1_3600_6548# sta vss vss p_w1_l0p28
XXS_XQB vdd m1_3188_6220# stb vss vss p_w1_l0p28
XXS_XNA sta vm m1_3600_6548# vss n_w0p5_l0p28
XXS_XNB stb vm m1_3188_6220# vss n_w0p5_l0p28
XXD_XPT vdd vdd m1_3052_4742# a_368_4070# vss p_w1_l2
XXL_XD2a m1_644_2570# a_2130_2940# a_2130_2940# vss n_w4_l0p5_k1
XXPM_XSB abus sub_b m1_4052_1572# vss n_w1_l0p28
XXL_XD2b m1_644_2570# a_2130_2940# a_2130_2940# vss n_w4_l0p5_k1
XXL_XD1a m1_644_2570# a_338_2940# a_338_2940# vss n_w4_l0p5_k1
XXPM_XSC m1_3704_1572# en m1_3360_172# vss n_w1_l0p28
XXC_XC vss vss vm vss n_w7p07_l7p07
XXT_XR1 m1_2020_9600# m1_1540_9160# vbn_leak vss n_w0p5_l1p5
XXS_XPH vdd m1_4902_6422# vdd hold vss p_w1_l2
XXD_Xi1_XN a_1684_3624# vss a_1424_4734# vss n_w0p5_l0p28
XXL_XD1b m1_644_2570# a_338_2940# a_338_2940# vss n_w4_l0p5_k1
XXPR_XSW m1_2972_1572# rsel m1_2280_960# vss n_w1_l0p28
XXT_XR2 m1_208_9160# m1_2020_9600# vbn_leak vss n_w0p5_l1p5
XXT_XP0 vdd m1_2436_8920# t0 vm vss p_w1_l0p28
XXD_XN1 a_2720_3620# vss a_2720_3620# vss n_w1_l2
XXT_XR3 m1_236_9612# m1_208_9160# vbn_leak vss n_w0p5_l1p5
XXT_XP1 vdd m1_1960_6220# t1 vm vss p_w1_l0p28
XXR_XCR_XC vss a_2510_1740# vss vss n_w3p54_l3p54
XXD_XN2 vss a_1684_3624# a_2720_3620# vss n_w1_l2
XXD_XM1 a_2720_3620# vm vdd m1_3052_4742# vss p_w2_l1
XXD_Xi1_XP vdd a_1424_4734# a_1684_3624# m1_1092_4130# vss p_w1_l0p28
XXT_XN0 t0 a_480_5620# m1_2436_8920# vss n_w0p5_l0p28
XXT_XP2 vdd m1_1400_6220# t2 vm vss p_w1_l0p28
XXD_XM2 a_1684_3624# aux vdd m1_3052_4742# vss p_w2_l1
XXPM_XMB vss m1_4822_412# vbn_prb vss n_w2_l2
XXT_XN1 t1 a_480_5620# m1_1960_6220# vss n_w0p5_l0p28
XXT_XP3 vdd m1_841_6220# t3 vm vss p_w1_l0p28
XXT_XL0 m1_2436_8920# m1_236_9612# vbn_leak vss n_w0p5_l3
XXT_XLT m1_236_9612# vdd vbn_leak vss n_w0p5_l3
XXT_XN2 t2 a_480_5620# m1_1400_6220# vss n_w0p5_l0p28
XXD_Xi1_XS vdd vdd m1_1092_4130# a_368_4070# vss p_w1_l2
XXT_XL1 m1_1960_6220# m1_208_9160# vbn_leak vss n_w0p5_l3
XXT_XN3 t3 a_480_5620# m1_841_6220# vss n_w0p5_l0p28
XXR_XPC vdd a_2510_1740# a_2784_4734# vdd vss p_w1_l0p28
XXD_XH1 vdd a_1684_3624# a_1424_4734# m1_1244_4440# vss p_w1_l0p28
XXPM_XME m1_3360_172# en m1_4822_412# vss n_w1_l0p28
XXT_XL2 m1_1400_6220# m1_2020_9600# vbn_leak vss n_w0p5_l3
XXT_XL3 m1_841_6220# m1_1540_9160# vbn_leak vss n_w0p5_l3
XXD_XH2 vdd vdd m1_1244_4440# a_368_4070# vss p_w1_l6
XXPM_XMF m1_3360_172# vdd vm vss n_w4_l2
XXPC vdd vdd a_368_4070# a_368_4070# vss p_w1_l2
XXNC a_368_4070# vss vbn_prb vss n_w1_l2
XXS_XHL vdd vm hold a_1682_2940# vss p_w1_l0p28
XXD_Xi2_XN a_1424_4734# vss spk vss n_w0p5_l0p28
XXS_XMR mreset a_2510_1740# vdd vss n_w0p5_l0p28
XXD_Xi2_XP vdd spk a_1424_4734# vdd vss p_w1_l0p28
XXPR_XSB abus sub m1_2972_1572# vss n_w1_l0p28
XXPR_XSC m1_2448_868# en m1_2280_960# vss n_w1_l0p28
XXT_XRB m1_1104_10052# m1_1540_9160# vbn_leak vss n_w0p5_l4
XXT_XRA vss m1_1104_10052# vbn_leak vss n_w0p5_l4
C0 vreset vm 0.15354f
C1 m1_4822_412# vdd 0.01221f
C2 m1_3360_172# m1_4822_412# 0.05008f
C3 m1_3600_6548# vbp_syn 0.10055f
C4 m1_841_6220# vdd 0.03399f
C5 vbp_st m1_236_9612# 0
C6 m1_644_2570# a_1684_3624# 0.01137f
C7 en sub_b 0.04123f
C8 m1_644_2570# aux 0.00316f
C9 vreset a_2720_3620# 0
C10 a_368_4070# m1_2436_8920# 0.00161f
C11 vbp_st mreset 0
C12 m1_841_6220# a_1682_2940# 0.00164f
C13 vm spk 0.12f
C14 vbp_syn vdd 5.0366f
C15 vbn_leak m1_236_9612# 0.83992f
C16 a_368_4070# el 0.02034f
C17 sub_b rsel 0.20759f
C18 aux m1_3188_6220# 0.00155f
C19 m1_3360_172# vbp_syn 0.06893f
C20 a_2510_1740# vm 0.17879f
C21 vbn_prb m1_4802_1762# 0.14693f
C22 a_368_4070# vbn_ref 0
C23 vm a_480_5620# 0.45397f
C24 sub m1_2280_960# 0
C25 a_338_2940# a_2130_2940# 0.00151f
C26 hold m1_3188_6220# 0
C27 m1_3052_4742# a_368_4070# 0.22776f
C28 mreset vbn_leak 0.02825f
C29 vbp_syn a_1682_2940# 0
C30 stb vbp_syn 0.00106f
C31 t2 hold 0.03581f
C32 spk a_2720_3620# 0.03774f
C33 sta mreset 0.01573f
C34 m1_3704_1572# m1_2280_960# 0
C35 a_2130_2940# vdd 0.00164f
C36 a_2510_1740# a_2720_3620# 0.49003f
C37 a_480_5620# a_2720_3620# 0
C38 a_2784_4734# vdd 0.41972f
C39 m1_2020_9600# m1_1960_6220# 0.00275f
C40 a_338_2940# m1_1092_4130# 0
C41 vm m1_4822_412# 0
C42 vbn_prb vsrc 0.04769f
C43 t0 m1_236_9612# 0.00103f
C44 m1_841_6220# vm 0.03544f
C45 m1_1960_6220# t1 0.27252f
C46 a_2130_2940# a_1682_2940# 0.11573f
C47 sub_b sub 0.1422f
C48 abus el 0.03394f
C49 abus m1_4052_1572# 0.00965f
C50 a_2784_4734# a_1682_2940# 0
C51 m1_2280_960# vbn_leak 0
C52 vdd m1_1092_4130# 0.54338f
C53 vbn_prb a_1684_3624# 0.00734f
C54 t0 mreset 0
C55 abus vbn_ref 0.07643f
C56 vreset a_368_4070# 0
C57 vbp_syn vm 0.24602f
C58 vbn_prb aux 0.05081f
C59 m1_3704_1572# sub_b 0
C60 a_1682_2940# m1_1092_4130# 0.01358f
C61 vbn_prb hold 0.05309f
C62 en m1_4802_1762# 0.11313f
C63 sub_b vbp_st 0.01435f
C64 m1_1960_6220# rsel 0.04269f
C65 vbp_syn a_2720_3620# 0.04524f
C66 a_368_4070# spk 0.08043f
C67 vdd m1_1400_6220# 0.05976f
C68 a_2130_2940# vm 0.03399f
C69 sub_b vbn_leak 0.31251f
C70 a_368_4070# a_2510_1740# 0.28229f
C71 m1_2972_1572# vdd 0.0038f
C72 a_368_4070# a_480_5620# 0.36744f
C73 m1_2020_9600# aux 0
C74 a_2784_4734# vm 0.0128f
C75 m1_3360_172# m1_2972_1572# 0.00276f
C76 sta sub_b 0.0244f
C77 en vsrc 0.06535f
C78 a_338_2940# vdd 0.00807f
C79 a_1682_2940# m1_1400_6220# 0
C80 m1_3600_6548# vdd 0.20299f
C81 vreset abus 3.44218f
C82 m1_4902_6422# vbn_ref 0.09993f
C83 m1_1104_10052# vdd 0.01066f
C84 m1_2448_868# m1_4052_1572# 0.01864f
C85 a_2130_2940# a_2720_3620# 0.01131f
C86 vsrc rsel 0
C87 hold t1 0.03581f
C88 m1_2448_868# el 0.04811f
C89 vm m1_1092_4130# 0.01117f
C90 a_2784_4734# a_2720_3620# 0.02135f
C91 m1_2448_868# vbn_ref 0.03511f
C92 en a_1684_3624# 0
C93 a_338_2940# a_1682_2940# 0.01529f
C94 m1_3600_6548# stb 0.00109f
C95 m1_3360_172# vdd 0.31893f
C96 en aux 0.06544f
C97 rsel a_1684_3624# 0.36345f
C98 a_1424_4734# m1_644_2570# 0.00852f
C99 t0 sub_b 0.01099f
C100 m1_1092_4130# a_2720_3620# 0
C101 aux rsel 0.00389f
C102 a_1682_2940# vdd 0.6863f
C103 stb vdd 0.16074f
C104 en hold 0.17277f
C105 m1_2436_8920# m1_236_9612# 0.02764f
C106 abus a_2510_1740# 0.00643f
C107 m1_208_9160# m1_236_9612# 0.14518f
C108 el m1_236_9612# 0
C109 a_368_4070# vbp_syn 0.35704f
C110 vm m1_1400_6220# 0.0616f
C111 t3 m1_236_9612# 0.00386f
C112 hold rsel 0.02756f
C113 m1_2972_1572# vm 0.00417f
C114 m1_4802_1762# vbp_st 0.00793f
C115 m1_1244_4440# a_1684_3624# 0.00641f
C116 el mreset 0.05943f
C117 vreset m1_4902_6422# 0
C118 mreset vbn_ref 0
C119 a_338_2940# vm 0.21631f
C120 m1_3600_6548# vm 0.02386f
C121 m1_1960_6220# vbn_leak 0.01622f
C122 m1_4802_1762# vbn_leak 0
C123 abus m1_4822_412# 0.00649f
C124 vreset m1_2448_868# 0.12242f
C125 a_2130_2940# a_368_4070# 0.00183f
C126 m1_1540_9160# m1_2020_9600# 0.08003f
C127 sub a_1684_3624# 0.05092f
C128 a_368_4070# a_2784_4734# 0.03214f
C129 vm vdd 2.28415f
C130 vsrc vbp_st 3.28878f
C131 sub aux 0.00125f
C132 m1_3360_172# vm 0.23882f
C133 a_2510_1740# m1_4902_6422# 0.0283f
C134 sub hold 0.09874f
C135 abus vbp_syn 0.22941f
C136 m1_4052_1572# m1_2280_960# 0
C137 el m1_2280_960# 0.01386f
C138 a_368_4070# m1_1092_4130# 0.25462f
C139 a_1682_2940# vm 0.54801f
C140 stb vm 0.04439f
C141 vbp_st a_1684_3624# 0
C142 vsrc vbn_leak 3.29216f
C143 m1_2448_868# a_2510_1740# 0.14081f
C144 vdd a_2720_3620# 0.14673f
C145 t0 m1_1960_6220# 0.09391f
C146 vbp_st aux 0
C147 vsrc sta 0
C148 vreset mreset 0
C149 vbn_leak a_1684_3624# 0.00455f
C150 vbp_st hold 0.03353f
C151 m1_1540_9160# rsel 0.15368f
C152 a_1682_2940# a_2720_3620# 0
C153 vbn_leak aux 3.35489f
C154 m1_2436_8920# sub_b 0.00595f
C155 a_368_4070# m1_1400_6220# 0
C156 vbn_prb m1_644_2570# 0.00217f
C157 m1_4052_1572# sub_b 0.00909f
C158 el sub_b 0.32639f
C159 sta aux 0
C160 hold vbn_leak 0.03595f
C161 mreset spk 0.00703f
C162 sub_b vbn_ref 0.02617f
C163 sta hold 0
C164 m1_4902_6422# vbp_syn 0.36896f
C165 m1_3052_4742# sub_b 0.00768f
C166 a_2510_1740# mreset 0.05899f
C167 a_338_2940# a_368_4070# 0.01045f
C168 m1_3600_6548# a_368_4070# 0.00141f
C169 vreset m1_2280_960# 0.16931f
C170 m1_2448_868# vbp_syn 0.03995f
C171 vm a_2720_3620# 0.06151f
C172 a_368_4070# vdd 2.56133f
C173 m1_841_6220# m1_236_9612# 0.02532f
C174 a_1424_4734# rsel 0.1635f
C175 t0 hold 0.06366f
C176 t1 m1_3188_6220# 0
C177 a_368_4070# a_1682_2940# 0.34825f
C178 stb a_368_4070# 0.0011f
C179 m1_2448_868# a_2130_2940# 0
C180 a_2510_1740# m1_2280_960# 0.13552f
C181 abus m1_2972_1572# 0.00853f
C182 t2 t1 0.0102f
C183 vbp_syn m1_236_9612# 0.00373f
C184 vreset sub_b 0.00461f
C185 m1_644_2570# en 0.01378f
C186 a_1424_4734# m1_1244_4440# 0.01428f
C187 vbp_syn mreset 0.2264f
C188 m1_2436_8920# m1_1960_6220# 0.00178f
C189 m1_644_2570# rsel 0.06789f
C190 m1_1540_9160# vbn_leak 0.42134f
C191 m1_208_9160# m1_1960_6220# 0.10334f
C192 sub_b spk 0.00712f
C193 abus vdd 0.19176f
C194 a_1424_4734# sub 0
C195 m1_4802_1762# vbn_ref 0.07727f
C196 abus m1_3360_172# 0.09898f
C197 t2 rsel 0.00468f
C198 a_2510_1740# sub_b 0.05238f
C199 a_368_4070# vm 0.6154f
C200 m1_644_2570# m1_1244_4440# 0.0048f
C201 vbp_syn m1_2280_960# 0
C202 m1_208_9160# vsrc 0
C203 el vsrc 0
C204 t2 m1_1244_4440# 0
C205 m1_2448_868# m1_2972_1572# 0.01408f
C206 a_368_4070# a_2720_3620# 0.05471f
C207 m1_3600_6548# m1_4902_6422# -0.01073f
C208 vsrc vbn_ref 0.0395f
C209 m1_644_2570# sub 0.09799f
C210 sub m1_3188_6220# 0
C211 el a_1684_3624# 0.0081f
C212 vbn_prb en 0.09705f
C213 vbn_ref a_1684_3624# 0.00152f
C214 m1_208_9160# aux 0
C215 m1_4052_1572# aux 0.03689f
C216 m1_4902_6422# vdd 0.14962f
C217 a_2130_2940# m1_2280_960# 0.005f
C218 el aux 3.32203f
C219 m1_3704_1572# m1_644_2570# 0
C220 vreset m1_4802_1762# 0.00845f
C221 vbn_prb rsel 0
C222 m1_3052_4742# a_1684_3624# 0.11374f
C223 m1_2436_8920# hold 0.27015f
C224 m1_1400_6220# m1_236_9612# 0.0151f
C225 abus vm 0.0129f
C226 aux vbn_ref 0
C227 m1_208_9160# hold 0.05114f
C228 m1_644_2570# vbp_st 0
C229 sub_b vbp_syn 0.23882f
C230 m1_2448_868# vdd 0.23336f
C231 el hold 0.02603f
C232 m1_3052_4742# aux 0.01914f
C233 t3 hold 0.19131f
C234 m1_2448_868# m1_3360_172# 0.11628f
C235 hold vbn_ref 0.17517f
C236 m1_1960_6220# spk 0.25688f
C237 m1_644_2570# vbn_leak 0.21421f
C238 m1_1104_10052# m1_236_9612# 0.005f
C239 abus a_2720_3620# 0
C240 m1_1960_6220# a_480_5620# 0.11283f
C241 vreset vsrc 0.03535f
C242 m1_2020_9600# rsel 0.09894f
C243 m1_3600_6548# mreset 0.03296f
C244 a_2130_2940# sub_b 0.00676f
C245 sta m1_3188_6220# 0.20875f
C246 t2 vbn_leak 0.00761f
C247 vdd m1_236_9612# 0.03961f
C248 sub_b a_2784_4734# 0
C249 t1 rsel 0.41821f
C250 vbn_prb sub 0
C251 vreset a_1684_3624# 0
C252 mreset vdd 0.15856f
C253 vreset aux 0.03533f
C254 m1_2972_1572# m1_2280_960# 0
C255 a_2510_1740# vsrc 0.11605f
C256 vreset hold 0.02317f
C257 m1_841_6220# m1_1960_6220# 0
C258 en rsel 0.04725f
C259 m1_2448_868# vm 0.11006f
C260 t0 m1_3188_6220# 0
C261 vbn_prb vbp_st 3.38211f
C262 spk a_1684_3624# 0.11825f
C263 m1_1540_9160# m1_2436_8920# 0
C264 m1_208_9160# m1_1540_9160# 0.01189f
C265 t0 t2 0
C266 a_2510_1740# a_1684_3624# 0.21836f
C267 a_480_5620# a_1684_3624# 0.03274f
C268 spk aux 0
C269 a_2510_1740# aux 0.34915f
C270 vbn_prb vbn_leak 0.08441f
C271 m1_2280_960# vdd 0.00138f
C272 spk hold 0.09606f
C273 vsrc m1_4822_412# 0.00459f
C274 sub_b m1_1400_6220# 0
C275 m1_3360_172# m1_2280_960# 0.00125f
C276 vbn_prb sta 0
C277 a_2510_1740# hold 0.00163f
C278 hold a_480_5620# 0.02439f
C279 m1_1244_4440# rsel 0.12214f
C280 m1_3600_6548# sub_b 0.046f
C281 en sub 0.02611f
C282 vsrc vbp_syn 0.22096f
C283 m1_4822_412# aux 0.00143f
C284 m1_2020_9600# vbn_leak 0.28886f
C285 sub rsel 0.36688f
C286 sub_b vdd 0.76053f
C287 vbn_leak t1 0
C288 m1_3704_1572# en 0.00127f
C289 a_1424_4734# el 0
C290 vbp_syn a_1684_3624# 0.2086f
C291 m1_3360_172# sub_b 0.00256f
C292 m1_841_6220# hold 0.03667f
C293 en vbp_st 0.06588f
C294 m1_3704_1572# rsel 0.0208f
C295 vbp_syn aux 0.12461f
C296 sub_b a_1682_2940# 0
C297 a_1424_4734# m1_3052_4742# 0.00147f
C298 stb sub_b 0.1259f
C299 vbp_st rsel 0
C300 vm m1_2280_960# 0.20694f
C301 vbp_syn hold 0.55871f
C302 en vbn_leak 0.07412f
C303 a_2130_2940# a_1684_3624# 0.00396f
C304 en sta 0
C305 vbn_leak rsel 0.38568f
C306 m1_644_2570# el 0.12834f
C307 a_2784_4734# a_1684_3624# 0.04876f
C308 m1_2436_8920# m1_3188_6220# 0
C309 m1_1960_6220# m1_1400_6220# 0
C310 a_2130_2940# aux 0
C311 t0 t1 0.0144f
C312 el m1_3188_6220# 0.02368f
C313 m1_644_2570# vbn_ref 0
C314 a_2784_4734# aux 0
C315 t2 m1_2436_8920# 0
C316 m1_208_9160# t2 0.03144f
C317 t3 t2 0.00505f
C318 m1_1092_4130# a_1684_3624# 0.19226f
C319 sub_b vm 0.1686f
C320 abus m1_4902_6422# 0
C321 a_368_4070# mreset 0
C322 abus m1_2448_868# 0.06404f
C323 m1_1960_6220# vdd 0.02837f
C324 m1_1540_9160# m1_841_6220# -0
C325 t0 rsel 0
C326 sub vbn_leak 0.06844f
C327 sub_b a_2720_3620# 0.00728f
C328 a_1424_4734# spk 0.24309f
C329 sta sub 0
C330 a_1424_4734# a_2510_1740# 0
C331 a_1424_4734# a_480_5620# 0.08338f
C332 stb m1_1960_6220# 0
C333 vreset m1_644_2570# 0.00801f
C334 m1_3704_1572# vbn_leak 0
C335 vbn_prb m1_208_9160# 0
C336 vbn_prb el 0.021f
C337 vbn_prb m1_4052_1572# 0
C338 vbp_st vbn_leak 0.00117f
C339 hold m1_1400_6220# 0.03f
C340 vbn_prb vbn_ref 3.45615f
C341 vsrc vdd 0.18634f
C342 sta vbp_st 0
C343 vsrc m1_3360_172# 0.02779f
C344 m1_3600_6548# aux 0.00217f
C345 abus mreset 0
C346 m1_644_2570# spk 0
C347 t0 sub 0.0095f
C348 vdd a_1684_3624# 0.58984f
C349 spk m1_3188_6220# 0.02683f
C350 m1_644_2570# a_2510_1740# 0.07629f
C351 m1_644_2570# a_480_5620# 0.02804f
C352 m1_2436_8920# m1_2020_9600# 0.0059f
C353 sta vbn_leak 0
C354 m1_208_9160# m1_2020_9600# 0.0066f
C355 a_2510_1740# m1_3188_6220# 0.05905f
C356 el m1_2020_9600# 0
C357 vdd aux 0.5856f
C358 t2 spk 0
C359 m1_1960_6220# vm 0.07636f
C360 m1_3360_172# aux 0.02978f
C361 m1_2436_8920# t1 0
C362 m1_208_9160# t1 0.028f
C363 a_1682_2940# a_1684_3624# 0.01548f
C364 t2 a_480_5620# 0.23204f
C365 hold vdd 0.62882f
C366 a_368_4070# sub_b 0.41842f
C367 stb aux 0
C368 abus m1_2280_960# 0.00128f
C369 vreset vbn_prb 0.04855f
C370 a_1682_2940# hold 0.03072f
C371 stb hold 0.00185f
C372 t0 vbn_leak 0.00273f
C373 m1_4052_1572# en 0.00116f
C374 en el 0.18647f
C375 vsrc vm 0
C376 t0 sta 0
C377 m1_2436_8920# rsel 0.0047f
C378 a_1424_4734# a_2130_2940# 0.00393f
C379 en vbn_ref 3.44676f
C380 m1_208_9160# rsel 0.05303f
C381 m1_4052_1572# rsel 0
C382 el rsel 0.00858f
C383 m1_841_6220# t2 0.20943f
C384 m1_644_2570# vbp_syn 0.08293f
C385 a_1424_4734# a_2784_4734# 0.03005f
C386 m1_1540_9160# m1_1400_6220# 0.08454f
C387 t3 rsel 0
C388 rsel vbn_ref 0
C389 vm a_1684_3624# 0.02298f
C390 vbp_syn m1_3188_6220# 0.02832f
C391 vsrc a_2720_3620# 0
C392 vbn_prb a_2510_1740# 0.10837f
C393 abus sub_b 0.11032f
C394 vm aux 0.0064f
C395 a_1424_4734# m1_1092_4130# 0.12332f
C396 el m1_1244_4440# 0.0018f
C397 m1_1540_9160# m1_1104_10052# 0.00844f
C398 vm hold 0.02231f
C399 a_1684_3624# a_2720_3620# 0.38477f
C400 m1_644_2570# a_2130_2940# 0.46888f
C401 m1_644_2570# a_2784_4734# 0.00166f
C402 m1_1540_9160# vdd 0.01627f
C403 m1_2448_868# m1_2280_960# 0.03098f
C404 aux a_2720_3620# 0.00232f
C405 m1_2436_8920# sub 0.10073f
C406 a_368_4070# m1_1960_6220# 0
C407 vbn_prb m1_4822_412# 0.07062f
C408 el sub 0
C409 spk t1 0.00466f
C410 vreset en 3.43598f
C411 a_1424_4734# m1_1400_6220# 0.00125f
C412 m1_644_2570# m1_1092_4130# 0
C413 t1 a_480_5620# 0.19229f
C414 vreset rsel 0.00275f
C415 m1_3052_4742# sub 0.01444f
C416 m1_3704_1572# m1_4052_1572# 0
C417 m1_4902_6422# sub_b 0
C418 vbn_prb vbp_syn 0.13402f
C419 m1_208_9160# vbp_st 0
C420 el vbp_st 0
C421 m1_2448_868# sub_b 0.00939f
C422 a_368_4070# vsrc 0
C423 vbp_st vbn_ref 0.04128f
C424 a_2510_1740# en 0.08714f
C425 spk rsel 0.13138f
C426 m1_2436_8920# vbn_leak 0.11776f
C427 m1_208_9160# vbn_leak 0.35843f
C428 m1_4052_1572# vbn_leak 0.00484f
C429 el vbn_leak 0.06177f
C430 a_2510_1740# rsel 0.20649f
C431 a_1424_4734# vdd 0.68688f
C432 rsel a_480_5620# 0.25711f
C433 m1_2436_8920# sta 0
C434 t3 vbn_leak 0.00392f
C435 a_368_4070# a_1684_3624# 0.16472f
C436 vbn_leak vbn_ref 0.01431f
C437 abus m1_4802_1762# 0.19654f
C438 m1_644_2570# m1_2972_1572# 0.00144f
C439 el sta 0
C440 vbn_prb a_2130_2940# 0
C441 vbp_syn m1_2020_9600# 0
C442 m1_3052_4742# vbn_leak 0
C443 a_368_4070# aux 0.01305f
C444 sta vbn_ref 0
C445 vreset sub 0.00197f
C446 t2 m1_1400_6220# 0.27577f
C447 m1_644_2570# a_338_2940# 0.39381f
C448 a_1424_4734# a_1682_2940# 0.022f
C449 m1_1244_4440# spk 0.00326f
C450 a_368_4070# hold 0.00112f
C451 en m1_4822_412# 0.08642f
C452 m1_3600_6548# m1_3188_6220# 0.04544f
C453 m1_1244_4440# a_480_5620# 0.14495f
C454 sub_b mreset 0.00222f
C455 vreset m1_3704_1572# 0.00107f
C456 m1_644_2570# vdd 0.03552f
C457 t0 m1_2436_8920# 0.45617f
C458 t0 m1_208_9160# 0.04172f
C459 abus vsrc 0.09648f
C460 t2 m1_1104_10052# 0
C461 vreset vbp_st 0.03539f
C462 sub spk 0.04431f
C463 m1_644_2570# m1_3360_172# 0
C464 t0 el 0
C465 vdd m1_3188_6220# 0.22381f
C466 en vbp_syn 0.30406f
C467 a_2510_1740# sub 0.29089f
C468 sub a_480_5620# 0
C469 t2 vdd 0.13013f
C470 m1_644_2570# a_1682_2940# 0.25286f
C471 abus a_1684_3624# 0
C472 vbp_syn rsel 0.08509f
C473 vreset vbn_leak 0.03653f
C474 stb m1_3188_6220# 0.13166f
C475 a_1424_4734# vm 0.00562f
C476 abus aux 0.03464f
C477 m1_3704_1572# a_2510_1740# 0
C478 vreset sta 0
C479 t2 a_1682_2940# 0
C480 m1_2448_868# m1_4802_1762# 0.01907f
C481 abus hold 0
C482 sub_b m1_2280_960# 0
C483 a_2510_1740# vbp_st 0.09704f
C484 a_2130_2940# en 0.00619f
C485 spk vbn_leak 0
C486 a_1424_4734# a_2720_3620# 0.00284f
C487 a_2130_2940# rsel 0.00884f
C488 a_2784_4734# rsel 0.02728f
C489 m1_4902_6422# vsrc 0.00963f
C490 a_2510_1740# vbn_leak 0.28356f
C491 sta spk 0
C492 vbn_leak a_480_5620# 0
C493 m1_644_2570# vm 0.18587f
C494 m1_1960_6220# m1_236_9612# 0.00262f
C495 m1_2020_9600# m1_1400_6220# 0
C496 a_2510_1740# sta 0
C497 m1_2448_868# vsrc 0.04105f
C498 sub vbp_syn 0.00933f
C499 vm m1_3188_6220# 0.04184f
C500 vbn_prb vdd 0.23281f
C501 vbp_st m1_4822_412# 0.01159f
C502 vbn_prb m1_3360_172# 0.03469f
C503 t1 m1_1400_6220# 0.00121f
C504 m1_1092_4130# rsel 0.19318f
C505 a_2130_2940# m1_1244_4440# 0
C506 t2 vm 0.04871f
C507 m1_3704_1572# vbp_syn 0.04136f
C508 m1_644_2570# a_2720_3620# 0.00377f
C509 m1_2020_9600# m1_1104_10052# 0.00135f
C510 m1_4822_412# vbn_leak 0.00239f
C511 m1_4902_6422# hold -0.01665f
C512 t0 spk 0.24512f
C513 m1_2448_868# aux 0.03231f
C514 vbp_st vbp_syn 0.16809f
C515 m1_841_6220# vbn_leak 0.03737f
C516 a_2130_2940# sub 0.02978f
C517 vsrc m1_236_9612# 0
C518 t0 a_480_5620# 0.06179f
C519 m1_2020_9600# vdd 0
C520 m1_1244_4440# m1_1092_4130# 0.21259f
C521 sub a_2784_4734# 0.25103f
C522 m1_208_9160# m1_2436_8920# 0.11451f
C523 el m1_2436_8920# 0
C524 m1_208_9160# el 0
C525 m1_4052_1572# el 0.04158f
C526 vdd t1 0.1194f
C527 rsel m1_1400_6220# 0.51159f
C528 t3 m1_208_9160# 0.05548f
C529 vsrc mreset 0.01081f
C530 vbp_syn vbn_leak 0.24976f
C531 a_1424_4734# a_368_4070# 0.10633f
C532 m1_208_9160# vbn_ref 0
C533 m1_2972_1572# rsel 0.01326f
C534 el vbn_ref 0
C535 sta vbp_syn 0.00659f
C536 sub m1_1092_4130# 0
C537 m1_3052_4742# el 0
C538 aux m1_236_9612# 0
C539 a_1682_2940# t1 0.00125f
C540 stb t1 0
C541 vbn_prb vm 0
C542 hold m1_236_9612# 0.00124f
C543 m1_1104_10052# rsel 0
C544 en vdd 0.2981f
C545 mreset aux 0.03786f
C546 a_2130_2940# vbn_leak 0.01792f
C547 en m1_3360_172# 0.14838f
C548 vdd rsel 0.89436f
C549 a_2784_4734# vbn_leak 0
C550 mreset hold 0.00927f
C551 m1_644_2570# a_368_4070# 0.00621f
C552 m1_3360_172# rsel 0.00595f
C553 vbn_prb a_2720_3620# 0.00227f
C554 t0 vbp_syn 0
C555 sub_b m1_1960_6220# 0
C556 a_368_4070# m1_3188_6220# 0
C557 m1_4802_1762# sub_b 0
C558 sub m1_2972_1572# 0.01112f
C559 a_1682_2940# rsel 0.04943f
C560 stb rsel 0
C561 a_368_4070# t2 0
C562 vreset m1_4052_1572# 0.001f
C563 vreset el 0.35481f
C564 m1_1244_4440# vdd 0.18659f
C565 vm t1 0.07289f
C566 m1_3600_6548# sub 0
C567 m1_2280_960# aux 0
C568 vreset vbn_ref 0.04923f
C569 a_1682_2940# m1_1244_4440# 0.00573f
C570 vsrc sub_b 0.02771f
C571 m1_2436_8920# spk 0.0424f
C572 m1_208_9160# spk 0.00166f
C573 sub vdd 0.35439f
C574 el spk 0
C575 t3 spk 0
C576 en vm 0.40632f
C577 m1_3360_172# sub 0.00189f
C578 m1_2436_8920# a_480_5620# 0.01379f
C579 vbn_leak m1_1400_6220# 0.06934f
C580 m1_644_2570# abus 0.00799f
C581 m1_4052_1572# a_2510_1740# 0
C582 a_2510_1740# el 0.15529f
C583 el a_480_5620# 0.1572f
C584 m1_2972_1572# vbn_leak 0
C585 sub_b a_1684_3624# 0.0081f
C586 m1_1540_9160# m1_236_9612# 0.04408f
C587 t3 a_480_5620# 0.16917f
C588 vm rsel 0.10234f
C589 m1_3052_4742# spk 0.00151f
C590 a_2510_1740# vbn_ref 0.07568f
C591 sub a_1682_2940# 0.00385f
C592 m1_3704_1572# vdd 0.03441f
C593 stb sub 0.15303f
C594 m1_3704_1572# m1_3360_172# 0.01037f
C595 m1_3052_4742# a_480_5620# 0
C596 sub_b aux 0.15595f
C597 vbn_prb a_368_4070# 0
C598 m1_3052_4742# a_2510_1740# 0.17913f
C599 vbp_st vdd 0.19972f
C600 en a_2720_3620# 0
C601 m1_1104_10052# vbn_leak 0.0079f
C602 m1_3360_172# vbp_st 0.02939f
C603 sub_b hold 0.0409f
C604 m1_3600_6548# sta 0.13964f
C605 rsel a_2720_3620# 0.1f
C606 m1_1244_4440# vm 0.00133f
C607 el m1_4822_412# 0.00123f
C608 m1_841_6220# m1_2436_8920# 0
C609 vdd vbn_leak 0.42925f
C610 m1_208_9160# m1_841_6220# 0.04681f
C611 m1_4822_412# vbn_ref 0.07762f
C612 m1_3360_172# vbn_leak 0.03045f
C613 t0 m1_1400_6220# 0
C614 t3 m1_841_6220# 0.27267f
C615 sta vdd 0.20151f
C616 m1_2436_8920# vbp_syn 0
C617 a_1682_2940# vbn_leak 0
C618 sub vm 0.17979f
C619 m1_208_9160# vbp_syn 0.04668f
C620 el vbp_syn 0.11642f
C621 m1_4902_6422# m1_3188_6220# -0.01073f
C622 t0 m1_3600_6548# 0
C623 stb sta 0.02411f
C624 vreset a_2510_1740# 0.0694f
C625 m1_644_2570# m1_2448_868# 0
C626 vbp_syn vbn_ref 0.09319f
C627 vbn_prb abus 0.34804f
C628 m1_3052_4742# vbp_syn 0.04305f
C629 m1_3704_1572# vm 0.00228f
C630 m1_4802_1762# vsrc 0.00103f
C631 sub a_2720_3620# 0.07481f
C632 t0 vdd 0.10654f
C633 vbp_st vm 0
C634 a_368_4070# en 0
C635 a_2130_2940# el 0.1324f
C636 a_2510_1740# spk 0.01205f
C637 spk a_480_5620# 0.13757f
C638 el a_2784_4734# 0
C639 vreset m1_4822_412# 0.02237f
C640 a_368_4070# rsel 0.15345f
C641 a_2510_1740# a_480_5620# 0
C642 t0 a_1682_2940# 0
C643 t0 stb 0.00219f
C644 vm vbn_leak 0.00248f
C645 vbp_st a_2720_3620# 0
C646 m1_1960_6220# hold 0.03609f
C647 sta vm 0.05544f
C648 m1_3052_4742# a_2784_4734# 0.02255f
C649 t2 m1_236_9612# 0.00103f
C650 el m1_1092_4130# 0
C651 mreset m1_3188_6220# 0.05939f
C652 vreset vbp_syn 0.32699f
C653 a_368_4070# m1_1244_4440# 0.06582f
C654 vsrc a_1684_3624# 0
C655 vbn_leak a_2720_3620# 0.01103f
C656 vbn_prb m1_4902_6422# 0.10591f
C657 m1_841_6220# spk 0
C658 vsrc aux 0
C659 vbn_prb m1_2448_868# 0.11978f
C660 m1_841_6220# a_480_5620# 0.24585f
C661 abus en 0.23162f
C662 vsrc hold 0.02827f
C663 t0 vm 0.04559f
C664 vbp_syn spk 0
C665 a_368_4070# sub 0.15658f
C666 m1_2436_8920# m1_1400_6220# 0
C667 m1_208_9160# m1_1400_6220# 0.03315f
C668 abus rsel 0.01567f
C669 aux a_1684_3624# 0.11897f
C670 vreset a_2130_2940# 0
C671 m1_644_2570# m1_2280_960# 0.00243f
C672 a_2510_1740# vbp_syn 0.82785f
C673 vbp_syn a_480_5620# 0
C674 el m1_2972_1572# 0
C675 m1_3600_6548# m1_2436_8920# 0.00104f
C676 vbn_prb m1_236_9612# 0
C677 a_338_2940# el 0.09107f
C678 m1_3600_6548# el 0.02141f
C679 hold aux 0.02669f
C680 m1_208_9160# m1_1104_10052# 0.00298f
C681 a_368_4070# vbp_st 0
C682 a_2130_2940# spk 0.01604f
C683 vbn_prb mreset 0
C684 m1_1540_9160# m1_1960_6220# 0.0011f
C685 a_2784_4734# spk 0.31883f
C686 m1_3052_4742# m1_3600_6548# 0
C687 m1_2436_8920# vdd 0.03679f
C688 m1_208_9160# vdd 0.00417f
C689 a_2130_2940# a_480_5620# 0.20809f
C690 a_2130_2940# a_2510_1740# 0.19304f
C691 m1_4052_1572# vdd 0.01699f
C692 el vdd 3.89788f
C693 a_368_4070# vbn_leak 0.04838f
C694 a_2510_1740# a_2784_4734# 0.0043f
C695 t3 vdd 0.12018f
C696 a_2784_4734# a_480_5620# 0
C697 el m1_3360_172# 0.0484f
C698 m1_644_2570# sub_b 0.17137f
C699 en m1_4902_6422# 0.00861f
C700 vdd vbn_ref 0.3761f
C701 abus sub 0.00227f
C702 a_368_4070# sta 0.00166f
C703 m1_2020_9600# m1_236_9612# 0.116f
C704 m1_3360_172# vbn_ref 0.03533f
C705 sub_b m1_3188_6220# 0.05477f
C706 m1_3052_4742# vdd 0.1921f
C707 stb m1_2436_8920# 0.00869f
C708 spk m1_1092_4130# 0
C709 m1_2448_868# en 0.09092f
C710 el a_1682_2940# 0.13779f
C711 stb el 0
C712 t3 a_1682_2940# 0.00526f
C713 t1 m1_236_9612# 0.00103f
C714 t2 sub_b 0
C715 a_2510_1740# m1_1092_4130# 0
C716 m1_1092_4130# a_480_5620# 0.08352f
C717 m1_3704_1572# abus 0.01102f
C718 m1_2448_868# rsel 0.01397f
C719 vreset m1_2972_1572# 0.0031f
C720 abus vbp_st 0.1108f
C721 t0 a_368_4070# 0.00159f
C722 spk m1_1400_6220# 0
C723 abus vbn_leak 0.07484f
C724 a_2130_2940# vbp_syn 0
C725 rsel m1_236_9612# 0.04112f
C726 vbp_syn a_2784_4734# 0
C727 m1_2436_8920# vm 0.03258f
C728 a_480_5620# m1_1400_6220# 0.06602f
C729 vreset vdd 0.26306f
C730 m1_4052_1572# vm 0
C731 el vm 0.63007f
C732 en mreset 0
C733 a_2510_1740# m1_2972_1572# 0.0195f
C734 m1_1540_9160# hold 0
C735 vreset m1_3360_172# 0.03486f
C736 t3 vm 0.05788f
C737 vm vbn_ref 0
C738 m1_2448_868# sub 0.0169f
C739 vbn_prb sub_b 0.02547f
C740 a_338_2940# a_2510_1740# 0
C741 m1_3052_4742# vm 0.15293f
C742 m1_3600_6548# a_2510_1740# 0.04909f
C743 a_338_2940# a_480_5620# -0.03481f
C744 el a_2720_3620# 0
C745 spk vdd 0.70269f
C746 m1_644_2570# m1_4802_1762# 0
C747 a_2130_2940# a_2784_4734# 0.01119f
C748 m1_4902_6422# vbp_st 0.07319f
C749 m1_1960_6220# m1_3188_6220# 0
C750 m1_3704_1572# m1_2448_868# 0.02667f
C751 vbn_ref a_2720_3620# 0
C752 vdd a_480_5620# 1.80147f
C753 a_2510_1740# vdd 1.24379f
C754 m1_841_6220# m1_1400_6220# 0.0156f
C755 a_2510_1740# m1_3360_172# 0.01314f
C756 m1_3052_4742# a_2720_3620# 0.16899f
C757 t2 m1_1960_6220# 0
C758 m1_2448_868# vbp_st 0.03217f
C759 a_1424_4734# a_1684_3624# 0.44856f
C760 en m1_2280_960# 0.11659f
C761 a_1682_2940# spk 0.09451f
C762 stb spk 0
C763 m1_4902_6422# vbn_leak 0.0032f
C764 a_2510_1740# a_1682_2940# 0.0037f
C765 a_1682_2940# a_480_5620# 0.95109f
C766 stb a_2510_1740# 0.00165f
C767 m1_2280_960# rsel 0.00355f
C768 stb a_480_5620# 0
C769 a_2784_4734# m1_1092_4130# 0
C770 m1_4902_6422# sta 0
C771 sub_b t1 0
C772 vbp_syn m1_2972_1572# 0
C773 m1_2448_868# vbn_leak 0.04602f
C774 m1_644_2570# vsrc 0.00106f
C775 vbp_st vss 0.98936f
C776 vsrc vss 1.06528f
C777 m1_3360_172# vss 0.88392f
C778 m1_1104_10052# vss 0.01565f
C779 m1_2280_960# vss 0.12636f
C780 en vss 2.14304f
C781 abus vss 4.58238f
C782 sub vss 0.42582f
C783 mreset vss 0.68178f
C784 spk vss 0.56929f
C785 hold vss 2.95913f
C786 vdd vss 20.515f
C787 m1_1244_4440# vss -0.03848f
C788 a_368_4070# vss -0.10389f
C789 m1_1540_9160# vss 0.21701f
C790 m1_2020_9600# vss 0.16954f
C791 m1_4822_412# vss 0.28416f
C792 m1_1092_4130# vss -0.02612f
C793 m1_841_6220# vss 0.18723f
C794 t3 vss 0.46814f
C795 vbn_prb vss 1.47854f
C796 aux vss 0.60037f
C797 m1_1400_6220# vss 0.16941f
C798 t2 vss 0.32767f
C799 m1_3052_4742# vss -0.19389f
C800 m1_1960_6220# vss 0.17983f
C801 t1 vss 0.28524f
C802 m1_236_9612# vss 0.65308f
C803 m1_208_9160# vss 1.22651f
C804 a_2720_3620# vss 0.5563f
C805 m1_2436_8920# vss 0.46977f
C806 t0 vss 0.29546f
C807 m1_2972_1572# vss -0.04045f
C808 rsel vss 2.82441f
C809 a_1424_4734# vss 0.24957f
C810 a_1684_3624# vss 0.29029f
C811 vm vss 2.38008f
C812 m1_3704_1572# vss -0.05326f
C813 m1_644_2570# vss 0.24705f
C814 a_338_2940# vss -0.05305f
C815 sub_b vss 0.78889f
C816 m1_3188_6220# vss 0.2805f
C817 stb vss 0.37375f
C818 sta vss 0.25919f
C819 m1_2448_868# vss 0.70763f
C820 vreset vss 0.97822f
C821 a_2510_1740# vss 1.90311f
C822 m1_4802_1762# vss -0.00625f
C823 vbn_ref vss 1.05896f
C824 a_2130_2940# vss 0.37349f
C825 a_1682_2940# vss 0.8809f
C826 a_2784_4734# vss -0.0161f
C827 m1_4902_6422# vss -0.1955f
C828 m1_3600_6548# vss -0.04329f
C829 vbp_syn vss 2.13221f
C830 a_480_5620# vss 0.12517f
C831 el vss 0.89399f
C832 vbn_leak vss 4.38063f
C833 m1_4052_1572# vss -0.03695f
.ends
