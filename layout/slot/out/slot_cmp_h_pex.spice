* NGSPICE file created from slot_cmp_h.ext - technology: gf180mcuD

.subckt p_w2_l4 a_400_n200# a_n400_n244# w_n574_n330# a_n488_n200# VSUBS
X0 a_400_n200# a_n400_n244# a_n488_n200# w_n574_n330# pfet_03v3 ad=0.88p pd=4.88u as=0.88p ps=4.88u w=2u l=4u
C0 a_n400_n244# a_n488_n200# 0.07019f
C1 a_n488_n200# w_n574_n330# 0.07409f
C2 a_n488_n200# a_400_n200# 0.01073f
C3 a_n400_n244# w_n574_n330# 0.42229f
C4 a_n400_n244# a_400_n200# 0.07019f
C5 w_n574_n330# a_400_n200# 0.07409f
C6 a_400_n200# VSUBS 0.18936f
C7 a_n488_n200# VSUBS 0.18936f
C8 w_n574_n330# VSUBS 2.27304f
.ends

.subckt n_w1_l0p28 a_28_n100# a_n28_n144# a_n116_n100# VSUBS
X0 a_28_n100# a_n28_n144# a_n116_n100# VSUBS nfet_03v3 ad=0.44p pd=2.88u as=0.44p ps=2.88u w=1u l=0.28u
C0 a_n116_n100# a_28_n100# 0.04256f
C1 a_28_n100# a_n28_n144# 0.00769f
C2 a_n116_n100# a_n28_n144# 0.00769f
C3 a_28_n100# VSUBS 0.09911f
C4 a_n116_n100# VSUBS 0.09911f
.ends

.subckt n_w2_l2 a_n288_n200# a_200_n200# a_n200_n244# VSUBS
X0 a_200_n200# a_n200_n244# a_n288_n200# VSUBS nfet_03v3 ad=0.88p pd=4.88u as=0.88p ps=4.88u w=2u l=2u
C0 a_n288_n200# a_200_n200# 0.02133f
C1 a_200_n200# a_n200_n244# 0.0587f
C2 a_n288_n200# a_n200_n244# 0.0587f
C3 a_200_n200# VSUBS 0.2667f
C4 a_n288_n200# VSUBS 0.2667f
.ends

.subckt n_w2_l4 a_400_n200# a_n400_n244# a_n488_n200# VSUBS
X0 a_400_n200# a_n400_n244# a_n488_n200# VSUBS nfet_03v3 ad=0.88p pd=4.88u as=0.88p ps=4.88u w=2u l=4u
C0 a_n488_n200# a_400_n200# 0.01073f
C1 a_400_n200# a_n400_n244# 0.07019f
C2 a_n488_n200# a_n400_n244# 0.07019f
C3 a_400_n200# VSUBS 0.41684f
C4 a_n488_n200# VSUBS 0.41684f
.ends

.subckt n_w4_l1 a_n188_n400# a_100_n400# a_n100_n444# VSUBS
X0 a_100_n400# a_n100_n444# a_n188_n400# VSUBS nfet_03v3 ad=1.76p pd=8.88u as=1.76p ps=8.88u w=4u l=1u
C0 a_n188_n400# a_100_n400# 0.07756f
C1 a_100_n400# a_n100_n444# 0.08505f
C2 a_n188_n400# a_n100_n444# 0.08505f
C3 a_100_n400# VSUBS 0.26859f
C4 a_n188_n400# VSUBS 0.26859f
.ends

.subckt n_w0p5_l0p28 a_n28_n94# a_n116_n50# a_28_n50# VSUBS
X0 a_28_n50# a_n28_n94# a_n116_n50# VSUBS nfet_03v3 ad=0.22p pd=1.88u as=0.22p ps=1.88u w=0.5u l=0.28u
C0 a_n116_n50# a_28_n50# 0.02085f
C1 a_28_n50# a_n28_n94# 0.00377f
C2 a_n116_n50# a_n28_n94# 0.00377f
C3 a_28_n50# VSUBS 0.07987f
C4 a_n116_n50# VSUBS 0.07987f
.ends

.subckt n_w1_l0p5 a_n138_n100# a_50_n100# a_n50_n144# VSUBS
X0 a_50_n100# a_n50_n144# a_n138_n100# VSUBS nfet_03v3 ad=0.44p pd=2.88u as=0.44p ps=2.88u w=1u l=0.5u
C0 a_n138_n100# a_50_n100# 0.03085f
C1 a_50_n100# a_n50_n144# 0.01275f
C2 a_n138_n100# a_n50_n144# 0.01275f
C3 a_50_n100# VSUBS 0.11563f
C4 a_n138_n100# VSUBS 0.11563f
.ends

.subckt p_w1_l0p28 w_n202_n230# a_28_n100# a_n28_n144# a_n116_n100# VSUBS
X0 a_28_n100# a_n28_n144# a_n116_n100# w_n202_n230# pfet_03v3 ad=0.44p pd=2.88u as=0.44p ps=2.88u w=1u l=0.28u
C0 a_n28_n144# a_n116_n100# 0.00769f
C1 a_n116_n100# w_n202_n230# 0.01808f
C2 a_n116_n100# a_28_n100# 0.04256f
C3 a_n28_n144# w_n202_n230# 0.05841f
C4 a_n28_n144# a_28_n100# 0.00769f
C5 w_n202_n230# a_28_n100# 0.01808f
C6 a_28_n100# VSUBS 0.0597f
C7 a_n116_n100# VSUBS 0.0597f
C8 w_n202_n230# VSUBS 0.55752f
.ends

.subckt n_w4_l2 a_n288_n400# a_200_n400# a_n200_n444# VSUBS
X0 a_200_n400# a_n200_n444# a_n288_n400# VSUBS nfet_03v3 ad=1.76p pd=8.88u as=1.76p ps=8.88u w=4u l=2u
C0 a_n288_n400# a_200_n400# 0.04287f
C1 a_200_n400# a_n200_n444# 0.11799f
C2 a_n288_n400# a_n200_n444# 0.11799f
C3 a_200_n400# VSUBS 0.34365f
C4 a_n288_n400# VSUBS 0.34365f
.ends

.subckt p_w1_l2 w_n374_n230# a_n288_n100# a_200_n100# a_n200_n144# VSUBS
X0 a_200_n100# a_n200_n144# a_n288_n100# w_n374_n230# pfet_03v3 ad=0.44p pd=2.88u as=0.44p ps=2.88u w=1u l=2u
C0 a_n200_n144# a_n288_n100# 0.02905f
C1 a_n288_n100# w_n374_n230# 0.03135f
C2 a_n288_n100# a_200_n100# 0.01056f
C3 a_n200_n144# w_n374_n230# 0.22666f
C4 a_n200_n144# a_200_n100# 0.02905f
C5 w_n374_n230# a_200_n100# 0.03135f
C6 a_200_n100# VSUBS 0.1047f
C7 a_n288_n100# VSUBS 0.1047f
C8 w_n374_n230# VSUBS 1.03224f
.ends

.subckt n_w7p07_l7p07 a_707_n707# a_n795_n707# a_n707_n751# VSUBS
X0 a_707_n707# a_n707_n751# a_n795_n707# VSUBS nfet_03v3 ad=3.1108p pd=15.02u as=3.1108p ps=15.02u w=7.07u l=7.07u
C0 a_n795_n707# a_707_n707# 0.0212f
C1 a_707_n707# a_n707_n751# 0.27012f
C2 a_n795_n707# a_n707_n751# 0.27012f
C3 a_707_n707# VSUBS 0.84237f
C4 a_n795_n707# VSUBS 0.84237f
.ends

.subckt n_w0p5_l1p5 a_150_n50# a_n238_n50# a_n150_n94# VSUBS
X0 a_150_n50# a_n150_n94# a_n238_n50# VSUBS nfet_03v3 ad=0.22p pd=1.88u as=0.22p ps=1.88u w=0.5u l=1.5u
C0 a_n238_n50# a_150_n50# 0.00671f
C1 a_150_n50# a_n150_n94# 0.01269f
C2 a_n238_n50# a_n150_n94# 0.01269f
C3 a_150_n50# VSUBS 0.17146f
C4 a_n238_n50# VSUBS 0.17146f
.ends

.subckt n_w1_l2 a_n288_n100# a_200_n100# a_n200_n144# VSUBS
X0 a_200_n100# a_n200_n144# a_n288_n100# VSUBS nfet_03v3 ad=0.44p pd=2.88u as=0.44p ps=2.88u w=1u l=2u
C0 a_n288_n100# a_200_n100# 0.01056f
C1 a_200_n100# a_n200_n144# 0.02905f
C2 a_n288_n100# a_n200_n144# 0.02905f
C3 a_200_n100# VSUBS 0.22823f
C4 a_n288_n100# VSUBS 0.22823f
.ends

.subckt n_w3p54_l3p54 a_354_n354# a_n354_n398# a_n442_n354# VSUBS
X0 a_354_n354# a_n354_n398# a_n442_n354# VSUBS nfet_03v3 ad=1.5576p pd=7.96u as=1.5576p ps=7.96u w=3.54u l=3.54u
C0 a_n442_n354# a_354_n354# 0.02161f
C1 a_354_n354# a_n354_n398# 0.12189f
C2 a_n442_n354# a_n354_n398# 0.12189f
C3 a_354_n354# VSUBS 0.44156f
C4 a_n442_n354# VSUBS 0.44156f
.ends

.subckt p_w2_l1 a_100_n200# a_n100_n244# w_n274_n330# a_n188_n200# VSUBS
X0 a_100_n200# a_n100_n244# a_n188_n200# w_n274_n330# pfet_03v3 ad=0.88p pd=4.88u as=0.88p ps=4.88u w=2u l=1u
C0 a_n100_n244# a_n188_n200# 0.04231f
C1 a_n188_n200# w_n274_n330# 0.04851f
C2 a_n188_n200# a_100_n200# 0.03858f
C3 a_n100_n244# w_n274_n330# 0.12884f
C4 a_n100_n244# a_100_n200# 0.04231f
C5 w_n274_n330# a_100_n200# 0.04851f
C6 a_100_n200# VSUBS 0.11088f
C7 a_n188_n200# VSUBS 0.11088f
C8 w_n274_n330# VSUBS 1.08504f
.ends

.subckt n_w0p5_l3 a_n388_n50# a_300_n50# a_n300_n94# VSUBS
X0 a_300_n50# a_n300_n94# a_n388_n50# VSUBS nfet_03v3 ad=0.22p pd=1.88u as=0.22p ps=1.88u w=0.5u l=3u
C0 a_n388_n50# a_300_n50# 0.00348f
C1 a_300_n50# a_n300_n94# 0.01602f
C2 a_n388_n50# a_n300_n94# 0.01602f
C3 a_300_n50# VSUBS 0.28406f
C4 a_n388_n50# VSUBS 0.28406f
.ends

.subckt p_w1_l6 w_n774_n230# a_n688_n100# a_600_n100# a_n600_n144# VSUBS
X0 a_600_n100# a_n600_n144# a_n688_n100# w_n774_n230# pfet_03v3 ad=0.44p pd=2.88u as=0.44p ps=2.88u w=1u l=6u
C0 a_n600_n144# a_n688_n100# 0.03688f
C1 a_n688_n100# w_n774_n230# 0.03955f
C2 a_n688_n100# a_600_n100# 0.00349f
C3 a_n600_n144# w_n774_n230# 0.61793f
C4 a_n600_n144# a_600_n100# 0.03688f
C5 w_n774_n230# a_600_n100# 0.03955f
C6 a_600_n100# VSUBS 0.20933f
C7 a_n688_n100# VSUBS 0.20933f
C8 w_n774_n230# VSUBS 2.13624f
.ends

.subckt n_w0p5_l4 a_n488_n50# a_400_n50# a_n400_n94# VSUBS
X0 a_400_n50# a_n400_n94# a_n488_n50# VSUBS nfet_03v3 ad=0.22p pd=1.88u as=0.22p ps=1.88u w=0.5u l=4u
C0 a_n488_n50# a_400_n50# 0.0026f
C1 a_400_n50# a_n400_n94# 0.01702f
C2 a_n488_n50# a_n400_n94# 0.01702f
C3 a_400_n50# VSUBS 0.35913f
C4 a_n488_n50# VSUBS 0.35913f
.ends

.subckt slot_cmp_h vss vbp_syn vdd el aux vbn_leak vsrc vbp_st vbn_prb vbn_ref en
+ vreset abus spk t3 t2 t1 t0 sta stb hold mreset rsel sub sub_b vm
XXL_XP1 a_480_5620# a_480_5620# vdd vdd vss p_w2_l4
XXPM_XSW m1_4052_1572# rsel m1_3704_1572# vss n_w1_l0p28
XXL_XP2 a_1632_2940# a_480_5620# vdd vdd vss p_w2_l4
XXPR_XMB vss m1_4802_1762# vbn_prb vss n_w2_l2
XXL_XMT m1_644_2570# vbn_leak vss vss n_w2_l4
XXL_XM1 a_288_2940# a_480_5620# el vss n_w4_l1
XXS_XWA m1_4902_6422# vbp_syn vdd m1_3600_6548# vss p_w2_l4
XXR_Xi_XN spk vss a_2784_4734# vss n_w0p5_l0p28
XXL_XM2 a_2080_2940# a_1632_2940# a_1632_2940# vss n_w4_l1
XXS_XWB m1_4902_6422# vbp_syn vdd m1_3188_6220# vss p_w2_l4
XXR_XNR vss vbn_ref a_2510_1740# vss n_w2_l4
XXPR_XME m1_2448_868# en m1_4802_1762# vss n_w1_l0p28
XXR_XSW vreset vm a_2510_1740# vss n_w1_l0p5
XXR_Xi_XP vdd a_2784_4734# spk vdd vss p_w1_l0p28
XXPR_XMF m1_2448_868# vdd a_2510_1740# vss n_w4_l2
XXS_XQA vdd m1_3600_6548# sta vss vss p_w1_l0p28
XXS_XQB vdd m1_3188_6220# stb vss vss p_w1_l0p28
XXS_XNA sta vm m1_3600_6548# vss n_w0p5_l0p28
XXS_XNB stb vm m1_3188_6220# vss n_w0p5_l0p28
XXD_XPT vdd vdd m1_3052_4742# a_368_4070# vss p_w1_l2
XXL_XD2a m1_644_2570# a_2080_2940# a_2080_2940# vss n_w4_l1
XXPM_XSB abus sub_b m1_4052_1572# vss n_w1_l0p28
XXL_XD2b m1_644_2570# a_2080_2940# a_2080_2940# vss n_w4_l1
XXL_XD1a m1_644_2570# a_288_2940# a_288_2940# vss n_w4_l1
XXPM_XSC m1_3704_1572# en m1_3360_172# vss n_w1_l0p28
XXC_XC vss vss vm vss n_w7p07_l7p07
XXT_XR1 m1_2020_9600# m1_1540_9160# vbn_leak vss n_w0p5_l1p5
XXS_XPH vdd m1_4902_6422# vdd hold vss p_w1_l2
XXD_Xi1_XN a_1684_3624# vss a_1424_4734# vss n_w0p5_l0p28
XXL_XD1b m1_644_2570# a_288_2940# a_288_2940# vss n_w4_l1
XXPR_XSW m1_2972_1572# rsel m1_2280_960# vss n_w1_l0p28
XXT_XR2 m1_208_9160# m1_2020_9600# vbn_leak vss n_w0p5_l1p5
XXT_XP0 vdd m1_2436_8920# t0 vm vss p_w1_l0p28
XXD_XN1 a_2720_3620# vss a_2720_3620# vss n_w1_l2
XXT_XR3 m1_236_9612# m1_208_9160# vbn_leak vss n_w0p5_l1p5
XXT_XP1 vdd m1_1960_6220# t1 vm vss p_w1_l0p28
XXR_XCR_XC vss a_2510_1740# vss vss n_w3p54_l3p54
XXD_XN2 vss a_1684_3624# a_2720_3620# vss n_w1_l2
XXD_XM1 a_2720_3620# vm vdd m1_3052_4742# vss p_w2_l1
XXD_Xi1_XP vdd a_1424_4734# a_1684_3624# m1_1092_4130# vss p_w1_l0p28
XXT_XN0 t0 a_480_5620# m1_2436_8920# vss n_w0p5_l0p28
XXT_XP2 vdd m1_1400_6220# t2 vm vss p_w1_l0p28
XXD_XM2 a_1684_3624# aux vdd m1_3052_4742# vss p_w2_l1
XXPM_XMB vss m1_4822_412# vbn_prb vss n_w2_l2
XXT_XN1 t1 a_480_5620# m1_1960_6220# vss n_w0p5_l0p28
XXT_XP3 vdd m1_841_6220# t3 vm vss p_w1_l0p28
XXT_XL0 m1_2436_8920# m1_236_9612# vbn_leak vss n_w0p5_l3
XXT_XLT m1_236_9612# vdd vbn_leak vss n_w0p5_l3
XXT_XN2 t2 a_480_5620# m1_1400_6220# vss n_w0p5_l0p28
XXD_Xi1_XS vdd vdd m1_1092_4130# a_368_4070# vss p_w1_l2
XXT_XL1 m1_1960_6220# m1_208_9160# vbn_leak vss n_w0p5_l3
XXT_XN3 t3 a_480_5620# m1_841_6220# vss n_w0p5_l0p28
XXR_XPC vdd a_2510_1740# a_2784_4734# vdd vss p_w1_l0p28
XXD_XH1 vdd a_1684_3624# a_1424_4734# m1_1244_4440# vss p_w1_l0p28
XXPM_XME m1_3360_172# en m1_4822_412# vss n_w1_l0p28
XXT_XL2 m1_1400_6220# m1_2020_9600# vbn_leak vss n_w0p5_l3
XXT_XL3 m1_841_6220# m1_1540_9160# vbn_leak vss n_w0p5_l3
XXD_XH2 vdd vdd m1_1244_4440# a_368_4070# vss p_w1_l6
XXPM_XMF m1_3360_172# vdd vm vss n_w4_l2
XXPC vdd vdd a_368_4070# a_368_4070# vss p_w1_l2
XXNC a_368_4070# vss vbn_prb vss n_w1_l2
XXS_XHL vdd vm hold a_1632_2940# vss p_w1_l0p28
XXD_Xi2_XN a_1424_4734# vss spk vss n_w0p5_l0p28
XXS_XMR mreset a_2510_1740# vdd vss n_w0p5_l0p28
XXD_Xi2_XP vdd spk a_1424_4734# vdd vss p_w1_l0p28
XXPR_XSB abus sub m1_2972_1572# vss n_w1_l0p28
XXPR_XSC m1_2448_868# en m1_2280_960# vss n_w1_l0p28
XXT_XRB m1_1104_10052# m1_1540_9160# vbn_leak vss n_w0p5_l4
XXT_XRA vss m1_1104_10052# vbn_leak vss n_w0p5_l4
C0 sub a_1424_4734# 0
C1 m1_1400_6220# a_1632_2940# 0
C2 m1_208_9160# m1_236_9612# 0.14518f
C3 m1_2280_960# m1_2972_1572# 0
C4 abus a_1684_3624# 0
C5 spk a_2784_4734# 0.31883f
C6 vsrc rsel 0
C7 m1_3052_4742# a_368_4070# 0.22776f
C8 m1_208_9160# vbp_syn 0.04668f
C9 vsrc vbp_st 3.28878f
C10 spk vbp_syn 0
C11 vreset vbp_syn 0.32699f
C12 aux m1_2280_960# 0
C13 t1 vbn_leak 0
C14 a_1684_3624# m1_644_2570# 0.01103f
C15 stb m1_2436_8920# 0.00869f
C16 m1_4802_1762# vbp_st 0.00793f
C17 sub a_2720_3620# 0.07481f
C18 aux vbn_prb 0.05081f
C19 vbn_leak m1_4902_6422# 0.0032f
C20 sub el 0
C21 vm m1_2972_1572# 0.00417f
C22 t1 vdd 0.1194f
C23 a_368_4070# a_480_5620# 0.36731f
C24 sub sub_b 0.1422f
C25 sta m1_4902_6422# 0
C26 en aux 0.06544f
C27 vm t0 0.04559f
C28 vdd m1_4902_6422# 0.14962f
C29 a_1684_3624# a_2510_1740# 0.21836f
C30 vsrc m1_3360_172# 0.02779f
C31 vbn_leak m1_2280_960# 0
C32 a_1424_4734# a_2080_2940# 0.00484f
C33 m1_1400_6220# m1_1960_6220# 0
C34 t1 m1_208_9160# 0.028f
C35 vm aux 0.0064f
C36 t1 spk 0.00466f
C37 vbn_leak vbn_prb 0.08441f
C38 aux m1_2020_9600# 0
C39 vreset m1_4902_6422# 0
C40 m1_2280_960# vdd 0.00138f
C41 a_1632_2940# t3 0.00526f
C42 sta vbn_prb 0
C43 m1_3052_4742# a_2510_1740# 0.17913f
C44 a_480_5620# m1_644_2570# 0.02315f
C45 en vbn_leak 0.07412f
C46 vm m1_1092_4130# 0.01117f
C47 a_1684_3624# a_1632_2940# 0.01569f
C48 rsel a_368_4070# 0.15345f
C49 vdd vbn_prb 0.23281f
C50 a_2720_3620# a_2080_2940# 0.0119f
C51 vbn_leak m1_3704_1572# 0
C52 a_368_4070# vbp_st 0
C53 vm vbn_leak 0.00248f
C54 m1_3600_6548# vbp_syn 0.10055f
C55 el a_2080_2940# 0.12949f
C56 en sta 0
C57 vreset m1_2280_960# 0.16931f
C58 m1_1244_4440# m1_1092_4130# 0.21259f
C59 abus rsel 0.01567f
C60 a_2080_2940# sub_b 0.00771f
C61 m1_841_6220# m1_236_9612# 0.02532f
C62 m1_2020_9600# vbn_leak 0.28886f
C63 en vdd 0.2981f
C64 m1_208_9160# vbn_prb 0
C65 vreset vbn_prb 0.04855f
C66 vm sta 0.05544f
C67 stb el 0
C68 m1_2436_8920# m1_236_9612# 0.02764f
C69 vdd m1_3704_1572# 0.03441f
C70 abus vbp_st 0.1108f
C71 a_2510_1740# a_480_5620# 0
C72 vm vdd 2.28415f
C73 stb sub_b 0.1259f
C74 vsrc m1_2448_868# 0.04105f
C75 m1_2020_9600# vdd 0
C76 rsel m1_644_2570# 0.06787f
C77 en vreset 3.43598f
C78 m1_2436_8920# vbp_syn 0
C79 hold m1_1540_9160# 0
C80 vbn_ref m1_4822_412# 0.07762f
C81 vdd m1_1244_4440# 0.18659f
C82 m1_2448_868# m1_4802_1762# 0.01907f
C83 vreset m1_3704_1572# 0.00107f
C84 vbp_st m1_644_2570# 0
C85 vm vreset 0.15354f
C86 vm spk 0.12f
C87 abus m1_4052_1572# 0.00965f
C88 m1_208_9160# m1_2020_9600# 0.0066f
C89 a_1632_2940# a_480_5620# 0.94837f
C90 abus m1_3360_172# 0.09898f
C91 a_2720_3620# vbn_ref 0
C92 spk m1_1244_4440# 0.00326f
C93 a_1424_4734# a_2784_4734# 0.03005f
C94 m1_3600_6548# m1_4902_6422# -0.01073f
C95 rsel a_2510_1740# 0.20649f
C96 el vbn_ref 0
C97 a_2510_1740# vbp_st 0.09704f
C98 vbn_ref sub_b 0.02617f
C99 m1_3360_172# m1_644_2570# 0
C100 t1 m1_2436_8920# 0
C101 vbn_leak m1_2972_1572# 0
C102 mreset vbp_st 0
C103 hold t2 0.03581f
C104 rsel a_1632_2940# 0.04993f
C105 a_2720_3620# a_2784_4734# 0.02135f
C106 vbn_leak t0 0.00273f
C107 a_2510_1740# m1_4052_1572# 0
C108 el m1_236_9612# 0
C109 hold vsrc 0.02827f
C110 el a_2784_4734# 0
C111 vdd m1_2972_1572# 0.0038f
C112 sub a_1684_3624# 0.05092f
C113 aux vbn_leak 3.35489f
C114 a_2720_3620# vbp_syn 0.04524f
C115 sta t0 0
C116 a_2784_4734# sub_b 0
C117 a_2510_1740# m1_3360_172# 0.01314f
C118 m1_1960_6220# a_480_5620# 0.11283f
C119 t0 vdd 0.10654f
C120 aux sta 0
C121 el vbp_syn 0.11642f
C122 abus m1_2448_868# 0.06404f
C123 vbp_syn sub_b 0.23882f
C124 vm m1_3600_6548# 0.02386f
C125 rsel m1_1104_10052# 0
C126 aux vdd 0.5856f
C127 vreset m1_2972_1572# 0.0031f
C128 a_288_2940# a_368_4070# 0.01143f
C129 sub m1_3052_4742# 0.01444f
C130 m1_208_9160# t0 0.04172f
C131 vsrc m1_4802_1762# 0.00103f
C132 spk t0 0.24512f
C133 m1_2448_868# m1_644_2570# 0
C134 vm m1_841_6220# 0.03544f
C135 aux m1_208_9160# 0
C136 aux spk 0
C137 aux vreset 0.03533f
C138 vdd m1_1092_4130# 0.54338f
C139 sta vbn_leak 0
C140 vm m1_2436_8920# 0.03258f
C141 rsel m1_1960_6220# 0.04269f
C142 vbn_leak vdd 0.42925f
C143 a_1684_3624# a_2080_2940# 0.00484f
C144 m1_2436_8920# m1_2020_9600# 0.0059f
C145 a_288_2940# m1_644_2570# 0.40572f
C146 sub a_480_5620# 0
C147 t1 sub_b 0
C148 spk m1_1092_4130# 0
C149 m1_1400_6220# m1_236_9612# 0.0151f
C150 sta vdd 0.20151f
C151 m1_4822_412# vbn_prb 0.07062f
C152 m1_2448_868# a_2510_1740# 0.14081f
C153 hold a_368_4070# 0.00112f
C154 m1_4902_6422# sub_b 0
C155 m1_208_9160# vbn_leak 0.35843f
C156 vreset vbn_leak 0.03653f
C157 spk vbn_leak 0
C158 t2 a_368_4070# 0
C159 sta spk 0
C160 en m1_4822_412# 0.08642f
C161 vm a_1424_4734# 0.00562f
C162 sta vreset 0
C163 a_288_2940# a_2510_1740# 0
C164 el m1_2280_960# 0.01386f
C165 a_2720_3620# vbn_prb 0.00227f
C166 hold abus 0
C167 m1_208_9160# vdd 0.00417f
C168 vsrc a_368_4070# 0
C169 m1_2280_960# sub_b 0
C170 spk vdd 0.70269f
C171 vreset vdd 0.26306f
C172 hold m1_3188_6220# 0
C173 vm m1_4822_412# 0
C174 sub rsel 0.36688f
C175 el vbn_prb 0.021f
C176 vbn_prb sub_b 0.02547f
C177 a_1424_4734# m1_1244_4440# 0.01428f
C178 m1_3600_6548# t0 0
C179 en a_2720_3620# 0
C180 vsrc abus 0.09648f
C181 m1_208_9160# spk 0.00166f
C182 a_2080_2940# a_480_5620# 0.20726f
C183 en el 0.18647f
C184 m1_3600_6548# aux 0.00217f
C185 a_288_2940# a_1632_2940# 0.00904f
C186 a_1684_3624# vbn_ref 0.00152f
C187 vm a_2720_3620# 0.06151f
C188 en sub_b 0.04123f
C189 abus m1_4802_1762# 0.19654f
C190 t1 m1_1400_6220# 0.00121f
C191 stb a_480_5620# 0
C192 vm el 0.64858f
C193 sub_b m1_3704_1572# 0
C194 vsrc m1_644_2570# 0.00106f
C195 vm sub_b 0.1686f
C196 el m1_2020_9600# 0
C197 m1_2436_8920# t0 0.45617f
C198 t3 m1_236_9612# 0.00386f
C199 hold a_2510_1740# 0.00163f
C200 sub m1_3360_172# 0.00189f
C201 m1_4802_1762# m1_644_2570# 0
C202 el m1_1244_4440# 0.0018f
C203 a_1684_3624# a_2784_4734# 0.04876f
C204 hold mreset 0.00927f
C205 rsel a_2080_2940# 0.00995f
C206 m1_1540_9160# m1_1104_10052# 0.00844f
C207 m1_3600_6548# sta 0.13964f
C208 vsrc a_2510_1740# 0.11605f
C209 a_1684_3624# vbp_syn 0.2086f
C210 stb rsel 0
C211 m1_3600_6548# vdd 0.20299f
C212 hold a_1632_2940# 0.03072f
C213 vbn_leak m1_841_6220# 0.03737f
C214 vsrc mreset 0.01081f
C215 m1_3052_4742# a_2784_4734# 0.02255f
C216 t2 a_1632_2940# 0
C217 m1_2436_8920# vbn_leak 0.11776f
C218 m1_3052_4742# vbp_syn 0.04305f
C219 m1_1960_6220# m1_1540_9160# 0.0011f
C220 m1_3188_6220# a_368_4070# 0
C221 vdd m1_841_6220# 0.03399f
C222 m1_2436_8920# sta 0
C223 vm m1_1400_6220# 0.0616f
C224 aux m1_4822_412# 0.00143f
C225 m1_2436_8920# vdd 0.03679f
C226 m1_1400_6220# m1_2020_9600# 0
C227 a_368_4070# m1_644_2570# 0.00611f
C228 el m1_2972_1572# 0
C229 sub m1_2448_868# 0.0169f
C230 a_1424_4734# m1_1092_4130# 0.12332f
C231 t2 m1_1104_10052# 0
C232 a_2784_4734# a_480_5620# 0
C233 m1_208_9160# m1_841_6220# 0.04681f
C234 spk m1_841_6220# 0
C235 rsel vbn_ref 0
C236 el t0 0
C237 aux a_2720_3620# 0.00232f
C238 m1_208_9160# m1_2436_8920# 0.11451f
C239 m1_2436_8920# spk 0.0424f
C240 t0 sub_b 0.01099f
C241 abus m1_644_2570# 0.00799f
C242 vbp_syn a_480_5620# 0
C243 vbn_ref vbp_st 0.04128f
C244 aux el 3.32203f
C245 vbn_leak m1_4822_412# 0.00239f
C246 hold m1_1960_6220# 0.03609f
C247 aux sub_b 0.15595f
C248 a_2510_1740# a_368_4070# 0.28229f
C249 a_1424_4734# vdd 0.68688f
C250 t2 m1_1960_6220# 0
C251 a_2720_3620# m1_1092_4130# 0
C252 rsel m1_236_9612# 0.04112f
C253 mreset a_368_4070# 0
C254 m1_4822_412# vdd 0.01221f
C255 el m1_1092_4130# 0
C256 rsel a_2784_4734# 0.02728f
C257 a_1684_3624# vbn_prb 0.00734f
C258 a_2720_3620# vbn_leak 0.01103f
C259 abus a_2510_1740# 0.00643f
C260 vbp_st m1_236_9612# 0
C261 a_1424_4734# spk 0.24309f
C262 el vbn_leak 0.06177f
C263 m1_3188_6220# a_2510_1740# 0.05905f
C264 m1_2448_868# a_2080_2940# 0
C265 rsel vbp_syn 0.08509f
C266 vbn_ref m1_3360_172# 0.03533f
C267 vbn_leak sub_b 0.31251f
C268 mreset abus 0
C269 a_1632_2940# a_368_4070# 0.34825f
C270 t1 a_480_5620# 0.19229f
C271 vreset m1_4822_412# 0.02237f
C272 a_2720_3620# vdd 0.14673f
C273 en a_1684_3624# 0
C274 vm t3 0.05788f
C275 sta el 0
C276 m1_3188_6220# mreset 0.05939f
C277 vbp_syn vbp_st 0.16809f
C278 a_2510_1740# m1_644_2570# 0.06277f
C279 sta sub_b 0.0244f
C280 hold sub 0.09874f
C281 vm a_1684_3624# 0.02298f
C282 el vdd 3.89816f
C283 a_288_2940# a_2080_2940# 0
C284 m1_1400_6220# t0 0
C285 vdd sub_b 0.76053f
C286 a_2720_3620# vreset 0
C287 spk a_2720_3620# 0.03774f
C288 a_1684_3624# m1_1244_4440# 0.00641f
C289 m1_3600_6548# m1_2436_8920# 0.00104f
C290 m1_208_9160# el 0
C291 spk el 0
C292 el vreset 0.35481f
C293 a_1632_2940# m1_644_2570# 0.25827f
C294 spk sub_b 0.00712f
C295 vreset sub_b 0.00461f
C296 t1 rsel 0.41821f
C297 vm m1_3052_4742# 0.15293f
C298 vbp_syn m1_3360_172# 0.06893f
C299 mreset a_2510_1740# 0.05899f
C300 m1_2436_8920# m1_841_6220# 0
C301 m1_2448_868# vbn_ref 0.03511f
C302 m1_1960_6220# a_368_4070# 0
C303 m1_4902_6422# vbp_st 0.07319f
C304 m1_1400_6220# vbn_leak 0.06934f
C305 a_1632_2940# a_2510_1740# 0.0039f
C306 vm a_480_5620# 0.44812f
C307 rsel m1_2280_960# 0.00355f
C308 hold stb 0.00185f
C309 rsel vbn_prb 0
C310 m1_1400_6220# vdd 0.05976f
C311 m1_3188_6220# m1_1960_6220# 0
C312 m1_1244_4440# a_480_5620# 0.14495f
C313 vbp_st vbn_prb 3.38211f
C314 m1_1400_6220# m1_208_9160# 0.03315f
C315 en rsel 0.04725f
C316 m1_1400_6220# spk 0
C317 m1_2448_868# vbp_syn 0.03995f
C318 rsel m1_3704_1572# 0.0208f
C319 sub a_368_4070# 0.15658f
C320 m1_4052_1572# m1_2280_960# 0
C321 en vbp_st 0.06588f
C322 m1_3600_6548# el 0.02141f
C323 a_1684_3624# aux 0.11897f
C324 vm rsel 0.10234f
C325 m1_3600_6548# sub_b 0.046f
C326 m1_4052_1572# vbn_prb 0
C327 m1_2280_960# m1_3360_172# 0.00125f
C328 vm vbp_st 0
C329 m1_1540_9160# m1_236_9612# 0.04408f
C330 rsel m1_2020_9600# 0.09894f
C331 sub abus 0.00227f
C332 m1_3360_172# vbn_prb 0.03469f
C333 rsel m1_1244_4440# 0.12214f
C334 hold vbn_ref 0.17517f
C335 m1_3188_6220# sub 0
C336 a_1684_3624# m1_1092_4130# 0.19226f
C337 vbn_leak t3 0.00392f
C338 en m1_4052_1572# 0.00116f
C339 m1_3052_4742# aux 0.01914f
C340 m1_2436_8920# el 0
C341 m1_4052_1572# m1_3704_1572# 0
C342 sub m1_644_2570# 0.09799f
C343 a_1684_3624# vbn_leak 0.00455f
C344 m1_2436_8920# sub_b 0.00595f
C345 vm m1_4052_1572# 0
C346 en m1_3360_172# 0.14838f
C347 vsrc vbn_ref 0.0395f
C348 m1_3360_172# m1_3704_1572# 0.01037f
C349 vm m1_3360_172# 0.23882f
C350 vdd t3 0.12018f
C351 hold m1_236_9612# 0.00124f
C352 t0 a_480_5620# 0.06179f
C353 a_2080_2940# a_368_4070# 0.00183f
C354 vbn_ref m1_4802_1762# 0.07727f
C355 a_1684_3624# vdd 0.58984f
C356 t2 m1_236_9612# 0.00103f
C357 a_1424_4734# a_2720_3620# 0.00284f
C358 m1_3052_4742# vbn_leak 0
C359 m1_208_9160# t3 0.05548f
C360 stb a_368_4070# 0.0011f
C361 sub a_2510_1740# 0.29089f
C362 hold vbp_syn 0.55871f
C363 spk t3 0
C364 a_1424_4734# el 0
C365 m1_2448_868# m1_2280_960# 0.03098f
C366 vsrc m1_236_9612# 0
C367 a_1684_3624# vreset 0
C368 a_1684_3624# spk 0.11825f
C369 el m1_4822_412# 0.00123f
C370 rsel m1_2972_1572# 0.01326f
C371 m1_2448_868# vbn_prb 0.11978f
C372 m1_3052_4742# vdd 0.1921f
C373 m1_1092_4130# a_480_5620# 0.08352f
C374 vsrc vbp_syn 0.22096f
C375 m1_3188_6220# stb 0.13166f
C376 rsel t0 0
C377 m1_1400_6220# m1_841_6220# 0.0156f
C378 a_2080_2940# m1_644_2570# 0.46727f
C379 vbn_leak a_480_5620# 0
C380 sub a_1632_2940# 0.00385f
C381 m1_1400_6220# m1_2436_8920# 0
C382 en m1_2448_868# 0.09092f
C383 a_2720_3620# el 0
C384 rsel aux 0.00389f
C385 m1_3052_4742# spk 0.00151f
C386 a_2720_3620# sub_b 0.00728f
C387 m1_2448_868# m1_3704_1572# 0.02667f
C388 aux vbp_st 0
C389 hold t1 0.03581f
C390 vm m1_2448_868# 0.11006f
C391 vdd a_480_5620# 1.80147f
C392 el sub_b 0.32639f
C393 vbn_ref a_368_4070# 0
C394 t1 t2 0.0102f
C395 a_2510_1740# a_2080_2940# 0.2159f
C396 rsel m1_1092_4130# 0.19318f
C397 hold m1_4902_6422# -0.01665f
C398 m1_3360_172# m1_2972_1572# 0.00276f
C399 vm a_288_2940# 0.22625f
C400 stb a_2510_1740# 0.00165f
C401 rsel vbn_leak 0.38568f
C402 abus vbn_ref 0.07643f
C403 spk a_480_5620# 0.13757f
C404 aux m1_4052_1572# 0.03689f
C405 m1_1400_6220# a_1424_4734# 0.00125f
C406 vbn_leak vbp_st 0.00117f
C407 vsrc m1_4902_6422# 0.00963f
C408 aux m1_3360_172# 0.02978f
C409 a_2784_4734# a_368_4070# 0.03214f
C410 m1_2020_9600# m1_1540_9160# 0.08003f
C411 a_1632_2940# a_2080_2940# 0.11778f
C412 rsel vdd 0.89436f
C413 hold vbn_prb 0.05309f
C414 vbn_ref m1_644_2570# 0
C415 sta vbp_st 0
C416 vbp_syn a_368_4070# 0.35704f
C417 vdd vbp_st 0.19972f
C418 m1_841_6220# t3 0.27267f
C419 m1_4052_1572# vbn_leak 0.00484f
C420 hold en 0.17277f
C421 vsrc vbn_prb 0.04769f
C422 rsel m1_208_9160# 0.05303f
C423 rsel vreset 0.00275f
C424 rsel spk 0.13138f
C425 m1_3600_6548# m1_3052_4742# 0
C426 vbn_leak m1_3360_172# 0.03045f
C427 abus vbp_syn 0.22941f
C428 m1_208_9160# vbp_st 0
C429 m1_1400_6220# sub_b 0
C430 hold vm 0.02231f
C431 vreset vbp_st 0.03539f
C432 m1_4802_1762# vbn_prb 0.14693f
C433 vbn_ref a_2510_1740# 0.07568f
C434 m1_3188_6220# vbp_syn 0.02832f
C435 m1_2448_868# m1_2972_1572# 0.01408f
C436 a_2784_4734# m1_644_2570# 0.00156f
C437 m1_4052_1572# vdd 0.01699f
C438 vm t2 0.04871f
C439 vsrc en 0.06535f
C440 mreset vbn_ref 0
C441 vdd m1_3360_172# 0.31893f
C442 vbp_syn m1_644_2570# 0.08293f
C443 vsrc vm 0
C444 en m1_4802_1762# 0.11313f
C445 t2 m1_1244_4440# 0
C446 m1_2448_868# aux 0.03231f
C447 vreset m1_4052_1572# 0.001f
C448 a_2784_4734# a_2510_1740# 0.0043f
C449 vreset m1_3360_172# 0.03486f
C450 a_1424_4734# a_1684_3624# 0.44856f
C451 stb m1_1960_6220# 0
C452 m1_3188_6220# t1 0
C453 a_2510_1740# vbp_syn 0.82785f
C454 m1_841_6220# a_480_5620# 0.24585f
C455 abus m1_4902_6422# 0
C456 m1_2448_868# vbn_leak 0.04602f
C457 m1_2436_8920# a_480_5620# 0.01379f
C458 m1_3188_6220# m1_4902_6422# -0.01073f
C459 mreset vbp_syn 0.2264f
C460 a_1632_2940# a_2784_4734# 0
C461 a_1424_4734# m1_3052_4742# 0.00147f
C462 a_368_4070# vbn_prb 0
C463 a_288_2940# m1_1092_4130# 0
C464 a_1684_3624# a_2720_3620# 0.38477f
C465 abus m1_2280_960# 0.00128f
C466 a_1632_2940# vbp_syn 0
C467 sub a_2080_2940# 0.03134f
C468 m1_2448_868# vdd 0.23336f
C469 a_1684_3624# el 0.0081f
C470 abus vbn_prb 0.34804f
C471 en a_368_4070# 0
C472 a_1684_3624# sub_b 0.0081f
C473 hold t0 0.06366f
C474 sub stb 0.15303f
C475 m1_236_9612# m1_1104_10052# 0.005f
C476 vbn_leak m1_1540_9160# 0.42134f
C477 m1_2280_960# m1_644_2570# 0.00146f
C478 m1_3052_4742# a_2720_3620# 0.16899f
C479 vm a_368_4070# 0.6154f
C480 a_1424_4734# a_480_5620# 0.08338f
C481 t2 t0 0
C482 rsel m1_2436_8920# 0.0047f
C483 a_288_2940# vdd 0.00934f
C484 hold aux 0.02669f
C485 m1_2448_868# vreset 0.12242f
C486 abus en 0.23162f
C487 vbn_prb m1_644_2570# 0.00217f
C488 a_2510_1740# m1_4902_6422# 0.0283f
C489 m1_3052_4742# el 0
C490 abus m1_3704_1572# 0.01102f
C491 m1_3052_4742# sub_b 0.00768f
C492 m1_1244_4440# a_368_4070# 0.06582f
C493 vdd m1_1540_9160# 0.01627f
C494 vm abus 0.0129f
C495 vsrc aux 0
C496 m1_3188_6220# vm 0.04184f
C497 t1 a_1632_2940# 0.00125f
C498 m1_1960_6220# m1_236_9612# 0.00262f
C499 en m1_644_2570# 0.01378f
C500 a_2510_1740# m1_2280_960# 0.13552f
C501 a_2720_3620# a_480_5620# 0
C502 m1_3704_1572# m1_644_2570# 0
C503 m1_208_9160# m1_1540_9160# 0.01189f
C504 hold vbn_leak 0.03595f
C505 vm m1_644_2570# 0.17384f
C506 a_2510_1740# vbn_prb 0.10837f
C507 a_1424_4734# rsel 0.1635f
C508 el a_480_5620# 0.14543f
C509 t2 vbn_leak 0.00761f
C510 hold sta 0
C511 mreset vbn_prb 0
C512 m1_1244_4440# m1_644_2570# 0.0048f
C513 hold vdd 0.62882f
C514 en a_2510_1740# 0.08714f
C515 vsrc vbn_leak 3.29216f
C516 m1_4822_412# vbp_st 0.01159f
C517 a_2510_1740# m1_3704_1572# 0
C518 t2 vdd 0.13013f
C519 vm a_2510_1740# 0.17879f
C520 vbn_leak m1_4802_1762# 0
C521 vsrc sta 0
C522 mreset en 0
C523 rsel a_2720_3620# 0.1f
C524 hold m1_208_9160# 0.05114f
C525 sub a_2784_4734# 0.25103f
C526 hold spk 0.09606f
C527 hold vreset 0.02317f
C528 vsrc vdd 0.18634f
C529 rsel el 0.00859f
C530 a_2720_3620# vbp_st 0
C531 m1_208_9160# t2 0.03144f
C532 t1 m1_1960_6220# 0.27252f
C533 spk t2 0
C534 rsel sub_b 0.20759f
C535 t0 a_368_4070# 0.00159f
C536 el vbp_st 0
C537 sub vbp_syn 0.00933f
C538 m1_4822_412# m1_3360_172# 0.05008f
C539 abus m1_2972_1572# 0.00853f
C540 vbp_st sub_b 0.01435f
C541 vsrc m1_208_9160# 0
C542 vm a_1632_2940# 0.55342f
C543 vsrc vreset 0.03535f
C544 aux a_368_4070# 0.01305f
C545 vreset m1_4802_1762# 0.00845f
C546 m1_1400_6220# a_480_5620# 0.06602f
C547 m1_3188_6220# t0 0
C548 a_1632_2940# m1_1244_4440# 0.00576f
C549 m1_2972_1572# m1_644_2570# 0.00144f
C550 abus aux 0.03464f
C551 el m1_4052_1572# 0.04158f
C552 a_368_4070# m1_1092_4130# 0.25462f
C553 m1_4052_1572# sub_b 0.00909f
C554 m1_3188_6220# aux 0.00155f
C555 el m1_3360_172# 0.0484f
C556 vbn_leak a_368_4070# 0.04838f
C557 m1_3360_172# sub_b 0.00256f
C558 a_2784_4734# a_2080_2940# 0.0115f
C559 m1_2020_9600# m1_1104_10052# 0.00135f
C560 m1_1540_9160# m1_841_6220# -0
C561 aux m1_644_2570# 0.00316f
C562 sta a_368_4070# 0.00166f
C563 m1_2436_8920# m1_1540_9160# 0
C564 a_2080_2940# vbp_syn 0
C565 a_2510_1740# m1_2972_1572# 0.0195f
C566 abus vbn_leak 0.07484f
C567 m1_1400_6220# rsel 0.51159f
C568 vdd a_368_4070# 2.56133f
C569 vm m1_1960_6220# 0.07636f
C570 stb vbp_syn 0.00106f
C571 m1_1092_4130# m1_644_2570# 0
C572 a_1684_3624# m1_3052_4742# 0.11374f
C573 m1_2020_9600# m1_1960_6220# 0.00275f
C574 m1_3188_6220# sta 0.20875f
C575 aux a_2510_1740# 0.34915f
C576 sub m1_2280_960# 0
C577 mreset t0 0
C578 abus vdd 0.19176f
C579 vbn_leak m1_644_2570# 0.21421f
C580 vreset a_368_4070# 0
C581 spk a_368_4070# 0.08043f
C582 hold m1_841_6220# 0.03667f
C583 m1_3188_6220# vdd 0.22381f
C584 sub vbn_prb 0
C585 mreset aux 0.03786f
C586 hold m1_2436_8920# 0.27015f
C587 t2 m1_841_6220# 0.20943f
C588 t3 a_480_5620# 0.16917f
C589 a_1632_2940# t0 0
C590 vdd m1_644_2570# 0.03552f
C591 a_2510_1740# m1_1092_4130# 0
C592 abus vreset 3.44218f
C593 m1_2448_868# el 0.04811f
C594 m1_2436_8920# t2 0
C595 a_1684_3624# a_480_5620# 0.03274f
C596 m1_2448_868# sub_b 0.00939f
C597 sub en 0.02611f
C598 m1_3188_6220# spk 0.02683f
C599 a_2510_1740# vbn_leak 0.28356f
C600 t1 stb 0
C601 vm sub 0.17979f
C602 vbn_ref vbp_syn 0.09319f
C603 vreset m1_644_2570# 0.00801f
C604 a_288_2940# el 0.08128f
C605 spk m1_644_2570# 0
C606 mreset vbn_leak 0.02825f
C607 sta a_2510_1740# 0
C608 a_1632_2940# m1_1092_4130# 0.01364f
C609 a_2510_1740# vdd 1.24379f
C610 m1_3052_4742# a_480_5620# 0
C611 a_2080_2940# m1_2280_960# 0.0062f
C612 mreset sta 0.01573f
C613 rsel t3 0
C614 a_1632_2940# vbn_leak 0
C615 a_2080_2940# vbn_prb 0
C616 mreset vdd 0.15856f
C617 a_1684_3624# rsel 0.36345f
C618 vbp_syn m1_236_9612# 0.00373f
C619 spk a_2510_1740# 0.01205f
C620 a_2510_1740# vreset 0.0694f
C621 a_2784_4734# vbp_syn 0
C622 a_1684_3624# vbp_st 0
C623 t0 m1_1960_6220# 0.09391f
C624 m1_3600_6548# a_368_4070# 0.00141f
C625 a_1632_2940# vdd 0.68711f
C626 en a_2080_2940# 0.00599f
C627 mreset spk 0.00703f
C628 vsrc m1_4822_412# 0.00459f
C629 mreset vreset 0
C630 vbn_leak m1_1104_10052# 0.0079f
C631 vm a_2080_2940# 0.03438f
C632 hold el 0.02603f
C633 vbn_ref m1_4902_6422# 0.09993f
C634 hold sub_b 0.0409f
C635 spk a_1632_2940# 0.09451f
C636 m1_3188_6220# m1_3600_6548# 0.04544f
C637 vm stb 0.04439f
C638 vsrc a_2720_3620# 0
C639 a_2080_2940# m1_1244_4440# 0
C640 t2 sub_b 0
C641 m1_2436_8920# a_368_4070# 0.00161f
C642 vdd m1_1104_10052# 0.01066f
C643 t1 m1_236_9612# 0.00103f
C644 vsrc el 0
C645 sub m1_2972_1572# 0.01112f
C646 vsrc sub_b 0.02771f
C647 vbn_leak m1_1960_6220# 0.01622f
C648 m1_1400_6220# m1_1540_9160# 0.08454f
C649 rsel a_480_5620# 0.25711f
C650 vbn_ref vbn_prb 3.45615f
C651 sub t0 0.0095f
C652 m1_208_9160# m1_1104_10052# 0.00298f
C653 m1_4802_1762# sub_b 0
C654 m1_3188_6220# m1_2436_8920# 0
C655 sub aux 0.00125f
C656 m1_1960_6220# vdd 0.02837f
C657 vbp_syn m1_4902_6422# 0.36896f
C658 en vbn_ref 3.44676f
C659 a_1424_4734# a_368_4070# 0.10633f
C660 m1_3600_6548# a_2510_1740# 0.04909f
C661 vbn_prb m1_236_9612# 0
C662 vm vbn_ref 0
C663 sub m1_1092_4130# 0
C664 m1_3600_6548# mreset 0.03296f
C665 m1_208_9160# m1_1960_6220# 0.10334f
C666 hold m1_1400_6220# 0.03f
C667 spk m1_1960_6220# 0.25688f
C668 vbp_syn m1_2280_960# 0
C669 sub vbn_leak 0.06844f
C670 m1_1400_6220# t2 0.27577f
C671 vbp_syn vbn_prb 0.13402f
C672 rsel vbp_st 0
C673 abus m1_4822_412# 0.00649f
C674 a_2720_3620# a_368_4070# 0.05471f
C675 sub sta 0
C676 a_1424_4734# m1_644_2570# 0.00836f
C677 el a_368_4070# 0.02106f
C678 vm a_2784_4734# 0.0128f
C679 sub vdd 0.35439f
C680 en vbp_syn 0.30406f
C681 aux a_2080_2940# 0
C682 stb t0 0.00219f
C683 a_368_4070# sub_b 0.41842f
C684 m1_2020_9600# m1_236_9612# 0.116f
C685 vbp_syn m1_3704_1572# 0.04136f
C686 abus a_2720_3620# 0
C687 rsel m1_4052_1572# 0
C688 a_1632_2940# m1_841_6220# 0.00164f
C689 vm vbp_syn 0.24602f
C690 stb aux 0
C691 abus el 0.03394f
C692 rsel m1_3360_172# 0.00595f
C693 sub vreset 0.00197f
C694 m1_2020_9600# vbp_syn 0
C695 abus sub_b 0.11032f
C696 sub spk 0.04431f
C697 m1_3188_6220# el 0.02368f
C698 a_1424_4734# a_2510_1740# 0
C699 vbp_st m1_3360_172# 0.02939f
C700 a_2720_3620# m1_644_2570# 0.00376f
C701 m1_3188_6220# sub_b 0.05477f
C702 a_2080_2940# vbn_leak 0.01792f
C703 el m1_644_2570# 0.13341f
C704 m1_4902_6422# vbn_prb 0.10591f
C705 sub_b m1_644_2570# 0.17111f
C706 hold t3 0.19131f
C707 a_2080_2940# vdd 0.0024f
C708 t1 vm 0.07289f
C709 a_1424_4734# a_1632_2940# 0.02247f
C710 t2 t3 0.00505f
C711 en m1_4902_6422# 0.00861f
C712 a_2720_3620# a_2510_1740# 0.49002f
C713 stb sta 0.02411f
C714 a_288_2940# a_480_5620# -0.02664f
C715 aux vbn_ref 0
C716 m1_1400_6220# a_368_4070# 0
C717 stb vdd 0.16074f
C718 el a_2510_1740# 0.15546f
C719 m1_1960_6220# m1_841_6220# 0
C720 a_2510_1740# sub_b 0.05238f
C721 vreset a_2080_2940# 0
C722 spk a_2080_2940# 0.01634f
C723 vsrc a_1684_3624# 0
C724 m1_2436_8920# m1_1960_6220# 0.00178f
C725 en m1_2280_960# 0.11659f
C726 mreset el 0.05943f
C727 rsel m1_2448_868# 0.01397f
C728 t0 m1_236_9612# 0.00103f
C729 mreset sub_b 0.00222f
C730 m1_2280_960# m1_3704_1572# 0
C731 en vbn_prb 0.09705f
C732 vm m1_2280_960# 0.20694f
C733 a_2720_3620# a_1632_2940# 0
C734 stb spk 0
C735 vbp_syn m1_2972_1572# 0
C736 m1_2448_868# vbp_st 0.03217f
C737 aux m1_236_9612# 0
C738 m1_3600_6548# sub 0
C739 aux a_2784_4734# 0
C740 vm vbn_prb 0
C741 el a_1632_2940# 0.17764f
C742 vbn_ref vbn_leak 0.01431f
C743 vbp_syn t0 0
C744 a_1632_2940# sub_b 0
C745 sta vbn_ref 0
C746 aux vbp_syn 0.12461f
C747 en m1_3704_1572# 0.00127f
C748 rsel m1_1540_9160# 0.15368f
C749 hold a_480_5620# 0.02439f
C750 vm en 0.40632f
C751 m1_2448_868# m1_4052_1572# 0.01864f
C752 vbn_ref vdd 0.3761f
C753 a_2784_4734# m1_1092_4130# 0
C754 t2 a_480_5620# 0.23204f
C755 vm m1_3704_1572# 0.00228f
C756 m1_2448_868# m1_3360_172# 0.11628f
C757 sub m1_2436_8920# 0.10073f
C758 vbn_leak m1_236_9612# 0.83992f
C759 a_2784_4734# vbn_leak 0
C760 m1_208_9160# vbn_ref 0
C761 vbn_ref vreset 0.04923f
C762 vm m1_1244_4440# 0.00133f
C763 vbp_syn vbn_leak 0.24976f
C764 t1 t0 0.0144f
C765 vdd m1_236_9612# 0.03961f
C766 a_2784_4734# vdd 0.41972f
C767 a_1684_3624# a_368_4070# 0.16472f
C768 hold rsel 0.02756f
C769 sta vbp_syn 0.00659f
C770 m1_1960_6220# sub_b 0
C771 rsel t2 0.00468f
C772 m1_3600_6548# stb 0.00109f
C773 hold vbp_st 0.03353f
C774 vbp_syn vdd 5.0366f
C775 vbp_st vss 0.98936f
C776 vsrc vss 1.06528f
C777 m1_3360_172# vss 0.88392f
C778 m1_1104_10052# vss 0.01565f
C779 m1_2280_960# vss 0.1262f
C780 en vss 2.14294f
C781 abus vss 4.58238f
C782 sub vss 0.42494f
C783 mreset vss 0.68178f
C784 spk vss 0.56924f
C785 hold vss 2.95913f
C786 vdd vss 20.515f
C787 m1_1244_4440# vss -0.03848f
C788 a_368_4070# vss -0.10867f
C789 m1_1540_9160# vss 0.21701f
C790 m1_2020_9600# vss 0.16954f
C791 m1_4822_412# vss 0.28416f
C792 m1_1092_4130# vss -0.02612f
C793 m1_841_6220# vss 0.18723f
C794 t3 vss 0.46814f
C795 vbn_prb vss 1.47853f
C796 aux vss 0.60037f
C797 m1_1400_6220# vss 0.16941f
C798 t2 vss 0.32767f
C799 m1_3052_4742# vss -0.19389f
C800 m1_1960_6220# vss 0.17983f
C801 t1 vss 0.28524f
C802 m1_236_9612# vss 0.65308f
C803 m1_208_9160# vss 1.22651f
C804 a_2720_3620# vss 0.55561f
C805 m1_2436_8920# vss 0.46977f
C806 t0 vss 0.29546f
C807 m1_2972_1572# vss -0.04045f
C808 rsel vss 2.82321f
C809 a_1424_4734# vss 0.24837f
C810 a_1684_3624# vss 0.28931f
C811 vm vss 2.35626f
C812 m1_3704_1572# vss -0.05326f
C813 m1_644_2570# vss 0.22317f
C814 a_288_2940# vss -0.04155f
C815 sub_b vss 0.78822f
C816 m1_3188_6220# vss 0.2805f
C817 stb vss 0.37375f
C818 sta vss 0.25919f
C819 m1_2448_868# vss 0.70763f
C820 vreset vss 0.97814f
C821 a_2510_1740# vss 1.89507f
C822 m1_4802_1762# vss -0.00625f
C823 vbn_ref vss 1.05896f
C824 a_2080_2940# vss 0.40533f
C825 a_1632_2940# vss 0.88221f
C826 a_2784_4734# vss -0.01627f
C827 m1_4902_6422# vss -0.1955f
C828 m1_3600_6548# vss -0.04329f
C829 vbp_syn vss 2.13221f
C830 a_480_5620# vss 0.11941f
C831 el vss 0.84385f
C832 vbn_leak vss 4.38063f
C833 m1_4052_1572# vss -0.03695f
.ends
