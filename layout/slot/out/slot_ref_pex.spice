* NGSPICE file created from slot_ref.ext - technology: gf180mcuD

.subckt n_w1_l0p28 a_28_n100# a_n28_n144# a_n116_n100# VSUBS
X0 a_28_n100# a_n28_n144# a_n116_n100# VSUBS nfet_03v3 ad=0.44p pd=2.88u as=0.44p ps=2.88u w=1u l=0.28u
C0 a_n116_n100# a_28_n100# 0.04256f
C1 a_n28_n144# a_28_n100# 0.00769f
C2 a_n28_n144# a_n116_n100# 0.00769f
C3 a_28_n100# VSUBS 0.09911f
C4 a_n116_n100# VSUBS 0.09911f
.ends

.subckt n_w2_l2 a_n288_n200# a_200_n200# a_n200_n244# VSUBS
X0 a_200_n200# a_n200_n244# a_n288_n200# VSUBS nfet_03v3 ad=0.88p pd=4.88u as=0.88p ps=4.88u w=2u l=2u
C0 a_n288_n200# a_200_n200# 0.02133f
C1 a_n200_n244# a_200_n200# 0.0587f
C2 a_n200_n244# a_n288_n200# 0.0587f
C3 a_200_n200# VSUBS 0.2667f
C4 a_n288_n200# VSUBS 0.2667f
.ends

.subckt n_w4_l2 a_n288_n400# a_200_n400# a_n200_n444# VSUBS
X0 a_200_n400# a_n200_n444# a_n288_n400# VSUBS nfet_03v3 ad=1.76p pd=8.88u as=1.76p ps=8.88u w=4u l=2u
C0 a_n288_n400# a_200_n400# 0.04287f
C1 a_n200_n444# a_200_n400# 0.11799f
C2 a_n200_n444# a_n288_n400# 0.11799f
C3 a_200_n400# VSUBS 0.34365f
C4 a_n288_n400# VSUBS 0.34365f
.ends

.subckt slot_ref vss vbp_syn vdd el aux vbn_leak vsrc vbp_st vbn_prb vbn_ref en vreset
+ abus rsel sub
XXPM_XSW m1_4052_1572# rsel m1_3692_1572# vss n_w1_l0p28
XXPM_XSB abus sub m1_4052_1572# vss n_w1_l0p28
XXPM_XSC m1_3692_1572# en m1_3360_308# vss n_w1_l0p28
XXPM_XMB vss m1_4802_412# vbn_prb vss n_w2_l2
XXPM_XME m1_3360_308# en m1_4802_412# vss n_w1_l0p28
XXPM_XMF m1_3360_308# vdd el vss n_w4_l2
C0 sub vbn_ref 0.00147f
C1 abus sub 0.0013f
C2 m1_4052_1572# el 0.04914f
C3 aux vbn_prb 0
C4 vbp_st abus 0.03029f
C5 vbn_leak en 0.03855f
C6 aux el 1.56752f
C7 vbn_leak vdd 0.14737f
C8 m1_3360_308# vbn_prb 0.02513f
C9 m1_3360_308# el 0.19982f
C10 vbp_st sub 0.00358f
C11 vsrc m1_3360_308# 0.02306f
C12 vbp_syn vbn_prb 0
C13 vbp_syn el 0.1187f
C14 m1_4052_1572# rsel 0
C15 rsel aux 0.00194f
C16 vreset en 1.57215f
C17 vbn_leak vbn_prb 0
C18 vbn_leak el 0.00121f
C19 m1_4802_412# en 0.08214f
C20 vreset vdd 0.13663f
C21 vsrc vbn_leak 1.56386f
C22 m1_3360_308# rsel 0.00944f
C23 m1_4052_1572# aux 0.03646f
C24 m1_4802_412# vdd 0.01301f
C25 vbp_syn rsel 0.31178f
C26 vbn_ref en 1.62565f
C27 m1_3360_308# m1_4052_1572# 0.00222f
C28 abus en 0.03957f
C29 m1_3360_308# aux 0.02345f
C30 vbn_ref vdd 0.13682f
C31 abus vdd 0.09024f
C32 sub en 0.01646f
C33 vreset vbn_prb 0
C34 vreset el 0
C35 vbp_st en 0.03882f
C36 m1_4802_412# vbn_prb 0.12338f
C37 vbp_syn m1_3360_308# 0.09557f
C38 m1_4802_412# el 0.00107f
C39 sub vdd 0.50099f
C40 vbp_st vdd 0.13814f
C41 m1_4802_412# vsrc 0.0052f
C42 m1_4052_1572# vbn_leak 0.00474f
C43 vbn_leak aux 1.56386f
C44 vbn_ref vbn_prb 1.58433f
C45 vbn_ref el 0
C46 abus vbn_prb 0.04986f
C47 abus el 0
C48 m1_3360_308# vbn_leak 0.02354f
C49 vsrc abus 0.03569f
C50 sub vbn_prb 0.00219f
C51 sub el 0.05481f
C52 vbp_st vbn_prb 1.60076f
C53 vbp_st el 0
C54 vsrc sub 0.00673f
C55 vbp_st vsrc 1.56386f
C56 m1_4802_412# aux 0.00157f
C57 vreset m1_3360_308# 0.00771f
C58 m1_4802_412# m1_3360_308# 0.03174f
C59 m1_3692_1572# en 0.00689f
C60 en vdd 0.21115f
C61 m1_4052_1572# abus 0
C62 rsel sub 1.22421f
C63 m1_3692_1572# vdd 0.03544f
C64 m1_3360_308# vbn_ref 0.03697f
C65 m1_3360_308# abus 0.00559f
C66 m1_4052_1572# sub 0.02099f
C67 sub aux 0.05516f
C68 m1_4802_412# vbn_leak 0.00266f
C69 m1_3360_308# sub 0.00193f
C70 en vbn_prb 0.05236f
C71 vbp_st m1_3360_308# 0.02359f
C72 en el 0.0589f
C73 vsrc en 0.03865f
C74 vbn_prb vdd 0.1383f
C75 vbp_syn sub 0.03878f
C76 vdd el 2.01861f
C77 m1_3692_1572# el 0.01878f
C78 vbn_leak abus 0.02891f
C79 vsrc vdd 0.13948f
C80 vbn_leak sub 0.03478f
C81 m1_4802_412# vreset 0.00934f
C82 rsel en 0.02029f
C83 vbn_prb el 0
C84 rsel m1_3692_1572# 0.0143f
C85 rsel vdd 0.40372f
C86 vsrc vbn_prb 0.00629f
C87 vsrc el 0
C88 m1_4052_1572# en 0.0049f
C89 vreset abus 1.59242f
C90 aux en 0.0385f
C91 m1_4802_412# vbn_ref 0.08278f
C92 m1_4802_412# abus 0.00442f
C93 m1_4052_1572# vdd 0.01699f
C94 m1_4052_1572# m1_3692_1572# 0
C95 aux vdd 0.23827f
C96 m1_3360_308# en 0.08809f
C97 vreset sub 0
C98 abus vbn_ref 0.02763f
C99 m1_3360_308# vdd 0.10099f
C100 m1_3360_308# m1_3692_1572# 0.00801f
C101 vbp_syn en 0.05758f
C102 vbp_st m1_4802_412# 0.01407f
C103 rsel el 0.01429f
C104 vbp_syn vdd 2.04667f
C105 vbp_syn m1_3692_1572# 0.04355f
C106 vreset vss 0.5234f
C107 vbn_ref vss 0.43185f
C108 vbp_st vss 0.43135f
C109 vsrc vss 0.44024f
C110 vbn_leak vss 0.39455f
C111 aux vss 0.33111f
C112 vbp_syn vss 0.95024f
C113 vdd vss 36.04369f
C114 el vss 0.5501f
C115 m1_4802_412# vss 0.16364f
C116 vbn_prb vss 0.72934f
C117 m1_3360_308# vss 1.20844f
C118 en vss 1.01884f
C119 abus vss 2.89903f
C120 m1_4052_1572# vss -0.03936f
C121 sub vss 1.41693f
C122 m1_3692_1572# vss -0.04035f
C123 rsel vss 0.65654f
.ends
