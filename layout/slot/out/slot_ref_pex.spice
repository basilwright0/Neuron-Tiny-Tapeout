* NGSPICE file created from slot_ref.ext - technology: gf180mcuD

.subckt n_w1_l0p28 a_28_n100# a_n28_n144# a_n116_n100# VSUBS
X0 a_28_n100# a_n28_n144# a_n116_n100# VSUBS nfet_03v3 ad=0.44p pd=2.88u as=0.44p ps=2.88u w=1u l=0.28u
C0 a_n28_n144# a_n116_n100# 0.00769f
C1 a_n116_n100# a_28_n100# 0.04256f
C2 a_n28_n144# a_28_n100# 0.00769f
C3 a_28_n100# VSUBS 0.09911f
C4 a_n116_n100# VSUBS 0.09911f
.ends

.subckt n_w2_l2 a_n288_n200# a_200_n200# a_n200_n244# VSUBS
X0 a_200_n200# a_n200_n244# a_n288_n200# VSUBS nfet_03v3 ad=0.88p pd=4.88u as=0.88p ps=4.88u w=2u l=2u
C0 a_n200_n244# a_n288_n200# 0.0587f
C1 a_n288_n200# a_200_n200# 0.02133f
C2 a_n200_n244# a_200_n200# 0.0587f
C3 a_200_n200# VSUBS 0.2667f
C4 a_n288_n200# VSUBS 0.2667f
.ends

.subckt n_w4_l2 a_n288_n400# a_200_n400# a_n200_n444# VSUBS
X0 a_200_n400# a_n200_n444# a_n288_n400# VSUBS nfet_03v3 ad=1.76p pd=8.88u as=1.76p ps=8.88u w=4u l=2u
C0 a_n200_n444# a_n288_n400# 0.11799f
C1 a_n288_n400# a_200_n400# 0.04287f
C2 a_n200_n444# a_200_n400# 0.11799f
C3 a_200_n400# VSUBS 0.34365f
C4 a_n288_n400# VSUBS 0.34365f
.ends

.subckt slot_ref vss vbp_syn vdd el aux vbn_leak vsrc vbp_st vbn_prb vbn_ref en vreset
+ abus rsel sub
XXPM_XSW m1_4052_1572# rsel m1_3692_1572# vss n_w1_l0p28
XXPM_XSB abus sub m1_4052_1572# vss n_w1_l0p28
XXPM_XSC m1_3692_1572# en m1_3360_308# vss n_w1_l0p28
XXPM_XMB vss m1_4802_412# vbn_prb vss n_w2_l2
XXPM_XME m1_3360_308# en m1_4802_412# vss n_w1_l0p28
XXPM_XMF m1_3360_308# vdd el vss n_w4_l2
C0 rsel vdd 0.40372f
C1 rsel m1_3692_1572# 0.0143f
C2 vsrc vbn_prb 0.00629f
C3 vsrc el 0
C4 m1_4052_1572# en 0.0049f
C5 vreset abus 1.67295f
C6 aux en 0.0385f
C7 m1_4802_412# vbn_ref 0.08278f
C8 m1_4802_412# abus 0.00442f
C9 m1_4052_1572# m1_3692_1572# 0
C10 m1_4052_1572# vdd 0.01699f
C11 aux vdd 0.23827f
C12 m1_3360_308# en 0.08809f
C13 vreset sub 0
C14 abus vbn_ref 0.02763f
C15 m1_3360_308# m1_3692_1572# 0.00801f
C16 m1_3360_308# vdd 0.10099f
C17 vbp_syn en 0.05758f
C18 vbp_st m1_4802_412# 0.01407f
C19 rsel el 0.01429f
C20 vbp_syn vdd 2.13391f
C21 vbp_syn m1_3692_1572# 0.04355f
C22 sub vbn_ref 0.00147f
C23 abus sub 0.0013f
C24 m1_4052_1572# el 0.04914f
C25 aux vbn_prb 0
C26 vbp_st abus 0.03029f
C27 vbn_leak en 0.03855f
C28 aux el 1.64805f
C29 vbn_leak vdd 0.14737f
C30 m1_3360_308# vbn_prb 0.02513f
C31 m1_3360_308# el 0.19982f
C32 vbp_st sub 0.00358f
C33 vsrc m1_3360_308# 0.02306f
C34 vbp_syn vbn_prb 0
C35 vbp_syn el 0.1187f
C36 m1_4052_1572# rsel 0
C37 rsel aux 0.00194f
C38 vreset en 1.65268f
C39 vbn_leak vbn_prb 0
C40 vbn_leak el 0.00121f
C41 m1_4802_412# en 0.08214f
C42 vreset vdd 0.13663f
C43 vsrc vbn_leak 1.64439f
C44 m1_3360_308# rsel 0.00944f
C45 m1_4052_1572# aux 0.03646f
C46 m1_4802_412# vdd 0.01301f
C47 vbp_syn rsel 0.31178f
C48 vbn_ref en 1.70618f
C49 m1_3360_308# m1_4052_1572# 0.00222f
C50 abus en 0.03957f
C51 m1_3360_308# aux 0.02345f
C52 vbn_ref vdd 0.13682f
C53 abus vdd 0.09024f
C54 sub en 0.01646f
C55 vreset vbn_prb 0
C56 vreset el 0
C57 vbp_st en 0.03882f
C58 m1_4802_412# vbn_prb 0.12338f
C59 vbp_syn m1_3360_308# 0.09557f
C60 m1_4802_412# el 0.00107f
C61 sub vdd 0.50099f
C62 vbp_st vdd 0.13814f
C63 m1_4802_412# vsrc 0.0052f
C64 m1_4052_1572# vbn_leak 0.00474f
C65 vbn_leak aux 1.64439f
C66 vbn_ref vbn_prb 1.66486f
C67 vbn_ref el 0
C68 abus vbn_prb 0.04986f
C69 abus el 0
C70 m1_3360_308# vbn_leak 0.02354f
C71 vsrc abus 0.03569f
C72 sub vbn_prb 0.00219f
C73 sub el 0.05481f
C74 vbp_st vbn_prb 1.68129f
C75 vbp_st el 0
C76 vsrc sub 0.00673f
C77 vbp_st vsrc 1.64439f
C78 m1_4802_412# aux 0.00157f
C79 vreset m1_3360_308# 0.00771f
C80 m1_4802_412# m1_3360_308# 0.03174f
C81 m1_3692_1572# en 0.00689f
C82 en vdd 0.21115f
C83 m1_4052_1572# abus 0
C84 rsel sub 1.22421f
C85 m1_3692_1572# vdd 0.03544f
C86 m1_3360_308# vbn_ref 0.03697f
C87 m1_3360_308# abus 0.00559f
C88 m1_4052_1572# sub 0.02099f
C89 sub aux 0.05516f
C90 m1_4802_412# vbn_leak 0.00266f
C91 m1_3360_308# sub 0.00193f
C92 en vbn_prb 0.05236f
C93 vbp_st m1_3360_308# 0.02359f
C94 en el 0.0589f
C95 vsrc en 0.03865f
C96 vbn_prb vdd 0.1383f
C97 vbp_syn sub 0.03878f
C98 vdd el 2.10585f
C99 m1_3692_1572# el 0.01878f
C100 vbn_leak abus 0.02891f
C101 vsrc vdd 0.13948f
C102 vbn_leak sub 0.03478f
C103 m1_4802_412# vreset 0.00934f
C104 rsel en 0.02029f
C105 vbn_prb el 0
C106 vreset vss 0.55057f
C107 vbn_ref vss 0.45491f
C108 vbp_st vss 0.4535f
C109 vsrc vss 0.4622f
C110 vbn_leak vss 0.41639f
C111 aux vss 0.35287f
C112 vbp_syn vss 1.03989f
C113 vdd vss 36.04818f
C114 el vss 0.57109f
C115 m1_4802_412# vss 0.16364f
C116 vbn_prb vss 0.75181f
C117 m1_3360_308# vss 1.20844f
C118 en vss 1.0431f
C119 abus vss 3.02596f
C120 m1_4052_1572# vss -0.03936f
C121 sub vss 1.41706f
C122 m1_3692_1572# vss -0.04035f
C123 rsel vss 0.65654f
.ends
