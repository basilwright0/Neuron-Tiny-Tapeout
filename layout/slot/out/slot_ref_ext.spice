* NGSPICE file created from slot_ref.ext - technology: gf180mcuD

.subckt n_w1_l0p28 a_28_n100# a_n28_n144# a_n116_n100# VSUBS
X0 a_28_n100# a_n28_n144# a_n116_n100# VSUBS nfet_03v3 ad=0.44p pd=2.88u as=0.44p ps=2.88u w=1u l=0.28u
.ends

.subckt n_w2_l2 a_n288_n200# a_200_n200# a_n200_n244# VSUBS
X0 a_200_n200# a_n200_n244# a_n288_n200# VSUBS nfet_03v3 ad=0.88p pd=4.88u as=0.88p ps=4.88u w=2u l=2u
.ends

.subckt n_w4_l2 a_n288_n400# a_200_n400# a_n200_n444# VSUBS
X0 a_200_n400# a_n200_n444# a_n288_n400# VSUBS nfet_03v3 ad=1.76p pd=8.88u as=1.76p ps=8.88u w=4u l=2u
.ends

.subckt slot_ref vss vbp_syn vdd el aux vbn_leak vsrc vbp_st vbn_prb vbn_ref en vreset
+ abus rsel sub
XXPM_XSW m1_4052_1572# rsel m1_3692_1572# vss n_w1_l0p28
XXPM_XSB abus sub m1_4052_1572# vss n_w1_l0p28
XXPM_XSC m1_3692_1572# en m1_3360_308# vss n_w1_l0p28
XXPM_XMB vss m1_4802_412# vbn_prb vss n_w2_l2
XXPM_XME m1_3360_308# en m1_4802_412# vss n_w1_l0p28
XXPM_XMF m1_3360_308# vdd el vss n_w4_l2
.ends
