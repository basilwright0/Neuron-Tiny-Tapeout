* NGSPICE file created from slot_dummy.ext - technology: gf180mcuD

.subckt p_w2_l4 a_400_n200# a_n400_n244# w_n574_n330# a_n488_n200# VSUBS
X0 a_400_n200# a_n400_n244# a_n488_n200# w_n574_n330# pfet_03v3 ad=0.88p pd=4.88u as=0.88p ps=4.88u w=2u l=4u
C0 a_400_n200# a_n400_n244# 0.07019f
C1 w_n574_n330# a_400_n200# 0.07409f
C2 w_n574_n330# a_n400_n244# 0.42229f
C3 a_400_n200# a_n488_n200# 0.01073f
C4 a_n400_n244# a_n488_n200# 0.07019f
C5 w_n574_n330# a_n488_n200# 0.07409f
C6 a_400_n200# VSUBS 0.18936f
C7 a_n488_n200# VSUBS 0.18936f
C8 w_n574_n330# VSUBS 2.27304f
.ends

.subckt p_w0p22_l1 a_100_n22# a_n100_n66# w_n278_n159# a_n192_n36# VSUBS
X0 a_100_n22# a_n100_n66# a_n192_n36# w_n278_n159# pfet_03v3 ad=0.1516p pd=1.64u as=0.1516p ps=1.64u w=0.22u l=1u
C0 a_100_n22# a_n192_n36# 0.00453f
C1 w_n278_n159# a_100_n22# 0.00771f
C2 w_n278_n159# a_n192_n36# 0.00771f
C3 a_100_n22# a_n100_n66# 0.00509f
C4 a_n192_n36# a_n100_n66# 0.00509f
C5 w_n278_n159# a_n100_n66# 0.13163f
C6 a_100_n22# VSUBS 0.05952f
C7 a_n192_n36# VSUBS 0.05952f
C8 w_n278_n159# VSUBS 0.53042f
.ends

.subckt n_w1_l0p28 a_28_n100# a_n28_n144# a_n116_n100# VSUBS
X0 a_28_n100# a_n28_n144# a_n116_n100# VSUBS nfet_03v3 ad=0.44p pd=2.88u as=0.44p ps=2.88u w=1u l=0.28u
C0 a_n28_n144# a_n116_n100# 0.00769f
C1 a_n116_n100# a_28_n100# 0.04256f
C2 a_n28_n144# a_28_n100# 0.00769f
C3 a_28_n100# VSUBS 0.09911f
C4 a_n116_n100# VSUBS 0.09911f
.ends

.subckt n_w2_l2 a_n288_n200# a_200_n200# a_n200_n244# VSUBS
X0 a_200_n200# a_n200_n244# a_n288_n200# VSUBS nfet_03v3 ad=0.88p pd=4.88u as=0.88p ps=4.88u w=2u l=2u
C0 a_n200_n244# a_n288_n200# 0.0587f
C1 a_n288_n200# a_200_n200# 0.02133f
C2 a_n200_n244# a_200_n200# 0.0587f
C3 a_200_n200# VSUBS 0.2667f
C4 a_n288_n200# VSUBS 0.2667f
.ends

.subckt n_w2_l4 a_400_n200# a_n400_n244# a_n488_n200# VSUBS
X0 a_400_n200# a_n400_n244# a_n488_n200# VSUBS nfet_03v3 ad=0.88p pd=4.88u as=0.88p ps=4.88u w=2u l=4u
C0 a_n400_n244# a_n488_n200# 0.07019f
C1 a_n488_n200# a_400_n200# 0.01073f
C2 a_n400_n244# a_400_n200# 0.07019f
C3 a_400_n200# VSUBS 0.41684f
C4 a_n488_n200# VSUBS 0.41684f
.ends

.subckt n_w4_l1 a_n188_n400# a_100_n400# a_n100_n444# VSUBS
X0 a_100_n400# a_n100_n444# a_n188_n400# VSUBS nfet_03v3 ad=1.76p pd=8.88u as=1.76p ps=8.88u w=4u l=1u
C0 a_n100_n444# a_n188_n400# 0.08505f
C1 a_n188_n400# a_100_n400# 0.07756f
C2 a_n100_n444# a_100_n400# 0.08505f
C3 a_100_n400# VSUBS 0.26859f
C4 a_n188_n400# VSUBS 0.26859f
.ends

.subckt n_w0p5_l0p28 a_n28_n94# a_n116_n50# a_28_n50# VSUBS
X0 a_28_n50# a_n28_n94# a_n116_n50# VSUBS nfet_03v3 ad=0.22p pd=1.88u as=0.22p ps=1.88u w=0.5u l=0.28u
C0 a_n28_n94# a_n116_n50# 0.00377f
C1 a_n116_n50# a_28_n50# 0.02085f
C2 a_n28_n94# a_28_n50# 0.00377f
C3 a_28_n50# VSUBS 0.07987f
C4 a_n116_n50# VSUBS 0.07987f
.ends

.subckt p_w1_l0p5 a_n138_n100# a_50_n100# a_n50_n144# w_n224_n230# VSUBS
X0 a_50_n100# a_n50_n144# a_n138_n100# w_n224_n230# pfet_03v3 ad=0.44p pd=2.88u as=0.44p ps=2.88u w=1u l=0.5u
C0 a_50_n100# a_n50_n144# 0.01275f
C1 w_n224_n230# a_50_n100# 0.0205f
C2 w_n224_n230# a_n50_n144# 0.07993f
C3 a_50_n100# a_n138_n100# 0.03085f
C4 a_n50_n144# a_n138_n100# 0.01275f
C5 w_n224_n230# a_n138_n100# 0.0205f
C6 a_50_n100# VSUBS 0.06546f
C7 a_n138_n100# VSUBS 0.06546f
C8 w_n224_n230# VSUBS 0.61824f
.ends

.subckt n_w0p5_l0p5 a_n138_n50# a_50_n50# a_n50_n94# VSUBS
X0 a_50_n50# a_n50_n94# a_n138_n50# VSUBS nfet_03v3 ad=0.22p pd=1.88u as=0.22p ps=1.88u w=0.5u l=0.5u
C0 a_n50_n94# a_n138_n50# 0.00625f
C1 a_n138_n50# a_50_n50# 0.01511f
C2 a_n50_n94# a_50_n50# 0.00625f
C3 a_50_n50# VSUBS 0.09639f
C4 a_n138_n50# VSUBS 0.09639f
.ends

.subckt p_w1_l0p28 w_n202_n230# a_28_n100# a_n28_n144# a_n116_n100# VSUBS
X0 a_28_n100# a_n28_n144# a_n116_n100# w_n202_n230# pfet_03v3 ad=0.44p pd=2.88u as=0.44p ps=2.88u w=1u l=0.28u
C0 a_28_n100# a_n28_n144# 0.00769f
C1 w_n202_n230# a_28_n100# 0.01808f
C2 w_n202_n230# a_n28_n144# 0.05841f
C3 a_28_n100# a_n116_n100# 0.04256f
C4 a_n28_n144# a_n116_n100# 0.00769f
C5 w_n202_n230# a_n116_n100# 0.01808f
C6 a_28_n100# VSUBS 0.0597f
C7 a_n116_n100# VSUBS 0.0597f
C8 w_n202_n230# VSUBS 0.55752f
.ends

.subckt n_w1_l0p5 a_n138_n100# a_50_n100# a_n50_n144# VSUBS
X0 a_50_n100# a_n50_n144# a_n138_n100# VSUBS nfet_03v3 ad=0.44p pd=2.88u as=0.44p ps=2.88u w=1u l=0.5u
C0 a_n50_n144# a_n138_n100# 0.01275f
C1 a_n138_n100# a_50_n100# 0.03085f
C2 a_n50_n144# a_50_n100# 0.01275f
C3 a_50_n100# VSUBS 0.11563f
C4 a_n138_n100# VSUBS 0.11563f
.ends

.subckt n_w4_l2 a_n288_n400# a_200_n400# a_n200_n444# VSUBS
X0 a_200_n400# a_n200_n444# a_n288_n400# VSUBS nfet_03v3 ad=1.76p pd=8.88u as=1.76p ps=8.88u w=4u l=2u
C0 a_n200_n444# a_n288_n400# 0.11799f
C1 a_n288_n400# a_200_n400# 0.04287f
C2 a_n200_n444# a_200_n400# 0.11799f
C3 a_200_n400# VSUBS 0.34365f
C4 a_n288_n400# VSUBS 0.34365f
.ends

.subckt p_w1_l2 w_n374_n230# a_n288_n100# a_200_n100# a_n200_n144# VSUBS
X0 a_200_n100# a_n200_n144# a_n288_n100# w_n374_n230# pfet_03v3 ad=0.44p pd=2.88u as=0.44p ps=2.88u w=1u l=2u
C0 a_200_n100# a_n200_n144# 0.02905f
C1 w_n374_n230# a_200_n100# 0.03135f
C2 w_n374_n230# a_n200_n144# 0.22666f
C3 a_200_n100# a_n288_n100# 0.01056f
C4 a_n200_n144# a_n288_n100# 0.02905f
C5 w_n374_n230# a_n288_n100# 0.03135f
C6 a_200_n100# VSUBS 0.1047f
C7 a_n288_n100# VSUBS 0.1047f
C8 w_n374_n230# VSUBS 1.03224f
.ends

.subckt n_w7p07_l7p07 a_707_n707# a_n795_n707# a_n707_n751# VSUBS
X0 a_707_n707# a_n707_n751# a_n795_n707# VSUBS nfet_03v3 ad=3.1108p pd=15.02u as=3.1108p ps=15.02u w=7.07u l=7.07u
C0 a_n707_n751# a_n795_n707# 0.27012f
C1 a_n795_n707# a_707_n707# 0.0212f
C2 a_n707_n751# a_707_n707# 0.27012f
C3 a_707_n707# VSUBS 0.84237f
C4 a_n795_n707# VSUBS 0.84237f
.ends

.subckt n_w3p54_l3p54 a_354_n354# a_n354_n398# a_n442_n354# VSUBS
X0 a_354_n354# a_n354_n398# a_n442_n354# VSUBS nfet_03v3 ad=1.5576p pd=7.96u as=1.5576p ps=7.96u w=3.54u l=3.54u
C0 a_n354_n398# a_n442_n354# 0.12189f
C1 a_n442_n354# a_354_n354# 0.02161f
C2 a_n354_n398# a_354_n354# 0.12189f
C3 a_354_n354# VSUBS 0.44156f
C4 a_n442_n354# VSUBS 0.44156f
.ends

.subckt n_w0p22_l2 a_200_n22# a_n200_n66# a_n292_n36# VSUBS
X0 a_200_n22# a_n200_n66# a_n292_n36# VSUBS nfet_03v3 ad=0.1516p pd=1.64u as=0.1516p ps=1.64u w=0.22u l=2u
C0 a_n292_n36# a_n200_n66# 0.00705f
C1 a_n200_n66# a_200_n22# 0.00705f
C2 a_n292_n36# a_200_n22# 0.00245f
C3 a_200_n22# VSUBS 0.20767f
C4 a_n292_n36# VSUBS 0.20767f
.ends

.subckt slot_dummy vss vbp_syn vdd el aux vbn_leak vsrc vbp_st vbn_prb vbn_ref en
+ vreset abus sta stb hold mreset vm
XXL_XP1 a_480_5620# a_480_5620# vdd vdd vss p_w2_l4
XXD_XK a_3184_3624# a_2940_5022# vdd vdd vss p_w0p22_l1
XXPM_XSW m1_4052_1572# vss m1_3704_1572# vss n_w1_l0p28
XXL_XP2 a_1632_2940# a_480_5620# vdd vdd vss p_w2_l4
XXPR_XMB vss m1_4802_1762# vbn_prb vss n_w2_l2
XXL_XMT m1_201_2312# vbn_leak vss vss n_w2_l4
XXL_XM1 a_288_2940# a_480_5620# el vss n_w4_l1
XXS_XWA m1_4904_6422# vbp_syn vdd m1_3652_6784# vss p_w2_l4
XXR_Xi_XN a_2940_5022# vss a_3844_4734# vss n_w0p5_l0p28
XXL_XM2 a_2080_2940# a_1632_2940# a_1632_2940# vss n_w4_l1
XXS_XWB m1_4904_6422# vbp_syn vdd m1_3200_6220# vss p_w2_l4
XXR_XNR vss vbn_ref a_2510_1690# vss n_w2_l4
XXD_XPI m1_1718_4540# a_2160_3542# vm vdd vss p_w1_l0p5
XXPR_XME m1_2420_960# vss m1_4802_1762# vss n_w1_l0p28
XXR_XSW vreset vm a_2510_1690# vss n_w0p5_l0p5
XXR_Xi_XP vdd a_3844_4734# a_2940_5022# vdd vss p_w1_l0p28
XXD_XNI vsrc a_2160_3542# vm vss n_w1_l0p5
XXPR_XMF m1_2420_960# vdd a_2510_1690# vss n_w4_l2
XXS_XQA vdd m1_3652_6784# sta vss vss p_w1_l0p28
XXS_XQB vdd m1_3200_6220# stb vss vss p_w1_l0p28
XXS_XNA sta vm m1_3652_6784# vss n_w0p5_l0p28
XXS_XNB stb vm m1_3200_6220# vss n_w0p5_l0p28
XXD_XS2 vdd vdd m1_2260_4540# vbp_st vss p_w1_l2
XXD_XPS vdd vdd m1_1718_4540# vbp_st vss p_w1_l2
XXD_XS3 vdd vdd m1_1540_4540# vbp_st vss p_w1_l2
XXL_XD2a m1_201_2312# a_2080_2940# a_2080_2940# vss n_w4_l1
XXPM_XSB abus vss m1_4052_1572# vss n_w1_l0p28
XXL_XD2b m1_201_2312# a_2080_2940# a_2080_2940# vss n_w4_l1
XXL_XD1a m1_201_2312# a_288_2940# a_288_2940# vss n_w4_l1
XXPM_XSC m1_3704_1572# vss m1_3348_296# vss n_w1_l0p28
XXC_XC vss vss vm vss n_w7p07_l7p07
XXS_XPH vdd m1_4904_6422# vdd hold vss p_w1_l2
XXD_XP2 vdd a_2804_3624# a_2160_3542# m1_2260_4540# vss p_w1_l0p28
XXL_XD1b m1_201_2312# a_288_2940# a_288_2940# vss n_w4_l1
XXPR_XSW m1_2972_1572# vss m1_2260_960# vss n_w1_l0p28
XXD_Xi4_XN a_3184_3624# vss a_2940_5022# vss n_w0p5_l0p28
XXD_XP3 vdd a_3184_3624# a_2804_3624# m1_1540_4540# vss p_w1_l0p28
XXR_XCR_XC vss a_2510_1690# vss vss n_w3p54_l3p54
XXD_XN2 a_2804_3624# a_2160_3542# vsrc vss n_w0p22_l2
XXD_Xi4_XP vdd a_2940_5022# a_3184_3624# vdd vss p_w1_l0p28
XXD_XN3 a_2804_3624# vsrc a_3184_3624# vss n_w0p5_l0p28
XXPM_XMB vss m1_4802_532# vbn_prb vss n_w2_l2
XXR_XPC vdd a_2510_1690# a_3844_4734# vdd vss p_w1_l0p28
XXPM_XME m1_3348_296# vss m1_4802_532# vss n_w1_l0p28
XXPM_XMF m1_3348_296# vdd vm vss n_w4_l2
XXS_XHL vdd vm hold a_1632_2940# vss p_w1_l0p28
XXS_XMR mreset a_2510_1690# vdd vss n_w0p5_l0p28
XXPR_XSB abus vss m1_2972_1572# vss n_w1_l0p28
XXPR_XSC m1_2420_960# vss m1_2260_960# vss n_w1_l0p28
C0 vbn_leak vm 0.00826f
C1 vm m1_3704_1572# 0
C2 a_3844_4734# a_3184_3624# 0.00119f
C3 vdd m1_4904_6422# 0.29242f
C4 vdd m1_201_2312# 0.02352f
C5 a_2940_5022# vreset 0
C6 en vbn_prb 0.00459f
C7 m1_1718_4540# m1_2260_4540# 0.16322f
C8 a_2804_3624# vm 0.06735f
C9 m1_1718_4540# m1_1540_4540# 0.07132f
C10 a_3844_4734# abus 0
C11 a_2080_2940# a_480_5620# 0.24302f
C12 vdd m1_1718_4540# 0.32825f
C13 en m1_4904_6422# 0.01212f
C14 a_2080_2940# vsrc 0.01193f
C15 vbn_prb sta 0
C16 vbn_leak m1_3704_1572# 0
C17 a_3844_4734# a_2160_3542# 0
C18 vbn_ref a_3184_3624# 0
C19 aux a_2080_2940# 0
C20 a_3184_3624# stb 0
C21 m1_4904_6422# sta 0
C22 vdd mreset 0.07265f
C23 a_3184_3624# vm 0.00632f
C24 vbn_ref abus 0.07096f
C25 vdd m1_2420_960# 0.1059f
C26 en mreset 0
C27 m1_4802_532# vbn_prb 0.17019f
C28 abus vm 0.01581f
C29 vbp_syn m1_3348_296# 0.0715f
C30 vsrc m1_3652_6784# 0.00186f
C31 a_3184_3624# vbn_leak 0.0019f
C32 a_2160_3542# vm 0.26419f
C33 mreset sta 0.04969f
C34 en m1_2420_960# 0.04212f
C35 m1_2972_1572# m1_3348_296# 0
C36 vbp_syn a_480_5620# 0
C37 aux m1_3652_6784# 0.00808f
C38 vbp_syn vsrc 0.20038f
C39 m1_2260_4540# vbp_st 0.31506f
C40 a_1632_2940# a_2510_1690# 0.00721f
C41 vbp_syn aux 0.11753f
C42 vbn_leak abus 0.07601f
C43 vbp_st m1_1540_4540# 0.01089f
C44 a_3184_3624# a_2804_3624# 0.28567f
C45 abus m1_3704_1572# 0.00817f
C46 el a_2510_1690# 0.25115f
C47 vdd vbp_st 1.55964f
C48 a_2510_1690# hold 0.20731f
C49 en vbp_st 0
C50 vsrc m1_3200_6220# 0
C51 a_480_5620# a_288_2940# -0.00343f
C52 a_2160_3542# a_2804_3624# 0.01797f
C53 aux m1_3200_6220# 0.00878f
C54 m1_4802_532# m1_2420_960# 0
C55 sta vbp_st 0.00237f
C56 a_3844_4734# vsrc 0.04485f
C57 a_1632_2940# a_2080_2940# 0.21133f
C58 el a_2080_2940# 0.20314f
C59 a_3844_4734# aux 0
C60 m1_4052_1572# a_2510_1690# 0
C61 vbn_ref m1_3348_296# 0.03988f
C62 vm m1_3348_296# 0.23273f
C63 a_2160_3542# a_3184_3624# 0.00482f
C64 vbn_ref vsrc 0.04951f
C65 a_2510_1690# vbn_prb 0.1092f
C66 m1_4802_532# vbp_st 0.01482f
C67 a_480_5620# vm 0.75365f
C68 vbn_ref aux 0
C69 vsrc vm 0.16451f
C70 m1_4904_6422# a_2510_1690# 0
C71 a_2510_1690# m1_201_2312# 0.14388f
C72 aux vm 0.00161f
C73 m1_3704_1572# m1_3348_296# 0.00111f
C74 vbn_leak m1_3348_296# 0.03131f
C75 el m1_3652_6784# 0.02869f
C76 a_1632_2940# vbp_syn 0
C77 hold m1_3652_6784# 0
C78 m1_1718_4540# a_2510_1690# 0.01161f
C79 vbp_syn el 0.12807f
C80 vbn_leak a_480_5620# 0
C81 vbp_syn hold 0.08468f
C82 vbn_leak vsrc 1.65206f
C83 en m1_4802_1762# 0.04004f
C84 aux vbn_leak 1.60363f
C85 a_2940_5022# m1_2260_4540# 0.03535f
C86 mreset a_2510_1690# 0.14828f
C87 el m1_2972_1572# 0
C88 a_2940_5022# m1_1540_4540# 0
C89 a_2080_2940# m1_201_2312# 0.3681f
C90 a_2804_3624# a_480_5620# 0.00137f
C91 a_2804_3624# vsrc 0.15821f
C92 vdd a_2940_5022# 0.68352f
C93 a_1632_2940# m1_3200_6220# 0
C94 a_2510_1690# m1_2420_960# 0.12539f
C95 el m1_3200_6220# 0.03278f
C96 hold m1_3200_6220# 0.04569f
C97 m1_2260_4540# vreset 0
C98 en a_2940_5022# 0
C99 el a_288_2940# 0.08111f
C100 a_3844_4734# el 0
C101 abus m1_3348_296# 0.11328f
C102 a_3184_3624# a_480_5620# 0
C103 vdd vreset 0.37249f
C104 a_3184_3624# vsrc 0.07129f
C105 vbn_prb m1_3652_6784# 0
C106 a_2510_1690# vbp_st 0.38168f
C107 m1_4904_6422# m1_3652_6784# 0.00128f
C108 vbp_syn vbn_prb 0.06493f
C109 en vreset 1.59984f
C110 vsrc abus 0.09371f
C111 a_1632_2940# stb 0
C112 a_2080_2940# m1_2420_960# 0.00143f
C113 vbn_ref el 0
C114 vbp_syn m1_4904_6422# 0.13408f
C115 vbp_syn m1_201_2312# 0.05111f
C116 aux abus 0.03701f
C117 a_1632_2940# vm 0.32599f
C118 a_2160_3542# a_480_5620# 0.06017f
C119 a_2160_3542# vsrc 0.23545f
C120 hold stb 0.06675f
C121 sta vreset 0
C122 vbn_ref hold 0.06106f
C123 el vm 0.05298f
C124 hold vm 0.04837f
C125 vbp_syn m1_1718_4540# 0
C126 m1_2972_1572# m1_201_2312# 0
C127 a_1632_2940# vbn_leak 0
C128 m1_4904_6422# m1_3200_6220# -0.01073f
C129 a_3844_4734# vbn_prb 0
C130 vbp_syn mreset 0.12462f
C131 m1_4802_532# vreset 0.00688f
C132 el vbn_leak 0.19036f
C133 m1_201_2312# a_288_2940# 0.42817f
C134 vbn_leak hold 0.02708f
C135 a_3844_4734# m1_201_2312# 0.00146f
C136 m1_2260_960# a_2510_1690# 0.06544f
C137 a_1632_2940# a_2804_3624# 0.12444f
C138 vbp_syn m1_2420_960# 0.06964f
C139 el a_2804_3624# 0
C140 a_2804_3624# hold 0
C141 vbn_ref vbn_prb 1.67253f
C142 m1_2972_1572# m1_2420_960# 0.00826f
C143 mreset m1_3200_6220# 0.18864f
C144 vbn_prb vm 0
C145 a_2510_1690# m1_4802_1762# 0
C146 vbn_ref m1_4904_6422# 0.11545f
C147 vsrc m1_3348_296# 0.03127f
C148 m1_3652_6784# vbp_st 0.00667f
C149 a_1632_2940# a_3184_3624# 0.00585f
C150 vbn_leak m1_4052_1572# 0.00484f
C151 el a_3184_3624# 0
C152 m1_4052_1572# m1_3704_1572# 0
C153 m1_4904_6422# vm 0
C154 aux m1_3348_296# 0.03135f
C155 vm m1_201_2312# 0.49026f
C156 vbp_syn vbp_st 0.18139f
C157 m1_2260_960# a_2080_2940# 0.00469f
C158 m1_1718_4540# stb 0
C159 vsrc a_480_5620# 0.07774f
C160 el abus 0.03634f
C161 vbn_leak vbn_prb 0.00159f
C162 m1_1718_4540# vm 0.09922f
C163 aux vsrc 0.03763f
C164 abus hold 0
C165 a_1632_2940# a_2160_3542# 0.22453f
C166 a_2940_5022# a_2510_1690# 0.1257f
C167 a_2160_3542# el 0
C168 vbn_leak m1_4904_6422# 0.00368f
C169 vbn_ref mreset 0
C170 vbn_leak m1_201_2312# 0.29666f
C171 a_2160_3542# hold 0
C172 m1_3200_6220# vbp_st 0.0015f
C173 mreset vm 0.00198f
C174 vbn_ref m1_2420_960# 0.03552f
C175 vbp_st a_288_2940# 0
C176 vbn_leak m1_1718_4540# 0
C177 a_2804_3624# m1_201_2312# 0
C178 a_3844_4734# vbp_st 0.00238f
C179 a_2510_1690# vreset 0.39856f
C180 m1_2420_960# vm 0.30134f
C181 m1_4052_1572# abus 0.00525f
C182 a_2804_3624# m1_1718_4540# 0.00933f
C183 vbn_leak mreset 0.0334f
C184 a_2080_2940# a_2940_5022# 0.11832f
C185 a_3184_3624# m1_201_2312# 0.00163f
C186 m1_2260_960# m1_2972_1572# 0.00162f
C187 vbn_ref vbp_st 0.04398f
C188 vbp_st stb 0
C189 vbn_leak m1_2420_960# 0.04272f
C190 m1_2420_960# m1_3704_1572# 0.02915f
C191 m1_2260_4540# m1_1540_4540# 0
C192 abus vbn_prb 0.30681f
C193 vdd m1_2260_4540# 0.22215f
C194 vbp_st vm 0.38112f
C195 vdd m1_1540_4540# 0.55991f
C196 abus m1_201_2312# 0
C197 a_2080_2940# vreset 0
C198 a_3184_3624# m1_1718_4540# 0.00272f
C199 en m1_2260_4540# 0
C200 el m1_3348_296# 0.03653f
C201 a_2160_3542# m1_201_2312# 0.00152f
C202 en vdd 0.29117f
C203 a_1632_2940# a_480_5620# 0.179f
C204 a_1632_2940# vsrc 0.04337f
C205 vbn_leak vbp_st 0.04031f
C206 el a_480_5620# 0.09047f
C207 el vsrc 0.04353f
C208 vbp_syn a_2940_5022# 0.05742f
C209 a_2160_3542# m1_1718_4540# 0.04888f
C210 vdd sta 0.13992f
C211 hold a_480_5620# 0.00863f
C212 vsrc hold 0.02869f
C213 aux el 1.56834f
C214 mreset abus 0
C215 aux hold 0.02666f
C216 a_2804_3624# vbp_st 0.00277f
C217 a_2940_5022# m1_2972_1572# 0.00123f
C218 en sta 0
C219 abus m1_2420_960# 0.10382f
C220 m1_2260_960# vm 0.13934f
C221 m1_4052_1572# m1_3348_296# 0
C222 vbp_syn vreset 0.03949f
C223 vdd m1_4802_532# 0.01021f
C224 a_3184_3624# vbp_st 0.00495f
C225 a_2940_5022# a_288_2940# 0.32208f
C226 vbn_ref m1_4802_1762# 0.07652f
C227 m1_2972_1572# vreset 0.0112f
C228 vbn_prb m1_3348_296# 0.0405f
C229 a_3844_4734# a_2940_5022# 0.28945f
C230 en m1_4802_532# 0.04181f
C231 aux m1_4052_1572# 0.0313f
C232 abus vbp_st 0.118f
C233 vsrc vbn_prb 0.01164f
C234 a_2160_3542# vbp_st 0.01531f
C235 a_3844_4734# vreset 0
C236 aux vbn_prb 0
C237 a_480_5620# m1_201_2312# 0.01152f
C238 m1_4904_6422# vsrc 0.0104f
C239 vsrc m1_201_2312# 0.02347f
C240 vbn_ref a_2940_5022# 0
C241 a_2940_5022# stb 0
C242 vbn_leak m1_4802_1762# 0
C243 aux m1_4904_6422# 0.0021f
C244 aux m1_201_2312# 0.00182f
C245 a_2940_5022# vm 7.77898f
C246 m1_1718_4540# a_480_5620# 0.03892f
C247 m1_1718_4540# vsrc 0.00487f
C248 aux m1_1718_4540# 0
C249 a_1632_2940# el 0.07576f
C250 vbn_ref vreset 0.04927f
C251 a_1632_2940# hold 0.01437f
C252 m1_2420_960# m1_3348_296# 0.13871f
C253 vreset vm 0.08921f
C254 el hold 0.02619f
C255 vsrc mreset 0.0167f
C256 vbn_leak a_2940_5022# 0.06102f
C257 m1_2260_960# abus 0.00235f
C258 aux mreset 0.02379f
C259 a_2510_1690# m1_2260_4540# 0.13024f
C260 vsrc m1_2420_960# 0.03294f
C261 a_2510_1690# m1_1540_4540# 0.00177f
C262 a_2804_3624# a_2940_5022# 0.02012f
C263 vdd a_2510_1690# 1.95277f
C264 aux m1_2420_960# 0.03243f
C265 vbn_leak vreset 0.04549f
C266 vreset m1_3704_1572# 0.00615f
C267 vbp_st m1_3348_296# 0.03884f
C268 abus m1_4802_1762# 0.30957f
C269 en a_2510_1690# 0.0618f
C270 el m1_4052_1572# 0.0372f
C271 a_3184_3624# a_2940_5022# 0.18075f
C272 vbp_st a_480_5620# 0.20117f
C273 vsrc vbp_st 1.60853f
C274 a_2510_1690# sta 0
C275 aux vbp_st 0.03867f
C276 a_2080_2940# m1_1540_4540# 0
C277 el vbn_prb 0.00246f
C278 vdd a_2080_2940# 0.0028f
C279 a_2940_5022# abus 0
C280 a_1632_2940# m1_201_2312# 0.3078f
C281 hold vbn_prb 0.05012f
C282 el m1_4904_6422# 0.00135f
C283 el m1_201_2312# 0.26924f
C284 m1_4904_6422# hold 0.0729f
C285 a_2160_3542# a_2940_5022# 0.02277f
C286 a_1632_2940# m1_1718_4540# 0.04185f
C287 el m1_1718_4540# 0
C288 m1_2260_960# m1_3348_296# 0.00257f
C289 abus vreset 1.81936f
C290 m1_1718_4540# hold 0.00123f
C291 m1_3652_6784# m1_2260_4540# 0
C292 vdd m1_3652_6784# 0.40704f
C293 vbp_syn m1_2260_4540# 0.03194f
C294 el mreset 0.02247f
C295 mreset hold 0.06805f
C296 vbp_syn m1_1540_4540# 0
C297 vbp_syn vdd 2.93872f
C298 el m1_2420_960# 0.03184f
C299 en m1_3652_6784# 0
C300 vdd m1_2972_1572# 0.00498f
C301 vbp_syn en 0
C302 vsrc m1_4802_1762# 0
C303 m1_3652_6784# sta 0.04542f
C304 m1_4904_6422# vbn_prb 0.12948f
C305 vbn_prb m1_201_2312# 0
C306 m1_2260_4540# m1_3200_6220# 0
C307 vbp_syn sta 0.09609f
C308 vdd m1_3200_6220# 0.25047f
C309 a_1632_2940# vbp_st 0.09491f
C310 a_3844_4734# m1_2260_4540# 0.00242f
C311 vdd a_288_2940# 0.0017f
C312 el vbp_st 0.03949f
C313 a_3844_4734# m1_1540_4540# 0
C314 a_3844_4734# vdd 0.36879f
C315 hold vbp_st 0.03731f
C316 m1_4052_1572# m1_2420_960# 0.01864f
C317 a_2940_5022# a_480_5620# 0.15048f
C318 a_2940_5022# vsrc 0.15493f
C319 mreset vbn_prb 0
C320 vreset m1_3348_296# 0.01108f
C321 aux a_2940_5022# 0
C322 en a_3844_4734# 0
C323 sta m1_3200_6220# 0.06327f
C324 vbn_ref m1_2260_4540# 0
C325 m1_2260_4540# stb 0
C326 m1_4904_6422# mreset 0
C327 vbn_prb m1_2420_960# 0.1351f
C328 m1_2260_4540# vm 0.00604f
C329 vdd stb 0.1129f
C330 vbn_ref vdd 0.37547f
C331 vsrc vreset 0.03447f
C332 m1_2420_960# m1_201_2312# 0
C333 m1_1540_4540# vm 0.20544f
C334 vdd vm 1.34297f
C335 aux vreset 0.03354f
C336 en vbn_ref 1.60498f
C337 m1_2260_960# el 0
C338 en vm 0
C339 vbn_leak m1_2260_4540# 0
C340 sta stb 0.01199f
C341 a_2080_2940# a_2510_1690# 0.01969f
C342 vbn_prb vbp_st 1.62465f
C343 vbn_ref sta 0
C344 vdd vbn_leak 0.16605f
C345 vdd m1_3704_1572# 0.03521f
C346 sta vm 0.05407f
C347 m1_4904_6422# vbp_st 0.05532f
C348 a_2804_3624# m1_2260_4540# 0.01174f
C349 a_2804_3624# m1_1540_4540# 0.19924f
C350 en vbn_leak 0
C351 vdd a_2804_3624# 0.3326f
C352 m1_1718_4540# vbp_st 0.23631f
C353 vbn_ref m1_4802_532# 0.08012f
C354 vbn_leak sta 0
C355 m1_4802_532# vm 0
C356 a_3184_3624# m1_2260_4540# 0.00199f
C357 a_2510_1690# m1_3652_6784# 0.00874f
C358 a_1632_2940# a_2940_5022# 0.16237f
C359 mreset vbp_st 0
C360 a_3184_3624# m1_1540_4540# 0.00319f
C361 el a_2940_5022# 0.14377f
C362 a_3184_3624# vdd 0.39496f
C363 vbp_syn a_2510_1690# 0.52774f
C364 a_2940_5022# hold 0
C365 m1_2420_960# vbp_st 0.03535f
C366 m1_2260_960# m1_201_2312# 0.00174f
C367 vdd abus 0.22886f
C368 m1_4802_532# vbn_leak 0.00211f
C369 m1_2972_1572# a_2510_1690# 0.04604f
C370 a_2160_3542# m1_2260_4540# 0.12648f
C371 a_2160_3542# m1_1540_4540# 0.07526f
C372 el vreset 0.05379f
C373 a_2160_3542# vdd 0.45783f
C374 hold vreset 0.00307f
C375 vbn_prb m1_4802_1762# 0.16707f
C376 a_2510_1690# m1_3200_6220# 0.00198f
C377 en abus 0.06201f
C378 vbp_syn a_2080_2940# 0
C379 a_3844_4734# a_2510_1690# 0.21546f
C380 m1_2260_960# m1_2420_960# 0.04192f
C381 a_2940_5022# vbn_prb 0
C382 m1_4052_1572# vreset 0.00429f
C383 a_2940_5022# m1_201_2312# 0.09532f
C384 vbn_ref a_2510_1690# 0.1186f
C385 a_2510_1690# stb 0.02818f
C386 m1_4802_532# abus 0.00781f
C387 a_2080_2940# a_288_2940# 0.00363f
C388 a_2510_1690# vm 0.52701f
C389 vbp_syn m1_3652_6784# 0.13992f
C390 vbn_prb vreset 0.045f
C391 m1_2420_960# m1_4802_1762# 0.01902f
C392 m1_1718_4540# a_2940_5022# 0.01958f
C393 vdd m1_3348_296# 0.34692f
C394 vreset m1_201_2312# 0.00104f
C395 m1_2260_4540# a_480_5620# 0.03689f
C396 vsrc m1_2260_4540# 0
C397 vbn_leak a_2510_1690# 0.3371f
C398 a_2510_1690# m1_3704_1572# 0
C399 vbp_syn m1_2972_1572# 0
C400 a_480_5620# m1_1540_4540# 0.06948f
C401 vsrc m1_1540_4540# 0.01462f
C402 en m1_3348_296# 0.03885f
C403 vdd a_480_5620# 1.82477f
C404 aux m1_2260_4540# 0
C405 m1_3652_6784# m1_3200_6220# 0.06161f
C406 vdd vsrc 0.24302f
C407 a_2080_2940# vm 0.48079f
C408 aux vdd 0.1776f
C409 vbp_st m1_4802_1762# 0.00545f
C410 vbp_syn m1_3200_6220# 0.24528f
C411 a_2804_3624# a_2510_1690# 0.00383f
C412 a_3844_4734# m1_3652_6784# 0
C413 en vsrc 0
C414 mreset vreset 0
C415 vbp_syn a_3844_4734# 0.15479f
C416 vsrc sta 0
C417 m1_2420_960# vreset 0.04512f
C418 vbn_leak a_2080_2940# 0.00179f
C419 aux sta 0
C420 a_3184_3624# a_2510_1690# 0.01652f
C421 a_2940_5022# vbp_st 0.02205f
C422 vbn_ref m1_3652_6784# 0
C423 m1_3652_6784# stb 0.00306f
C424 m1_4802_532# m1_3348_296# 0.07968f
C425 m1_3652_6784# vm 0.04408f
C426 vbp_syn stb 0
C427 vbp_syn vbn_ref 0.00576f
C428 a_2804_3624# a_2080_2940# 0.00516f
C429 abus a_2510_1690# 0.01839f
C430 vbp_syn vm 0.20305f
C431 m1_4802_532# vsrc 0.00416f
C432 vbp_st vreset 0.03471f
C433 a_2160_3542# a_2510_1690# 0.0015f
C434 aux m1_4802_532# 0.00123f
C435 m1_2972_1572# vm 0.00102f
C436 vbn_leak m1_3652_6784# 0.004f
C437 m1_3200_6220# stb 0.1298f
C438 vbp_syn m1_3704_1572# 0.04159f
C439 vbp_syn vbn_leak 0.18802f
C440 a_1632_2940# m1_2260_4540# 0.17336f
C441 m1_3200_6220# vm 0.05787f
C442 a_3844_4734# vbn_ref 0
C443 el m1_2260_4540# 0
C444 a_1632_2940# m1_1540_4540# 0.10996f
C445 m1_2260_960# a_2940_5022# 0
C446 a_1632_2940# vdd 0.50026f
C447 hold m1_2260_4540# 0.00265f
C448 vm a_288_2940# 0.03943f
C449 el m1_1540_4540# 0
C450 a_3844_4734# vm 0
C451 vbn_leak m1_2972_1572# 0.00356f
C452 el vdd 1.94379f
C453 a_2160_3542# a_2080_2940# 0.01636f
C454 vdd hold 0.51392f
C455 vbn_leak m1_3200_6220# 0.00428f
C456 en el 0
C457 m1_2260_960# vreset 0.0557f
C458 en hold 0.02619f
C459 a_3844_4734# vbn_leak 0.00566f
C460 vbp_syn a_3184_3624# 0
C461 vbn_ref vm 0
C462 stb vm 0.03154f
C463 el sta 0
C464 a_2510_1690# m1_3348_296# 0.02097f
C465 hold sta 0
C466 vdd m1_4052_1572# 0.01699f
C467 a_3844_4734# a_2804_3624# 0.0013f
C468 vreset m1_4802_1762# 0.01693f
C469 vbp_syn abus 0.05274f
C470 a_2510_1690# a_480_5620# 0.00366f
C471 vsrc a_2510_1690# 0.15666f
C472 vbn_prb m1_2260_4540# 0
C473 vbp_syn a_2160_3542# 0
C474 vbn_ref vbn_leak 0.01324f
C475 a_3184_3624# m1_3200_6220# 0
C476 aux a_2510_1690# 0.13482f
C477 m1_2972_1572# abus 0.01237f
C478 el m1_4802_532# 0
C479 vdd vbn_prb 0.11228f
C480 en vss 0.55927f
C481 aux vss 0.40202f
C482 m1_3348_296# vss 0.92891f
C483 m1_3652_6784# vss -0.01672f
C484 m1_2260_960# vss 0.31882f
C485 abus vss 2.66702f
C486 mreset vss 0.66189f
C487 hold vss 1.11223f
C488 vdd vss 16.05408f
C489 m1_4802_532# vss 0.19151f
C490 vbn_prb vss 0.68579f
C491 a_3184_3624# vss 0.34925f
C492 a_2804_3624# vss 0.12261f
C493 a_2940_5022# vss 1.01152f
C494 m1_2972_1572# vss -0.02362f
C495 m1_2260_4540# vss 0.03044f
C496 vm vss 3.91448f
C497 m1_3704_1572# vss -0.03257f
C498 m1_201_2312# vss 0.11399f
C499 a_288_2940# vss -0.18582f
C500 m1_1540_4540# vss 0.14417f
C501 vbp_st vss 0.36929f
C502 m1_3200_6220# vss 0.35059f
C503 stb vss 0.23283f
C504 sta vss 0.1406f
C505 m1_2420_960# vss 0.82119f
C506 a_2160_3542# vss 0.29489f
C507 vsrc vss 0.79567f
C508 vreset vss 0.61899f
C509 a_2510_1690# vss 3.73383f
C510 m1_4802_1762# vss 0.04526f
C511 m1_1718_4540# vss 0.08988f
C512 vbn_ref vss 0.62532f
C513 a_2080_2940# vss 0.12687f
C514 a_1632_2940# vss 0.17399f
C515 a_3844_4734# vss 0.02956f
C516 m1_4904_6422# vss -0.19658f
C517 vbp_syn vss 0.35422f
C518 a_480_5620# vss 0.29034f
C519 el vss 0.34933f
C520 vbn_leak vss 0.92935f
C521 m1_4052_1572# vss 0.01261f
.ends
