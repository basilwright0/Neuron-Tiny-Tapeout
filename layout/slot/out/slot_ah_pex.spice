* NGSPICE file created from slot_ah.ext - technology: gf180mcuD

.subckt p_w2_l4 a_400_n200# a_n400_n244# w_n574_n330# a_n488_n200# VSUBS
X0 a_400_n200# a_n400_n244# a_n488_n200# w_n574_n330# pfet_03v3 ad=0.88p pd=4.88u as=0.88p ps=4.88u w=2u l=4u
C0 a_n488_n200# a_400_n200# 0.01073f
C1 a_n400_n244# w_n574_n330# 0.42229f
C2 a_n400_n244# a_400_n200# 0.07019f
C3 a_400_n200# w_n574_n330# 0.07409f
C4 a_n400_n244# a_n488_n200# 0.07019f
C5 a_n488_n200# w_n574_n330# 0.07409f
C6 a_400_n200# VSUBS 0.18936f
C7 a_n488_n200# VSUBS 0.18936f
C8 w_n574_n330# VSUBS 2.27304f
.ends

.subckt n_w1_l0p28 a_28_n100# a_n28_n144# a_n116_n100# VSUBS
X0 a_28_n100# a_n28_n144# a_n116_n100# VSUBS nfet_03v3 ad=0.44p pd=2.88u as=0.44p ps=2.88u w=1u l=0.28u
C0 a_n116_n100# a_n28_n144# 0.00769f
C1 a_n116_n100# a_28_n100# 0.04256f
C2 a_28_n100# a_n28_n144# 0.00769f
C3 a_28_n100# VSUBS 0.09911f
C4 a_n116_n100# VSUBS 0.09911f
.ends

.subckt n_w2_l2 a_n288_n200# a_200_n200# a_n200_n244# VSUBS
X0 a_200_n200# a_n200_n244# a_n288_n200# VSUBS nfet_03v3 ad=0.88p pd=4.88u as=0.88p ps=4.88u w=2u l=2u
C0 a_n288_n200# a_n200_n244# 0.0587f
C1 a_n288_n200# a_200_n200# 0.02133f
C2 a_200_n200# a_n200_n244# 0.0587f
C3 a_200_n200# VSUBS 0.2667f
C4 a_n288_n200# VSUBS 0.2667f
.ends

.subckt n_w2_l4 a_400_n200# a_n400_n244# a_n488_n200# VSUBS
X0 a_400_n200# a_n400_n244# a_n488_n200# VSUBS nfet_03v3 ad=0.88p pd=4.88u as=0.88p ps=4.88u w=2u l=4u
C0 a_n488_n200# a_n400_n244# 0.07019f
C1 a_n488_n200# a_400_n200# 0.01073f
C2 a_400_n200# a_n400_n244# 0.07019f
C3 a_400_n200# VSUBS 0.41684f
C4 a_n488_n200# VSUBS 0.41684f
.ends

.subckt n_w0p5_l0p28 a_n28_n94# a_n116_n50# a_28_n50# VSUBS
X0 a_28_n50# a_n28_n94# a_n116_n50# VSUBS nfet_03v3 ad=0.22p pd=1.88u as=0.22p ps=1.88u w=0.5u l=0.28u
C0 a_n116_n50# a_n28_n94# 0.00377f
C1 a_n116_n50# a_28_n50# 0.02085f
C2 a_28_n50# a_n28_n94# 0.00377f
C3 a_28_n50# VSUBS 0.07987f
C4 a_n116_n50# VSUBS 0.07987f
.ends

.subckt p_w1_l0p5 a_n138_n100# a_50_n100# a_n50_n144# w_n224_n230# VSUBS
X0 a_50_n100# a_n50_n144# a_n138_n100# w_n224_n230# pfet_03v3 ad=0.44p pd=2.88u as=0.44p ps=2.88u w=1u l=0.5u
C0 a_n138_n100# a_50_n100# 0.03085f
C1 a_n50_n144# w_n224_n230# 0.07993f
C2 a_n50_n144# a_50_n100# 0.01275f
C3 a_50_n100# w_n224_n230# 0.0205f
C4 a_n50_n144# a_n138_n100# 0.01275f
C5 a_n138_n100# w_n224_n230# 0.0205f
C6 a_50_n100# VSUBS 0.06546f
C7 a_n138_n100# VSUBS 0.06546f
C8 w_n224_n230# VSUBS 0.61824f
.ends

.subckt n_w0p5_l0p5 a_n138_n50# a_50_n50# a_n50_n94# VSUBS
X0 a_50_n50# a_n50_n94# a_n138_n50# VSUBS nfet_03v3 ad=0.22p pd=1.88u as=0.22p ps=1.88u w=0.5u l=0.5u
C0 a_n138_n50# a_n50_n94# 0.00625f
C1 a_n138_n50# a_50_n50# 0.01511f
C2 a_50_n50# a_n50_n94# 0.00625f
C3 a_50_n50# VSUBS 0.09639f
C4 a_n138_n50# VSUBS 0.09639f
.ends

.subckt p_w1_l0p28 w_n202_n230# a_28_n100# a_n28_n144# a_n116_n100# VSUBS
X0 a_28_n100# a_n28_n144# a_n116_n100# w_n202_n230# pfet_03v3 ad=0.44p pd=2.88u as=0.44p ps=2.88u w=1u l=0.28u
C0 a_n116_n100# a_28_n100# 0.04256f
C1 a_n28_n144# w_n202_n230# 0.05841f
C2 a_n28_n144# a_28_n100# 0.00769f
C3 a_28_n100# w_n202_n230# 0.01808f
C4 a_n28_n144# a_n116_n100# 0.00769f
C5 a_n116_n100# w_n202_n230# 0.01808f
C6 a_28_n100# VSUBS 0.0597f
C7 a_n116_n100# VSUBS 0.0597f
C8 w_n202_n230# VSUBS 0.55752f
.ends

.subckt n_w1_l0p5 a_n138_n100# a_50_n100# a_n50_n144# VSUBS
X0 a_50_n100# a_n50_n144# a_n138_n100# VSUBS nfet_03v3 ad=0.44p pd=2.88u as=0.44p ps=2.88u w=1u l=0.5u
C0 a_n138_n100# a_n50_n144# 0.01275f
C1 a_n138_n100# a_50_n100# 0.03085f
C2 a_50_n100# a_n50_n144# 0.01275f
C3 a_50_n100# VSUBS 0.11563f
C4 a_n138_n100# VSUBS 0.11563f
.ends

.subckt n_w4_l2 a_n288_n400# a_200_n400# a_n200_n444# VSUBS
X0 a_200_n400# a_n200_n444# a_n288_n400# VSUBS nfet_03v3 ad=1.76p pd=8.88u as=1.76p ps=8.88u w=4u l=2u
C0 a_n288_n400# a_n200_n444# 0.11799f
C1 a_n288_n400# a_200_n400# 0.04287f
C2 a_200_n400# a_n200_n444# 0.11799f
C3 a_200_n400# VSUBS 0.34365f
C4 a_n288_n400# VSUBS 0.34365f
.ends

.subckt p_w1_l2 w_n374_n230# a_n288_n100# a_200_n100# a_n200_n144# VSUBS
X0 a_200_n100# a_n200_n144# a_n288_n100# w_n374_n230# pfet_03v3 ad=0.44p pd=2.88u as=0.44p ps=2.88u w=1u l=2u
C0 a_n288_n100# a_200_n100# 0.01056f
C1 a_n200_n144# w_n374_n230# 0.22666f
C2 a_n200_n144# a_200_n100# 0.02905f
C3 a_200_n100# w_n374_n230# 0.03135f
C4 a_n200_n144# a_n288_n100# 0.02905f
C5 a_n288_n100# w_n374_n230# 0.03135f
C6 a_200_n100# VSUBS 0.1047f
C7 a_n288_n100# VSUBS 0.1047f
C8 w_n374_n230# VSUBS 1.03224f
.ends

.subckt n_w7p07_l7p07 a_707_n707# a_n795_n707# a_n707_n751# VSUBS
X0 a_707_n707# a_n707_n751# a_n795_n707# VSUBS nfet_03v3 ad=3.1108p pd=15.02u as=3.1108p ps=15.02u w=7.07u l=7.07u
C0 a_n795_n707# a_n707_n751# 0.27012f
C1 a_n795_n707# a_707_n707# 0.0212f
C2 a_707_n707# a_n707_n751# 0.27012f
C3 a_707_n707# VSUBS 0.84237f
C4 a_n795_n707# VSUBS 0.84237f
.ends

.subckt n_w3p54_l3p54 a_354_n354# a_n354_n398# a_n442_n354# VSUBS
X0 a_354_n354# a_n354_n398# a_n442_n354# VSUBS nfet_03v3 ad=1.5576p pd=7.96u as=1.5576p ps=7.96u w=3.54u l=3.54u
C0 a_n442_n354# a_n354_n398# 0.12189f
C1 a_n442_n354# a_354_n354# 0.02161f
C2 a_354_n354# a_n354_n398# 0.12189f
C3 a_354_n354# VSUBS 0.44156f
C4 a_n442_n354# VSUBS 0.44156f
.ends

.subckt n_w0p22_l2 a_200_n22# a_n200_n66# a_n292_n36# VSUBS
X0 a_200_n22# a_n200_n66# a_n292_n36# VSUBS nfet_03v3 ad=0.1516p pd=1.64u as=0.1516p ps=1.64u w=0.22u l=2u
C0 a_n200_n66# a_n292_n36# 0.00705f
C1 a_n200_n66# a_200_n22# 0.00705f
C2 a_200_n22# a_n292_n36# 0.00245f
C3 a_200_n22# VSUBS 0.20767f
C4 a_n292_n36# VSUBS 0.20767f
.ends

.subckt slot_ah vss vbp_syn vdd el aux vbn_leak vsrc vbp_st vbn_prb vbn_ref en vreset
+ abus spk sta stb hold mreset rsel sub sub_b vm
XXL_XP1 a_480_5620# a_480_5620# vdd vdd vss p_w2_l4
XXPM_XSW m1_1488_2730# rsel m1_3360_172# vss n_w1_l0p28
XXL_XP2 a_1580_2680# a_480_5620# vdd vdd vss p_w2_l4
XXPR_XMB vss m1_4822_1769# vbn_prb vss n_w2_l2
XXL_XMT m1_201_2570# vbn_leak vss vss n_w2_l4
XXL_XM1 a_280_2680# a_480_5620# el vss n_w2_l2
XXS_XWA m1_4902_6422# vbp_syn vdd m1_3652_6232# vss p_w2_l4
XXR_Xi_XN spk vss a_3844_4734# vss n_w0p5_l0p28
XXL_XM2 a_2240_2680# a_1580_2680# a_1580_2680# vss n_w2_l2
XXS_XWB m1_4902_6422# vbp_syn vdd m1_3212_6232# vss p_w2_l4
XXR_XNR vss vbn_ref a_2510_1690# vss n_w2_l4
XXD_XPI m1_1718_4540# a_2160_3542# vm vdd vss p_w1_l0p5
XXPR_XME m1_2628_744# en m1_4822_1769# vss n_w1_l0p28
XXR_XSW vreset vm a_2510_1690# vss n_w0p5_l0p5
XXR_Xi_XP vdd a_3844_4734# spk vdd vss p_w1_l0p28
XXD_XNI vsrc a_2160_3542# vm vss n_w1_l0p5
XXPR_XMF m1_2628_744# vdd a_2510_1690# vss n_w4_l2
XXS_XQA vdd m1_3652_6232# sta vss vss p_w1_l0p28
XXS_XQB vdd m1_3212_6232# stb vss vss p_w1_l0p28
XXL_XD1 m1_201_2570# a_280_2680# a_280_2680# vss n_w2_l2
XXS_XNA sta vm m1_3652_6232# vss n_w0p5_l0p28
XXL_XD2 m1_201_2570# a_2240_2680# a_2240_2680# vss n_w2_l2
XXS_XNB stb vm m1_3212_6232# vss n_w0p5_l0p28
XXD_XS2 vdd vdd m1_2240_4440# vbp_st vss p_w1_l2
XXD_XPS vdd vdd m1_1718_4540# vbp_st vss p_w1_l2
XXPM_XSB m1_1488_2730# sub_b abus vss n_w1_l0p28
XXC_XC vss vss vm vss n_w7p07_l7p07
XXS_XPH vdd m1_4902_6422# vdd hold vss p_w1_l2
XXD_XP2 vdd a_2804_3624# a_2160_3542# m1_2240_4440# vss p_w1_l0p28
XXPR_XSW m1_2960_1600# rsel m1_2628_744# vss n_w1_l0p28
XXD_Xi4_XN a_3184_3624# vss spk vss n_w0p5_l0p28
XXD_XP3 vdd a_3184_3624# a_2804_3624# vdd vss p_w1_l0p28
XXR_XCR_XC vss a_2510_1690# vss vss n_w3p54_l3p54
XXD_XN2 a_2804_3624# a_2160_3542# vsrc vss n_w0p22_l2
XXD_Xi4_XP vdd spk a_3184_3624# vdd vss p_w1_l0p28
XXD_XN3 a_2804_3624# vsrc a_3184_3624# vss n_w0p5_l0p28
XXPM_XMB vss m1_4822_412# vbn_prb vss n_w2_l2
XXR_XPC vdd a_2510_1690# a_3844_4734# vdd vss p_w1_l0p28
XXPM_XME m1_3360_172# en m1_4822_412# vss n_w1_l0p28
XXPM_XMF m1_3360_172# vdd vm vss n_w4_l2
XXS_XHL vdd vm hold a_1580_2680# vss p_w1_l0p28
XXS_XMR mreset a_2510_1690# vdd vss n_w0p5_l0p28
XXPR_XSB m1_2960_1600# sub abus vss n_w1_l0p28
C0 a_2160_3542# a_3184_3624# 0
C1 a_2804_3624# a_2510_1690# 0
C2 m1_3652_6232# el 0.10631f
C3 m1_1488_2730# sub 0.10198f
C4 spk m1_2240_4440# 0.13404f
C5 vsrc vbp_st 1.59462f
C6 sta aux 0
C7 a_480_5620# el 0.04747f
C8 a_280_2680# a_1580_2680# 0
C9 vsrc m1_4822_1769# 0.00456f
C10 a_3844_4734# a_2804_3624# 0.0014f
C11 vsrc a_3184_3624# 0.00772f
C12 m1_3652_6232# a_2510_1690# 0
C13 m1_2960_1600# el 0
C14 m1_201_2570# aux 0
C15 m1_1718_4540# vm 0.17528f
C16 sub_b sta 0.01724f
C17 a_480_5620# a_2510_1690# 0
C18 vreset el 0.24298f
C19 vbp_st a_2804_3624# 0.00221f
C20 sub a_1580_2680# 0.11077f
C21 m1_2960_1600# vreset 0.0053f
C22 el a_2510_1690# 0.17052f
C23 a_2160_3542# vbp_syn 0
C24 vbn_leak m1_4902_6422# 0.00341f
C25 m1_4902_6422# vdd 0.04449f
C26 m1_201_2570# sub_b 0.10321f
C27 a_2804_3624# a_3184_3624# 0.0557f
C28 m1_2960_1600# a_2510_1690# 0.01121f
C29 sta mreset 0.07457f
C30 vreset a_2510_1690# 0.25545f
C31 el abus 0.041f
C32 vbn_leak spk 0.04075f
C33 sub_b aux 0.26312f
C34 spk vdd 0.7203f
C35 a_3844_4734# el 0
C36 vsrc vbp_syn 0.20812f
C37 m1_2960_1600# abus 0.10402f
C38 sub m1_2240_4440# 0.12071f
C39 m1_3652_6232# vbp_st 0.00125f
C40 el m1_4822_412# 0.00123f
C41 vreset abus 1.71954f
C42 m1_3212_6232# sta 0.03588f
C43 a_480_5620# vbp_st 0
C44 vreset a_3844_4734# 0
C45 aux mreset 0.04558f
C46 a_2510_1690# abus 0.0237f
C47 vreset m1_4822_412# 0.02351f
C48 m1_201_2570# rsel 0.04518f
C49 vbp_st el 0.02184f
C50 a_3844_4734# a_2510_1690# 0.2026f
C51 vm m1_4902_6422# 0
C52 a_480_5620# a_3184_3624# 0
C53 en m1_4902_6422# 0
C54 rsel aux 0
C55 m1_2960_1600# vbp_st 0
C56 sta hold 0.00338f
C57 vbp_syn a_2804_3624# 0
C58 vbn_ref m1_2628_744# 0.0354f
C59 vm spk 8.22133f
C60 a_280_2680# vdd 0
C61 vbp_st vreset 0.03623f
C62 a_3844_4734# abus 0
C63 sub_b mreset 0.66338f
C64 m1_2960_1600# m1_4822_1769# 0
C65 m1_3212_6232# aux 0
C66 m1_4902_6422# vbn_prb 0.11578f
C67 en spk 0
C68 m1_1718_4540# a_2160_3542# 0.02555f
C69 stb a_1580_2680# 0
C70 m1_2628_744# sub 0.00215f
C71 m1_4822_412# abus 0.00637f
C72 vreset m1_4822_1769# 0.00947f
C73 vbp_st a_2510_1690# 0.29406f
C74 vbn_leak vbn_ref 0.00846f
C75 vbn_ref vdd 0.30452f
C76 rsel sub_b 0.30572f
C77 vbn_prb spk 0
C78 a_3184_3624# a_2510_1690# 0.00478f
C79 vbn_leak sub 0.09683f
C80 m1_3652_6232# vbp_syn 0.39348f
C81 hold aux 0.02605f
C82 vbp_st abus 0.03742f
C83 sub vdd 0.32355f
C84 m1_3212_6232# sub_b 0.00649f
C85 vbp_st a_3844_4734# 0.00148f
C86 m1_1488_2730# a_2240_2680# 0.23033f
C87 m1_4822_1769# abus 0.01415f
C88 stb m1_2240_4440# 0
C89 a_480_5620# vbp_syn 0
C90 vbp_st m1_4822_412# 0.01164f
C91 rsel mreset 0.09181f
C92 a_280_2680# vm 0.14894f
C93 a_3844_4734# a_3184_3624# 0.00655f
C94 vbp_syn el 0.10362f
C95 m1_3212_6232# mreset 0.10191f
C96 sub_b hold 0.13418f
C97 m1_201_2570# m1_3360_172# 0
C98 m1_2960_1600# vbp_syn 0
C99 vbn_ref vm 0
C100 m1_3360_172# aux 0.0289f
C101 vbn_ref en 1.6485f
C102 vreset vbp_syn 0.03132f
C103 m1_1718_4540# a_2804_3624# 0.00569f
C104 vbp_st m1_4822_1769# 0.01317f
C105 vbp_st a_3184_3624# 0.00149f
C106 vm sub 0.05756f
C107 hold mreset 0.43224f
C108 vbp_syn a_2510_1690# 0.32338f
C109 a_2240_2680# a_1580_2680# 0.20862f
C110 en sub 0
C111 vbn_ref vbn_prb 1.67186f
C112 a_2160_3542# spk 0.04921f
C113 sub_b m1_3360_172# 0
C114 vbn_prb sub 0
C115 rsel hold 0.25005f
C116 vbp_syn abus 0.10709f
C117 vsrc m1_4902_6422# 0.01219f
C118 a_3844_4734# vbp_syn 0.17099f
C119 m1_3212_6232# hold 0
C120 stb vdd 0.11602f
C121 a_480_5620# m1_1718_4540# 0.21577f
C122 vsrc spk 0.12159f
C123 m1_1718_4540# el 0
C124 vbp_st vbp_syn 0.17351f
C125 rsel m1_3360_172# 0.02543f
C126 vbp_syn a_3184_3624# 0.00853f
C127 m1_1718_4540# a_2510_1690# 0
C128 a_2804_3624# spk 0.01206f
C129 stb vm 0.07703f
C130 m1_1488_2730# m1_201_2570# 0.21884f
C131 m1_2628_744# a_2240_2680# 0
C132 a_2160_3542# sub 0.0065f
C133 m1_1488_2730# aux 0.21089f
C134 m1_3652_6232# m1_4902_6422# 0.00142f
C135 vbn_leak a_2240_2680# 0.01452f
C136 vsrc vbn_ref 0.02811f
C137 a_2240_2680# vdd 0
C138 m1_3652_6232# spk 0
C139 vsrc sub 0.08317f
C140 m1_1488_2730# sub_b 0.14306f
C141 el m1_4902_6422# 0.00123f
C142 a_480_5620# spk 0.06768f
C143 m1_201_2570# a_1580_2680# 0.32546f
C144 vbp_st m1_1718_4540# 0.16743f
C145 el spk 0.05416f
C146 sta m1_2240_4440# 0
C147 m1_1718_4540# a_3184_3624# 0
C148 a_2510_1690# m1_4902_6422# 0.242f
C149 vm a_2240_2680# 0.00934f
C150 a_2804_3624# sub 0.1075f
C151 m1_1488_2730# rsel 0.24852f
C152 a_2510_1690# spk 0.1734f
C153 sub_b a_1580_2680# 0.14013f
C154 aux m1_2240_4440# 0
C155 a_280_2680# a_480_5620# 0.00461f
C156 a_280_2680# el 0.01714f
C157 a_3844_4734# spk 0.18629f
C158 mreset a_1580_2680# 0.00258f
C159 sub_b m1_2240_4440# 0.03993f
C160 el vbn_ref 0
C161 m1_1718_4540# vbp_syn 0
C162 vbp_st m1_4902_6422# 0.0707f
C163 a_480_5620# sub 0.03762f
C164 vbn_leak sta 0
C165 rsel a_1580_2680# 0.22224f
C166 sta vdd 0.13629f
C167 m1_2960_1600# vbn_ref 0
C168 m1_201_2570# m1_2628_744# 0
C169 el sub 0
C170 vbp_st spk 0.05198f
C171 vreset vbn_ref 0.05125f
C172 mreset m1_2240_4440# 0.00326f
C173 m1_2628_744# aux 0.03761f
C174 m1_2960_1600# sub 0.05739f
C175 vbn_ref a_2510_1690# 0.17062f
C176 vbn_leak m1_201_2570# 0.12258f
C177 a_3184_3624# spk 0.23096f
C178 vreset sub 0
C179 m1_201_2570# vdd 0.00326f
C180 m1_1488_2730# m1_3360_172# 0.01037f
C181 vbn_leak aux 1.59414f
C182 rsel m1_2240_4440# 0
C183 a_2510_1690# sub 0.17081f
C184 vdd aux 0.18499f
C185 hold a_1580_2680# 0.03512f
C186 vbn_ref abus 0.03834f
C187 m1_2628_744# sub_b 0.00436f
C188 a_2160_3542# a_2240_2680# 0.00373f
C189 m1_3212_6232# m1_2240_4440# 0
C190 a_3844_4734# vbn_ref 0
C191 vm sta 0.08653f
C192 sub abus 0.01034f
C193 vbn_ref m1_4822_412# 0.07811f
C194 en sta 0
C195 a_3844_4734# sub 0.00233f
C196 vbn_leak sub_b 0.39169f
C197 sub_b vdd 1.28745f
C198 vbp_syn m1_4902_6422# 0.1891f
C199 vsrc a_2240_2680# 0.00946f
C200 sta vbn_prb 0
C201 m1_201_2570# vm 0.10513f
C202 vbp_st vbn_ref 0.04167f
C203 vbp_syn spk 0.02374f
C204 m1_201_2570# en 0
C205 vm aux 0
C206 rsel m1_2628_744# 0.01155f
C207 m1_4822_1769# vbn_ref 0.08364f
C208 vbn_leak mreset 0.02498f
C209 vbn_ref a_3184_3624# 0
C210 vbp_st sub 0.02006f
C211 vdd mreset 0.28821f
C212 en aux 0
C213 m1_201_2570# vbn_prb 0.00108f
C214 a_3184_3624# sub 0.1082f
C215 vbn_leak rsel 0.07775f
C216 rsel vdd 0.56075f
C217 vbn_prb aux 0
C218 a_2804_3624# a_2240_2680# 0
C219 vm sub_b 0.29464f
C220 vbn_leak m1_3212_6232# 0
C221 m1_3212_6232# vdd 0.42116f
C222 sub_b en 0.00679f
C223 sub_b vbn_prb 0.01584f
C224 vm mreset 0.18271f
C225 vbn_leak hold 0.02685f
C226 hold vdd 0.47036f
C227 en mreset 0
C228 vbp_syn vbn_ref 0.00579f
C229 a_480_5620# a_2240_2680# 0.08582f
C230 rsel vm 0.3718f
C231 m1_1718_4540# spk 0.05336f
C232 vbp_syn sub 0.03931f
C233 vbn_prb mreset 0
C234 rsel en 0
C235 m1_2628_744# m1_3360_172# 0.1329f
C236 el a_2240_2680# 0.00905f
C237 m1_3212_6232# vm 0.08889f
C238 a_2160_3542# m1_201_2570# 0.00225f
C239 vsrc sta 0
C240 vbp_st stb 0
C241 m1_3212_6232# en 0
C242 rsel vbn_prb 0
C243 vbn_leak m1_3360_172# 0.03329f
C244 m1_3360_172# vdd 0.22891f
C245 m1_1488_2730# a_1580_2680# 0.3821f
C246 vreset a_2240_2680# 0
C247 stb a_3184_3624# 0
C248 m1_3212_6232# vbn_prb 0
C249 vm hold 0.01731f
C250 a_2240_2680# a_2510_1690# 0.03724f
C251 vsrc m1_201_2570# 0.12923f
C252 en hold 0.01271f
C253 vsrc aux 0.03389f
C254 a_2160_3542# sub_b 0.07333f
C255 vbn_prb hold 0.04752f
C256 m1_1488_2730# m1_2240_4440# 0.00737f
C257 m1_4902_6422# spk 0.00122f
C258 vm m1_3360_172# 0.18656f
C259 vsrc sub_b 0.06872f
C260 a_2804_3624# m1_201_2570# 0
C261 m1_1718_4540# sub 0.0539f
C262 en m1_3360_172# 0.08313f
C263 vbp_syn stb 0
C264 m1_3652_6232# sta 0.10353f
C265 a_2160_3542# rsel 0.21896f
C266 vbn_prb m1_3360_172# 0.03484f
C267 vsrc mreset 0.01108f
C268 a_1580_2680# m1_2240_4440# 0.07048f
C269 m1_1488_2730# m1_2628_744# 0.0273f
C270 el sta 0
C271 a_2804_3624# sub_b 0.03969f
C272 vsrc rsel 0.22141f
C273 m1_3652_6232# aux 0.02385f
C274 a_480_5620# m1_201_2570# 0.08732f
C275 vbn_leak m1_1488_2730# 0.19614f
C276 m1_1488_2730# vdd 0.37815f
C277 vsrc m1_3212_6232# 0
C278 vreset sta 0
C279 el m1_201_2570# 0.12069f
C280 vbn_ref m1_4902_6422# 0.10444f
C281 a_280_2680# spk 0.11951f
C282 a_2510_1690# sta 0
C283 el aux 1.56834f
C284 m1_3652_6232# sub_b 0.01288f
C285 vreset m1_201_2570# 0
C286 vbn_ref spk 0
C287 m1_2960_1600# aux 0
C288 vsrc hold 0.03328f
C289 a_2804_3624# rsel 0.02029f
C290 vbp_syn a_2240_2680# 0
C291 a_480_5620# sub_b 0.33746f
C292 vreset aux 0.0361f
C293 m1_201_2570# a_2510_1690# 0.08475f
C294 sub spk 0.25583f
C295 m1_3652_6232# mreset 0.0013f
C296 el sub_b 0.17283f
C297 a_2510_1690# aux 0.09417f
C298 vbn_leak a_1580_2680# 0.00187f
C299 vdd a_1580_2680# 0.48329f
C300 m1_1488_2730# vm 0.18122f
C301 m1_201_2570# abus 0.00186f
C302 m1_1488_2730# en 0.00314f
C303 a_480_5620# mreset 0
C304 a_3844_4734# m1_201_2570# 0
C305 vreset sub_b 0.0049f
C306 abus aux 0.03883f
C307 vbp_st sta 0.00277f
C308 vsrc m1_3360_172# 0.02775f
C309 a_3844_4734# aux 0
C310 el mreset 0.03288f
C311 m1_1488_2730# vbn_prb 0.01369f
C312 m1_3652_6232# m1_3212_6232# 0.66309f
C313 sub_b a_2510_1690# 0.27296f
C314 a_480_5620# rsel 0.27338f
C315 m1_4822_412# aux 0.00143f
C316 vbn_leak m1_2240_4440# 0
C317 vdd m1_2240_4440# 0.44514f
C318 el rsel 0
C319 vbp_st m1_201_2570# 0
C320 vreset mreset 0
C321 sub_b abus 0.02984f
C322 m1_2960_1600# rsel 0.11519f
C323 vm a_1580_2680# 0.19769f
C324 m1_4822_1769# m1_201_2570# 0
C325 vbp_st aux 0.02155f
C326 a_3844_4734# sub_b 0.005f
C327 m1_3652_6232# hold 0.00346f
C328 m1_3212_6232# el 0.01042f
C329 a_2510_1690# mreset 0.09399f
C330 vbn_ref sub 0
C331 vreset rsel 0.00231f
C332 m1_4822_1769# aux 0
C333 a_480_5620# hold 0.00665f
C334 rsel a_2510_1690# 0.21145f
C335 abus mreset 0
C336 stb spk 0.00986f
C337 el hold 0.02529f
C338 vbp_st sub_b 0.15807f
C339 m1_3212_6232# a_2510_1690# 0
C340 vm m1_2240_4440# 0.00275f
C341 vbn_leak m1_2628_744# 0.04514f
C342 m1_2628_744# vdd 0.19146f
C343 rsel abus 0.08061f
C344 vbp_syn sta 0.07848f
C345 m1_4822_1769# sub_b 0
C346 sub_b a_3184_3624# 0
C347 vreset hold 0.00201f
C348 a_2160_3542# m1_1488_2730# 0.19938f
C349 vbn_prb m1_2240_4440# 0
C350 vbn_leak vdd 0.15089f
C351 a_3844_4734# m1_3212_6232# 0
C352 vbp_st mreset 0.00984f
C353 a_2510_1690# hold 0.18984f
C354 vbp_syn m1_201_2570# 0.06802f
C355 el m1_3360_172# 0.05451f
C356 a_3184_3624# mreset 0.00206f
C357 vbp_st rsel 0
C358 vbp_syn aux 0.11402f
C359 vsrc m1_1488_2730# 0.18811f
C360 abus hold 0
C361 m1_2960_1600# m1_3360_172# 0.08657f
C362 m1_4822_1769# rsel 0
C363 vbp_st m1_3212_6232# 0.00176f
C364 vreset m1_3360_172# 0.03481f
C365 vm m1_2628_744# 0.49604f
C366 rsel a_3184_3624# 0.00646f
C367 m1_2628_744# en 0.08127f
C368 a_2510_1690# m1_3360_172# 0.0071f
C369 a_2160_3542# a_1580_2680# 0.32577f
C370 m1_3212_6232# a_3184_3624# 0
C371 a_2240_2680# spk 0.04938f
C372 vbp_syn sub_b 0.4792f
C373 vbn_leak vm 0.00247f
C374 stb sub 0.01704f
C375 vm vdd 0.94498f
C376 m1_2628_744# vbn_prb 0.14938f
C377 vbn_leak en 0
C378 vbp_st hold 0.02959f
C379 en vdd 0.15838f
C380 abus m1_3360_172# 0.15119f
C381 m1_1488_2730# a_2804_3624# 0.14328f
C382 vsrc a_1580_2680# 0.15071f
C383 vbn_leak vbn_prb 0.0015f
C384 vbp_syn mreset 0.0342f
C385 vbn_prb vdd 0.09291f
C386 a_2160_3542# m1_2240_4440# 0.0555f
C387 m1_4822_412# m1_3360_172# 0.05008f
C388 vbp_syn rsel 0.02174f
C389 vbp_st m1_3360_172# 0.02934f
C390 m1_1718_4540# aux 0
C391 vsrc m1_2240_4440# 0
C392 vbp_syn m1_3212_6232# -0.00147f
C393 a_480_5620# m1_1488_2730# 0.08565f
C394 vm en 0
C395 a_2804_3624# a_1580_2680# 0.13276f
C396 m1_1488_2730# el 0.2539f
C397 vm vbn_prb 0
C398 m1_1718_4540# sub_b 0.16494f
C399 a_2240_2680# sub 0
C400 vbp_syn hold 0.13799f
C401 m1_2960_1600# m1_1488_2730# 0.00809f
C402 en vbn_prb 0.01283f
C403 m1_4902_6422# sta 0
C404 vreset m1_1488_2730# 0.01376f
C405 a_2804_3624# m1_2240_4440# 0.08526f
C406 m1_1488_2730# a_2510_1690# 0.47586f
C407 a_2160_3542# vdd 0.32369f
C408 m1_1718_4540# mreset 0.00358f
C409 vsrc m1_2628_744# 0.03125f
C410 a_480_5620# a_1580_2680# 0.23086f
C411 m1_1488_2730# abus 0.09792f
C412 el a_1580_2680# 0.00865f
C413 vbp_syn m1_3360_172# 0.08478f
C414 m1_1718_4540# rsel 0.00952f
C415 m1_4902_6422# aux 0.00196f
C416 vsrc vbn_leak 1.74027f
C417 m1_201_2570# spk 0.1018f
C418 a_3844_4734# m1_1488_2730# 0.03751f
C419 vsrc vdd 0.18899f
C420 spk aux 0
C421 a_480_5620# m1_2240_4440# 0.00851f
C422 a_2510_1690# a_1580_2680# 0.00426f
C423 sub_b m1_4902_6422# 0
C424 a_2160_3542# vm 0.11974f
C425 el m1_2240_4440# 0
C426 vbp_st m1_1488_2730# 0.02527f
C427 m1_1718_4540# hold 0
C428 m1_4822_1769# m1_1488_2730# 0.02366f
C429 sub_b spk 0.17918f
C430 a_2804_3624# vdd 0.43486f
C431 m1_1488_2730# a_3184_3624# 0.14302f
C432 vbn_ref sta 0
C433 vsrc vm 0.1043f
C434 a_280_2680# m1_201_2570# 0.11555f
C435 a_2510_1690# m1_2240_4440# 0.06009f
C436 vsrc en 0.00106f
C437 spk mreset 0.1731f
C438 vbn_ref m1_201_2570# 0
C439 m1_3652_6232# vbn_leak 0.0109f
C440 vsrc vbn_prb 0.01627f
C441 m1_3652_6232# vdd 0.29263f
C442 vbp_st a_1580_2680# 0.0086f
C443 m1_3212_6232# m1_4902_6422# -0.01072f
C444 vbn_ref aux 0
C445 el m1_2628_744# 0.11105f
C446 a_3844_4734# m1_2240_4440# 0.0018f
C447 m1_201_2570# sub 0.0616f
C448 rsel spk 0.1963f
C449 a_480_5620# vbn_leak 0
C450 a_480_5620# vdd 1.56095f
C451 m1_2960_1600# m1_2628_744# 0.05164f
C452 a_2804_3624# vm 0
C453 a_3184_3624# a_1580_2680# 0.0283f
C454 sub aux 0
C455 m1_3212_6232# spk 0.00407f
C456 vbn_leak el 0.02925f
C457 vreset m1_2628_744# 0.18075f
C458 vbp_syn m1_1488_2730# 0.10351f
C459 el vdd 2.06015f
C460 m1_4902_6422# hold 0.05238f
C461 vbn_ref sub_b 0.03329f
C462 m1_2628_744# a_2510_1690# 0.14796f
C463 m1_2960_1600# vbn_leak 0
C464 m1_2960_1600# vdd 0.00207f
C465 vbp_st m1_2240_4440# 0.14072f
C466 vbn_leak vreset 0.03641f
C467 vreset vdd 0.29271f
C468 sub_b sub 0.10076f
C469 spk hold 0.22515f
C470 a_3184_3624# m1_2240_4440# 0.12559f
C471 m1_3652_6232# vm 0.02961f
C472 m1_2628_744# abus 0.13326f
C473 vbn_leak a_2510_1690# 0.58648f
C474 a_2510_1690# vdd 1.53091f
C475 vbn_ref mreset 0
C476 a_480_5620# vm 0.47112f
C477 stb sta 0.01596f
C478 vbn_leak abus 0.04197f
C479 m1_3652_6232# vbn_prb 0
C480 sub mreset 0.13608f
C481 abus vdd 0.25158f
C482 vsrc a_2160_3542# 0.30936f
C483 vbn_ref rsel 0
C484 vbp_syn a_1580_2680# 0
C485 el vm 0.61818f
C486 vbn_leak a_3844_4734# 0.00103f
C487 a_3844_4734# vdd 0.38687f
C488 el en 0
C489 m1_2960_1600# vm 0.024f
C490 vbn_leak m1_4822_412# 0.00239f
C491 m1_3212_6232# vbn_ref 0
C492 m1_4822_412# vdd 0.01221f
C493 vbp_st m1_2628_744# 0.03977f
C494 rsel sub 0.47161f
C495 vreset vm 0.20509f
C496 m1_2960_1600# en 0
C497 el vbn_prb 0
C498 m1_4822_1769# m1_2628_744# 0.01745f
C499 vreset en 1.61245f
C500 m1_3212_6232# sub 0
C501 m1_1718_4540# m1_1488_2730# 0
C502 vm a_2510_1690# 0.34142f
C503 m1_2960_1600# vbn_prb 0
C504 vbp_syn m1_2240_4440# 0.04769f
C505 vbp_st vbn_leak 0.02687f
C506 vbp_st vdd 1.09023f
C507 en a_2510_1690# 0.29696f
C508 vbn_ref hold 0.0472f
C509 a_2160_3542# a_2804_3624# 0.13928f
C510 vreset vbn_prb 0.05149f
C511 vbn_leak m1_4822_1769# 0.00155f
C512 vbn_leak a_3184_3624# 0.00144f
C513 vm abus 0.07513f
C514 a_3184_3624# vdd 0.41259f
C515 a_2510_1690# vbn_prb 0.14099f
C516 sub hold 0.14315f
C517 en abus 0.04443f
C518 stb sub_b 0.0013f
C519 a_3844_4734# vm 0
C520 a_3844_4734# en 0
C521 vm m1_4822_412# 0
C522 vsrc a_2804_3624# 0.10017f
C523 vbn_prb abus 0.0564f
C524 en m1_4822_412# 0.0834f
C525 a_3844_4734# vbn_prb 0
C526 vbn_ref m1_3360_172# 0.03584f
C527 m1_1718_4540# a_1580_2680# 0.17044f
C528 stb mreset 0.09603f
C529 vbp_st vm 0.0073f
C530 m1_4822_412# vbn_prb 0.0725f
C531 vbp_syn m1_2628_744# 0.07412f
C532 a_480_5620# a_2160_3542# 0.05739f
C533 vbp_st en 0
C534 sub m1_3360_172# 0.00241f
C535 m1_201_2570# a_2240_2680# 0.19117f
C536 a_2160_3542# el 0
C537 vm a_3184_3624# 0
C538 vsrc m1_3652_6232# 0.00246f
C539 stb rsel 0.03704f
C540 m1_4822_1769# en 0.0872f
C541 vbn_leak vbp_syn 0.20128f
C542 vbp_st vbn_prb 1.63795f
C543 vbp_syn vdd 2.79662f
C544 m1_1718_4540# m1_2240_4440# 0.03422f
C545 m1_3212_6232# stb 0.09451f
C546 a_480_5620# vsrc 0.03752f
C547 m1_4822_1769# vbn_prb 0.12869f
C548 m1_1488_2730# spk 0.33652f
C549 vsrc el 0.03446f
C550 a_2160_3542# a_2510_1690# 0
C551 vsrc m1_2960_1600# 0
C552 sub_b a_2240_2680# 0.00135f
C553 stb hold 0.02143f
C554 vsrc vreset 0.03646f
C555 a_3844_4734# a_2160_3542# 0
C556 a_480_5620# a_2804_3624# 0.00276f
C557 vsrc a_2510_1690# 0.15452f
C558 vbp_syn vm 0.14165f
C559 vbp_syn en 0
C560 a_2804_3624# el 0
C561 spk a_1580_2680# 0.11712f
C562 vsrc abus 0.07023f
C563 rsel a_2240_2680# 0.00313f
C564 vsrc a_3844_4734# 0
C565 vbp_syn vbn_prb 0.06039f
C566 m1_1718_4540# vdd 0.25165f
C567 m1_1488_2730# vbn_ref 0.21198f
C568 vsrc m1_4822_412# 0.00459f
C569 aux vss 0.29196f
C570 m1_3360_172# vss 0.89115f
C571 abus vss 2.18325f
C572 sub vss 0.37721f
C573 mreset vss 1.09257f
C574 hold vss 1.38611f
C575 vdd vss 18.1185f
C576 m1_4822_412# vss 0.26647f
C577 en vss 0.54375f
C578 vbn_prb vss 0.77308f
C579 a_3184_3624# vss 0.2016f
C580 a_2804_3624# vss 0.20892f
C581 spk vss 1.06621f
C582 m1_2960_1600# vss -0.05443f
C583 rsel vss 0.83328f
C584 m1_2240_4440# vss -0.06692f
C585 vm vss 3.52117f
C586 sub_b vss 1.04727f
C587 vbp_st vss 0.29583f
C588 m1_3212_6232# vss 0.13993f
C589 stb vss 0.24581f
C590 a_2240_2680# vss 0.39475f
C591 sta vss 0.13038f
C592 m1_201_2570# vss 0.21664f
C593 m1_2628_744# vss 0.67448f
C594 a_2160_3542# vss 0.27761f
C595 vsrc vss 0.83269f
C596 vreset vss 0.50371f
C597 a_2510_1690# vss 2.51226f
C598 m1_4822_1769# vss 0.0698f
C599 m1_1718_4540# vss -0.06227f
C600 vbn_ref vss 0.58532f
C601 a_1580_2680# vss 0.3611f
C602 a_3844_4734# vss 0.00638f
C603 m1_4902_6422# vss -0.19031f
C604 m1_3652_6232# vss -0.05093f
C605 vbp_syn vss 0.2429f
C606 a_280_2680# vss 0.08104f
C607 el vss 0.88345f
C608 vbn_leak vss 0.78284f
C609 m1_1488_2730# vss 2.35603f
C610 a_480_5620# vss 0.08396f
.ends
