* NGSPICE file created from slot_ah.ext - technology: gf180mcuD

.subckt p_w2_l4 a_400_n200# a_n400_n244# w_n574_n330# a_n488_n200# VSUBS
X0 a_400_n200# a_n400_n244# a_n488_n200# w_n574_n330# pfet_03v3 ad=0.88p pd=4.88u as=0.88p ps=4.88u w=2u l=4u
C0 a_n400_n244# a_400_n200# 0.07019f
C1 a_n488_n200# w_n574_n330# 0.07409f
C2 a_n488_n200# a_n400_n244# 0.07019f
C3 a_n400_n244# w_n574_n330# 0.42229f
C4 a_n488_n200# a_400_n200# 0.01073f
C5 w_n574_n330# a_400_n200# 0.07409f
C6 a_400_n200# VSUBS 0.18936f
C7 a_n488_n200# VSUBS 0.18936f
C8 w_n574_n330# VSUBS 2.27304f
.ends

.subckt p_w0p22_l1 a_100_n22# a_n100_n66# w_n278_n159# a_n192_n36# VSUBS
X0 a_100_n22# a_n100_n66# a_n192_n36# w_n278_n159# pfet_03v3 ad=0.1516p pd=1.64u as=0.1516p ps=1.64u w=0.22u l=1u
C0 a_n192_n36# a_100_n22# 0.00453f
C1 a_n100_n66# w_n278_n159# 0.13163f
C2 a_n100_n66# a_n192_n36# 0.00509f
C3 a_n192_n36# w_n278_n159# 0.00771f
C4 a_n100_n66# a_100_n22# 0.00509f
C5 w_n278_n159# a_100_n22# 0.00771f
C6 a_100_n22# VSUBS 0.05952f
C7 a_n192_n36# VSUBS 0.05952f
C8 w_n278_n159# VSUBS 0.53042f
.ends

.subckt n_w1_l0p28 a_28_n100# a_n28_n144# a_n116_n100# VSUBS
X0 a_28_n100# a_n28_n144# a_n116_n100# VSUBS nfet_03v3 ad=0.44p pd=2.88u as=0.44p ps=2.88u w=1u l=0.28u
C0 a_28_n100# a_n28_n144# 0.00769f
C1 a_28_n100# a_n116_n100# 0.04256f
C2 a_n116_n100# a_n28_n144# 0.00769f
C3 a_28_n100# VSUBS 0.09911f
C4 a_n116_n100# VSUBS 0.09911f
.ends

.subckt n_w2_l2 a_n288_n200# a_200_n200# a_n200_n244# VSUBS
X0 a_200_n200# a_n200_n244# a_n288_n200# VSUBS nfet_03v3 ad=0.88p pd=4.88u as=0.88p ps=4.88u w=2u l=2u
C0 a_200_n200# a_n200_n244# 0.0587f
C1 a_200_n200# a_n288_n200# 0.02133f
C2 a_n288_n200# a_n200_n244# 0.0587f
C3 a_200_n200# VSUBS 0.2667f
C4 a_n288_n200# VSUBS 0.2667f
.ends

.subckt n_w2_l4 a_400_n200# a_n400_n244# a_n488_n200# VSUBS
X0 a_400_n200# a_n400_n244# a_n488_n200# VSUBS nfet_03v3 ad=0.88p pd=4.88u as=0.88p ps=4.88u w=2u l=4u
C0 a_400_n200# a_n400_n244# 0.07019f
C1 a_400_n200# a_n488_n200# 0.01073f
C2 a_n488_n200# a_n400_n244# 0.07019f
C3 a_400_n200# VSUBS 0.41684f
C4 a_n488_n200# VSUBS 0.41684f
.ends

.subckt n_w4_l1 a_n188_n400# a_100_n400# a_n100_n444# VSUBS
X0 a_100_n400# a_n100_n444# a_n188_n400# VSUBS nfet_03v3 ad=1.76p pd=8.88u as=1.76p ps=8.88u w=4u l=1u
C0 a_100_n400# a_n100_n444# 0.08505f
C1 a_100_n400# a_n188_n400# 0.07756f
C2 a_n188_n400# a_n100_n444# 0.08505f
C3 a_100_n400# VSUBS 0.26859f
C4 a_n188_n400# VSUBS 0.26859f
.ends

.subckt n_w0p5_l0p28 a_n28_n94# a_n116_n50# a_28_n50# VSUBS
X0 a_28_n50# a_n28_n94# a_n116_n50# VSUBS nfet_03v3 ad=0.22p pd=1.88u as=0.22p ps=1.88u w=0.5u l=0.28u
C0 a_28_n50# a_n28_n94# 0.00377f
C1 a_28_n50# a_n116_n50# 0.02085f
C2 a_n116_n50# a_n28_n94# 0.00377f
C3 a_28_n50# VSUBS 0.07987f
C4 a_n116_n50# VSUBS 0.07987f
.ends

.subckt p_w1_l0p5 a_n138_n100# a_50_n100# a_n50_n144# w_n224_n230# VSUBS
X0 a_50_n100# a_n50_n144# a_n138_n100# w_n224_n230# pfet_03v3 ad=0.44p pd=2.88u as=0.44p ps=2.88u w=1u l=0.5u
C0 a_n50_n144# a_50_n100# 0.01275f
C1 a_n138_n100# w_n224_n230# 0.0205f
C2 a_n138_n100# a_n50_n144# 0.01275f
C3 a_n50_n144# w_n224_n230# 0.07993f
C4 a_n138_n100# a_50_n100# 0.03085f
C5 w_n224_n230# a_50_n100# 0.0205f
C6 a_50_n100# VSUBS 0.06546f
C7 a_n138_n100# VSUBS 0.06546f
C8 w_n224_n230# VSUBS 0.61824f
.ends

.subckt n_w0p5_l0p5 a_n138_n50# a_50_n50# a_n50_n94# VSUBS
X0 a_50_n50# a_n50_n94# a_n138_n50# VSUBS nfet_03v3 ad=0.22p pd=1.88u as=0.22p ps=1.88u w=0.5u l=0.5u
C0 a_50_n50# a_n50_n94# 0.00625f
C1 a_50_n50# a_n138_n50# 0.01511f
C2 a_n138_n50# a_n50_n94# 0.00625f
C3 a_50_n50# VSUBS 0.09639f
C4 a_n138_n50# VSUBS 0.09639f
.ends

.subckt p_w1_l0p28 w_n202_n230# a_28_n100# a_n28_n144# a_n116_n100# VSUBS
X0 a_28_n100# a_n28_n144# a_n116_n100# w_n202_n230# pfet_03v3 ad=0.44p pd=2.88u as=0.44p ps=2.88u w=1u l=0.28u
C0 a_n28_n144# a_28_n100# 0.00769f
C1 a_n116_n100# w_n202_n230# 0.01808f
C2 a_n116_n100# a_n28_n144# 0.00769f
C3 a_n28_n144# w_n202_n230# 0.05841f
C4 a_n116_n100# a_28_n100# 0.04256f
C5 w_n202_n230# a_28_n100# 0.01808f
C6 a_28_n100# VSUBS 0.0597f
C7 a_n116_n100# VSUBS 0.0597f
C8 w_n202_n230# VSUBS 0.55752f
.ends

.subckt n_w1_l0p5 a_n138_n100# a_50_n100# a_n50_n144# VSUBS
X0 a_50_n100# a_n50_n144# a_n138_n100# VSUBS nfet_03v3 ad=0.44p pd=2.88u as=0.44p ps=2.88u w=1u l=0.5u
C0 a_50_n100# a_n50_n144# 0.01275f
C1 a_50_n100# a_n138_n100# 0.03085f
C2 a_n138_n100# a_n50_n144# 0.01275f
C3 a_50_n100# VSUBS 0.11563f
C4 a_n138_n100# VSUBS 0.11563f
.ends

.subckt n_w4_l2 a_n288_n400# a_200_n400# a_n200_n444# VSUBS
X0 a_200_n400# a_n200_n444# a_n288_n400# VSUBS nfet_03v3 ad=1.76p pd=8.88u as=1.76p ps=8.88u w=4u l=2u
C0 a_200_n400# a_n200_n444# 0.11799f
C1 a_200_n400# a_n288_n400# 0.04287f
C2 a_n288_n400# a_n200_n444# 0.11799f
C3 a_200_n400# VSUBS 0.34365f
C4 a_n288_n400# VSUBS 0.34365f
.ends

.subckt p_w1_l2 w_n374_n230# a_n288_n100# a_200_n100# a_n200_n144# VSUBS
X0 a_200_n100# a_n200_n144# a_n288_n100# w_n374_n230# pfet_03v3 ad=0.44p pd=2.88u as=0.44p ps=2.88u w=1u l=2u
C0 a_n200_n144# a_200_n100# 0.02905f
C1 a_n288_n100# w_n374_n230# 0.03135f
C2 a_n288_n100# a_n200_n144# 0.02905f
C3 a_n200_n144# w_n374_n230# 0.22666f
C4 a_n288_n100# a_200_n100# 0.01056f
C5 w_n374_n230# a_200_n100# 0.03135f
C6 a_200_n100# VSUBS 0.1047f
C7 a_n288_n100# VSUBS 0.1047f
C8 w_n374_n230# VSUBS 1.03224f
.ends

.subckt n_w7p07_l7p07 a_707_n707# a_n795_n707# a_n707_n751# VSUBS
X0 a_707_n707# a_n707_n751# a_n795_n707# VSUBS nfet_03v3 ad=3.1108p pd=15.02u as=3.1108p ps=15.02u w=7.07u l=7.07u
C0 a_707_n707# a_n707_n751# 0.27012f
C1 a_707_n707# a_n795_n707# 0.0212f
C2 a_n795_n707# a_n707_n751# 0.27012f
C3 a_707_n707# VSUBS 0.84237f
C4 a_n795_n707# VSUBS 0.84237f
.ends

.subckt n_w3p54_l3p54 a_354_n354# a_n354_n398# a_n442_n354# VSUBS
X0 a_354_n354# a_n354_n398# a_n442_n354# VSUBS nfet_03v3 ad=1.5576p pd=7.96u as=1.5576p ps=7.96u w=3.54u l=3.54u
C0 a_354_n354# a_n354_n398# 0.12189f
C1 a_354_n354# a_n442_n354# 0.02161f
C2 a_n442_n354# a_n354_n398# 0.12189f
C3 a_354_n354# VSUBS 0.44156f
C4 a_n442_n354# VSUBS 0.44156f
.ends

.subckt n_w0p22_l2 a_200_n22# a_n200_n66# a_n292_n36# VSUBS
X0 a_200_n22# a_n200_n66# a_n292_n36# VSUBS nfet_03v3 ad=0.1516p pd=1.64u as=0.1516p ps=1.64u w=0.22u l=2u
C0 a_200_n22# a_n292_n36# 0.00245f
C1 a_200_n22# a_n200_n66# 0.00705f
C2 a_n200_n66# a_n292_n36# 0.00705f
C3 a_200_n22# VSUBS 0.20767f
C4 a_n292_n36# VSUBS 0.20767f
.ends

.subckt slot_ah vss vbp_syn vdd el aux vbn_leak vsrc vbp_st vbn_prb vbn_ref en vreset
+ abus spk sta stb hold mreset rsel sub sub_b vm
XXL_XP1 a_480_5620# a_480_5620# vdd vdd vss p_w2_l4
XXD_XK a_3184_3624# spk vdd vdd vss p_w0p22_l1
XXPM_XSW m1_4052_1572# rsel m1_3704_1572# vss n_w1_l0p28
XXL_XP2 a_1632_2940# a_480_5620# vdd vdd vss p_w2_l4
XXPR_XMB vss m1_4802_1762# vbn_prb vss n_w2_l2
XXL_XMT m1_201_2200# vbn_leak vss vss n_w2_l4
XXL_XM1 a_288_2940# a_480_5620# el vss n_w4_l1
XXS_XWA m1_4904_6422# vbp_syn vdd m1_3652_6232# vss p_w2_l4
XXR_Xi_XN spk vss a_3844_4734# vss n_w0p5_l0p28
XXL_XM2 a_2080_2940# a_1632_2940# a_1632_2940# vss n_w4_l1
XXS_XWB m1_4904_6422# vbp_syn vdd m1_3180_6220# vss p_w2_l4
XXR_XNR vss vbn_ref a_2510_1690# vss n_w2_l4
XXD_XPI m1_1692_4664# a_2160_3542# vm vdd vss p_w1_l0p5
XXPR_XME m1_2640_602# en m1_4802_1762# vss n_w1_l0p28
XXR_XSW vreset vm a_2510_1690# vss n_w0p5_l0p5
XXR_Xi_XP vdd a_3844_4734# spk vdd vss p_w1_l0p28
XXD_XNI vsrc a_2160_3542# vm vss n_w1_l0p5
XXPR_XMF m1_2640_602# vdd a_2510_1690# vss n_w4_l2
XXS_XQA vdd m1_3652_6232# sta vss vss p_w1_l0p28
XXS_XQB vdd m1_3180_6220# stb vss vss p_w1_l0p28
XXS_XNA sta vm m1_3652_6232# vss n_w0p5_l0p28
XXS_XNB stb vm m1_3180_6220# vss n_w0p5_l0p28
XXD_XS2 vdd vdd m1_2140_4664# vbp_st vss p_w1_l2
XXD_XPS vdd vdd m1_1692_4664# vbp_st vss p_w1_l2
XXD_XS3 vdd vdd m1_1540_4540# vbp_st vss p_w1_l2
XXL_XD2a m1_201_2200# a_2080_2940# a_2080_2940# vss n_w4_l1
XXPM_XSB abus sub_b m1_4052_1572# vss n_w1_l0p28
XXL_XD2b m1_201_2200# a_2080_2940# a_2080_2940# vss n_w4_l1
XXL_XD1a m1_201_2200# a_288_2940# a_288_2940# vss n_w4_l1
XXPM_XSC m1_3704_1572# en m1_3360_972# vss n_w1_l0p28
XXC_XC vss vss vm vss n_w7p07_l7p07
XXS_XPH vdd m1_4904_6422# vdd hold vss p_w1_l2
XXD_XP2 vdd a_2804_3624# a_2160_3542# m1_2140_4664# vss p_w1_l0p28
XXL_XD1b m1_201_2200# a_288_2940# a_288_2940# vss n_w4_l1
XXPR_XSW m1_2972_1572# rsel m1_2140_960# vss n_w1_l0p28
XXD_Xi4_XN a_3184_3624# vss spk vss n_w0p5_l0p28
XXD_XP3 vdd a_3184_3624# a_2804_3624# m1_1540_4540# vss p_w1_l0p28
XXR_XCR_XC vss a_2510_1690# vss vss n_w3p54_l3p54
XXD_XN2 a_2804_3624# a_2160_3542# vsrc vss n_w0p22_l2
XXD_Xi4_XP vdd spk a_3184_3624# vdd vss p_w1_l0p28
XXD_XN3 a_2804_3624# vsrc a_3184_3624# vss n_w0p5_l0p28
XXPM_XMB vss m1_4822_412# vbn_prb vss n_w2_l2
XXR_XPC vdd a_2510_1690# a_3844_4734# vdd vss p_w1_l0p28
XXPM_XME m1_3360_972# en m1_4822_412# vss n_w1_l0p28
XXPM_XMF m1_3360_972# vdd vm vss n_w4_l2
XXS_XHL vdd vm hold a_1632_2940# vss p_w1_l0p28
XXS_XMR mreset a_2510_1690# vdd vss n_w0p5_l0p28
XXPR_XSB abus sub m1_2972_1572# vss n_w1_l0p28
XXPR_XSC m1_2640_602# en m1_2140_960# vss n_w1_l0p28
C0 hold sta 0
C1 vbn_leak m1_4802_1762# 0
C2 vm a_1632_2940# 0.27519f
C3 m1_3652_6232# el 0.10143f
C4 vbn_leak m1_3704_1572# 0
C5 stb sub_b 0.00118f
C6 aux m1_4822_412# 0.00143f
C7 vbp_syn en 0.10087f
C8 rsel vbn_ref 0
C9 m1_201_2200# vbp_syn 0.05988f
C10 m1_3180_6220# a_1632_2940# 0
C11 rsel m1_3360_972# 0.00778f
C12 a_2080_2940# a_2160_3542# 0.00537f
C13 vbn_prb vbp_syn 0.06093f
C14 m1_2140_4664# vdd 0.2993f
C15 a_288_2940# el 0.05202f
C16 aux vdd 0.16104f
C17 vbn_leak vreset 0.03446f
C18 spk vbn_ref 0
C19 m1_4052_1572# vdd 0.01699f
C20 en m1_4822_412# 0.08724f
C21 m1_3652_6232# sub 0.00137f
C22 vm a_2080_2940# 0.1147f
C23 vbn_prb m1_4822_412# 0.05814f
C24 abus vsrc 0.09088f
C25 m1_1540_4540# m1_1692_4664# 0.07135f
C26 m1_2140_4664# sub_b 0.14205f
C27 vbp_st vsrc 1.64772f
C28 aux sub_b 0.12481f
C29 vdd en 0.45215f
C30 m1_4052_1572# sub_b 0.05166f
C31 m1_201_2200# vdd 0.02701f
C32 vbp_st abus 0.10577f
C33 vbn_prb vdd 0.1842f
C34 m1_2140_960# en 0.05087f
C35 a_2510_1690# m1_1692_4664# 0
C36 a_3844_4734# el 0.001f
C37 a_480_5620# m1_1540_4540# 0.0326f
C38 stb a_1632_2940# 0
C39 m1_3652_6232# vbn_leak 0.00205f
C40 sub_b en 0.24101f
C41 vreset m1_4802_1762# 0.00845f
C42 m1_201_2200# sub_b 0.11553f
C43 vm vbn_ref 0
C44 vbn_prb sub_b 0.119f
C45 m1_2640_602# aux 0.03314f
C46 vm m1_3360_972# 0.26792f
C47 a_2510_1690# a_480_5620# 0.00203f
C48 en m1_2972_1572# 0.02253f
C49 m1_4052_1572# m1_2640_602# 0.01867f
C50 a_2510_1690# sta 0
C51 m1_3180_6220# vbn_ref 0
C52 en m1_4904_6422# 0.00336f
C53 hold vsrc 0.02425f
C54 m1_2140_4664# a_1632_2940# 0.11502f
C55 vbp_syn mreset 0.03383f
C56 el vbp_syn 0.09845f
C57 vbn_prb m1_4904_6422# 0.08721f
C58 m1_2640_602# en 0.30684f
C59 m1_2640_602# m1_201_2200# 0
C60 abus hold 0.00388f
C61 vbp_st hold 0.03589f
C62 m1_2640_602# vbn_prb 0.14713f
C63 rsel m1_1692_4664# 0.07539f
C64 el m1_4822_412# 0
C65 a_2804_3624# m1_1692_4664# 0
C66 a_3844_4734# vbn_leak 0.00157f
C67 spk m1_1692_4664# 0.05671f
C68 m1_201_2200# a_1632_2940# 0.26961f
C69 rsel a_480_5620# 0
C70 sub vbp_syn 0.00227f
C71 rsel sta 0
C72 m1_2140_4664# a_2080_2940# 0
C73 vdd mreset 0.11809f
C74 a_3844_4734# a_3184_3624# 0.05417f
C75 el vdd 1.92231f
C76 aux a_2080_2940# 0
C77 a_2804_3624# a_480_5620# 0
C78 a_480_5620# spk 0.14915f
C79 a_2160_3542# m1_1692_4664# 0.0326f
C80 mreset sub_b 0.09014f
C81 el sub_b 0.23868f
C82 a_2080_2940# en 0
C83 m1_1540_4540# vsrc 0.0016f
C84 vbn_leak vbp_syn 0.22379f
C85 m1_201_2200# a_2080_2940# 0.6822f
C86 sub vdd 0.28028f
C87 m1_2140_4664# vbn_ref 0
C88 vm m1_1692_4664# 0.09283f
C89 a_480_5620# a_2160_3542# 0.12722f
C90 aux vbn_ref 0
C91 vbp_st m1_1540_4540# 0.01263f
C92 vbp_syn a_3184_3624# 0.00189f
C93 m1_2140_960# sub 0
C94 aux m1_3360_972# 0.03457f
C95 a_2510_1690# vsrc 0.29191f
C96 m1_4052_1572# m1_3360_972# 0
C97 vbn_leak m1_4822_412# 0.00239f
C98 m1_2640_602# el 0.0339f
C99 a_2510_1690# abus 0.00813f
C100 sub sub_b 0.1011f
C101 vm a_480_5620# 0.83484f
C102 a_2510_1690# vbp_st 0.31944f
C103 vm sta 0.05833f
C104 a_3844_4734# vreset 0
C105 en vbn_ref 1.68537f
C106 sub m1_2972_1572# 0.01418f
C107 vbn_leak vdd 0.13711f
C108 en m1_3360_972# 0.1569f
C109 m1_201_2200# m1_3360_972# 0.0021f
C110 vbn_prb vbn_ref 1.66024f
C111 vbn_prb m1_3360_972# 0.03286f
C112 m1_3180_6220# sta 0.03816f
C113 el a_1632_2940# 0.09653f
C114 vdd a_3184_3624# 0.42754f
C115 vbp_syn m1_3704_1572# 0.03933f
C116 m1_2640_602# sub 0.00214f
C117 vbn_leak sub_b 0.29795f
C118 vbn_leak m1_2972_1572# 0
C119 rsel vsrc 0.08957f
C120 stb m1_1692_4664# 0
C121 sub_b a_3184_3624# 0.12908f
C122 vreset vbp_syn 0.03961f
C123 a_2510_1690# hold 0
C124 rsel abus 0.0828f
C125 a_2804_3624# vsrc 0.14693f
C126 vbn_leak m1_4904_6422# 0
C127 spk vsrc 0.11255f
C128 sub a_1632_2940# 0.44484f
C129 rsel vbp_st 0.09011f
C130 el a_2080_2940# 0.16835f
C131 m1_3704_1572# vdd 0.03616f
C132 m1_2640_602# vbn_leak 0.04496f
C133 stb sta 0.02949f
C134 vreset m1_4822_412# 0.01742f
C135 abus spk 0.01131f
C136 a_2804_3624# vbp_st 0.00333f
C137 vbp_st spk 0.21711f
C138 m1_4802_1762# sub_b 0.00454f
C139 m1_2140_4664# m1_1692_4664# 0.14583f
C140 vreset vdd 0.33156f
C141 a_2160_3542# vsrc 0.26287f
C142 m1_3652_6232# vbp_syn 0.22754f
C143 vbn_leak a_1632_2940# 0
C144 m1_2140_960# vreset 0.11755f
C145 sub a_2080_2940# 0.07737f
C146 mreset vbn_ref 0
C147 el vbn_ref 0
C148 vbp_st a_2160_3542# 0.00533f
C149 m1_2140_4664# a_480_5620# 0.00992f
C150 a_1632_2940# a_3184_3624# 0
C151 m1_2140_4664# sta 0
C152 el m1_3360_972# 0.02651f
C153 vm vsrc 0.15168f
C154 vreset sub_b 0.26367f
C155 rsel hold 0.05628f
C156 aux sta 0
C157 m1_2640_602# m1_4802_1762# 0.0272f
C158 vreset m1_2972_1572# 0
C159 vm abus 0.00677f
C160 m1_2640_602# m1_3704_1572# 0.02628f
C161 vm vbp_st 0.19962f
C162 spk hold 0.24816f
C163 m1_3180_6220# vsrc 0
C164 a_2510_1690# m1_1540_4540# 0.00589f
C165 vbn_leak a_2080_2940# 0.00409f
C166 m1_3652_6232# vdd 0.25748f
C167 m1_201_2200# a_480_5620# 0.00963f
C168 en sta 0
C169 m1_3180_6220# vbp_st 0.01354f
C170 sub m1_3360_972# 0.00155f
C171 m1_2640_602# vreset 0.11656f
C172 vbn_prb sta 0
C173 a_288_2940# vdd 0.00176f
C174 a_3844_4734# vbp_syn 0.13161f
C175 m1_3652_6232# sub_b 0.00414f
C176 vbn_leak vbn_ref 0.0145f
C177 vm hold 0.03621f
C178 vbn_leak m1_3360_972# 0.03536f
C179 m1_3652_6232# m1_4904_6422# -0.01073f
C180 a_3184_3624# vbn_ref 0
C181 stb vbp_st 0.00351f
C182 a_3844_4734# vdd 0.43062f
C183 m1_3180_6220# hold 0
C184 a_2804_3624# m1_1540_4540# 0.15471f
C185 m1_1540_4540# spk -0
C186 rsel a_2510_1690# 0.16272f
C187 vreset a_2080_2940# 0.00126f
C188 m1_2140_4664# vsrc 0
C189 a_2804_3624# a_2510_1690# 0.09512f
C190 a_3844_4734# sub_b 0.00486f
C191 aux vsrc 0.04529f
C192 a_2510_1690# spk 0.18444f
C193 m1_4802_1762# vbn_ref 0.07537f
C194 el a_480_5620# 0.13481f
C195 m1_2140_4664# vbp_st 0.27428f
C196 aux abus 0.03113f
C197 m1_1540_4540# a_2160_3542# 0.03949f
C198 mreset sta 0.02438f
C199 m1_3704_1572# m1_3360_972# 0
C200 aux vbp_st 0.03954f
C201 el sta 0
C202 m1_4052_1572# abus 0.00116f
C203 vbp_syn vdd 2.82267f
C204 stb hold 0.00154f
C205 sub m1_1692_4664# 0.02906f
C206 en vsrc 0.03078f
C207 m1_201_2200# vsrc 0.0364f
C208 a_2510_1690# a_2160_3542# 0.06587f
C209 vreset vbn_ref 0.04811f
C210 vbn_prb vsrc 0.01361f
C211 vm m1_1540_4540# 0.03719f
C212 vreset m1_3360_972# 0.05323f
C213 abus en 0.44921f
C214 vdd m1_4822_412# 0.01261f
C215 m1_201_2200# abus 0
C216 vbp_st en 0.031f
C217 vbp_syn sub_b 0.25216f
C218 vbn_prb abus 0.33655f
C219 sub a_480_5620# 0.0079f
C220 vbn_prb vbp_st 1.63176f
C221 sub sta 0
C222 vm a_2510_1690# 0.47457f
C223 a_2804_3624# rsel 0.08183f
C224 a_288_2940# a_2080_2940# 0.00401f
C225 rsel spk 0.51321f
C226 vbp_syn m1_4904_6422# 0.2248f
C227 aux hold 0.01944f
C228 a_2804_3624# spk 0.02342f
C229 m1_3180_6220# a_2510_1690# 0.00157f
C230 a_3184_3624# m1_1692_4664# 0.00223f
C231 m1_2640_602# vbp_syn 0.05449f
C232 vbn_leak a_480_5620# 0
C233 vdd sub_b 1.14338f
C234 vbn_leak sta 0
C235 rsel a_2160_3542# 0
C236 vdd m1_2972_1572# 0.00535f
C237 en hold 0.03737f
C238 a_2804_3624# a_2160_3542# 0.06266f
C239 vbn_prb hold 0.07144f
C240 m1_2140_960# m1_2972_1572# 0.00162f
C241 a_2160_3542# spk 0
C242 vdd m1_4904_6422# 0.39327f
C243 vm rsel 0.07063f
C244 m1_2640_602# vdd 0.10691f
C245 mreset vsrc 0.01114f
C246 a_2804_3624# vm 0
C247 el vsrc 0.06255f
C248 vm spk 8.22299f
C249 m1_2140_960# m1_2640_602# 0.01327f
C250 m1_3180_6220# rsel 0.01496f
C251 sub_b m1_4904_6422# 0.00241f
C252 mreset abus 0
C253 el abus 0.03241f
C254 vbp_st mreset 0.00245f
C255 el vbp_st 0.04345f
C256 m1_2640_602# sub_b 0.00954f
C257 m1_2140_4664# m1_1540_4540# 0.05577f
C258 a_3844_4734# vbn_ref 0
C259 vbp_syn a_2080_2940# 0
C260 vdd a_1632_2940# 0.41284f
C261 m1_3180_6220# spk 0.01619f
C262 m1_2640_602# m1_2972_1572# 0.00236f
C263 vm a_2160_3542# 0.21251f
C264 sub vsrc 0.12218f
C265 a_2510_1690# m1_2140_4664# 0.00588f
C266 vreset sta 0
C267 a_2510_1690# aux 0.21391f
C268 m1_4052_1572# a_2510_1690# 0
C269 sub_b a_1632_2940# 0.16815f
C270 sub abus 0.00339f
C271 m1_201_2200# m1_1540_4540# 0
C272 sub vbp_st 0.05327f
C273 stb rsel 0.09729f
C274 vbp_syn vbn_ref 0.00547f
C275 vdd a_2080_2940# 0.00115f
C276 vbp_syn m1_3360_972# 0.05782f
C277 mreset hold 0.11335f
C278 a_2510_1690# en 0.13159f
C279 el hold 0.0208f
C280 a_2510_1690# m1_201_2200# 0.15806f
C281 stb spk 0.00565f
C282 vbn_leak vsrc 1.64135f
C283 m1_2140_960# a_2080_2940# 0
C284 m1_3180_6220# vm 0.25785f
C285 a_2510_1690# vbn_prb 0.14319f
C286 vbn_leak abus 0.13221f
C287 m1_4822_412# vbn_ref 0.07762f
C288 a_3184_3624# vsrc 0.05605f
C289 a_2080_2940# sub_b 0.00114f
C290 vbn_leak vbp_st 0.03992f
C291 m1_3652_6232# sta 0.14887f
C292 m1_4822_412# m1_3360_972# 0.05008f
C293 rsel m1_2140_4664# 0.06201f
C294 rsel aux 0
C295 vbp_st a_3184_3624# 0
C296 vdd vbn_ref 0.4662f
C297 m1_4052_1572# rsel 0
C298 a_288_2940# a_480_5620# -0.0037f
C299 sub hold 0.1249f
C300 a_2804_3624# m1_2140_4664# 0.01536f
C301 vdd m1_3360_972# 0.27215f
C302 m1_2140_4664# spk 0.09146f
C303 aux spk 0.00133f
C304 m1_2140_960# m1_3360_972# 0.00292f
C305 m1_2640_602# a_2080_2940# 0
C306 vm stb 0.03727f
C307 m1_4802_1762# vsrc 0
C308 rsel en 0.10557f
C309 sub_b vbn_ref 0.18018f
C310 rsel m1_201_2200# 0.14079f
C311 sub_b m1_3360_972# 0
C312 rsel vbn_prb 0
C313 m1_4802_1762# abus 0.22744f
C314 m1_4802_1762# vbp_st 0.00753f
C315 a_2804_3624# m1_201_2200# 0
C316 m1_2140_4664# a_2160_3542# 0.1085f
C317 m1_3180_6220# stb 0.13181f
C318 vbn_leak hold 0.01936f
C319 m1_3704_1572# abus 0.00133f
C320 en spk 0.04797f
C321 m1_3360_972# m1_2972_1572# 0
C322 m1_201_2200# spk 0.28054f
C323 a_2080_2940# a_1632_2940# 0.06637f
C324 vbn_prb spk 0
C325 vreset vsrc 0.03425f
C326 m1_4904_6422# vbn_ref 0.11202f
C327 m1_2640_602# vbn_ref 0.03806f
C328 vm m1_2140_4664# 0.00344f
C329 vreset abus 1.64394f
C330 a_2510_1690# mreset 0.22173f
C331 m1_2640_602# m1_3360_972# 0.09799f
C332 el a_2510_1690# 0.22717f
C333 vm aux 0
C334 vreset vbp_st 0.03433f
C335 vm m1_4052_1572# 0
C336 m1_201_2200# a_2160_3542# 0.00475f
C337 m1_3180_6220# m1_2140_4664# 0.01335f
C338 sub m1_1540_4540# 0.06615f
C339 m1_3180_6220# aux 0
C340 vbp_syn a_480_5620# 0
C341 vm en 0.10609f
C342 vm m1_201_2200# 0.21971f
C343 vbp_syn sta 0.0927f
C344 m1_3652_6232# vsrc 0
C345 vm vbn_prb 0
C346 sub a_2510_1690# 0.16365f
C347 vdd m1_1692_4664# 0.32667f
C348 m1_3652_6232# vbp_st 0
C349 m1_3180_6220# vbn_prb 0
C350 vreset hold 0.00942f
C351 rsel mreset 0.00118f
C352 rsel el 0.03351f
C353 stb m1_2140_4664# 0
C354 m1_1540_4540# a_3184_3624# 0.00293f
C355 a_288_2940# vbp_st 0
C356 vdd a_480_5620# 1.60653f
C357 sub_b m1_1692_4664# 0.02992f
C358 a_2804_3624# el 0.00393f
C359 mreset spk 0.17513f
C360 vdd sta 0.12556f
C361 vbn_leak a_2510_1690# 0.21754f
C362 el spk 0.29791f
C363 a_2510_1690# a_3184_3624# 0.0914f
C364 a_480_5620# sub_b 0.58209f
C365 rsel sub 0.31264f
C366 sub_b sta 0.00201f
C367 a_3844_4734# vsrc 0.03493f
C368 el a_2160_3542# 0
C369 a_2804_3624# sub 0.22845f
C370 a_3844_4734# abus 0
C371 m1_3360_972# vbn_ref 0.03584f
C372 m1_2140_4664# aux 0
C373 sub spk 0.38919f
C374 a_3844_4734# vbp_st 0.0101f
C375 m1_4052_1572# aux 0.0316f
C376 m1_4904_6422# sta 0
C377 vm mreset 0.00107f
C378 vm el 0.05366f
C379 a_2510_1690# m1_3704_1572# 0
C380 rsel vbn_leak 0.06452f
C381 a_1632_2940# m1_1692_4664# 0.06285f
C382 vbp_syn vsrc 0.25212f
C383 aux en 0.0295f
C384 sub a_2160_3542# 0.01946f
C385 m1_3180_6220# mreset 0.05693f
C386 m1_2140_4664# vbn_prb 0
C387 m1_201_2200# aux 0.00248f
C388 rsel a_3184_3624# 0.19996f
C389 m1_3180_6220# el 0.011f
C390 m1_4052_1572# en 0.00988f
C391 vbn_leak spk 0.29363f
C392 aux vbn_prb 0
C393 vreset a_2510_1690# 0.05576f
C394 vbp_syn abus 0.02816f
C395 a_480_5620# a_1632_2940# 0.18989f
C396 vbp_syn vbp_st 0.21518f
C397 a_2804_3624# a_3184_3624# 0.08895f
C398 a_3184_3624# spk 0.25275f
C399 vm sub 0.07034f
C400 m1_4822_412# vsrc 0.00459f
C401 m1_201_2200# en 0
C402 abus m1_4822_412# 0.00445f
C403 vbn_prb en 0.05529f
C404 m1_201_2200# vbn_prb 0
C405 vbp_st m1_4822_412# 0.01047f
C406 m1_3180_6220# sub 0.00163f
C407 vdd vsrc 0.26877f
C408 rsel m1_3704_1572# 0.01715f
C409 a_2160_3542# a_3184_3624# 0.008f
C410 stb mreset 0.0786f
C411 vdd abus 0.16899f
C412 a_2080_2940# a_480_5620# 0.25322f
C413 vdd vbp_st 1.58678f
C414 vm vbn_leak 0.00189f
C415 m1_3652_6232# a_2510_1690# 0.31054f
C416 m1_2140_960# abus 0
C417 sub_b vsrc 0.15349f
C418 vbp_syn hold 0.05101f
C419 rsel vreset 0
C420 vm a_3184_3624# 0.00138f
C421 abus sub_b 0.19811f
C422 m1_3180_6220# vbn_leak 0
C423 a_288_2940# a_2510_1690# 0
C424 vbp_st sub_b 0.33774f
C425 vreset spk 0.00512f
C426 abus m1_2972_1572# 0.00804f
C427 m1_3180_6220# a_3184_3624# 0
C428 stb sub 0.01181f
C429 m1_4904_6422# vsrc 0.02005f
C430 el m1_2140_4664# 0.00124f
C431 aux mreset 0.03186f
C432 el aux 1.56834f
C433 m1_2640_602# vsrc 0.04429f
C434 sta vbn_ref 0
C435 m1_4052_1572# el 0.03752f
C436 a_3844_4734# m1_1540_4540# 0
C437 vbp_st m1_4904_6422# 0.08827f
C438 vdd hold 0.71358f
C439 m1_2640_602# abus 0.07469f
C440 m1_2640_602# vbp_st 0.05328f
C441 vm m1_3704_1572# 0.00129f
C442 m1_3652_6232# rsel 0
C443 a_3844_4734# a_2510_1690# 0.20067f
C444 mreset en 0
C445 el en 0.02943f
C446 a_1632_2940# vsrc 0.04519f
C447 el m1_201_2200# 0.22967f
C448 sub m1_2140_4664# 0.06647f
C449 vbn_prb mreset 0
C450 el vbn_prb 0.00233f
C451 m1_3652_6232# spk 0
C452 sub_b hold 0.20144f
C453 vm vreset 0.24311f
C454 stb a_3184_3624# 0
C455 vbp_st a_1632_2940# 0.07428f
C456 a_288_2940# spk 0.46138f
C457 m1_4904_6422# hold -0.02083f
C458 sub en 0.01644f
C459 sub m1_201_2200# 0.02138f
C460 vbn_leak m1_2140_4664# 0
C461 a_2510_1690# vbp_syn 1.26952f
C462 a_2080_2940# vsrc 0.04259f
C463 sub vbn_prb 0
C464 vbn_leak aux 1.59952f
C465 m1_4052_1572# vbn_leak 0.00484f
C466 m1_2140_4664# a_3184_3624# 0.00411f
C467 a_3844_4734# rsel 0.01316f
C468 aux a_3184_3624# 0
C469 vm m1_3652_6232# 0.02927f
C470 vdd m1_1540_4540# 0.16831f
C471 a_2804_3624# a_3844_4734# 0.00111f
C472 a_3844_4734# spk 0.13677f
C473 a_1632_2940# hold 0.04363f
C474 vbn_leak en 0.03277f
C475 vbn_leak m1_201_2200# 0.35768f
C476 a_480_5620# m1_1692_4664# 0.04743f
C477 m1_3180_6220# m1_3652_6232# 0.60929f
C478 vbn_leak vbn_prb 0.00402f
C479 a_288_2940# vm 0.04863f
C480 a_2510_1690# vdd 2.22251f
C481 vsrc vbn_ref 0.05519f
C482 sub_b m1_1540_4540# 0.03104f
C483 m1_3360_972# vsrc 0.0286f
C484 m1_2140_960# a_2510_1690# 0.07006f
C485 abus vbn_ref 0.07958f
C486 el mreset 0.02577f
C487 vbp_st vbn_ref 0.04416f
C488 rsel vbp_syn 0.06539f
C489 abus m1_3360_972# 0.06261f
C490 a_3844_4734# a_2160_3542# 0
C491 vbp_st m1_3360_972# 0.02943f
C492 a_2510_1690# sub_b 0.12307f
C493 m1_4052_1572# m1_3704_1572# 0
C494 vbp_syn spk 0.02946f
C495 a_2510_1690# m1_2972_1572# 0.02758f
C496 vm a_3844_4734# 0
C497 m1_4802_1762# en 0.1097f
C498 vreset aux 0.0342f
C499 stb m1_3652_6232# 0.00248f
C500 m1_4052_1572# vreset 0
C501 m1_3704_1572# en 0.0401f
C502 a_2510_1690# m1_4904_6422# 0.0478f
C503 vbn_prb m1_4802_1762# 0.13949f
C504 sub mreset 0
C505 el sub 0.00907f
C506 m1_2640_602# a_2510_1690# 0.13455f
C507 m1_3180_6220# a_3844_4734# 0
C508 rsel vdd 0.33841f
C509 vbp_syn a_2160_3542# 0
C510 a_1632_2940# m1_1540_4540# 0.05012f
C511 m1_2140_960# rsel 0.00476f
C512 vreset en 1.7194f
C513 a_2804_3624# vdd 0.30839f
C514 hold vbn_ref 0.1037f
C515 vdd spk 0.79655f
C516 vreset vbn_prb 0.04245f
C517 rsel sub_b 0.55851f
C518 m1_2140_960# spk 0.01094f
C519 vm vbp_syn 0.20638f
C520 a_2510_1690# a_1632_2940# 0.12565f
C521 vbn_leak mreset 0.02676f
C522 el vbn_leak 0.18536f
C523 m1_3652_6232# aux 0.01738f
C524 rsel m1_2972_1572# 0.06097f
C525 a_2804_3624# sub_b 0.17298f
C526 sub_b spk 0.43536f
C527 el a_3184_3624# 0
C528 m1_3180_6220# vbp_syn 0.04238f
C529 vdd a_2160_3542# 0.4673f
C530 vm m1_4822_412# 0
C531 a_2080_2940# m1_1540_4540# 0
C532 spk m1_2972_1572# 0.00765f
C533 vsrc m1_1692_4664# 0
C534 m1_2640_602# rsel 0.00954f
C535 vbn_leak sub 0.14795f
C536 vbp_st m1_1692_4664# 0.3007f
C537 vm vdd 1.97182f
C538 a_2510_1690# a_2080_2940# 0.20807f
C539 sub_b a_2160_3542# 0.08442f
C540 m1_2640_602# spk 0.00437f
C541 a_480_5620# vsrc 0.01157f
C542 vm m1_2140_960# 0.16517f
C543 sta vsrc 0
C544 sub a_3184_3624# 0.00218f
C545 a_288_2940# m1_201_2200# 0.35641f
C546 rsel a_1632_2940# 0.00537f
C547 m1_3180_6220# vdd 0.41421f
C548 vbp_st a_480_5620# 0.28639f
C549 a_3844_4734# m1_2140_4664# 0.00129f
C550 vm sub_b 0.20053f
C551 vbp_st sta 0.00178f
C552 stb vbp_syn 0
C553 a_3844_4734# aux 0
C554 a_2804_3624# a_1632_2940# 0.01581f
C555 a_1632_2940# spk 0.12495f
C556 vm m1_2972_1572# 0.00606f
C557 vreset mreset 0
C558 el vreset 0.03397f
C559 m1_3180_6220# sub_b 0.00536f
C560 a_2510_1690# vbn_ref 0.08503f
C561 a_2510_1690# m1_3360_972# 0.01526f
C562 vbn_leak a_3184_3624# 0.00117f
C563 hold m1_1692_4664# 0
C564 a_3844_4734# en 0
C565 a_3844_4734# m1_201_2200# 0.00349f
C566 vm m1_2640_602# 0.37129f
C567 rsel a_2080_2940# 0.02265f
C568 a_3844_4734# vbn_prb 0
C569 a_1632_2940# a_2160_3542# 0.18169f
C570 m1_2140_4664# vbp_syn 0.01811f
C571 m1_3180_6220# m1_4904_6422# -0.01068f
C572 stb vdd 0.10967f
C573 aux vbp_syn 0.09697f
C574 a_2804_3624# a_2080_2940# 0.00309f
C575 a_2080_2940# spk 0.06093f
C576 a_480_5620# hold 0.00433f
C577 vreset sub 0
C578 aux vss 0.36549f
C579 m1_3360_972# vss 0.87261f
C580 m1_2640_602# vss 0.6991f
C581 m1_2140_960# vss 0.29523f
C582 en vss 0.96705f
C583 abus vss 2.43138f
C584 sub vss 0.85337f
C585 mreset vss 0.99614f
C586 hold vss 2.49509f
C587 vdd vss 15.48698f
C588 m1_4822_412# vss 0.31055f
C589 vbn_prb vss 0.70572f
C590 a_3184_3624# vss 0.23144f
C591 a_2804_3624# vss 0.07284f
C592 spk vss 1.96787f
C593 m1_2972_1572# vss -0.04697f
C594 rsel vss 0.84638f
C595 m1_2140_4664# vss 0.02431f
C596 vm vss 3.61577f
C597 m1_3704_1572# vss -0.05339f
C598 m1_201_2200# vss 0.36723f
C599 a_288_2940# vss -0.16788f
C600 sub_b vss 1.34876f
C601 a_2080_2940# vss 0.2785f
C602 m1_1540_4540# vss 0.06681f
C603 vbp_st vss 0.34892f
C604 m1_3180_6220# vss 0.15115f
C605 stb vss 0.18805f
C606 sta vss 0.17042f
C607 a_2160_3542# vss 0.39957f
C608 vsrc vss 1.08477f
C609 vreset vss 0.89598f
C610 a_2510_1690# vss 2.46715f
C611 m1_4802_1762# vss -0.00805f
C612 m1_1692_4664# vss 0.05209f
C613 vbn_ref vss 0.78874f
C614 a_1632_2940# vss 0.3011f
C615 a_3844_4734# vss 0.22685f
C616 m1_4904_6422# vss -0.18785f
C617 m1_3652_6232# vss -0.03524f
C618 vbp_syn vss 0.45415f
C619 el vss 0.37028f
C620 vbn_leak vss 0.60842f
C621 m1_4052_1572# vss -0.06005f
C622 a_480_5620# vss 0.29637f
.ends
