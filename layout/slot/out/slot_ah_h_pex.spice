* NGSPICE file created from slot_ah_h.ext - technology: gf180mcuD

.subckt p_w2_l4 a_400_n200# a_n400_n244# w_n574_n330# a_n488_n200# VSUBS
X0 a_400_n200# a_n400_n244# a_n488_n200# w_n574_n330# pfet_03v3 ad=0.88p pd=4.88u as=0.88p ps=4.88u w=2u l=4u
C0 a_n488_n200# w_n574_n330# 0.07409f
C1 a_400_n200# a_n400_n244# 0.07019f
C2 a_n488_n200# a_400_n200# 0.01073f
C3 a_n488_n200# a_n400_n244# 0.07019f
C4 a_400_n200# w_n574_n330# 0.07409f
C5 a_n400_n244# w_n574_n330# 0.42229f
C6 a_400_n200# VSUBS 0.18936f
C7 a_n488_n200# VSUBS 0.18936f
C8 w_n574_n330# VSUBS 2.27304f
.ends

.subckt p_w0p22_l1 a_100_n22# a_n100_n66# w_n278_n159# a_n192_n36# VSUBS
X0 a_100_n22# a_n100_n66# a_n192_n36# w_n278_n159# pfet_03v3 ad=0.1516p pd=1.64u as=0.1516p ps=1.64u w=0.22u l=1u
C0 a_n100_n66# w_n278_n159# 0.13163f
C1 a_100_n22# a_n192_n36# 0.00453f
C2 a_n100_n66# a_100_n22# 0.00509f
C3 a_n100_n66# a_n192_n36# 0.00509f
C4 a_100_n22# w_n278_n159# 0.00771f
C5 a_n192_n36# w_n278_n159# 0.00771f
C6 a_100_n22# VSUBS 0.05952f
C7 a_n192_n36# VSUBS 0.05952f
C8 w_n278_n159# VSUBS 0.53042f
.ends

.subckt n_w1_l0p28 a_28_n100# a_n28_n144# a_n116_n100# VSUBS
X0 a_28_n100# a_n28_n144# a_n116_n100# VSUBS nfet_03v3 ad=0.44p pd=2.88u as=0.44p ps=2.88u w=1u l=0.28u
C0 a_28_n100# a_n28_n144# 0.00769f
C1 a_28_n100# a_n116_n100# 0.04256f
C2 a_n116_n100# a_n28_n144# 0.00769f
C3 a_28_n100# VSUBS 0.09911f
C4 a_n116_n100# VSUBS 0.09911f
.ends

.subckt n_w2_l2 a_n288_n200# a_200_n200# a_n200_n244# VSUBS
X0 a_200_n200# a_n200_n244# a_n288_n200# VSUBS nfet_03v3 ad=0.88p pd=4.88u as=0.88p ps=4.88u w=2u l=2u
C0 a_200_n200# a_n200_n244# 0.0587f
C1 a_200_n200# a_n288_n200# 0.02133f
C2 a_n288_n200# a_n200_n244# 0.0587f
C3 a_200_n200# VSUBS 0.2667f
C4 a_n288_n200# VSUBS 0.2667f
.ends

.subckt n_w2_l4 a_400_n200# a_n400_n244# a_n488_n200# VSUBS
X0 a_400_n200# a_n400_n244# a_n488_n200# VSUBS nfet_03v3 ad=0.88p pd=4.88u as=0.88p ps=4.88u w=2u l=4u
C0 a_400_n200# a_n400_n244# 0.07019f
C1 a_400_n200# a_n488_n200# 0.01073f
C2 a_n488_n200# a_n400_n244# 0.07019f
C3 a_400_n200# VSUBS 0.41684f
C4 a_n488_n200# VSUBS 0.41684f
.ends

.subckt n_w4_l1 a_n188_n400# a_100_n400# a_n100_n444# VSUBS
X0 a_100_n400# a_n100_n444# a_n188_n400# VSUBS nfet_03v3 ad=1.76p pd=8.88u as=1.76p ps=8.88u w=4u l=1u
C0 a_100_n400# a_n100_n444# 0.08505f
C1 a_100_n400# a_n188_n400# 0.07756f
C2 a_n188_n400# a_n100_n444# 0.08505f
C3 a_100_n400# VSUBS 0.26859f
C4 a_n188_n400# VSUBS 0.26859f
.ends

.subckt n_w0p5_l0p28 a_n28_n94# a_n116_n50# a_28_n50# VSUBS
X0 a_28_n50# a_n28_n94# a_n116_n50# VSUBS nfet_03v3 ad=0.22p pd=1.88u as=0.22p ps=1.88u w=0.5u l=0.28u
C0 a_28_n50# a_n28_n94# 0.00377f
C1 a_28_n50# a_n116_n50# 0.02085f
C2 a_n116_n50# a_n28_n94# 0.00377f
C3 a_28_n50# VSUBS 0.07987f
C4 a_n116_n50# VSUBS 0.07987f
.ends

.subckt p_w1_l0p5 a_n138_n100# a_50_n100# a_n50_n144# w_n224_n230# VSUBS
X0 a_50_n100# a_n50_n144# a_n138_n100# w_n224_n230# pfet_03v3 ad=0.44p pd=2.88u as=0.44p ps=2.88u w=1u l=0.5u
C0 a_n138_n100# w_n224_n230# 0.0205f
C1 a_50_n100# a_n50_n144# 0.01275f
C2 a_n138_n100# a_50_n100# 0.03085f
C3 a_n138_n100# a_n50_n144# 0.01275f
C4 a_50_n100# w_n224_n230# 0.0205f
C5 a_n50_n144# w_n224_n230# 0.07993f
C6 a_50_n100# VSUBS 0.06546f
C7 a_n138_n100# VSUBS 0.06546f
C8 w_n224_n230# VSUBS 0.61824f
.ends

.subckt n_w0p5_l0p5 a_n138_n50# a_50_n50# a_n50_n94# VSUBS
X0 a_50_n50# a_n50_n94# a_n138_n50# VSUBS nfet_03v3 ad=0.22p pd=1.88u as=0.22p ps=1.88u w=0.5u l=0.5u
C0 a_50_n50# a_n50_n94# 0.00625f
C1 a_50_n50# a_n138_n50# 0.01511f
C2 a_n138_n50# a_n50_n94# 0.00625f
C3 a_50_n50# VSUBS 0.09639f
C4 a_n138_n50# VSUBS 0.09639f
.ends

.subckt p_w1_l0p28 w_n202_n230# a_28_n100# a_n28_n144# a_n116_n100# VSUBS
X0 a_28_n100# a_n28_n144# a_n116_n100# w_n202_n230# pfet_03v3 ad=0.44p pd=2.88u as=0.44p ps=2.88u w=1u l=0.28u
C0 a_n116_n100# w_n202_n230# 0.01808f
C1 a_28_n100# a_n28_n144# 0.00769f
C2 a_n116_n100# a_28_n100# 0.04256f
C3 a_n116_n100# a_n28_n144# 0.00769f
C4 a_28_n100# w_n202_n230# 0.01808f
C5 a_n28_n144# w_n202_n230# 0.05841f
C6 a_28_n100# VSUBS 0.0597f
C7 a_n116_n100# VSUBS 0.0597f
C8 w_n202_n230# VSUBS 0.55752f
.ends

.subckt n_w1_l0p5 a_n138_n100# a_50_n100# a_n50_n144# VSUBS
X0 a_50_n100# a_n50_n144# a_n138_n100# VSUBS nfet_03v3 ad=0.44p pd=2.88u as=0.44p ps=2.88u w=1u l=0.5u
C0 a_50_n100# a_n50_n144# 0.01275f
C1 a_50_n100# a_n138_n100# 0.03085f
C2 a_n138_n100# a_n50_n144# 0.01275f
C3 a_50_n100# VSUBS 0.11563f
C4 a_n138_n100# VSUBS 0.11563f
.ends

.subckt n_w4_l2 a_n288_n400# a_200_n400# a_n200_n444# VSUBS
X0 a_200_n400# a_n200_n444# a_n288_n400# VSUBS nfet_03v3 ad=1.76p pd=8.88u as=1.76p ps=8.88u w=4u l=2u
C0 a_200_n400# a_n200_n444# 0.11799f
C1 a_200_n400# a_n288_n400# 0.04287f
C2 a_n288_n400# a_n200_n444# 0.11799f
C3 a_200_n400# VSUBS 0.34365f
C4 a_n288_n400# VSUBS 0.34365f
.ends

.subckt p_w1_l2 w_n374_n230# a_n288_n100# a_200_n100# a_n200_n144# VSUBS
X0 a_200_n100# a_n200_n144# a_n288_n100# w_n374_n230# pfet_03v3 ad=0.44p pd=2.88u as=0.44p ps=2.88u w=1u l=2u
C0 a_n288_n100# w_n374_n230# 0.03135f
C1 a_200_n100# a_n200_n144# 0.02905f
C2 a_n288_n100# a_200_n100# 0.01056f
C3 a_n288_n100# a_n200_n144# 0.02905f
C4 a_200_n100# w_n374_n230# 0.03135f
C5 a_n200_n144# w_n374_n230# 0.22666f
C6 a_200_n100# VSUBS 0.1047f
C7 a_n288_n100# VSUBS 0.1047f
C8 w_n374_n230# VSUBS 1.03224f
.ends

.subckt n_w7p07_l7p07 a_707_n707# a_n795_n707# a_n707_n751# VSUBS
X0 a_707_n707# a_n707_n751# a_n795_n707# VSUBS nfet_03v3 ad=3.1108p pd=15.02u as=3.1108p ps=15.02u w=7.07u l=7.07u
C0 a_707_n707# a_n707_n751# 0.27012f
C1 a_707_n707# a_n795_n707# 0.0212f
C2 a_n795_n707# a_n707_n751# 0.27012f
C3 a_707_n707# VSUBS 0.84237f
C4 a_n795_n707# VSUBS 0.84237f
.ends

.subckt n_w0p5_l1p5 a_150_n50# a_n238_n50# a_n150_n94# VSUBS
X0 a_150_n50# a_n150_n94# a_n238_n50# VSUBS nfet_03v3 ad=0.22p pd=1.88u as=0.22p ps=1.88u w=0.5u l=1.5u
C0 a_150_n50# a_n150_n94# 0.01269f
C1 a_150_n50# a_n238_n50# 0.00671f
C2 a_n238_n50# a_n150_n94# 0.01269f
C3 a_150_n50# VSUBS 0.17146f
C4 a_n238_n50# VSUBS 0.17146f
.ends

.subckt n_w3p54_l3p54 a_354_n354# a_n354_n398# a_n442_n354# VSUBS
X0 a_354_n354# a_n354_n398# a_n442_n354# VSUBS nfet_03v3 ad=1.5576p pd=7.96u as=1.5576p ps=7.96u w=3.54u l=3.54u
C0 a_354_n354# a_n354_n398# 0.12189f
C1 a_354_n354# a_n442_n354# 0.02161f
C2 a_n442_n354# a_n354_n398# 0.12189f
C3 a_354_n354# VSUBS 0.44156f
C4 a_n442_n354# VSUBS 0.44156f
.ends

.subckt n_w0p22_l2 a_200_n22# a_n200_n66# a_n292_n36# VSUBS
X0 a_200_n22# a_n200_n66# a_n292_n36# VSUBS nfet_03v3 ad=0.1516p pd=1.64u as=0.1516p ps=1.64u w=0.22u l=2u
C0 a_200_n22# a_n292_n36# 0.00245f
C1 a_200_n22# a_n200_n66# 0.00705f
C2 a_n200_n66# a_n292_n36# 0.00705f
C3 a_200_n22# VSUBS 0.20767f
C4 a_n292_n36# VSUBS 0.20767f
.ends

.subckt n_w0p5_l3 a_n388_n50# a_300_n50# a_n300_n94# VSUBS
X0 a_300_n50# a_n300_n94# a_n388_n50# VSUBS nfet_03v3 ad=0.22p pd=1.88u as=0.22p ps=1.88u w=0.5u l=3u
C0 a_300_n50# a_n300_n94# 0.01602f
C1 a_300_n50# a_n388_n50# 0.00348f
C2 a_n388_n50# a_n300_n94# 0.01602f
C3 a_300_n50# VSUBS 0.28406f
C4 a_n388_n50# VSUBS 0.28406f
.ends

.subckt n_w0p5_l4 a_n488_n50# a_400_n50# a_n400_n94# VSUBS
X0 a_400_n50# a_n400_n94# a_n488_n50# VSUBS nfet_03v3 ad=0.22p pd=1.88u as=0.22p ps=1.88u w=0.5u l=4u
C0 a_400_n50# a_n400_n94# 0.01702f
C1 a_400_n50# a_n488_n50# 0.0026f
C2 a_n488_n50# a_n400_n94# 0.01702f
C3 a_400_n50# VSUBS 0.35913f
C4 a_n488_n50# VSUBS 0.35913f
.ends

.subckt slot_ah_h vss vbp_syn vdd el aux vbn_leak vsrc vbp_st vbn_prb vbn_ref en vreset
+ abus spk t3 t2 t1 t0 sta stb hold mreset rsel sub sub_b vm
XXL_XP1 a_480_5620# a_480_5620# vdd vdd vss p_w2_l4
XXD_XK a_3184_3624# spk vdd vdd vss p_w0p22_l1
XXPM_XSW m1_4052_1572# rsel m1_3704_1572# vss n_w1_l0p28
XXL_XP2 a_1632_2940# a_480_5620# vdd vdd vss p_w2_l4
XXPR_XMB vss m1_4822_1769# vbn_prb vss n_w2_l2
XXL_XMT m1_208_2424# vbn_leak vss vss n_w2_l4
XXL_XM1 a_288_2940# a_480_5620# el vss n_w4_l1
XXS_XWA m1_4904_6422# vbp_syn vdd m1_3652_6752# vss p_w2_l4
XXR_Xi_XN spk vss a_3844_4734# vss n_w0p5_l0p28
XXL_XM2 a_2080_2940# a_1632_2940# a_1632_2940# vss n_w4_l1
XXS_XWB m1_4904_6422# vbp_syn vdd m1_3160_6220# vss p_w2_l4
XXR_XNR vss vbn_ref a_2510_1690# vss n_w2_l4
XXD_XPI m1_1700_4540# a_2160_3542# vm vdd vss p_w1_l0p5
XXPR_XME m1_2418_960# en m1_4822_1769# vss n_w1_l0p28
XXR_XSW vreset vm a_2510_1690# vss n_w0p5_l0p5
XXR_Xi_XP vdd a_3844_4734# spk vdd vss p_w1_l0p28
XXD_XNI vsrc a_2160_3542# vm vss n_w1_l0p5
XXPR_XMF m1_2418_960# vdd a_2510_1690# vss n_w4_l2
XXS_XQA vdd m1_3652_6752# sta vss vss p_w1_l0p28
XXS_XQB vdd m1_3160_6220# stb vss vss p_w1_l0p28
XXS_XNA sta vm m1_3652_6752# vss n_w0p5_l0p28
XXS_XNB stb vm m1_3160_6220# vss n_w0p5_l0p28
XXD_XS2 vdd vdd m1_2260_4540# vbp_st vss p_w1_l2
XXD_XPS vdd vdd m1_1700_4540# vbp_st vss p_w1_l2
XXD_XS3 vdd vdd m1_1545_4540# vbp_st vss p_w1_l2
XXL_XD2a m1_208_2424# a_2080_2940# a_2080_2940# vss n_w4_l1
XXPM_XSB abus sub_b m1_4052_1572# vss n_w1_l0p28
XXL_XD2b m1_208_2424# a_2080_2940# a_2080_2940# vss n_w4_l1
XXL_XD1a m1_208_2424# a_288_2940# a_288_2940# vss n_w4_l1
XXPM_XSC m1_3704_1572# en m1_3360_972# vss n_w1_l0p28
XXC_XC vss vss vm vss n_w7p07_l7p07
XXS_XPH vdd m1_4904_6422# vdd hold vss p_w1_l2
XXT_XR1 m1_2117_7612# m1_1545_7160# vbn_leak vss n_w0p5_l1p5
XXD_XP2 vdd a_2804_3624# a_2160_3542# m1_2260_4540# vss p_w1_l0p28
XXL_XD1b m1_208_2424# a_288_2940# a_288_2940# vss n_w4_l1
XXPR_XSW m1_2972_1572# rsel m1_2180_1416# vss n_w1_l0p28
XXT_XR2 m1_236_6942# m1_2117_7612# vbn_leak vss n_w0p5_l1p5
XXT_XP0 vdd m1_2420_7480# t0 vm vss p_w1_l0p28
XXD_Xi4_XN a_3184_3624# vss spk vss n_w0p5_l0p28
XXD_XP3 vdd a_3184_3624# a_2804_3624# m1_1545_4540# vss p_w1_l0p28
XXT_XR3 m1_224_7600# m1_236_6942# vbn_leak vss n_w0p5_l1p5
XXT_XP1 vdd m1_1960_6220# t1 vm vss p_w1_l0p28
XXR_XCR_XC vss a_2510_1690# vss vss n_w3p54_l3p54
XXD_XN2 a_2804_3624# a_2160_3542# vsrc vss n_w0p22_l2
XXT_XN0 t0 a_480_5620# m1_2420_7480# vss n_w0p5_l0p28
XXT_XP2 vdd m1_1401_6220# t2 vm vss p_w1_l0p28
XXD_Xi4_XP vdd spk a_3184_3624# vdd vss p_w1_l0p28
XXD_XN3 a_2804_3624# vsrc a_3184_3624# vss n_w0p5_l0p28
XXPM_XMB vss m1_4822_412# vbn_prb vss n_w2_l2
XXT_XN1 t1 a_480_5620# m1_1960_6220# vss n_w0p5_l0p28
XXT_XP3 vdd m1_853_6232# t3 vm vss p_w1_l0p28
XXT_XL0 m1_2420_7480# m1_224_7600# vbn_leak vss n_w0p5_l3
XXT_XN2 t2 a_480_5620# m1_1401_6220# vss n_w0p5_l0p28
XXT_XLT m1_224_7600# vdd vbn_leak vss n_w0p5_l3
XXT_XL1 m1_1960_6220# m1_236_6942# vbn_leak vss n_w0p5_l3
XXT_XN3 t3 a_480_5620# m1_853_6232# vss n_w0p5_l0p28
XXR_XPC vdd a_2510_1690# a_3844_4734# vdd vss p_w1_l0p28
XXPM_XME m1_3360_972# en m1_4822_412# vss n_w1_l0p28
XXT_XL2 m1_1401_6220# m1_2117_7612# vbn_leak vss n_w0p5_l3
XXT_XL3 m1_853_6232# m1_1545_7160# vbn_leak vss n_w0p5_l3
XXPM_XMF m1_3360_972# vdd vm vss n_w4_l2
XXS_XHL vdd vm hold a_1632_2940# vss p_w1_l0p28
XXS_XMR mreset a_2510_1690# vdd vss n_w0p5_l0p28
XXPR_XSB abus sub m1_2972_1572# vss n_w1_l0p28
XXPR_XSC m1_2418_960# en m1_2180_1416# vss n_w1_l0p28
XXT_XRB m1_1104_8052# m1_1545_7160# vbn_leak vss n_w0p5_l4
XXT_XRA vss m1_1104_8052# vbn_leak vss n_w0p5_l4
C0 hold m1_853_6232# 0.00247f
C1 m1_224_7600# aux 0
C2 a_2080_2940# m1_1545_4540# 0
C3 a_3184_3624# vsrc 0.05859f
C4 m1_208_2424# a_3844_4734# 0.00142f
C5 sub_b en 0.01298f
C6 m1_1401_6220# m1_1960_6220# 0
C7 vbn_ref m1_4904_6422# 0.11398f
C8 vbp_syn m1_3704_1572# 0.03855f
C9 m1_2418_960# m1_4052_1572# 0.03342f
C10 rsel m1_2420_7480# 0.00107f
C11 m1_1545_4540# vdd 0.33208f
C12 rsel vm 0.22666f
C13 a_1632_2940# a_480_5620# 1.11715f
C14 a_3844_4734# en 0
C15 vbn_ref m1_4822_1769# 0.08321f
C16 m1_3652_6752# vbp_st 0
C17 t0 el 0
C18 stb m1_3160_6220# 0.19195f
C19 a_2160_3542# rsel 0
C20 a_2510_1690# m1_1700_4540# 0
C21 t0 sta 0
C22 vm aux 0.07917f
C23 vsrc m1_3160_6220# 0
C24 sub a_2510_1690# 0.08491f
C25 vreset hold 0.0018f
C26 a_1632_2940# hold 0.36941f
C27 vbn_ref vbp_st 0.04037f
C28 t0 vdd 0.11083f
C29 m1_2260_4540# a_480_5620# 0.01953f
C30 vbn_ref abus 0.06992f
C31 m1_3652_6752# sub_b 0.00353f
C32 t2 m1_1545_7160# 0.00105f
C33 vreset vbp_syn 0.036f
C34 vbn_ref m1_3360_972# 0.03584f
C35 a_2080_2940# el 0.21811f
C36 mreset spk 0.02865f
C37 m1_3652_6752# a_3844_4734# 0
C38 rsel m1_4052_1572# 0
C39 sta el 0
C40 vbn_ref sub_b 0.00154f
C41 el vdd 1.95176f
C42 vbn_leak m1_4904_6422# 0
C43 a_2080_2940# vdd 0.0014f
C44 a_3184_3624# a_480_5620# 0
C45 a_2510_1690# spk 0.39566f
C46 sta vdd 0.13249f
C47 vbn_ref a_3844_4734# 0
C48 vbn_leak m1_4822_1769# 0
C49 m1_2180_1416# vm 0.185f
C50 m1_2260_4540# vbp_syn 0.03656f
C51 m1_4052_1572# aux 0.02977f
C52 m1_1401_6220# a_480_5620# 0.17466f
C53 t2 vbn_leak 0.32716f
C54 m1_1545_7160# sub_b 0
C55 vbn_prb vm 0.27015f
C56 a_2804_3624# m1_208_2424# 0.01815f
C57 vbn_leak vbp_st 0.02632f
C58 m1_224_7600# m1_2420_7480# 0.00484f
C59 vbn_leak abus 0.07538f
C60 m1_224_7600# vm 0.00129f
C61 m1_208_2424# vsrc 0.21305f
C62 m1_1545_7160# m1_2117_7612# 0.01219f
C63 m1_1401_6220# hold 0
C64 vbn_leak m1_3360_972# 0.035f
C65 vsrc en 0.03422f
C66 a_1632_2940# m1_1700_4540# 0.17453f
C67 m1_236_6942# mreset 0
C68 vbn_leak sub_b 0.06597f
C69 m1_2180_1416# m1_4052_1572# 0
C70 vreset sub 0
C71 sub a_1632_2940# 0.00114f
C72 t1 m1_1545_7160# 0.14794f
C73 vbn_leak a_3844_4734# 0.00172f
C74 vm m1_2420_7480# 0.05434f
C75 a_2510_1690# m1_2418_960# 0.30236f
C76 vbn_leak m1_2117_7612# 0.28438f
C77 m1_2972_1572# abus 0.00643f
C78 m1_1545_4540# vbp_st 0.01412f
C79 vbp_syn m1_3160_6220# 0.10137f
C80 m1_2260_4540# m1_1700_4540# 0.06162f
C81 m1_3652_6752# stb 0
C82 a_2160_3542# vm 0.036f
C83 t3 vbn_leak 0.21138f
C84 sub m1_2260_4540# 0.08044f
C85 m1_3652_6752# vsrc 0.00123f
C86 m1_4904_6422# el 0
C87 m1_1545_4540# sub_b 0
C88 t1 vbn_leak 0.18813f
C89 a_1632_2940# spk 0.17886f
C90 sta m1_4904_6422# 0
C91 t0 vbp_st 0
C92 m1_208_2424# a_480_5620# 0.07626f
C93 m1_1545_4540# a_3844_4734# 0
C94 a_3184_3624# m1_1700_4540# 0.00612f
C95 m1_4904_6422# vdd -0.01187f
C96 vbn_ref vsrc 0.0454f
C97 sub a_3184_3624# 0.08723f
C98 m1_236_6942# m1_853_6232# 0.12947f
C99 m1_3704_1572# m1_2418_960# 0.03341f
C100 a_2510_1690# rsel 0.11194f
C101 m1_2260_4540# spk 0.09728f
C102 t0 sub_b 0.00652f
C103 t2 vdd 0.28255f
C104 mreset aux 0.02836f
C105 el vbp_st 0.02573f
C106 el abus 0.03219f
C107 m1_1960_6220# m1_1545_7160# 0
C108 sta vbp_st 0.00156f
C109 el m1_3360_972# 0.03714f
C110 m1_208_2424# vbp_syn 0.1108f
C111 t0 m1_2117_7612# 0.15068f
C112 a_2510_1690# aux 0.08882f
C113 vdd vbp_st 1.96962f
C114 vdd abus 0.1713f
C115 hold en 0.01209f
C116 el sub_b 0.10099f
C117 vreset m1_4822_412# 0.02041f
C118 a_2080_2940# sub_b 0.0036f
C119 m1_3360_972# vdd 0.2282f
C120 a_3184_3624# spk 0.30683f
C121 sta sub_b 0.0025f
C122 vbp_syn en 0.06453f
C123 vm a_288_2940# 0.04247f
C124 m1_236_6942# a_1632_2940# 0.00277f
C125 vreset m1_2418_960# 0.07305f
C126 stb vbn_leak 0.00154f
C127 a_3844_4734# el 0
C128 m1_1960_6220# vbn_leak 0.02157f
C129 vdd sub_b 0.57538f
C130 el m1_2117_7612# 0
C131 t1 t0 0.02651f
C132 rsel m1_3704_1572# 0.04526f
C133 vbn_leak vsrc 1.66918f
C134 a_3844_4734# vdd 0.36912f
C135 mreset vbn_prb 0
C136 vdd m1_2117_7612# 0.00155f
C137 m1_2180_1416# a_2510_1690# 0.17847f
C138 m1_3160_6220# spk 0.17691f
C139 mreset m1_224_7600# 0
C140 t3 vdd 0.18061f
C141 vbn_prb a_2510_1690# 0.21604f
C142 m1_3652_6752# vbp_syn 0.10379f
C143 a_2804_3624# m1_1545_4540# 0.14129f
C144 t1 vdd 0.11351f
C145 m1_1545_7160# a_480_5620# 0.0046f
C146 vbn_ref hold 0.05152f
C147 vreset rsel 0.04459f
C148 a_1632_2940# rsel -0
C149 m1_1545_4540# vsrc 0
C150 vbn_ref vbp_syn 0.00562f
C151 sub m1_208_2424# 0.06346f
C152 m1_1401_6220# m1_236_6942# 0.04777f
C153 mreset vm 0.00223f
C154 m1_1545_7160# hold 0
C155 t0 stb 0.00188f
C156 vreset aux 0.03339f
C157 a_2804_3624# t0 0
C158 t0 m1_1960_6220# 0.02292f
C159 m1_2180_1416# m1_3704_1572# 0
C160 sub en 0.03234f
C161 m1_4904_6422# vbp_st 0.0324f
C162 vbn_leak a_480_5620# 0.02606f
C163 m1_2260_4540# rsel 0.05167f
C164 a_2510_1690# vm 0.34014f
C165 m1_236_6942# m1_3160_6220# 0
C166 m1_4822_1769# vbp_st 0.00458f
C167 m1_4822_1769# abus 0.13444f
C168 t2 vbp_st 0
C169 a_2804_3624# el 0
C170 m1_208_2424# spk 0.08513f
C171 a_2804_3624# a_2080_2940# 0.00385f
C172 a_2160_3542# a_2510_1690# 0.19553f
C173 m1_224_7600# m1_853_6232# 0.01681f
C174 m1_2260_4540# aux 0
C175 sta stb 0.01153f
C176 vsrc el 0.06064f
C177 vbn_leak hold 0.46134f
C178 a_2080_2940# vsrc 0.0772f
C179 a_3184_3624# rsel 0.26769f
C180 en spk 0
C181 a_2804_3624# vdd 0.32166f
C182 stb vdd 0.10546f
C183 sta vsrc 0
C184 vbp_st abus 0.15901f
C185 m1_4822_1769# sub_b 0
C186 m1_1960_6220# vdd 0.02386f
C187 vbn_leak vbp_syn 0.23413f
C188 vreset m1_2180_1416# 0.047f
C189 m1_3360_972# vbp_st 0.029f
C190 m1_1545_4540# a_480_5620# 0.03738f
C191 vsrc vdd 0.19206f
C192 m1_3360_972# abus 0.12825f
C193 vreset vbn_prb 0.04778f
C194 a_2510_1690# m1_4052_1572# 0
C195 vbp_st sub_b 0.05961f
C196 t2 m1_2117_7612# 0
C197 m1_853_6232# m1_2420_7480# 0
C198 vbn_ref sub 0
C199 sub_b abus 0.03169f
C200 vm m1_3704_1572# 0.00124f
C201 vm m1_853_6232# 0.04068f
C202 rsel m1_3160_6220# 0.00566f
C203 m1_224_7600# a_1632_2940# 0
C204 m1_3360_972# sub_b 0
C205 m1_1545_4540# hold 0
C206 a_3844_4734# vbp_st 0.00359f
C207 t3 t2 0.02013f
C208 a_3844_4734# abus 0
C209 t0 a_480_5620# 0.16941f
C210 m1_3652_6752# spk 0
C211 vbp_syn m1_2972_1572# 0
C212 t1 t2 0.02693f
C213 m1_208_2424# m1_2418_960# 0
C214 m1_3160_6220# aux 0.00573f
C215 m1_4822_412# en 0.08345f
C216 a_3844_4734# sub_b 0.16586f
C217 vbn_ref spk 0
C218 m1_1104_8052# m1_1545_7160# -0.0026f
C219 el a_480_5620# 0.12602f
C220 t0 hold 0.22138f
C221 vreset vm 0.34593f
C222 m1_2418_960# en 0.19266f
C223 a_2080_2940# a_480_5620# 0.34514f
C224 a_1632_2940# vm 0.31527f
C225 m1_3704_1572# m1_4052_1572# 0
C226 t0 vbp_syn 0
C227 a_480_5620# vdd 2.50316f
C228 a_2160_3542# a_1632_2940# 0.04899f
C229 sub vbn_leak 0.10597f
C230 t1 sub_b 0
C231 hold el 0.02741f
C232 sta hold 0
C233 m1_2260_4540# vm 0.01137f
C234 m1_1104_8052# vbn_leak 0.05314f
C235 m1_1401_6220# m1_224_7600# 0.00218f
C236 m1_208_2424# rsel 0.06171f
C237 vbp_syn el 0.12244f
C238 a_2080_2940# vbp_syn 0
C239 t1 m1_2117_7612# 0
C240 hold vdd 1.10175f
C241 vsrc m1_4904_6422# 0.00188f
C242 sta vbp_syn 0.0153f
C243 m1_2260_4540# a_2160_3542# 0.1922f
C244 t2 m1_1960_6220# 0
C245 vbn_ref m1_4822_412# 0.07762f
C246 rsel en 0.19307f
C247 m1_1545_4540# m1_1700_4540# 0.09814f
C248 vbp_syn vdd 2.7227f
C249 vsrc m1_4822_1769# 0
C250 vbn_leak spk 0.00874f
C251 sub m1_2972_1572# 0.00159f
C252 m1_208_2424# aux 0
C253 sub m1_1545_4540# 0
C254 a_3184_3624# vm 0
C255 vbn_ref m1_2418_960# 0.03821f
C256 a_2804_3624# vbp_st 0.08537f
C257 stb vbp_st 0
C258 m1_1401_6220# m1_2420_7480# 0
C259 mreset a_2510_1690# 0.05828f
C260 m1_1401_6220# vm 0.07044f
C261 en aux 0.03428f
C262 a_3184_3624# a_2160_3542# 0
C263 vsrc vbp_st 1.59838f
C264 vsrc abus 0.08939f
C265 t0 m1_1700_4540# 0.00214f
C266 vsrc m1_3360_972# 0.02757f
C267 m1_236_6942# m1_1545_7160# 0.08254f
C268 a_2804_3624# sub_b 0
C269 stb sub_b 0.06352f
C270 m1_1960_6220# sub_b 0.00128f
C271 a_1632_2940# a_288_2940# 0
C272 t0 sub 0.00318f
C273 m1_3160_6220# vm 0.08222f
C274 m1_1545_4540# spk 0.14069f
C275 vsrc sub_b 0.01132f
C276 a_2804_3624# a_3844_4734# 0.00258f
C277 m1_2180_1416# m1_208_2424# 0.01197f
C278 m1_4822_412# vbn_leak 0.00239f
C279 vsrc a_3844_4734# 0.00212f
C280 vbn_ref rsel 0
C281 vbn_prb m1_208_2424# 0
C282 m1_3652_6752# aux 0.00816f
C283 sub el 0.04092f
C284 a_2080_2940# sub 0.00113f
C285 m1_2180_1416# en 0.03756f
C286 m1_236_6942# vbn_leak 0.6811f
C287 vbn_leak m1_2418_960# 0.03141f
C288 m1_1700_4540# vdd 0.31183f
C289 t0 spk 0
C290 t2 a_480_5620# 0.14899f
C291 vbn_prb en 0.05868f
C292 t1 stb 0
C293 sub vdd 0.27802f
C294 t1 m1_1960_6220# 0.10195f
C295 vbn_ref aux 0
C296 hold m1_4904_6422# 0.07151f
C297 a_2510_1690# m1_3704_1572# 0
C298 a_480_5620# vbp_st 0.21665f
C299 vbp_syn m1_4904_6422# 0.00383f
C300 el spk 0.14541f
C301 t2 hold 0
C302 a_2080_2940# spk 0.06203f
C303 sta spk 0.12396f
C304 m1_2972_1572# m1_2418_960# 0.02661f
C305 m1_208_2424# vm 0.15059f
C306 mreset vreset 0
C307 vdd spk 0.93625f
C308 a_480_5620# sub_b 0
C309 hold vbp_st 0.03369f
C310 vbn_leak rsel 0.06015f
C311 hold abus 0
C312 a_2160_3542# m1_208_2424# 0.00626f
C313 vreset a_2510_1690# 0.19749f
C314 vm en 0.26556f
C315 a_2510_1690# a_1632_2940# 0.00574f
C316 vbp_syn vbp_st 0.09537f
C317 a_480_5620# m1_2117_7612# 0
C318 vbp_syn abus 0.03578f
C319 vbn_ref vbn_prb 1.6716f
C320 t0 m1_236_6942# 0.05049f
C321 vbp_syn m1_3360_972# 0.09727f
C322 hold sub_b 0.01581f
C323 vbn_leak aux 1.65943f
C324 m1_1960_6220# stb 0
C325 t3 a_480_5620# 0.10376f
C326 vbp_syn sub_b 0.12576f
C327 a_2804_3624# vsrc 0.09769f
C328 m1_4822_412# el 0
C329 m1_2260_4540# a_2510_1690# 0.10939f
C330 rsel m1_2972_1572# 0.01007f
C331 hold m1_2117_7612# 0.13174f
C332 t1 a_480_5620# 0.14125f
C333 m1_1545_4540# rsel 0
C334 m1_236_6942# el 0
C335 el m1_2418_960# 0.02668f
C336 vbp_syn a_3844_4734# 0.24925f
C337 m1_3652_6752# vm 0.04979f
C338 a_2080_2940# m1_2418_960# 0
C339 vbp_syn m1_2117_7612# 0
C340 m1_4822_412# vdd 0.01254f
C341 t3 hold 0.02725f
C342 m1_4052_1572# en 0.00528f
C343 m1_1545_7160# m1_224_7600# 0.24151f
C344 a_1632_2940# m1_853_6232# 0
C345 m1_236_6942# vdd 0.13314f
C346 vdd m1_2418_960# 0.11962f
C347 t1 hold 0.01701f
C348 a_3184_3624# a_2510_1690# 0.10499f
C349 m1_2180_1416# vbn_leak 0
C350 vbn_ref vm 0.38496f
C351 t0 rsel 0
C352 vbn_prb vbn_leak 0.00144f
C353 m1_1700_4540# vbp_st 0.22524f
C354 m1_208_2424# a_288_2940# 0.45696f
C355 mreset m1_3160_6220# 0.04966f
C356 t2 m1_1104_8052# 0.02855f
C357 sub vbp_st 0.04908f
C358 m1_224_7600# vbn_leak 0.95192f
C359 sub abus 0.01383f
C360 m1_4904_6422# spk 0
C361 m1_1545_7160# vm 0.00138f
C362 rsel el 0.0392f
C363 sub m1_3360_972# 0
C364 a_2080_2940# rsel 0.03683f
C365 m1_1700_4540# sub_b 0
C366 a_2804_3624# a_480_5620# 0.00337f
C367 stb a_480_5620# 0
C368 m1_2180_1416# m1_2972_1572# 0.00104f
C369 m1_1960_6220# a_480_5620# 0.12613f
C370 sub sub_b 0.55724f
C371 rsel vdd 0.35378f
C372 vsrc a_480_5620# 0.08279f
C373 el aux 1.56566f
C374 a_2080_2940# aux 0
C375 sub a_3844_4734# 0.00638f
C376 vbp_st spk 0.20053f
C377 sta aux 0
C378 vbn_leak m1_2420_7480# 0.17865f
C379 vbn_leak vm 0.21344f
C380 m1_2260_4540# a_1632_2940# 0.00219f
C381 m1_1401_6220# m1_853_6232# 0
C382 stb hold 0
C383 sub m1_2117_7612# 0
C384 m1_1960_6220# hold 0.06796f
C385 vdd aux 0.17765f
C386 vsrc hold 0.03089f
C387 stb vbp_syn 0
C388 t1 m1_1700_4540# 0
C389 sub_b spk 0.46748f
C390 vsrc vbp_syn 0.16956f
C391 t3 m1_1104_8052# 0
C392 m1_236_6942# m1_4904_6422# 0
C393 a_3184_3624# a_1632_2940# 0
C394 a_3844_4734# spk 0.29532f
C395 m1_2180_1416# el 0
C396 t0 m1_224_7600# 0.04964f
C397 m1_2972_1572# vm 0.0038f
C398 a_2080_2940# m1_2180_1416# 0.00857f
C399 t1 m1_1104_8052# 0
C400 a_2510_1690# m1_208_2424# 0.19507f
C401 mreset en 0
C402 m1_1545_4540# vm 0.10164f
C403 m1_4822_1769# m1_2418_960# 0.01949f
C404 vbn_leak m1_4052_1572# 0.00484f
C405 vbn_prb el 0
C406 t2 m1_236_6942# 0.11349f
C407 m1_2180_1416# vdd 0
C408 m1_4822_412# vbp_st 0.01047f
C409 sta vbn_prb 0
C410 m1_4822_412# abus 0.00589f
C411 m1_1545_4540# a_2160_3542# 0.09491f
C412 a_2510_1690# en 0.42946f
C413 a_3184_3624# m1_2260_4540# 0.03455f
C414 m1_224_7600# el 0
C415 m1_236_6942# vbp_st 0
C416 vbn_prb vdd 0.08841f
C417 m1_4822_412# m1_3360_972# 0.05008f
C418 vbp_st m1_2418_960# 0.03833f
C419 m1_2418_960# abus 0.09716f
C420 t0 m1_2420_7480# 0.20039f
C421 t0 vm 0.06768f
C422 m1_3360_972# m1_2418_960# 0.07711f
C423 m1_224_7600# vdd 0.00143f
C424 hold a_480_5620# 0.71366f
C425 a_2804_3624# m1_1700_4540# 0.01249f
C426 stb m1_1700_4540# 0
C427 mreset m1_3652_6752# 0.02075f
C428 m1_236_6942# sub_b 0.13461f
C429 t0 a_2160_3542# 0
C430 m1_2418_960# sub_b 0.01246f
C431 vbp_syn a_480_5620# 0
C432 a_2804_3624# sub 0.00366f
C433 sub stb 0.00236f
C434 rsel m1_4822_1769# 0
C435 el vm 0.24413f
C436 a_2080_2940# vm 0.07396f
C437 sub vsrc 0.02861f
C438 m1_236_6942# m1_2117_7612# 0.00373f
C439 m1_4904_6422# aux 0
C440 mreset vbn_ref 0
C441 sta vm 0.05095f
C442 m1_3704_1572# en 0.0234f
C443 vdd m1_2420_7480# 0.05426f
C444 a_2160_3542# el 0.00211f
C445 a_2080_2940# a_2160_3542# 0.00884f
C446 vm vdd 1.89136f
C447 rsel vbp_st 0.128f
C448 t3 m1_236_6942# 0.15972f
C449 rsel abus 0.00241f
C450 vbn_ref a_2510_1690# 0.30364f
C451 vbp_syn hold 0.03183f
C452 a_3184_3624# m1_3160_6220# 0
C453 rsel m1_3360_972# 0.00193f
C454 a_2160_3542# vdd 0.33454f
C455 t1 m1_236_6942# 0.0833f
C456 a_2804_3624# spk 0.06362f
C457 stb spk 0.07052f
C458 vreset m1_208_2424# 0.00213f
C459 a_1632_2940# m1_208_2424# 0.26017f
C460 rsel sub_b 0.18764f
C461 vbp_st aux 0.02544f
C462 abus aux 0.0344f
C463 vsrc spk 0.15514f
C464 el m1_4052_1572# 0.03612f
C465 m1_3360_972# aux 0.02912f
C466 vreset en 1.82334f
C467 rsel a_3844_4734# 0
C468 vdd m1_4052_1572# 0.01699f
C469 vbn_prb m1_4904_6422# 0.12919f
C470 sub_b aux 0.0529f
C471 mreset vbn_leak 0.27992f
C472 m1_2260_4540# m1_208_2424# 0
C473 m1_1700_4540# a_480_5620# 0.14434f
C474 vbn_prb m1_4822_1769# 0.11722f
C475 sub a_480_5620# 0.02231f
C476 m1_224_7600# m1_4904_6422# 0
C477 a_3844_4734# aux 0
C478 m1_2117_7612# aux 0
C479 a_2510_1690# vbn_leak 0.17462f
C480 m1_2180_1416# abus 0
C481 el a_288_2940# 0.06336f
C482 hold m1_1700_4540# 0.00428f
C483 a_2080_2940# a_288_2940# 0.0036f
C484 t2 m1_224_7600# 0.03362f
C485 m1_2180_1416# m1_3360_972# 0
C486 vbn_prb vbp_st 1.61775f
C487 m1_236_6942# stb 0.00267f
C488 m1_4822_412# vsrc 0.00459f
C489 a_3184_3624# m1_208_2424# 0.00245f
C490 m1_1960_6220# m1_236_6942# 0.11833f
C491 m1_1545_7160# m1_853_6232# -0.00348f
C492 vbn_prb abus 0.30838f
C493 sub hold 0.10799f
C494 vbp_syn m1_1700_4540# 0
C495 vdd a_288_2940# 0.0017f
C496 vbn_prb m1_3360_972# 0.03281f
C497 m1_2180_1416# sub_b 0
C498 vsrc m1_2418_960# 0.02743f
C499 m1_224_7600# vbp_st 0
C500 a_480_5620# spk 0.18819f
C501 sub vbp_syn 0.04455f
C502 m1_4904_6422# vm 0.01392f
C503 vreset vbn_ref 0.04846f
C504 vbn_prb sub_b 0
C505 a_2510_1690# m1_2972_1572# 0.00303f
C506 m1_1545_4540# a_2510_1690# 0.04088f
C507 m1_4822_1769# vm 0.00177f
C508 t2 m1_2420_7480# 0
C509 t2 vm 0.06728f
C510 m1_224_7600# sub_b 0.03719f
C511 vbn_leak m1_3704_1572# 0
C512 vbn_prb a_3844_4734# 0
C513 vbn_leak m1_853_6232# 0.01425f
C514 t0 mreset 0
C515 hold spk 0.0034f
C516 vbp_st m1_2420_7480# 0.0031f
C517 vm vbp_st 0.48377f
C518 vm abus 0.12646f
C519 a_2804_3624# rsel 0.0486f
C520 vbp_syn spk 0.03582f
C521 stb rsel 0.12893f
C522 m1_224_7600# m1_2117_7612# 0.16273f
C523 vm m1_3360_972# 0.287f
C524 vsrc rsel 0.04462f
C525 a_2160_3542# vbp_st 0.08423f
C526 mreset el 0.02165f
C527 t3 m1_224_7600# 0.18495f
C528 sub_b m1_2420_7480# 0.028f
C529 vm sub_b 0.10308f
C530 mreset sta 0.06648f
C531 vbn_ref a_3184_3624# 0
C532 vreset vbn_leak 0.03376f
C533 t1 m1_224_7600# 0.0961f
C534 a_1632_2940# vbn_leak 0
C535 m1_236_6942# a_480_5620# 0.15111f
C536 mreset vdd 0.15497f
C537 a_2510_1690# el 0.12826f
C538 vsrc aux 0.04452f
C539 a_2080_2940# a_2510_1690# 0.2093f
C540 sub m1_1700_4540# 0.0539f
C541 a_2160_3542# sub_b 0
C542 a_3844_4734# vm 0
C543 m1_2117_7612# m1_2420_7480# 0.0806f
C544 sta a_2510_1690# 0
C545 vm m1_2117_7612# 0
C546 m1_3652_6752# m1_3160_6220# 0.17107f
C547 a_2510_1690# vdd 1.93326f
C548 abus m1_4052_1572# 0.00394f
C549 a_2160_3542# a_3844_4734# 0
C550 t3 vm 0.04439f
C551 m1_236_6942# hold 0.17995f
C552 t0 m1_853_6232# 0
C553 t1 m1_2420_7480# 0
C554 m1_1401_6220# m1_1545_7160# 0.07523f
C555 t1 vm 0.07767f
C556 vreset m1_2972_1572# 0.03957f
C557 sub_b m1_4052_1572# 0.05151f
C558 m1_236_6942# vbp_syn 0
C559 vbp_syn m1_2418_960# 0.03197f
C560 m1_208_2424# en 0
C561 m1_1545_4540# a_1632_2940# 0.08279f
C562 m1_1700_4540# spk 0.02065f
C563 sub spk 0.15294f
C564 rsel a_480_5620# 0.00413f
C565 a_3184_3624# vbn_leak 0.00226f
C566 vbp_st a_288_2940# 0
C567 vbn_prb vsrc 0.01316f
C568 stb m1_224_7600# 0
C569 m1_3704_1572# vdd 0.03146f
C570 m1_1545_4540# m1_2260_4540# 0.04043f
C571 m1_853_6232# vdd 0.1787f
C572 m1_1401_6220# vbn_leak 0.13336f
C573 t0 a_1632_2940# 0
C574 m1_224_7600# vsrc 0
C575 rsel hold 0.03241f
C576 vbp_syn rsel 0.07099f
C577 vbn_leak m1_3160_6220# 0.00316f
C578 vreset el 0.03695f
C579 a_1632_2940# el 0.04699f
C580 vreset a_2080_2940# 0.00594f
C581 stb m1_2420_7480# 0
C582 mreset m1_4904_6422# 0
C583 a_2080_2940# a_1632_2940# 0.07855f
C584 m1_1545_4540# a_3184_3624# 0.02064f
C585 t0 m1_2260_4540# 0
C586 m1_1960_6220# m1_2420_7480# 0.00505f
C587 hold aux 0.02114f
C588 a_2804_3624# vm 0.00202f
C589 stb vm 0.0741f
C590 vreset sta 0
C591 m1_1960_6220# vm 0.04852f
C592 vreset vdd 0.36458f
C593 vsrc vm 0.24843f
C594 a_1632_2940# vdd 0.66248f
C595 vbp_syn aux 0.11067f
C596 a_2510_1690# m1_4904_6422# 0.25695f
C597 a_2804_3624# a_2160_3542# 0.18601f
C598 vbn_ref en 1.68618f
C599 m1_236_6942# sub 0.02809f
C600 sub m1_2418_960# 0.01064f
C601 m1_2260_4540# el 0
C602 a_2160_3542# vsrc 0.26445f
C603 a_2080_2940# m1_2260_4540# 0
C604 m1_236_6942# m1_1104_8052# 0
C605 mreset vbp_st 0
C606 mreset abus 0
C607 m1_2260_4540# vdd 0.18495f
C608 m1_224_7600# a_480_5620# 0.01286f
C609 a_2510_1690# vbp_st 0.14353f
C610 a_2510_1690# abus 0.02191f
C611 a_3184_3624# el 0
C612 m1_236_6942# spk 0.02752f
C613 vbn_prb hold 0.04424f
C614 m1_2180_1416# vbp_syn 0
C615 a_2510_1690# m1_3360_972# 0.00294f
C616 vbn_leak m1_208_2424# 0.1349f
C617 rsel m1_1700_4540# 0.07647f
C618 t0 m1_3160_6220# 0
C619 vbn_prb vbp_syn 0.05779f
C620 sub rsel 0.95078f
C621 a_2510_1690# sub_b 0.29268f
C622 a_3184_3624# vdd 0.36148f
C623 m1_224_7600# hold 0.18735f
C624 mreset m1_2117_7612# 0.00125f
C625 vbn_leak en 0.03996f
C626 a_480_5620# m1_2420_7480# 0.01103f
C627 m1_1401_6220# vdd 0.05014f
C628 m1_224_7600# vbp_syn 0
C629 t2 m1_853_6232# 0.01397f
C630 a_480_5620# vm 0.69417f
C631 a_2510_1690# a_3844_4734# 0.42001f
C632 el m1_3160_6220# 0.02136f
C633 sta m1_3160_6220# 0.19129f
C634 a_2160_3542# a_480_5620# 0.1941f
C635 m1_3704_1572# abus 0.0042f
C636 m1_1545_4540# m1_208_2424# 0
C637 hold m1_2420_7480# 0.20241f
C638 m1_3160_6220# vdd 0.22728f
C639 rsel spk 0.08329f
C640 hold vm 0.20344f
C641 m1_3704_1572# m1_3360_972# 0.00969f
C642 m1_2972_1572# en 0.0332f
C643 vbp_syn m1_2420_7480# 0
C644 m1_3652_6752# vbn_leak 0.00394f
C645 vbp_syn vm 0.26921f
C646 vreset m1_4822_1769# 0.00947f
C647 a_2160_3542# hold 0
C648 t2 a_1632_2940# 0
C649 spk aux 0
C650 a_2160_3542# vbp_syn 0
C651 m1_2180_1416# sub 0
C652 vbn_ref vbn_leak 0.01449f
C653 vreset vbp_st 0.0335f
C654 a_1632_2940# vbp_st 0.08281f
C655 vreset abus 1.79386f
C656 sub vbn_prb 0
C657 vreset m1_3360_972# 0.04877f
C658 t3 m1_853_6232# 0.07307f
C659 m1_208_2424# el 0.15601f
C660 sub m1_224_7600# 0
C661 a_2080_2940# m1_208_2424# 0.49393f
C662 m1_1545_7160# vbn_leak 0.31046f
C663 vreset sub_b 0
C664 t1 m1_853_6232# 0
C665 m1_236_6942# rsel 0.01037f
C666 a_480_5620# a_288_2940# -0.00149f
C667 m1_2260_4540# vbp_st 0.08969f
C668 el en 0.03422f
C669 rsel m1_2418_960# 0.01259f
C670 mreset vsrc 0.01061f
C671 m1_1104_8052# m1_224_7600# 0.01525f
C672 m1_208_2424# vdd 0.01837f
C673 a_2080_2940# en 0.00117f
C674 vreset a_3844_4734# 0
C675 a_2804_3624# a_2510_1690# 0.14876f
C676 sta en 0
C677 m1_4822_412# aux 0.00143f
C678 vbn_prb spk 0
C679 m1_1700_4540# m1_2420_7480# 0
C680 m1_1700_4540# vm 0.13571f
C681 t0 m1_3652_6752# 0
C682 vdd en 0.2062f
C683 a_2510_1690# vsrc 0.23591f
C684 m1_2260_4540# sub_b 0.13476f
C685 m1_236_6942# aux 0
C686 m1_2418_960# aux 0.02647f
C687 t3 a_1632_2940# 0
C688 sub m1_2420_7480# 0.14221f
C689 m1_1401_6220# t2 0.11936f
C690 m1_224_7600# spk 0.00693f
C691 sub vm 0.11441f
C692 a_3184_3624# vbp_st 0.00634f
C693 m1_4904_6422# m1_3160_6220# -0.01073f
C694 a_2160_3542# m1_1700_4540# 0.01876f
C695 m1_2260_4540# a_3844_4734# 0.01002f
C696 sub a_2160_3542# 0
C697 m1_1401_6220# vbp_st 0
C698 m1_3652_6752# el 0.03012f
C699 m1_3652_6752# sta 0.01767f
C700 a_3184_3624# sub_b 0.0096f
C701 m1_3652_6752# vdd 0.31219f
C702 m1_1960_6220# m1_853_6232# 0
C703 vbn_ref el 0
C704 vm spk 7.9201f
C705 m1_3160_6220# vbp_st 0
C706 t0 m1_1545_7160# 0.09475f
C707 m1_1401_6220# sub_b 0
C708 vbn_leak m1_2972_1572# 0.00431f
C709 a_3184_3624# a_3844_4734# 0.0024f
C710 m1_4822_412# vbn_prb 0.05814f
C711 m1_2180_1416# m1_2418_960# 0.02085f
C712 vbn_ref sta 0
C713 rsel aux 0.00121f
C714 a_2160_3542# spk 0.06279f
C715 vbn_prb m1_2418_960# 0.14867f
C716 vbn_ref vdd 0.3162f
C717 m1_1401_6220# m1_2117_7612# -0.00348f
C718 m1_3160_6220# sub_b 0.03175f
C719 a_2510_1690# a_480_5620# 0.08484f
C720 m1_236_6942# m1_224_7600# 0.27641f
C721 t0 vbn_leak 0.07721f
C722 mreset hold 0.02611f
C723 a_2804_3624# a_1632_2940# 0
C724 m1_1545_7160# vdd 0.00349f
C725 t1 m1_1401_6220# 0.04143f
C726 vreset vsrc 0.03343f
C727 mreset vbp_syn 0.27609f
C728 a_1632_2940# vsrc 0.09178f
C729 m1_4904_6422# en 0
C730 a_2510_1690# hold 0.23606f
C731 m1_4822_412# vm 0
C732 m1_2180_1416# rsel 0.00406f
C733 vbn_leak el 0.27903f
C734 m1_236_6942# m1_2420_7480# 0.08756f
C735 a_2080_2940# vbn_leak 0.01666f
C736 a_2510_1690# vbp_syn 0.17059f
C737 m1_4822_1769# en 0.09726f
C738 m1_236_6942# vm 0.0083f
C739 vbn_prb rsel 0
C740 stb m1_2260_4540# 0
C741 sta vbn_leak 0
C742 vm m1_2418_960# 0.18337f
C743 a_2804_3624# m1_2260_4540# 0.10298f
C744 m1_208_2424# vbp_st 0
C745 m1_208_2424# abus 0
C746 vbn_leak vdd 0.34767f
C747 m1_2260_4540# vsrc 0
C748 a_480_5620# m1_853_6232# 0.11453f
C749 m1_2180_1416# aux 0
C750 m1_208_2424# m1_3360_972# 0.0029f
C751 vbp_st en 0.03595f
C752 abus en 0.32452f
C753 vbn_prb aux 0
C754 a_288_2940# spk 0.31827f
C755 m1_208_2424# sub_b 0.18881f
C756 m1_3652_6752# m1_4904_6422# -0.01073f
C757 m1_3360_972# en 0.11305f
C758 m1_2972_1572# el 0
C759 a_2804_3624# a_3184_3624# 0.28769f
C760 a_3184_3624# stb 0
C761 m1_1545_4540# el 0
C762 aux vss 0.53139f
C763 m1_3360_972# vss 0.87849f
C764 m1_3652_6752# vss 0.04478f
C765 m1_1104_8052# vss -0.02371f
C766 m1_2180_1416# vss 0.21621f
C767 en vss 0.92805f
C768 abus vss 2.67689f
C769 sub vss 0.33833f
C770 mreset vss 0.47057f
C771 hold vss 0.92192f
C772 vdd vss 17.65263f
C773 m1_1545_7160# vss 0.10557f
C774 m1_2117_7612# vss 0.27084f
C775 m1_4822_412# vss 0.31983f
C776 m1_853_6232# vss 0.04261f
C777 t3 vss 0.25568f
C778 vbn_prb vss 0.79747f
C779 a_3184_3624# vss 0.13223f
C780 m1_1401_6220# vss -0.02549f
C781 t2 vss 0.19887f
C782 a_2804_3624# vss 0.10861f
C783 m1_1960_6220# vss -0.02044f
C784 t1 vss 0.21798f
C785 m1_224_7600# vss 1.70785f
C786 m1_236_6942# vss 0.64919f
C787 spk vss 0.53011f
C788 m1_2420_7480# vss 0.08035f
C789 t0 vss 0.22106f
C790 m1_2972_1572# vss -0.0377f
C791 rsel vss 0.715f
C792 m1_2260_4540# vss 0.00321f
C793 vm vss 4.6647f
C794 m1_3704_1572# vss -0.06813f
C795 m1_208_2424# vss 0.71089f
C796 a_288_2940# vss -0.17607f
C797 sub_b vss 1.2853f
C798 m1_1545_4540# vss -0.00719f
C799 vbp_st vss 0.72752f
C800 m1_3160_6220# vss 0.15545f
C801 stb vss 0.19214f
C802 sta vss 0.27115f
C803 m1_2418_960# vss 0.57957f
C804 a_2160_3542# vss 0.17295f
C805 vsrc vss 1.11045f
C806 vreset vss 0.49272f
C807 a_2510_1690# vss 2.40944f
C808 m1_4822_1769# vss 0.0108f
C809 m1_1700_4540# vss -0.07631f
C810 vbn_ref vss 0.65792f
C811 a_2080_2940# vss 0.3479f
C812 a_1632_2940# vss 0.20862f
C813 a_3844_4734# vss 0.07344f
C814 m1_4904_6422# vss 0.05408f
C815 vbp_syn vss 1.35979f
C816 el vss 0.66895f
C817 vbn_leak vss 3.67743f
C818 m1_4052_1572# vss -0.06831f
C819 a_480_5620# vss 0.29671f
.ends
