* NGSPICE file created from slot_ah_h.ext - technology: gf180mcuD

.subckt p_w2_l4 a_400_n200# a_n400_n244# w_n574_n330# a_n488_n200# VSUBS
X0 a_400_n200# a_n400_n244# a_n488_n200# w_n574_n330# pfet_03v3 ad=0.88p pd=4.88u as=0.88p ps=4.88u w=2u l=4u
C0 a_n400_n244# a_400_n200# 0.07019f
C1 a_n488_n200# a_400_n200# 0.01073f
C2 a_n400_n244# a_n488_n200# 0.07019f
C3 w_n574_n330# a_400_n200# 0.07409f
C4 a_n400_n244# w_n574_n330# 0.42229f
C5 a_n488_n200# w_n574_n330# 0.07409f
C6 a_400_n200# VSUBS 0.18936f
C7 a_n488_n200# VSUBS 0.18936f
C8 w_n574_n330# VSUBS 2.27304f
.ends

.subckt p_w0p22_l1 a_100_n22# a_n100_n66# w_n278_n159# a_n192_n36# VSUBS
X0 a_100_n22# a_n100_n66# a_n192_n36# w_n278_n159# pfet_03v3 ad=0.1516p pd=1.64u as=0.1516p ps=1.64u w=0.22u l=1u
C0 a_n192_n36# a_100_n22# 0.00453f
C1 a_n100_n66# a_100_n22# 0.00509f
C2 a_n192_n36# a_n100_n66# 0.00509f
C3 w_n278_n159# a_100_n22# 0.00771f
C4 a_n192_n36# w_n278_n159# 0.00771f
C5 a_n100_n66# w_n278_n159# 0.13163f
C6 a_100_n22# VSUBS 0.05952f
C7 a_n192_n36# VSUBS 0.05952f
C8 w_n278_n159# VSUBS 0.53042f
.ends

.subckt n_w1_l0p28 a_28_n100# a_n28_n144# a_n116_n100# VSUBS
X0 a_28_n100# a_n28_n144# a_n116_n100# VSUBS nfet_03v3 ad=0.44p pd=2.88u as=0.44p ps=2.88u w=1u l=0.28u
C0 a_n116_n100# a_28_n100# 0.04256f
C1 a_n116_n100# a_n28_n144# 0.00769f
C2 a_28_n100# a_n28_n144# 0.00769f
C3 a_28_n100# VSUBS 0.09911f
C4 a_n116_n100# VSUBS 0.09911f
.ends

.subckt n_w2_l2 a_n288_n200# a_200_n200# a_n200_n244# VSUBS
X0 a_200_n200# a_n200_n244# a_n288_n200# VSUBS nfet_03v3 ad=0.88p pd=4.88u as=0.88p ps=4.88u w=2u l=2u
C0 a_n288_n200# a_200_n200# 0.02133f
C1 a_n288_n200# a_n200_n244# 0.0587f
C2 a_200_n200# a_n200_n244# 0.0587f
C3 a_200_n200# VSUBS 0.2667f
C4 a_n288_n200# VSUBS 0.2667f
.ends

.subckt n_w2_l4 a_400_n200# a_n400_n244# a_n488_n200# VSUBS
X0 a_400_n200# a_n400_n244# a_n488_n200# VSUBS nfet_03v3 ad=0.88p pd=4.88u as=0.88p ps=4.88u w=2u l=4u
C0 a_n488_n200# a_400_n200# 0.01073f
C1 a_n488_n200# a_n400_n244# 0.07019f
C2 a_400_n200# a_n400_n244# 0.07019f
C3 a_400_n200# VSUBS 0.41684f
C4 a_n488_n200# VSUBS 0.41684f
.ends

.subckt n_w4_l0p5_k1 a_n188_n400# a_50_n400# a_n50_n444# VSUBS
X0 a_50_n400# a_n50_n444# a_n188_n400# VSUBS nfet_03v3 ad=2.76p pd=9.38u as=2.76p ps=9.38u w=4u l=0.5u
C0 a_n188_n400# a_50_n400# 0.10174f
C1 a_n188_n400# a_n50_n444# 0.04238f
C2 a_50_n400# a_n50_n444# 0.04238f
C3 a_50_n400# VSUBS 0.23105f
C4 a_n188_n400# VSUBS 0.23105f
.ends

.subckt n_w0p5_l0p28 a_n28_n94# a_n116_n50# a_28_n50# VSUBS
X0 a_28_n50# a_n28_n94# a_n116_n50# VSUBS nfet_03v3 ad=0.22p pd=1.88u as=0.22p ps=1.88u w=0.5u l=0.28u
C0 a_n116_n50# a_28_n50# 0.02085f
C1 a_n116_n50# a_n28_n94# 0.00377f
C2 a_28_n50# a_n28_n94# 0.00377f
C3 a_28_n50# VSUBS 0.07987f
C4 a_n116_n50# VSUBS 0.07987f
.ends

.subckt p_w1_l0p5 a_n138_n100# a_50_n100# a_n50_n144# w_n224_n230# VSUBS
X0 a_50_n100# a_n50_n144# a_n138_n100# w_n224_n230# pfet_03v3 ad=0.44p pd=2.88u as=0.44p ps=2.88u w=1u l=0.5u
C0 a_n50_n144# a_50_n100# 0.01275f
C1 a_n138_n100# a_50_n100# 0.03085f
C2 a_n50_n144# a_n138_n100# 0.01275f
C3 w_n224_n230# a_50_n100# 0.0205f
C4 a_n50_n144# w_n224_n230# 0.07993f
C5 a_n138_n100# w_n224_n230# 0.0205f
C6 a_50_n100# VSUBS 0.06546f
C7 a_n138_n100# VSUBS 0.06546f
C8 w_n224_n230# VSUBS 0.61824f
.ends

.subckt n_w1_l0p5 a_n138_n100# a_50_n100# a_n50_n144# VSUBS
X0 a_50_n100# a_n50_n144# a_n138_n100# VSUBS nfet_03v3 ad=0.44p pd=2.88u as=0.44p ps=2.88u w=1u l=0.5u
C0 a_n138_n100# a_50_n100# 0.03085f
C1 a_n138_n100# a_n50_n144# 0.01275f
C2 a_50_n100# a_n50_n144# 0.01275f
C3 a_50_n100# VSUBS 0.11563f
C4 a_n138_n100# VSUBS 0.11563f
.ends

.subckt p_w1_l0p28 w_n202_n230# a_28_n100# a_n28_n144# a_n116_n100# VSUBS
X0 a_28_n100# a_n28_n144# a_n116_n100# w_n202_n230# pfet_03v3 ad=0.44p pd=2.88u as=0.44p ps=2.88u w=1u l=0.28u
C0 a_n28_n144# a_28_n100# 0.00769f
C1 a_n116_n100# a_28_n100# 0.04256f
C2 a_n28_n144# a_n116_n100# 0.00769f
C3 w_n202_n230# a_28_n100# 0.01808f
C4 a_n28_n144# w_n202_n230# 0.05841f
C5 a_n116_n100# w_n202_n230# 0.01808f
C6 a_28_n100# VSUBS 0.0597f
C7 a_n116_n100# VSUBS 0.0597f
C8 w_n202_n230# VSUBS 0.55752f
.ends

.subckt n_w4_l2 a_n288_n400# a_200_n400# a_n200_n444# VSUBS
X0 a_200_n400# a_n200_n444# a_n288_n400# VSUBS nfet_03v3 ad=1.76p pd=8.88u as=1.76p ps=8.88u w=4u l=2u
C0 a_n288_n400# a_200_n400# 0.04287f
C1 a_n288_n400# a_n200_n444# 0.11799f
C2 a_200_n400# a_n200_n444# 0.11799f
C3 a_200_n400# VSUBS 0.34365f
C4 a_n288_n400# VSUBS 0.34365f
.ends

.subckt p_w1_l2 w_n374_n230# a_n288_n100# a_200_n100# a_n200_n144# VSUBS
X0 a_200_n100# a_n200_n144# a_n288_n100# w_n374_n230# pfet_03v3 ad=0.44p pd=2.88u as=0.44p ps=2.88u w=1u l=2u
C0 a_n200_n144# a_200_n100# 0.02905f
C1 a_n288_n100# a_200_n100# 0.01056f
C2 a_n200_n144# a_n288_n100# 0.02905f
C3 w_n374_n230# a_200_n100# 0.03135f
C4 a_n200_n144# w_n374_n230# 0.22666f
C5 a_n288_n100# w_n374_n230# 0.03135f
C6 a_200_n100# VSUBS 0.1047f
C7 a_n288_n100# VSUBS 0.1047f
C8 w_n374_n230# VSUBS 1.03224f
.ends

.subckt n_w7p07_l7p07 a_707_n707# a_n795_n707# a_n707_n751# VSUBS
X0 a_707_n707# a_n707_n751# a_n795_n707# VSUBS nfet_03v3 ad=3.1108p pd=15.02u as=3.1108p ps=15.02u w=7.07u l=7.07u
C0 a_n795_n707# a_707_n707# 0.0212f
C1 a_n795_n707# a_n707_n751# 0.27012f
C2 a_707_n707# a_n707_n751# 0.27012f
C3 a_707_n707# VSUBS 0.84237f
C4 a_n795_n707# VSUBS 0.84237f
.ends

.subckt n_w0p5_l1p5 a_150_n50# a_n238_n50# a_n150_n94# VSUBS
X0 a_150_n50# a_n150_n94# a_n238_n50# VSUBS nfet_03v3 ad=0.22p pd=1.88u as=0.22p ps=1.88u w=0.5u l=1.5u
C0 a_n238_n50# a_150_n50# 0.00671f
C1 a_n238_n50# a_n150_n94# 0.01269f
C2 a_150_n50# a_n150_n94# 0.01269f
C3 a_150_n50# VSUBS 0.17146f
C4 a_n238_n50# VSUBS 0.17146f
.ends

.subckt n_w3p54_l3p54 a_354_n354# a_n354_n398# a_n442_n354# VSUBS
X0 a_354_n354# a_n354_n398# a_n442_n354# VSUBS nfet_03v3 ad=1.5576p pd=7.96u as=1.5576p ps=7.96u w=3.54u l=3.54u
C0 a_n442_n354# a_354_n354# 0.02161f
C1 a_n442_n354# a_n354_n398# 0.12189f
C2 a_354_n354# a_n354_n398# 0.12189f
C3 a_354_n354# VSUBS 0.44156f
C4 a_n442_n354# VSUBS 0.44156f
.ends

.subckt n_w0p22_l2 a_200_n22# a_n200_n66# a_n292_n36# VSUBS
X0 a_200_n22# a_n200_n66# a_n292_n36# VSUBS nfet_03v3 ad=0.1516p pd=1.64u as=0.1516p ps=1.64u w=0.22u l=2u
C0 a_n200_n66# a_200_n22# 0.00705f
C1 a_n200_n66# a_n292_n36# 0.00705f
C2 a_200_n22# a_n292_n36# 0.00245f
C3 a_200_n22# VSUBS 0.20767f
C4 a_n292_n36# VSUBS 0.20767f
.ends

.subckt n_w0p5_l3 a_n388_n50# a_300_n50# a_n300_n94# VSUBS
X0 a_300_n50# a_n300_n94# a_n388_n50# VSUBS nfet_03v3 ad=0.22p pd=1.88u as=0.22p ps=1.88u w=0.5u l=3u
C0 a_n388_n50# a_300_n50# 0.00348f
C1 a_n388_n50# a_n300_n94# 0.01602f
C2 a_300_n50# a_n300_n94# 0.01602f
C3 a_300_n50# VSUBS 0.28406f
C4 a_n388_n50# VSUBS 0.28406f
.ends

.subckt n_w0p5_l4 a_n488_n50# a_400_n50# a_n400_n94# VSUBS
X0 a_400_n50# a_n400_n94# a_n488_n50# VSUBS nfet_03v3 ad=0.22p pd=1.88u as=0.22p ps=1.88u w=0.5u l=4u
C0 a_n488_n50# a_400_n50# 0.0026f
C1 a_n488_n50# a_n400_n94# 0.01702f
C2 a_400_n50# a_n400_n94# 0.01702f
C3 a_400_n50# VSUBS 0.35913f
C4 a_n488_n50# VSUBS 0.35913f
.ends

.subckt slot_ah_h vss vbp_syn vdd el aux vbn_leak vsrc vbp_st vbn_prb vbn_ref en vreset
+ abus spk t3 t2 t1 t0 sta stb hold mreset rsel sub sub_b vm
XXL_XP1 a_480_5620# a_480_5620# vdd vdd vss p_w2_l4
XXD_XK a_3184_3624# spk vdd vdd vss p_w0p22_l1
XXPM_XSW m1_4052_1572# rsel m1_3704_1572# vss n_w1_l0p28
XXL_XP2 a_1682_2940# a_480_5620# vdd vdd vss p_w2_l4
XXPR_XMB vss m1_4802_1762# vbn_prb vss n_w2_l2
XXL_XMT m1_644_2312# vbn_leak vss vss n_w2_l4
XXL_XM1 a_338_2940# a_480_5620# el vss n_w4_l0p5_k1
XXS_XWA m1_4904_6422# vbp_syn vdd m1_3652_6232# vss p_w2_l4
XXR_Xi_XN spk vss a_3844_4734# vss n_w0p5_l0p28
XXL_XM2 a_2578_2940# a_1682_2940# a_1682_2940# vss n_w4_l0p5_k1
XXS_XWB m1_4904_6422# vbp_syn vdd m1_3212_6232# vss p_w2_l4
XXR_XNR vss vbn_ref a_2510_1740# vss n_w2_l4
XXD_XPI m1_1692_4664# a_2160_3542# vm vdd vss p_w1_l0p5
XXPR_XME m1_2424_756# en m1_4802_1762# vss n_w1_l0p28
XXR_XSW vreset vm a_2510_1740# vss n_w1_l0p5
XXR_Xi_XP vdd a_3844_4734# spk vdd vss p_w1_l0p28
XXD_XNI vsrc a_2160_3542# vm vss n_w1_l0p5
XXPR_XMF m1_2424_756# vdd a_2510_1740# vss n_w4_l2
XXS_XQA vdd m1_3652_6232# sta vss vss p_w1_l0p28
XXS_XQB vdd m1_3212_6232# stb vss vss p_w1_l0p28
XXS_XNA sta vm m1_3652_6232# vss n_w0p5_l0p28
XXS_XNB stb vm m1_3212_6232# vss n_w0p5_l0p28
XXD_XS2 vdd vdd m1_2260_4540# vbp_st vss p_w1_l2
XXD_XPS vdd vdd m1_1692_4664# vbp_st vss p_w1_l2
XXD_XS3 vdd vdd m1_1545_4540# vbp_st vss p_w1_l2
XXL_XD2a m1_644_2312# a_2578_2940# a_2578_2940# vss n_w4_l0p5_k1
XXPM_XSB abus sub_b m1_4052_1572# vss n_w1_l0p28
XXL_XD2b m1_644_2312# a_2578_2940# a_2578_2940# vss n_w4_l0p5_k1
XXL_XD1a m1_644_2312# a_338_2940# a_338_2940# vss n_w4_l0p5_k1
XXPM_XSC m1_3704_1572# en m1_3348_960# vss n_w1_l0p28
XXC_XC vss vss vm vss n_w7p07_l7p07
XXS_XPH vdd m1_4904_6422# vdd hold vss p_w1_l2
XXT_XR1 m1_2105_7600# m1_1557_7120# vbn_leak vss n_w0p5_l1p5
XXD_XP2 vdd a_2804_3624# a_2160_3542# m1_2260_4540# vss p_w1_l0p28
XXL_XD1b m1_644_2312# a_338_2940# a_338_2940# vss n_w4_l0p5_k1
XXPR_XSW m1_2972_1572# rsel m1_2260_960# vss n_w1_l0p28
XXT_XR2 m1_208_6996# m1_2105_7600# vbn_leak vss n_w0p5_l1p5
XXT_XP0 vdd m1_2436_6996# t0 vm vss p_w1_l0p28
XXD_Xi4_XN a_3184_3624# vss spk vss n_w0p5_l0p28
XXD_XP3 vdd a_3184_3624# a_2804_3624# m1_1545_4540# vss p_w1_l0p28
XXT_XR3 m1_208_7600# m1_208_6996# vbn_leak vss n_w0p5_l1p5
XXT_XP1 vdd m1_1973_6232# t1 vm vss p_w1_l0p28
XXR_XCR_XC vss a_2510_1740# vss vss n_w3p54_l3p54
XXD_XN2 a_2804_3624# a_2160_3542# vsrc vss n_w0p22_l2
XXT_XN0 t0 a_480_5620# m1_2436_6996# vss n_w0p5_l0p28
XXT_XP2 vdd m1_1401_6720# t2 vm vss p_w1_l0p28
XXD_Xi4_XP vdd spk a_3184_3624# vdd vss p_w1_l0p28
XXD_XN3 a_2804_3624# vsrc a_3184_3624# vss n_w0p5_l0p28
XXPM_XMB vss m1_4822_412# vbn_prb vss n_w2_l2
XXT_XN1 t1 a_480_5620# m1_1973_6232# vss n_w0p5_l0p28
XXT_XP3 vdd m1_796_6120# t3 vm vss p_w1_l0p28
XXT_XL0 m1_2436_6996# m1_208_7600# vbn_leak vss n_w0p5_l3
XXT_XN2 t2 a_480_5620# m1_1401_6720# vss n_w0p5_l0p28
XXT_XLT m1_208_7600# vdd vbn_leak vss n_w0p5_l3
XXT_XL1 m1_1973_6232# m1_208_6996# vbn_leak vss n_w0p5_l3
XXT_XN3 t3 a_480_5620# m1_796_6120# vss n_w0p5_l0p28
XXR_XPC vdd a_2510_1740# a_3844_4734# vdd vss p_w1_l0p28
XXPM_XME m1_3348_960# en m1_4822_412# vss n_w1_l0p28
XXT_XL2 m1_1401_6720# m1_2105_7600# vbn_leak vss n_w0p5_l3
XXT_XL3 m1_796_6120# m1_1557_7120# vbn_leak vss n_w0p5_l3
XXPM_XMF m1_3348_960# vdd vm vss n_w4_l2
XXS_XHL vdd vm hold a_1682_2940# vss p_w1_l0p28
XXS_XMR mreset a_2510_1740# vdd vss n_w0p5_l0p28
XXPR_XSB abus sub m1_2972_1572# vss n_w1_l0p28
XXPR_XSC m1_2424_756# en m1_2260_960# vss n_w1_l0p28
XXT_XRB m1_1104_8052# m1_1557_7120# vbn_leak vss n_w0p5_l4
XXT_XRA vss m1_1104_8052# vbn_leak vss n_w0p5_l4
C0 vreset a_2510_1740# 0.09771f
C1 a_3184_3624# sub 0.0629f
C2 vreset a_3844_4734# 0
C3 m1_2424_756# m1_4802_1762# 0.02111f
C4 vreset m1_4802_1762# 0.00845f
C5 m1_1401_6720# hold 0.00249f
C6 t0 m1_3212_6232# 0
C7 stb rsel 0.12542f
C8 vbn_prb rsel 0
C9 m1_644_2312# en 0.01881f
C10 a_2804_3624# a_2578_2940# 0
C11 a_480_5620# vsrc 0.13021f
C12 vdd hold 1.97062f
C13 t0 vm 0.0619f
C14 vbn_prb a_2510_1740# 0.21435f
C15 spk m1_1692_4664# 0.01628f
C16 vbn_prb a_3844_4734# 0
C17 t1 m1_1557_7120# 0.2089f
C18 vbn_prb m1_4802_1762# 0.12042f
C19 m1_3212_6232# sta 0.32895f
C20 a_480_5620# m1_2260_4540# 0.06854f
C21 vreset mreset 0
C22 spk a_2804_3624# 0.00565f
C23 m1_2105_7600# m1_2436_6996# 0.00869f
C24 vbp_st a_480_5620# 0.2038f
C25 sta vm 0.04872f
C26 a_480_5620# vbp_syn 0
C27 m1_4904_6422# hold 0.69894f
C28 m1_2424_756# en 0.11395f
C29 m1_3348_960# sub_b 0
C30 vreset en 1.8638f
C31 stb mreset 0.0015f
C32 m1_208_7600# vsrc 0
C33 m1_3212_6232# rsel 0
C34 vbn_prb mreset 0
C35 vdd m1_2972_1572# 0.00395f
C36 a_2804_3624# m1_644_2312# 0
C37 vm rsel 0.07803f
C38 vm a_2510_1740# 0.23084f
C39 vbn_prb en 0.06545f
C40 vdd vbn_ref 0.31335f
C41 vm a_3844_4734# 0.00745f
C42 m1_208_7600# vbp_st 0
C43 a_3184_3624# rsel 0.15677f
C44 m1_208_7600# vbp_syn 0.00151f
C45 vbn_leak hold 0.0804f
C46 m1_796_6120# m1_1973_6232# 0
C47 a_2578_2940# m1_1545_4540# 0
C48 a_3184_3624# a_2510_1740# 0.00254f
C49 a_3184_3624# a_3844_4734# 0.05848f
C50 m1_2105_7600# sub 0
C51 m1_3212_6232# mreset 0.03263f
C52 m1_208_6996# el 0
C53 m1_4904_6422# vbn_ref 0.11398f
C54 a_2160_3542# hold 0.00479f
C55 spk m1_1545_4540# 0.00253f
C56 vm mreset 0
C57 t3 hold 0.01686f
C58 m1_2436_6996# sub 0.13959f
C59 vdd m1_4822_412# 0.0096f
C60 m1_796_6120# vm 0.08148f
C61 vbn_leak m1_2972_1572# 0
C62 vsrc a_2578_2940# 0.13779f
C63 t0 m1_2105_7600# 0.07342f
C64 vm en 0.10525f
C65 m1_1692_4664# m1_1973_6232# 0
C66 t1 m1_208_6996# 0.08524f
C67 vbn_leak vbn_ref 0.014f
C68 m1_2260_4540# a_2578_2940# 0
C69 m1_2424_756# m1_4052_1572# 0.01864f
C70 spk vsrc 0.15417f
C71 m1_796_6120# t2 0.00336f
C72 t0 m1_2436_6996# 0.187f
C73 m1_2260_960# m1_3348_960# 0
C74 a_2578_2940# vbp_syn 0
C75 m1_3348_960# el 0.03642f
C76 spk m1_2260_4540# 0.21361f
C77 vdd m1_3652_6232# 0.24896f
C78 vm m1_1692_4664# 0.13124f
C79 vsrc m1_644_2312# 0.01829f
C80 a_480_5620# hold 0.86374f
C81 spk vbp_st 0.12536f
C82 spk vbp_syn 0.09009f
C83 abus sub 0.04017f
C84 a_2804_3624# vm 0
C85 m1_2105_7600# rsel 0
C86 t1 m1_1104_8052# 0.00165f
C87 a_3184_3624# m1_1692_4664# 0.00327f
C88 m1_208_6996# aux 0
C89 vbn_leak m1_4822_412# 0.00192f
C90 m1_2105_7600# a_2510_1740# 0
C91 m1_4904_6422# m1_3652_6232# -0.01073f
C92 a_3184_3624# a_2804_3624# 0.2629f
C93 vdd sub_b 0.41395f
C94 m1_2436_6996# rsel 0.00607f
C95 vbp_st m1_644_2312# 0
C96 m1_1557_7120# m1_208_6996# 0.14411f
C97 m1_644_2312# vbp_syn 0.10157f
C98 m1_2424_756# vsrc 0.03711f
C99 t0 sub 0.06097f
C100 vreset vsrc 0.0346f
C101 m1_208_7600# hold 0.0057f
C102 m1_2105_7600# mreset 0
C103 vbn_leak m1_3652_6232# 0.00306f
C104 stb vsrc 0
C105 vbn_prb vsrc 0.01206f
C106 vbp_st m1_2424_756# 0.03031f
C107 m1_2424_756# vbp_syn 0.12655f
C108 vbp_st vreset 0.03544f
C109 m1_3348_960# aux 0.03125f
C110 vreset vbp_syn 0.04129f
C111 m1_1557_7120# m1_1104_8052# -0.0026f
C112 stb m1_2260_4540# 0
C113 el a_1682_2940# 0.02486f
C114 vm m1_1545_4540# 0.03028f
C115 rsel sub 0.41869f
C116 vbn_leak sub_b 0.0817f
C117 stb vbp_st 0
C118 abus rsel 0.00147f
C119 stb vbp_syn 0.00619f
C120 a_2510_1740# sub 0.15027f
C121 vbn_prb vbp_st 1.71612f
C122 t0 sta 0
C123 a_3844_4734# sub 0.15818f
C124 a_3184_3624# m1_1545_4540# 0.02174f
C125 vbn_prb vbp_syn 0.03049f
C126 abus a_2510_1740# 0.04722f
C127 abus a_3844_4734# 0
C128 abus m1_4802_1762# 0.30809f
C129 a_2160_3542# sub_b 0
C130 m1_2260_960# m1_3704_1572# 0
C131 t1 a_1682_2940# 0
C132 t0 rsel 0
C133 vsrc vm 0.12664f
C134 m1_2260_960# vdd 0
C135 vdd el 2.04122f
C136 abus mreset 0
C137 a_3184_3624# vsrc 0.03406f
C138 spk hold 0.25952f
C139 vm m1_2260_4540# 0.00579f
C140 vbp_st m1_3212_6232# 0.00157f
C141 m1_3212_6232# vbp_syn 0.1263f
C142 sub en 0.04402f
C143 a_3184_3624# m1_2260_4540# 0.02374f
C144 sta a_2510_1740# 0
C145 vbp_st vm 0.12925f
C146 vm vbp_syn 0.11368f
C147 t1 m1_1401_6720# 0.07362f
C148 abus en 0.2665f
C149 a_3184_3624# vbp_st 0.00366f
C150 a_3184_3624# vbp_syn 0
C151 t0 mreset 0
C152 t1 vdd 0.11574f
C153 a_480_5620# sub_b 0
C154 spk m1_2972_1572# 0
C155 rsel a_2510_1740# 0.16878f
C156 a_3844_4734# rsel 0.07252f
C157 vbp_st t2 0
C158 sta mreset 0.01507f
C159 m1_1692_4664# sub 0.06319f
C160 a_3844_4734# a_2510_1740# 0.20873f
C161 m1_208_6996# m1_1104_8052# 0
C162 m1_4802_1762# a_2510_1740# 0
C163 m1_2260_960# vbn_leak 0
C164 spk vbn_ref 0
C165 a_2804_3624# sub 0.18452f
C166 vbn_leak el 0.14663f
C167 vreset hold 0.00188f
C168 sta en 0
C169 m1_2260_960# a_2160_3542# 0
C170 vdd aux 0.18345f
C171 m1_208_7600# sub_b 0.00319f
C172 a_2160_3542# el 0
C173 m1_1557_7120# m1_1401_6720# 0.0089f
C174 a_2510_1740# mreset 0.05003f
C175 m1_644_2312# vbn_ref 0
C176 stb hold 0.01097f
C177 t0 m1_1692_4664# 0
C178 vbn_prb hold 0.14538f
C179 vdd m1_1557_7120# 0
C180 t0 a_2804_3624# 0
C181 rsel en 0.06091f
C182 t1 vbn_leak 0.17958f
C183 vbp_st a_338_2940# 0
C184 vreset m1_2972_1572# 0
C185 m1_2424_756# m1_2972_1572# 0.00134f
C186 a_2510_1740# en 0.53513f
C187 a_3844_4734# en 0
C188 m1_4802_1762# en 0.11368f
C189 abus m1_4052_1572# 0.00324f
C190 m1_2424_756# vbn_ref 0.03822f
C191 vreset vbn_ref 0.04932f
C192 t1 t3 0
C193 m1_2105_7600# vbp_syn 0
C194 m1_1545_4540# sub 0.18385f
C195 rsel m1_1692_4664# 0.00536f
C196 m1_3212_6232# hold 0
C197 mreset en 0
C198 vbn_leak aux 1.70203f
C199 a_2804_3624# rsel 0.01776f
C200 m1_1692_4664# a_2510_1740# 0
C201 m1_2436_6996# vbp_st 0
C202 a_3844_4734# m1_1692_4664# 0
C203 spk m1_3652_6232# 0.00816f
C204 vm hold 0.31488f
C205 m1_2436_6996# vbp_syn 0
C206 a_480_5620# el 0.19264f
C207 vbn_prb vbn_ref 1.74886f
C208 a_2804_3624# a_2510_1740# 0
C209 sub_b a_2578_2940# 0
C210 a_2804_3624# a_3844_4734# 0.18981f
C211 a_3184_3624# hold 0.16211f
C212 vbn_leak m1_1557_7120# 0.18642f
C213 vreset m1_4822_412# 0.02001f
C214 spk sub_b 0.56334f
C215 vsrc sub 0.04387f
C216 t2 hold 0
C217 abus vsrc 0.09671f
C218 vm m1_2972_1572# 0.00716f
C219 t1 a_480_5620# 0.16686f
C220 m1_208_7600# el 0
C221 vbn_prb m1_4822_412# 0.11076f
C222 m1_2260_4540# sub 0.16212f
C223 m1_4052_1572# rsel 0
C224 m1_1401_6720# m1_208_6996# 0.07759f
C225 sub_b m1_644_2312# 0.07618f
C226 m1_4052_1572# a_2510_1740# 0
C227 vm vbn_ref 0
C228 vbp_st sub 0.13823f
C229 sub vbp_syn 0.05211f
C230 abus vbp_st 0.1157f
C231 abus vbp_syn 0.06436f
C232 vdd m1_208_6996# 0.04957f
C233 a_3184_3624# vbn_ref 0
C234 t1 m1_208_7600# 0.03518f
C235 t0 m1_2260_4540# 0
C236 a_3844_4734# m1_1545_4540# 0.00997f
C237 sta vsrc 0
C238 m1_2424_756# sub_b 0.00906f
C239 vreset sub_b 0
C240 t0 vbp_st 0
C241 t0 vbp_syn 0
C242 a_2804_3624# m1_1692_4664# 0.00417f
C243 vm m1_4822_412# 0
C244 a_480_5620# m1_1557_7120# 0
C245 vsrc rsel 0.03617f
C246 m1_2105_7600# hold 0
C247 stb sub_b 0.1209f
C248 m1_4052_1572# en 0.00567f
C249 m1_2260_960# a_2578_2940# 0.05203f
C250 vbp_st sta 0.00349f
C251 sta vbp_syn 0.02674f
C252 m1_3348_960# m1_3704_1572# 0.00111f
C253 vbn_prb sub_b 0.00243f
C254 el a_2578_2940# 0.22663f
C255 vsrc a_2510_1740# 0.38859f
C256 m1_3348_960# vdd 0.41284f
C257 vsrc a_3844_4734# 0.28359f
C258 m1_208_7600# aux 0
C259 vsrc m1_4802_1762# 0
C260 m1_2260_4540# rsel 0.07376f
C261 spk m1_2260_960# 0
C262 vbn_leak m1_208_6996# 0.75158f
C263 m1_2436_6996# hold 0.02375f
C264 m1_3212_6232# m1_3652_6232# 0.04772f
C265 spk el 0.16218f
C266 m1_2260_4540# a_2510_1740# 0.00255f
C267 m1_2260_4540# a_3844_4734# 0
C268 vbp_st rsel 0.04306f
C269 rsel vbp_syn 0.03843f
C270 m1_208_7600# m1_1557_7120# 0.00966f
C271 vm m1_3652_6232# 0.00843f
C272 vbp_st a_2510_1740# 0.27337f
C273 a_2510_1740# vbp_syn 0.32753f
C274 vbp_st a_3844_4734# 0.00313f
C275 vbp_st m1_4802_1762# 0.00495f
C276 a_3844_4734# vbp_syn 0.11205f
C277 vsrc mreset 0.01114f
C278 m1_3212_6232# sub_b 0.10497f
C279 t3 m1_208_6996# 0.13726f
C280 m1_2260_960# m1_644_2312# 0.03702f
C281 el m1_644_2312# 0.23298f
C282 m1_2260_4540# mreset 0
C283 vbn_leak m1_1104_8052# 0.01525f
C284 vm sub_b 0.06978f
C285 m1_1692_4664# m1_1545_4540# 0.0971f
C286 t1 spk 0
C287 vsrc en 0.03704f
C288 a_2804_3624# m1_1545_4540# 0.20376f
C289 vbp_st mreset 0
C290 a_3184_3624# sub_b 0.02576f
C291 mreset vbp_syn 0.29307f
C292 m1_3348_960# vbn_leak 0.03218f
C293 sub hold 0.34703f
C294 m1_2260_960# m1_2424_756# 0.01455f
C295 m1_2260_960# vreset 0.18148f
C296 abus hold 0
C297 t3 m1_1104_8052# 0
C298 a_2578_2940# aux 0
C299 m1_2424_756# el 0.03044f
C300 vreset el 0.03423f
C301 vbp_st en 0.03906f
C302 en vbp_syn 0.08363f
C303 vdd a_1682_2940# 0.72944f
C304 spk aux 0.00113f
C305 a_480_5620# m1_208_6996# 0.06844f
C306 a_2804_3624# vsrc 0.07256f
C307 stb el 0
C308 vbn_prb el 0
C309 t0 hold 0.00647f
C310 sub m1_2972_1572# 0
C311 m1_2260_4540# m1_1692_4664# 0.08395f
C312 abus m1_2972_1572# 0.01195f
C313 a_2804_3624# m1_2260_4540# 0.08448f
C314 vbp_st m1_1692_4664# 0.46088f
C315 m1_644_2312# aux 0
C316 sub vbn_ref 0
C317 sta hold 0
C318 vbp_st a_2804_3624# 0.00359f
C319 vdd m1_1401_6720# 0.06422f
C320 abus vbn_ref 0.09248f
C321 vdd m1_3704_1572# 0.03511f
C322 m1_208_7600# m1_208_6996# 0.31602f
C323 t1 stb 0
C324 m1_3212_6232# el 0.02332f
C325 rsel hold 0.34747f
C326 m1_2260_960# vm 0.13494f
C327 m1_2424_756# aux 0.03215f
C328 a_2510_1740# hold 0.56766f
C329 vreset aux 0.03456f
C330 vm el 0.07838f
C331 vbn_leak a_1682_2940# 0
C332 a_3844_4734# hold 0.22099f
C333 m1_4904_6422# vdd -0.07079f
C334 t1 m1_1973_6232# 0.07271f
C335 a_3184_3624# el 0
C336 abus m1_4822_412# 0.01227f
C337 m1_208_7600# m1_1104_8052# 0.00645f
C338 vsrc m1_1545_4540# 0.00157f
C339 a_2160_3542# a_1682_2940# 0.20541f
C340 m1_2436_6996# sub_b 0.00213f
C341 stb aux 0
C342 sta vbn_ref 0
C343 vbn_prb aux 0
C344 t3 a_1682_2940# 0
C345 rsel m1_2972_1572# 0.0346f
C346 m1_2260_4540# m1_1545_4540# 0.01391f
C347 vbn_leak m1_1401_6720# 0.21007f
C348 mreset hold 0
C349 t1 vm 0.06005f
C350 a_2510_1740# m1_2972_1572# 0.07005f
C351 stb m1_1557_7120# 0
C352 vbn_leak m1_3704_1572# 0
C353 m1_796_6120# hold 0.00244f
C354 vbp_st m1_1545_4540# 0.02577f
C355 rsel vbn_ref 0
C356 vdd vbn_leak 0.42469f
C357 hold en 0.01354f
C358 a_2510_1740# vbn_ref 0.32474f
C359 a_3844_4734# vbn_ref 0.00302f
C360 m1_4802_1762# vbn_ref 0.07567f
C361 t3 m1_1401_6720# 0
C362 vdd a_2160_3542# 0.29248f
C363 t1 t2 0.07819f
C364 m1_3212_6232# aux 0.00653f
C365 vsrc m1_2260_4540# 0
C366 m1_1557_7120# m1_1973_6232# 0.06718f
C367 spk m1_208_6996# 0.00884f
C368 m1_4904_6422# vbn_leak 0
C369 vdd t3 0.18084f
C370 sub_b sub 0.03832f
C371 abus sub_b 0.05253f
C372 vbp_st vsrc 1.68713f
C373 vm aux 0.00109f
C374 vsrc vbp_syn 0.18021f
C375 a_480_5620# a_1682_2940# 0.40965f
C376 el a_338_2940# 0.07883f
C377 t0 m1_3652_6232# 0
C378 mreset vbn_ref 0
C379 m1_1692_4664# hold 0.07608f
C380 m1_2972_1572# en 0.01609f
C381 vbp_st m1_2260_4540# 0.26668f
C382 a_2804_3624# hold 0.10403f
C383 m1_1557_7120# vm 0.00215f
C384 m1_2260_4540# vbp_syn 0.02219f
C385 sta m1_3652_6232# 0.0671f
C386 m1_2105_7600# el 0
C387 en vbn_ref 1.7775f
C388 vbp_st vbp_syn 0.20604f
C389 t0 sub_b 0
C390 a_480_5620# m1_1401_6720# 0.28759f
C391 m1_1557_7120# t2 0
C392 sta sub_b 0
C393 vdd a_480_5620# 2.28428f
C394 t3 vbn_leak 0.20601f
C395 m1_3652_6232# a_2510_1740# 0
C396 m1_3652_6232# a_3844_4734# 0
C397 t1 m1_2105_7600# 0
C398 m1_3348_960# m1_644_2312# 0
C399 m1_4822_412# en 0.08351f
C400 stb m1_208_6996# 0.03449f
C401 sub_b rsel 0.46758f
C402 m1_208_7600# m1_1401_6720# 0.00134f
C403 t1 m1_2436_6996# 0
C404 sub_b a_2510_1740# 0.11475f
C405 sub_b a_3844_4734# 0.05377f
C406 m1_4802_1762# sub_b 0
C407 m1_208_7600# vdd 0.01002f
C408 m1_1545_4540# hold 0.0432f
C409 m1_3652_6232# mreset 0.02141f
C410 m1_2260_960# sub 0
C411 m1_208_6996# m1_1973_6232# 0.1096f
C412 el sub 0.03583f
C413 m1_2260_960# abus 0
C414 m1_3348_960# m1_2424_756# 0.14487f
C415 m1_3348_960# vreset 0.04745f
C416 abus el 0.03784f
C417 a_1682_2940# a_2578_2940# 0.0512f
C418 a_480_5620# vbn_leak 0.01903f
C419 m1_3212_6232# m1_208_6996# 0.00246f
C420 m1_2105_7600# m1_1557_7120# 0.07884f
C421 vsrc hold 0.11451f
C422 vm m1_208_6996# 0.01147f
C423 m1_3348_960# vbn_prb 0.04182f
C424 spk a_1682_2940# 0.08861f
C425 a_480_5620# a_2160_3542# 0.29014f
C426 sub_b en 0.01373f
C427 t0 el 0
C428 m1_2436_6996# m1_1557_7120# 0
C429 t3 a_480_5620# 0.13045f
C430 m1_2260_4540# hold 0.16126f
C431 m1_208_7600# vbn_leak 0.51836f
C432 vbp_st hold 0.46055f
C433 sta el 0
C434 t2 m1_208_6996# 0.05179f
C435 hold vbp_syn 0.65804f
C436 m1_644_2312# a_1682_2940# 0.2917f
C437 vdd a_2578_2940# 0.00199f
C438 sub_b m1_1692_4664# 0
C439 t1 t0 0.04632f
C440 m1_2260_960# rsel 0.06573f
C441 aux sub 0
C442 spk vdd 0.87243f
C443 m1_208_7600# t3 0.18955f
C444 a_2804_3624# sub_b 0.00123f
C445 el rsel 0.04467f
C446 vsrc vbn_ref 0.04621f
C447 m1_3348_960# vm 0.2229f
C448 m1_2260_960# a_2510_1740# 0.14485f
C449 abus aux 0.03707f
C450 m1_2260_960# a_3844_4734# 0.00193f
C451 el a_2510_1740# 0.34103f
C452 el a_3844_4734# 0.00104f
C453 t2 m1_1104_8052# 0.03596f
C454 m1_4904_6422# spk 0
C455 vdd m1_644_2312# 0.0239f
C456 vbp_st vbn_ref 0.04333f
C457 vbn_ref vbp_syn 0.00577f
C458 vsrc m1_4822_412# 0.0037f
C459 el mreset 0.02914f
C460 vbn_leak a_2578_2940# 0.02016f
C461 m1_4052_1572# sub_b 0.01339f
C462 t0 m1_1557_7120# 0.09239f
C463 m1_2424_756# m1_3704_1572# 0.02956f
C464 sta aux 0
C465 m1_2105_7600# m1_208_6996# 0.05245f
C466 m1_208_7600# a_480_5620# 0
C467 m1_2260_960# en 0.04366f
C468 vdd m1_2424_756# 0.21166f
C469 vdd vreset 0.37986f
C470 a_2160_3542# a_2578_2940# 0.00405f
C471 m1_1973_6232# a_1682_2940# 0
C472 spk vbn_leak 0.06932f
C473 el en 0.03706f
C474 stb m1_1401_6720# 0
C475 vbp_st m1_4822_412# 0.0108f
C476 m1_2436_6996# m1_208_6996# 0.20198f
C477 rsel aux 0.00381f
C478 spk a_2160_3542# 0.01271f
C479 stb vdd 0.13649f
C480 vsrc m1_3652_6232# 0.00154f
C481 vdd vbn_prb 0.09293f
C482 a_2510_1740# aux 0.25378f
C483 vbn_leak m1_644_2312# 0.07402f
C484 a_3844_4734# aux 0
C485 vm a_1682_2940# 0.41408f
C486 m1_1401_6720# m1_1973_6232# 0.00113f
C487 m1_2260_960# a_2804_3624# 0
C488 a_3184_3624# a_1682_2940# 0
C489 a_2804_3624# el 0
C490 a_2160_3542# m1_644_2312# 0
C491 vdd m1_1973_6232# 0.07111f
C492 m1_4904_6422# vbn_prb 0.1006f
C493 vsrc sub_b 0.01409f
C494 vbp_st m1_3652_6232# 0.006f
C495 m1_3652_6232# vbp_syn 0.10654f
C496 aux mreset 0.03441f
C497 m1_2424_756# vbn_leak 0.04323f
C498 vbn_leak vreset 0.03464f
C499 sub_b m1_2260_4540# 0.04999f
C500 m1_1401_6720# vm 0.02407f
C501 vdd m1_3212_6232# 0.18028f
C502 a_480_5620# a_2578_2940# 0.39121f
C503 m1_208_6996# sub 0.023f
C504 vm m1_3704_1572# 0
C505 t1 m1_1692_4664# 0
C506 vbp_st sub_b 0.04519f
C507 vdd vm 2.26238f
C508 sub_b vbp_syn 0.09408f
C509 aux en 0.03632f
C510 stb vbn_leak 0.16242f
C511 spk a_480_5620# 0.0866f
C512 m1_796_6120# m1_1557_7120# -0.00167f
C513 vbn_prb vbn_leak 0
C514 m1_4904_6422# m1_3212_6232# -0.01073f
C515 m1_2260_960# m1_4052_1572# 0
C516 vdd a_3184_3624# 0.42073f
C517 m1_1401_6720# t2 0.10633f
C518 m1_4052_1572# el 0.04092f
C519 hold vbn_ref 0.04997f
C520 t0 m1_208_6996# 0.07017f
C521 vdd t2 0.28683f
C522 vbn_leak m1_1973_6232# 0.06458f
C523 a_480_5620# m1_644_2312# 0.13781f
C524 sta m1_208_6996# 0
C525 m1_3348_960# sub 0.00209f
C526 m1_208_7600# spk 0.00484f
C527 m1_3348_960# abus 0.10889f
C528 m1_3212_6232# vbn_leak 0.00653f
C529 t3 m1_1973_6232# 0
C530 vbn_leak vm 0.01768f
C531 m1_2260_960# vsrc 0
C532 a_3184_3624# vbn_leak 0.00204f
C533 vsrc el 0.06761f
C534 m1_208_6996# a_2510_1740# 0.00208f
C535 vm a_2160_3542# 0.16962f
C536 vdd a_338_2940# 0
C537 t3 vm 0.04824f
C538 stb a_480_5620# 0
C539 a_3184_3624# a_2160_3542# 0.00161f
C540 vbn_leak t2 0.14387f
C541 m1_2105_7600# m1_1401_6720# -0.00348f
C542 m1_4052_1572# aux 0.03612f
C543 m1_2260_960# vbp_syn 0
C544 m1_3652_6232# hold 0.01348f
C545 vbp_st el 0.04453f
C546 vdd m1_2105_7600# 0
C547 el vbp_syn 0.13814f
C548 m1_2436_6996# m1_1401_6720# 0
C549 m1_208_6996# mreset 0.00115f
C550 m1_4822_412# vbn_ref 0.08703f
C551 spk a_2578_2940# 0.20707f
C552 t3 t2 0.05739f
C553 a_480_5620# m1_1973_6232# 0.1051f
C554 m1_796_6120# m1_208_6996# 0.10816f
C555 m1_3348_960# rsel 0.00266f
C556 vdd m1_2436_6996# 0.03348f
C557 sub_b hold 0.20837f
C558 m1_208_7600# stb 0.03249f
C559 m1_208_7600# vbn_prb 0
C560 m1_3348_960# a_2510_1740# 0.02182f
C561 a_1682_2940# sub 0.05048f
C562 t1 vbp_st 0
C563 m1_644_2312# a_2578_2940# 0.4287f
C564 a_480_5620# vm 1.16981f
C565 vsrc aux 0.03767f
C566 a_3184_3624# a_480_5620# 0.00155f
C567 spk m1_644_2312# 0.0792f
C568 t0 a_1682_2940# 0
C569 m1_2105_7600# vbn_leak 0.41055f
C570 m1_208_7600# m1_3212_6232# 0.0038f
C571 m1_2424_756# a_2578_2940# 0
C572 a_480_5620# t2 0.22653f
C573 vreset a_2578_2940# 0
C574 abus m1_3704_1572# 0.00665f
C575 vdd sub 0.31875f
C576 sub_b vbn_ref 0.00363f
C577 vbp_st aux 0.0417f
C578 m1_208_7600# vm 0
C579 vdd abus 0.19859f
C580 aux vbp_syn 0.12233f
C581 m1_3348_960# en 0.15848f
C582 m1_2436_6996# vbn_leak 0.20054f
C583 t0 m1_1401_6720# 0
C584 rsel a_1682_2940# 0
C585 t0 vdd 0.10056f
C586 m1_208_7600# t2 0.0595f
C587 spk stb 0.02657f
C588 m1_2424_756# m1_644_2312# 0
C589 spk vbn_prb 0
C590 a_3844_4734# a_1682_2940# 0.00737f
C591 vreset m1_644_2312# 0
C592 el hold 0.0394f
C593 a_480_5620# a_338_2940# 0
C594 vdd sta 0.20165f
C595 vbn_leak sub 0.12396f
C596 spk m1_1973_6232# 0
C597 abus vbn_leak 0.07074f
C598 vbn_prb m1_644_2312# 0.00111f
C599 m1_2105_7600# a_480_5620# 0
C600 rsel m1_3704_1572# 0.0163f
C601 m1_2424_756# vreset 0.08879f
C602 vm a_2578_2940# 0.09896f
C603 m1_4904_6422# sta 0
C604 vdd rsel 0.33464f
C605 a_2160_3542# sub 0.01212f
C606 m1_796_6120# a_1682_2940# 0
C607 m1_3704_1572# a_2510_1740# 0
C608 spk m1_3212_6232# 0.10847f
C609 sub_b m1_3652_6232# 0
C610 m1_2260_960# m1_2972_1572# 0.0013f
C611 t1 hold 0
C612 vdd a_2510_1740# 1.63645f
C613 vdd a_3844_4734# 0.59267f
C614 m1_2436_6996# a_480_5620# 0.01966f
C615 spk vm 7.89141f
C616 m1_3348_960# m1_4052_1572# 0
C617 t0 vbn_leak 0.19364f
C618 vbn_prb m1_2424_756# 0.10984f
C619 vbn_prb vreset 0.04313f
C620 el vbn_ref 0
C621 spk a_3184_3624# 0.22493f
C622 m1_4904_6422# a_2510_1740# 0.36576f
C623 m1_208_7600# m1_2105_7600# 0.00943f
C624 m1_796_6120# m1_1401_6720# 0
C625 vbn_leak sta 0
C626 vdd mreset 0.10081f
C627 vm m1_644_2312# 0.24751f
C628 t0 t3 0
C629 vdd m1_796_6120# 0.32268f
C630 aux hold 0.0382f
C631 m1_208_7600# m1_2436_6996# -0.00271f
C632 m1_1692_4664# a_1682_2940# 0.09357f
C633 vbp_st m1_208_6996# 0
C634 a_3184_3624# m1_644_2312# 0
C635 m1_208_6996# vbp_syn 0
C636 m1_3704_1572# en 0.02589f
C637 a_2804_3624# a_1682_2940# 0.0023f
C638 vdd en 0.23193f
C639 vbn_leak rsel 0.09527f
C640 el m1_4822_412# 0
C641 m1_1557_7120# hold 0
C642 a_480_5620# sub 0.06758f
C643 stb m1_1973_6232# 0
C644 vbn_leak a_2510_1740# 0.36726f
C645 vbn_leak a_3844_4734# 0.01126f
C646 m1_2424_756# vm 0.39126f
C647 vreset vm 0.27595f
C648 vbn_leak m1_4802_1762# 0
C649 m1_3348_960# vsrc 0.03115f
C650 a_2160_3542# rsel 0
C651 a_338_2940# a_2578_2940# 0.00359f
C652 stb m1_3212_6232# 0.18567f
C653 a_2160_3542# a_2510_1740# 0
C654 a_2160_3542# a_3844_4734# 0.14668f
C655 vdd m1_1692_4664# 0.28596f
C656 stb vm 0.04174f
C657 spk a_338_2940# 0.28037f
C658 vbn_prb vm 0.00158f
C659 t0 a_480_5620# 0.10955f
C660 aux vbn_ref 0
C661 vdd a_2804_3624# 0.27486f
C662 vbn_leak mreset 0.14463f
C663 m1_3348_960# vbp_st 0.03879f
C664 m1_3348_960# vbp_syn 0.07213f
C665 stb a_3184_3624# 0
C666 m1_3652_6232# el 0.02275f
C667 m1_796_6120# vbn_leak 0.03529f
C668 vm m1_1973_6232# 0.07357f
C669 vbn_leak en 0.04406f
C670 a_338_2940# m1_644_2312# 0.49492f
C671 m1_2260_960# sub_b 0
C672 a_1682_2940# m1_1545_4540# 0.17434f
C673 sub_b el 0.10714f
C674 spk m1_2436_6996# 0.00145f
C675 t3 m1_796_6120# 0.18981f
C676 m1_208_7600# t0 0.07125f
C677 m1_3212_6232# vm 0.02914f
C678 m1_4822_412# aux 0.00115f
C679 m1_4052_1572# m1_3704_1572# 0
C680 a_480_5620# rsel 0.00284f
C681 vdd m1_4052_1572# 0.01699f
C682 t2 m1_1973_6232# 0
C683 a_3184_3624# m1_3212_6232# 0
C684 a_480_5620# a_2510_1740# 0.00179f
C685 a_480_5620# a_3844_4734# 0.00579f
C686 a_3184_3624# vm 0.00142f
C687 vsrc a_1682_2940# 0.14205f
C688 a_2578_2940# sub 0
C689 a_2160_3542# m1_1692_4664# 0.0051f
C690 vdd m1_1545_4540# 0.31514f
C691 m1_208_6996# hold 0.00372f
C692 t2 vm 0.06186f
C693 m1_2260_4540# a_1682_2940# 0.03512f
C694 a_2804_3624# a_2160_3542# 0.02975f
C695 m1_3652_6232# aux 0.00645f
C696 m1_208_7600# a_2510_1740# 0.0013f
C697 spk sub 0.08056f
C698 vbp_st a_1682_2940# 0.2412f
C699 m1_796_6120# a_480_5620# 0.13805f
C700 stb m1_2105_7600# 0
C701 sub_b aux 0.07451f
C702 vdd vsrc 0.22685f
C703 vbn_leak m1_4052_1572# 0.00484f
C704 stb m1_2436_6996# 0.08958f
C705 m1_644_2312# sub 0.03896f
C706 abus m1_644_2312# 0.00378f
C707 m1_208_7600# mreset 0.00221f
C708 vbp_st m1_1401_6720# 0
C709 spk t0 0
C710 vdd m1_2260_4540# 0.51842f
C711 m1_2105_7600# m1_1973_6232# 0.0048f
C712 m1_208_7600# m1_796_6120# 0.01948f
C713 m1_2260_960# el 0
C714 m1_3704_1572# vbp_syn 0.04136f
C715 vm a_338_2940# 0.04589f
C716 vdd vbp_st 1.71891f
C717 vdd vbp_syn 2.86159f
C718 a_480_5620# m1_1692_4664# 0.15559f
C719 spk sta 0.09062f
C720 m1_2436_6996# m1_1973_6232# 0.00433f
C721 a_480_5620# a_2804_3624# 0.00624f
C722 m1_2424_756# sub 0
C723 vreset sub 0
C724 rsel a_2578_2940# 0.01905f
C725 a_2160_3542# m1_1545_4540# 0.11196f
C726 abus m1_2424_756# 0.10221f
C727 m1_2105_7600# vm 0
C728 abus vreset 1.82741f
C729 a_2578_2940# a_2510_1740# 0.02619f
C730 m1_4904_6422# vbp_st 0.02925f
C731 m1_4904_6422# vbp_syn -0.07963f
C732 a_3844_4734# a_2578_2940# 0.03162f
C733 m1_2436_6996# m1_3212_6232# 0.002f
C734 m1_3348_960# m1_2972_1572# 0
C735 spk rsel 0.34479f
C736 stb sub 0.01482f
C737 vbn_leak vsrc 1.78855f
C738 m1_2436_6996# vm 0.13145f
C739 vbn_prb sub 0
C740 spk a_2510_1740# 0.02128f
C741 spk a_3844_4734# 0.21496f
C742 abus vbn_prb 0.35223f
C743 m1_3348_960# vbn_ref 0.03356f
C744 vsrc a_2160_3542# 0.16998f
C745 rsel m1_644_2312# 0.08058f
C746 m1_1973_6232# sub 0.00349f
C747 vbp_st vbn_leak 0.04086f
C748 vbn_leak vbp_syn 0.25828f
C749 m1_2436_6996# t2 0
C750 m1_644_2312# a_2510_1740# 0.17672f
C751 a_3844_4734# m1_644_2312# 0.00926f
C752 a_2160_3542# m1_2260_4540# 0.16455f
C753 sta vreset 0
C754 m1_2260_960# aux 0
C755 t0 stb 0.00249f
C756 m1_4802_1762# m1_644_2312# 0
C757 el aux 1.64571f
C758 a_2578_2940# en 0.00362f
C759 vbp_st a_2160_3542# 0.00601f
C760 a_1682_2940# hold 0.34249f
C761 a_2160_3542# vbp_syn 0
C762 a_480_5620# m1_1545_4540# 0.06066f
C763 m1_3348_960# m1_4822_412# 0.07018f
C764 stb sta 0.00742f
C765 m1_2424_756# rsel 0.00696f
C766 vm sub 0.04966f
C767 vreset rsel 0
C768 spk en 0
C769 vbn_prb sta 0
C770 abus vm 0.03247f
C771 t0 m1_1973_6232# 0.15422f
C772 m1_208_6996# sub_b 0.00404f
C773 m1_2424_756# a_2510_1740# 0.20463f
C774 aux vss 0.36725f
C775 m1_3348_960# vss 0.80751f
C776 m1_1104_8052# vss -0.00196f
C777 m1_2260_960# vss 0.39421f
C778 en vss 1.13846f
C779 abus vss 2.48947f
C780 sub vss 0.49774f
C781 mreset vss 0.64031f
C782 hold vss 0.97734f
C783 vdd vss 16.99345f
C784 m1_1557_7120# vss 0.13244f
C785 m1_2105_7600# vss 0.12741f
C786 m1_4822_412# vss 0.13826f
C787 m1_796_6120# vss -0.04573f
C788 t3 vss 0.40039f
C789 vbn_prb vss 0.70582f
C790 a_3184_3624# vss 0.18684f
C791 m1_1401_6720# vss 0.03849f
C792 t2 vss 0.30522f
C793 a_2804_3624# vss 0.11006f
C794 m1_1973_6232# vss 0.00346f
C795 t1 vss 0.30178f
C796 m1_208_7600# vss 2.71587f
C797 m1_208_6996# vss 1.22331f
C798 spk vss 0.80109f
C799 m1_2436_6996# vss 0.13276f
C800 t0 vss 0.27403f
C801 m1_2972_1572# vss -0.0561f
C802 rsel vss 0.74365f
C803 m1_2260_4540# vss -0.0748f
C804 vm vss 3.84719f
C805 m1_3704_1572# vss -0.0536f
C806 m1_644_2312# vss 0.4485f
C807 a_338_2940# vss -0.21724f
C808 sub_b vss 1.03926f
C809 m1_1545_4540# vss 0.07284f
C810 vbp_st vss 0.32309f
C811 m1_3212_6232# vss 0.09985f
C812 stb vss 0.91039f
C813 sta vss 0.24375f
C814 m1_2424_756# vss 0.63391f
C815 a_2160_3542# vss 0.33226f
C816 vsrc vss 1.00352f
C817 vreset vss 0.64484f
C818 a_2510_1740# vss 2.38002f
C819 m1_4802_1762# vss -0.01232f
C820 m1_1692_4664# vss -0.08775f
C821 vbn_ref vss 0.70591f
C822 a_2578_2940# vss 0.08247f
C823 a_1682_2940# vss 0.86564f
C824 a_3844_4734# vss 0.72818f
C825 m1_4904_6422# vss -0.2014f
C826 m1_3652_6232# vss -0.06338f
C827 vbp_syn vss 0.34781f
C828 a_480_5620# vss -0.02907f
C829 el vss 0.39215f
C830 vbn_leak vss 4.08563f
C831 m1_4052_1572# vss -0.0427f
.ends
