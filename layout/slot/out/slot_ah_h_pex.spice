* NGSPICE file created from slot_ah_h.ext - technology: gf180mcuD

.subckt p_w2_l4 a_400_n200# a_n400_n244# w_n574_n330# a_n488_n200# VSUBS
X0 a_400_n200# a_n400_n244# a_n488_n200# w_n574_n330# pfet_03v3 ad=0.88p pd=4.88u as=0.88p ps=4.88u w=2u l=4u
C0 w_n574_n330# a_n488_n200# 0.07409f
C1 a_n400_n244# a_400_n200# 0.07019f
C2 a_n400_n244# a_n488_n200# 0.07019f
C3 a_n488_n200# a_400_n200# 0.01073f
C4 w_n574_n330# a_n400_n244# 0.42229f
C5 w_n574_n330# a_400_n200# 0.07409f
C6 a_400_n200# VSUBS 0.18936f
C7 a_n488_n200# VSUBS 0.18936f
C8 w_n574_n330# VSUBS 2.27304f
.ends

.subckt n_w1_l0p28 a_28_n100# a_n28_n144# a_n116_n100# VSUBS
X0 a_28_n100# a_n28_n144# a_n116_n100# VSUBS nfet_03v3 ad=0.44p pd=2.88u as=0.44p ps=2.88u w=1u l=0.28u
C0 a_n28_n144# a_28_n100# 0.00769f
C1 a_n116_n100# a_28_n100# 0.04256f
C2 a_n28_n144# a_n116_n100# 0.00769f
C3 a_28_n100# VSUBS 0.09911f
C4 a_n116_n100# VSUBS 0.09911f
.ends

.subckt n_w2_l2 a_n288_n200# a_200_n200# a_n200_n244# VSUBS
X0 a_200_n200# a_n200_n244# a_n288_n200# VSUBS nfet_03v3 ad=0.88p pd=4.88u as=0.88p ps=4.88u w=2u l=2u
C0 a_n200_n244# a_200_n200# 0.0587f
C1 a_n288_n200# a_200_n200# 0.02133f
C2 a_n200_n244# a_n288_n200# 0.0587f
C3 a_200_n200# VSUBS 0.2667f
C4 a_n288_n200# VSUBS 0.2667f
.ends

.subckt n_w2_l4 a_400_n200# a_n400_n244# a_n488_n200# VSUBS
X0 a_400_n200# a_n400_n244# a_n488_n200# VSUBS nfet_03v3 ad=0.88p pd=4.88u as=0.88p ps=4.88u w=2u l=4u
C0 a_n400_n244# a_400_n200# 0.07019f
C1 a_n488_n200# a_400_n200# 0.01073f
C2 a_n400_n244# a_n488_n200# 0.07019f
C3 a_400_n200# VSUBS 0.41684f
C4 a_n488_n200# VSUBS 0.41684f
.ends

.subckt n_w0p5_l0p28 a_n28_n94# a_n116_n50# a_28_n50# VSUBS
X0 a_28_n50# a_n28_n94# a_n116_n50# VSUBS nfet_03v3 ad=0.22p pd=1.88u as=0.22p ps=1.88u w=0.5u l=0.28u
C0 a_n28_n94# a_28_n50# 0.00377f
C1 a_n116_n50# a_28_n50# 0.02085f
C2 a_n28_n94# a_n116_n50# 0.00377f
C3 a_28_n50# VSUBS 0.07987f
C4 a_n116_n50# VSUBS 0.07987f
.ends

.subckt p_w1_l0p5 a_n138_n100# a_50_n100# a_n50_n144# w_n224_n230# VSUBS
X0 a_50_n100# a_n50_n144# a_n138_n100# w_n224_n230# pfet_03v3 ad=0.44p pd=2.88u as=0.44p ps=2.88u w=1u l=0.5u
C0 w_n224_n230# a_n138_n100# 0.0205f
C1 a_n50_n144# a_50_n100# 0.01275f
C2 a_n50_n144# a_n138_n100# 0.01275f
C3 a_n138_n100# a_50_n100# 0.03085f
C4 w_n224_n230# a_n50_n144# 0.07993f
C5 w_n224_n230# a_50_n100# 0.0205f
C6 a_50_n100# VSUBS 0.06546f
C7 a_n138_n100# VSUBS 0.06546f
C8 w_n224_n230# VSUBS 0.61824f
.ends

.subckt n_w0p5_l0p5 a_n138_n50# a_50_n50# a_n50_n94# VSUBS
X0 a_50_n50# a_n50_n94# a_n138_n50# VSUBS nfet_03v3 ad=0.22p pd=1.88u as=0.22p ps=1.88u w=0.5u l=0.5u
C0 a_n50_n94# a_50_n50# 0.00625f
C1 a_n138_n50# a_50_n50# 0.01511f
C2 a_n50_n94# a_n138_n50# 0.00625f
C3 a_50_n50# VSUBS 0.09639f
C4 a_n138_n50# VSUBS 0.09639f
.ends

.subckt p_w1_l0p28 w_n202_n230# a_28_n100# a_n28_n144# a_n116_n100# VSUBS
X0 a_28_n100# a_n28_n144# a_n116_n100# w_n202_n230# pfet_03v3 ad=0.44p pd=2.88u as=0.44p ps=2.88u w=1u l=0.28u
C0 w_n202_n230# a_n116_n100# 0.01808f
C1 a_n28_n144# a_28_n100# 0.00769f
C2 a_n28_n144# a_n116_n100# 0.00769f
C3 a_n116_n100# a_28_n100# 0.04256f
C4 w_n202_n230# a_n28_n144# 0.05841f
C5 w_n202_n230# a_28_n100# 0.01808f
C6 a_28_n100# VSUBS 0.0597f
C7 a_n116_n100# VSUBS 0.0597f
C8 w_n202_n230# VSUBS 0.55752f
.ends

.subckt n_w1_l0p5 a_n138_n100# a_50_n100# a_n50_n144# VSUBS
X0 a_50_n100# a_n50_n144# a_n138_n100# VSUBS nfet_03v3 ad=0.44p pd=2.88u as=0.44p ps=2.88u w=1u l=0.5u
C0 a_n50_n144# a_50_n100# 0.01275f
C1 a_n138_n100# a_50_n100# 0.03085f
C2 a_n50_n144# a_n138_n100# 0.01275f
C3 a_50_n100# VSUBS 0.11563f
C4 a_n138_n100# VSUBS 0.11563f
.ends

.subckt n_w4_l2 a_n288_n400# a_200_n400# a_n200_n444# VSUBS
X0 a_200_n400# a_n200_n444# a_n288_n400# VSUBS nfet_03v3 ad=1.76p pd=8.88u as=1.76p ps=8.88u w=4u l=2u
C0 a_n200_n444# a_200_n400# 0.11799f
C1 a_n288_n400# a_200_n400# 0.04287f
C2 a_n200_n444# a_n288_n400# 0.11799f
C3 a_200_n400# VSUBS 0.34365f
C4 a_n288_n400# VSUBS 0.34365f
.ends

.subckt p_w1_l2 w_n374_n230# a_n288_n100# a_200_n100# a_n200_n144# VSUBS
X0 a_200_n100# a_n200_n144# a_n288_n100# w_n374_n230# pfet_03v3 ad=0.44p pd=2.88u as=0.44p ps=2.88u w=1u l=2u
C0 w_n374_n230# a_n288_n100# 0.03135f
C1 a_n200_n144# a_200_n100# 0.02905f
C2 a_n200_n144# a_n288_n100# 0.02905f
C3 a_n288_n100# a_200_n100# 0.01056f
C4 w_n374_n230# a_n200_n144# 0.22666f
C5 w_n374_n230# a_200_n100# 0.03135f
C6 a_200_n100# VSUBS 0.1047f
C7 a_n288_n100# VSUBS 0.1047f
C8 w_n374_n230# VSUBS 1.03224f
.ends

.subckt n_w7p07_l7p07 a_707_n707# a_n795_n707# a_n707_n751# VSUBS
X0 a_707_n707# a_n707_n751# a_n795_n707# VSUBS nfet_03v3 ad=3.1108p pd=15.02u as=3.1108p ps=15.02u w=7.07u l=7.07u
C0 a_n707_n751# a_707_n707# 0.27012f
C1 a_n795_n707# a_707_n707# 0.0212f
C2 a_n707_n751# a_n795_n707# 0.27012f
C3 a_707_n707# VSUBS 0.84237f
C4 a_n795_n707# VSUBS 0.84237f
.ends

.subckt n_w0p5_l1p5 a_150_n50# a_n238_n50# a_n150_n94# VSUBS
X0 a_150_n50# a_n150_n94# a_n238_n50# VSUBS nfet_03v3 ad=0.22p pd=1.88u as=0.22p ps=1.88u w=0.5u l=1.5u
C0 a_n150_n94# a_150_n50# 0.01269f
C1 a_n238_n50# a_150_n50# 0.00671f
C2 a_n150_n94# a_n238_n50# 0.01269f
C3 a_150_n50# VSUBS 0.17146f
C4 a_n238_n50# VSUBS 0.17146f
.ends

.subckt n_w3p54_l3p54 a_354_n354# a_n354_n398# a_n442_n354# VSUBS
X0 a_354_n354# a_n354_n398# a_n442_n354# VSUBS nfet_03v3 ad=1.5576p pd=7.96u as=1.5576p ps=7.96u w=3.54u l=3.54u
C0 a_n354_n398# a_354_n354# 0.12189f
C1 a_n442_n354# a_354_n354# 0.02161f
C2 a_n354_n398# a_n442_n354# 0.12189f
C3 a_354_n354# VSUBS 0.44156f
C4 a_n442_n354# VSUBS 0.44156f
.ends

.subckt n_w0p22_l2 a_200_n22# a_n200_n66# a_n292_n36# VSUBS
X0 a_200_n22# a_n200_n66# a_n292_n36# VSUBS nfet_03v3 ad=0.1516p pd=1.64u as=0.1516p ps=1.64u w=0.22u l=2u
C0 a_n292_n36# a_200_n22# 0.00245f
C1 a_n200_n66# a_200_n22# 0.00705f
C2 a_n292_n36# a_n200_n66# 0.00705f
C3 a_200_n22# VSUBS 0.20767f
C4 a_n292_n36# VSUBS 0.20767f
.ends

.subckt n_w0p5_l3 a_n388_n50# a_300_n50# a_n300_n94# VSUBS
X0 a_300_n50# a_n300_n94# a_n388_n50# VSUBS nfet_03v3 ad=0.22p pd=1.88u as=0.22p ps=1.88u w=0.5u l=3u
C0 a_n300_n94# a_300_n50# 0.01602f
C1 a_n388_n50# a_300_n50# 0.00348f
C2 a_n300_n94# a_n388_n50# 0.01602f
C3 a_300_n50# VSUBS 0.28406f
C4 a_n388_n50# VSUBS 0.28406f
.ends

.subckt n_w0p5_l4 a_n488_n50# a_400_n50# a_n400_n94# VSUBS
X0 a_400_n50# a_n400_n94# a_n488_n50# VSUBS nfet_03v3 ad=0.22p pd=1.88u as=0.22p ps=1.88u w=0.5u l=4u
C0 a_n400_n94# a_400_n50# 0.01702f
C1 a_n488_n50# a_400_n50# 0.0026f
C2 a_n400_n94# a_n488_n50# 0.01702f
C3 a_400_n50# VSUBS 0.35913f
C4 a_n488_n50# VSUBS 0.35913f
.ends

.subckt slot_ah_h vss vbp_syn vdd el aux vbn_leak vsrc vbp_st vbn_prb vbn_ref en vreset
+ abus spk t3 t2 t1 t0 sta stb hold mreset rsel sub sub_b vm
XXL_XP1 a_480_5620# a_480_5620# vdd vdd vss p_w2_l4
XXPM_XSW m1_3620_1976# rsel m1_3360_308# vss n_w1_l0p28
XXL_XP2 a_1580_2680# a_480_5620# vdd vdd vss p_w2_l4
XXPR_XMB vss m1_4822_1769# vbn_prb vss n_w2_l2
XXL_XMT m1_218_2312# vbn_leak vss vss n_w2_l4
XXL_XM1 a_280_2680# a_480_5620# el vss n_w2_l2
XXS_XWA m1_4822_6422# vbp_syn vdd m1_3652_6232# vss p_w2_l4
XXR_Xi_XN spk vss a_3844_4734# vss n_w0p5_l0p28
XXL_XM2 a_2240_2680# a_1580_2680# a_1580_2680# vss n_w2_l2
XXS_XWB m1_4822_6422# vbp_syn vdd m1_3212_6232# vss p_w2_l4
XXR_XNR vss vbn_ref a_2510_1690# vss n_w2_l4
XXD_XPI m1_1728_4540# a_2160_3542# vm vdd vss p_w1_l0p5
XXPR_XME m1_2640_980# en m1_4822_1769# vss n_w1_l0p28
XXR_XSW vreset vm a_2510_1690# vss n_w0p5_l0p5
XXR_Xi_XP vdd a_3844_4734# spk vdd vss p_w1_l0p28
XXD_XNI vsrc a_2160_3542# vm vss n_w1_l0p5
XXPR_XMF m1_2640_980# vdd a_2510_1690# vss n_w4_l2
XXS_XQA vdd m1_3652_6232# sta vss vss p_w1_l0p28
XXS_XQB vdd m1_3212_6232# stb vss vss p_w1_l0p28
XXL_XD1 m1_218_2312# a_280_2680# a_280_2680# vss n_w2_l2
XXS_XNA sta vm m1_3652_6232# vss n_w0p5_l0p28
XXL_XD2 m1_218_2312# a_2240_2680# a_2240_2680# vss n_w2_l2
XXS_XNB stb vm m1_3212_6232# vss n_w0p5_l0p28
XXD_XS2 vdd vdd m1_2240_4540# vbp_st vss p_w1_l2
XXD_XPS vdd vdd m1_1728_4540# vbp_st vss p_w1_l2
XXPM_XSB m1_3620_1976# sub_b abus vss n_w1_l0p28
XXC_XC vss vss vm vss n_w7p07_l7p07
XXS_XPH vdd m1_4822_6422# vdd hold vss p_w1_l2
XXT_XR1 m1_2117_7612# m1_1545_7160# vbn_leak vss n_w0p5_l1p5
XXD_XP2 vdd a_2804_3624# a_2160_3542# m1_2240_4540# vss p_w1_l0p28
XXPR_XSW m1_2960_1560# rsel m1_2640_980# vss n_w1_l0p28
XXT_XR2 m1_201_7160# m1_2117_7612# vbn_leak vss n_w0p5_l1p5
XXT_XP0 vdd m1_2521_6720# t0 vm vss p_w1_l0p28
XXD_Xi4_XN a_3184_3624# vss spk vss n_w0p5_l0p28
XXD_XP3 vdd a_3184_3624# a_2804_3624# vdd vss p_w1_l0p28
XXT_XR3 m1_230_7612# m1_201_7160# vbn_leak vss n_w0p5_l1p5
XXT_XP1 vdd m1_1960_6220# t1 vm vss p_w1_l0p28
XXR_XCR_XC vss a_2510_1690# vss vss n_w3p54_l3p54
XXD_XN2 a_2804_3624# a_2160_3542# vsrc vss n_w0p22_l2
XXT_XN0 t0 a_480_5620# m1_2521_6720# vss n_w0p5_l0p28
XXT_XP2 vdd m1_1400_6220# t2 vm vss p_w1_l0p28
XXD_Xi4_XP vdd spk a_3184_3624# vdd vss p_w1_l0p28
XXD_XN3 a_2804_3624# vsrc a_3184_3624# vss n_w0p5_l0p28
XXPM_XMB vss m1_4822_412# vbn_prb vss n_w2_l2
XXT_XN1 t1 a_480_5620# m1_1960_6220# vss n_w0p5_l0p28
XXT_XP3 vdd m1_853_6232# t3 vm vss p_w1_l0p28
XXT_XL0 m1_2521_6720# m1_230_7612# vbn_leak vss n_w0p5_l3
XXT_XN2 t2 a_480_5620# m1_1400_6220# vss n_w0p5_l0p28
XXT_XLT m1_230_7612# vdd vbn_leak vss n_w0p5_l3
XXT_XL1 m1_1960_6220# m1_201_7160# vbn_leak vss n_w0p5_l3
XXT_XN3 t3 a_480_5620# m1_853_6232# vss n_w0p5_l0p28
XXR_XPC vdd a_2510_1690# a_3844_4734# vdd vss p_w1_l0p28
XXPM_XME m1_3360_308# en m1_4822_412# vss n_w1_l0p28
XXT_XL2 m1_1400_6220# m1_2117_7612# vbn_leak vss n_w0p5_l3
XXT_XL3 m1_853_6232# m1_1545_7160# vbn_leak vss n_w0p5_l3
XXPM_XMF m1_3360_308# vdd vm vss n_w4_l2
XXS_XHL vdd vm hold a_1580_2680# vss p_w1_l0p28
XXS_XMR mreset a_2510_1690# vdd vss n_w0p5_l0p28
XXPR_XSB m1_2960_1560# sub abus vss n_w1_l0p28
XXT_XRB m1_1104_8052# m1_1545_7160# vbn_leak vss n_w0p5_l4
XXT_XRA vss m1_1104_8052# vbn_leak vss n_w0p5_l4
C0 vm a_1580_2680# 0.46957f
C1 sub vbp_syn 0.02072f
C2 vbp_syn m1_201_7160# 0
C3 m1_4822_1769# m1_3620_1976# 0.01584f
C4 hold vbp_st 0.2718f
C5 vreset m1_3620_1976# 0.04597f
C6 m1_4822_412# vbn_leak 0.00248f
C7 a_3184_3624# m1_1728_4540# 0.15326f
C8 vbp_syn m1_2640_980# 0.07767f
C9 a_3844_4734# hold 0
C10 m1_1400_6220# t1 0.02894f
C11 m1_2960_1560# a_2510_1690# 0.06672f
C12 m1_218_2312# el 0.10292f
C13 sta aux 0
C14 a_480_5620# spk 0.10956f
C15 t2 t1 0.04763f
C16 sub a_3184_3624# 0.19954f
C17 t1 vdd 0.10525f
C18 a_280_2680# el 0.05819f
C19 stb m1_2521_6720# 0.00179f
C20 abus aux 0.0314f
C21 m1_4822_412# en 0.0834f
C22 sta vbn_leak 0
C23 m1_218_2312# vreset 0.00184f
C24 rsel m1_230_7612# 0
C25 vm t1 0.05793f
C26 t0 spk 0
C27 abus vbn_leak 0.03434f
C28 vbp_syn el 0.14079f
C29 vbn_prb spk 0
C30 mreset vbn_ref 0
C31 a_480_5620# m1_1400_6220# 0.21177f
C32 vbp_st a_2510_1690# 0.1301f
C33 aux sub_b 0.0025f
C34 hold vsrc 0.09385f
C35 sta en 0
C36 a_3844_4734# a_2510_1690# 0.26052f
C37 t2 a_480_5620# 0.12476f
C38 a_2804_3624# m1_1728_4540# 0.04055f
C39 vbp_syn vreset 0.02804f
C40 mreset vdd 0.17448f
C41 a_480_5620# vdd 2.32292f
C42 vbp_syn m1_4822_6422# 0.16563f
C43 vbn_leak sub_b 0.05733f
C44 abus en 0.03536f
C45 vbn_prb vbn_ref 1.67186f
C46 mreset vm 0
C47 sub m1_3360_308# 0.00347f
C48 vm a_480_5620# 1.80313f
C49 t2 t0 0
C50 stb vbp_syn 0.00159f
C51 m1_2117_7612# m1_230_7612# 0.00585f
C52 sub a_2804_3624# 0.03282f
C53 t0 vdd 0.10571f
C54 vbn_prb vdd 0.09485f
C55 m1_1960_6220# sub_b 0.00259f
C56 m1_2640_980# m1_3360_308# 0.07414f
C57 en sub_b 0
C58 a_3184_3624# vreset 0
C59 vm t0 0.06116f
C60 a_2160_3542# a_1580_2680# 0.26798f
C61 sub_b a_1580_2680# 0
C62 vm vbn_prb 0
C63 t2 m1_1104_8052# 0.02879f
C64 hold m1_2521_6720# 0.06259f
C65 vsrc a_2510_1690# 0.34407f
C66 rsel m1_1728_4540# 0.17042f
C67 stb a_3184_3624# 0
C68 m1_2960_1560# vbn_leak 0.00407f
C69 sub rsel 0.54399f
C70 m1_3360_308# el 0.04269f
C71 m1_853_6232# m1_230_7612# 0.09056f
C72 m1_2117_7612# m1_1545_7160# 0.05367f
C73 vbp_st aux 0.03814f
C74 rsel m1_2640_980# 0.00391f
C75 m1_4822_412# vbn_prb 0.07515f
C76 m1_2960_1560# en 0
C77 sta mreset 0.01631f
C78 m1_3212_6232# spk 0.12201f
C79 m1_3360_308# vreset 0.00925f
C80 a_2510_1690# m1_3620_1976# 0.03353f
C81 sta a_480_5620# 0
C82 m1_2240_4540# m1_1728_4540# 0.03258f
C83 a_2804_3624# vreset 0
C84 a_3844_4734# aux 0
C85 mreset abus 0
C86 hold vbp_syn 0.11153f
C87 vbp_st vbn_leak 0.04142f
C88 a_2240_2680# spk 0.06522f
C89 a_3844_4734# vbn_leak 0
C90 sta t0 0
C91 sub m1_2240_4540# 0.05232f
C92 sta vbn_prb 0
C93 sub m1_2117_7612# 0
C94 m1_2117_7612# m1_201_7160# 0.13635f
C95 rsel el 0
C96 abus vbn_prb 0.03858f
C97 a_2510_1690# m1_218_2312# 0.05021f
C98 vbp_st en 0.00173f
C99 a_480_5620# a_2160_3542# 0.12547f
C100 a_480_5620# sub_b 0
C101 m1_230_7612# m1_1545_7160# 0.07205f
C102 vbp_st a_1580_2680# 0.00503f
C103 hold a_3184_3624# 0
C104 m1_3212_6232# vdd 0.21007f
C105 a_3844_4734# en 0
C106 m1_853_6232# m1_1545_7160# -0.00348f
C107 rsel vreset 0.06949f
C108 vsrc aux 0.03742f
C109 t0 sub_b 0.00188f
C110 m1_3212_6232# vm 0.02826f
C111 vbn_prb sub_b 0.00108f
C112 a_2240_2680# vdd 0
C113 el m1_3652_6232# 0.02119f
C114 vbp_syn a_2510_1690# 0.20871f
C115 stb rsel 0.10644f
C116 vsrc vbn_leak 1.61004f
C117 sub m1_230_7612# 0.00443f
C118 m1_230_7612# m1_201_7160# 0.50203f
C119 vm a_2240_2680# 0.12055f
C120 m1_2240_4540# el 0
C121 m1_4822_6422# m1_3652_6232# 0.00109f
C122 m1_853_6232# m1_201_7160# 0
C123 aux m1_3620_1976# 0.04252f
C124 vsrc en 0.00107f
C125 m1_2240_4540# vreset 0
C126 a_3184_3624# a_2510_1690# 0.05316f
C127 stb m1_3652_6232# 0
C128 hold a_2804_3624# 0.00574f
C129 vsrc a_1580_2680# 0.16575f
C130 vbn_leak m1_3620_1976# 0.17752f
C131 stb m1_2240_4540# 0
C132 m1_2960_1560# vbn_prb 0
C133 vbn_leak m1_2521_6720# 0.02945f
C134 m1_230_7612# el 0
C135 vbp_st mreset 0.00276f
C136 spk vbn_ref 0.00118f
C137 vbp_st a_480_5620# 0.00556f
C138 m1_230_7612# t3 0.19826f
C139 m1_3212_6232# sta 0.31685f
C140 m1_1545_7160# m1_201_7160# 0.01734f
C141 en m1_3620_1976# 0.0014f
C142 m1_853_6232# t3 0.06546f
C143 m1_3620_1976# a_1580_2680# 0
C144 m1_1960_6220# m1_2521_6720# 0
C145 spk vdd 0.58558f
C146 vbn_leak m1_218_2312# 0.22445f
C147 vbp_st t0 0
C148 hold rsel 0.23716f
C149 sub m1_1728_4540# 0.04807f
C150 a_2510_1690# m1_3360_308# 0.01778f
C151 vbp_st vbn_prb 1.63942f
C152 a_2804_3624# a_2510_1690# 0.12508f
C153 vm spk 7.88647f
C154 vbp_syn aux 0.1314f
C155 stb m1_230_7612# 0.02199f
C156 a_3844_4734# vbn_prb 0
C157 m1_3212_6232# sub_b 0.01974f
C158 t2 m1_1400_6220# 0.14209f
C159 m1_1400_6220# vdd 0.04552f
C160 sub m1_201_7160# 0.02979f
C161 vbn_ref vdd 0.31646f
C162 vbp_syn vbn_leak 0.29747f
C163 m1_218_2312# a_1580_2680# 0.15408f
C164 hold m1_3652_6232# 0
C165 sub m1_2640_980# 0.00108f
C166 a_2240_2680# sub_b 0
C167 a_2240_2680# a_2160_3542# 0.00291f
C168 vm m1_1400_6220# 0.05245f
C169 vm vbn_ref 0
C170 t2 vdd 0.27922f
C171 mreset vsrc 0.01081f
C172 vsrc a_480_5620# 0.05638f
C173 a_280_2680# a_1580_2680# 0
C174 hold m1_2240_4540# 0.28632f
C175 vm t2 0.03629f
C176 m1_1728_4540# el 0
C177 vm vdd 2.3694f
C178 t1 m1_2521_6720# 0
C179 vbp_syn en 0
C180 rsel a_2510_1690# 0.24001f
C181 vbp_syn a_1580_2680# 0
C182 vbn_leak a_3184_3624# 0.00174f
C183 vsrc vbn_prb 0.01277f
C184 sub el 0
C185 t3 m1_201_7160# 0.07954f
C186 m1_4822_412# vbn_ref 0.07811f
C187 sta spk 0.06781f
C188 m1_2640_980# el 0.28956f
C189 stb m1_1728_4540# 0
C190 a_3184_3624# a_1580_2680# 0
C191 a_480_5620# m1_2521_6720# 0.04673f
C192 abus spk 0
C193 sub vreset 0.01775f
C194 hold m1_230_7612# 0.00379f
C195 m1_4822_412# vdd 0.01273f
C196 aux m1_3360_308# 0.02311f
C197 m1_2240_4540# a_2510_1690# 0.02307f
C198 m1_4822_1769# m1_2640_980# 0.01707f
C199 vbn_prb m1_3620_1976# 0.00782f
C200 hold m1_853_6232# 0
C201 m1_2640_980# vreset 0.03286f
C202 m1_3212_6232# vbp_st 0.00283f
C203 sub stb 0.00852f
C204 stb m1_201_7160# 0.00809f
C205 sta vbn_ref 0
C206 vm m1_4822_412# 0
C207 t0 m1_2521_6720# 0.14038f
C208 vbn_leak m1_3360_308# 0.02593f
C209 a_480_5620# m1_218_2312# 0.04294f
C210 spk a_2160_3542# 0.02364f
C211 spk sub_b 0.37758f
C212 abus vbn_ref 0.02917f
C213 sta vdd 0.20005f
C214 a_280_2680# a_480_5620# 0.00389f
C215 abus vdd 0.23054f
C216 m1_4822_1769# el 0
C217 sta vm 0.08266f
C218 m1_3360_308# en 0.08721f
C219 vbn_prb m1_218_2312# 0
C220 mreset vbp_syn 0.2354f
C221 el vreset 0.03567f
C222 vbn_ref sub_b 0.00409f
C223 vbp_syn a_480_5620# 0
C224 m1_4822_6422# el 0.00143f
C225 vm abus 0.0413f
C226 a_2804_3624# a_1580_2680# 0.01318f
C227 m1_4822_1769# vreset 0.01888f
C228 vdd a_2160_3542# 0.41999f
C229 stb el 0
C230 vdd sub_b 0.50644f
C231 vbp_syn t0 0
C232 rsel vbn_leak 0.11684f
C233 hold m1_1728_4540# 0.05346f
C234 vbp_syn vbn_prb 0.05137f
C235 m1_2960_1560# spk 0
C236 vm a_2160_3542# 0.15014f
C237 vm sub_b 0.06926f
C238 aux m1_3652_6232# 0.00563f
C239 stb m1_4822_6422# 0.00106f
C240 vsrc a_2240_2680# 0.01126f
C241 sub hold 0.2117f
C242 hold m1_201_7160# 0
C243 rsel en 0
C244 m1_2240_4540# aux 0
C245 abus m1_4822_412# 0.00732f
C246 vbn_leak m1_3652_6232# 0.00277f
C247 rsel a_1580_2680# 0.00135f
C248 vbn_leak m1_2240_4540# 0
C249 vbp_st spk 0.1518f
C250 m1_2117_7612# vbn_leak 0.17249f
C251 m1_2960_1560# vdd 0.00688f
C252 a_3844_4734# spk 0.22523f
C253 m1_1728_4540# a_2510_1690# 0.20124f
C254 m1_2960_1560# vm 0.09723f
C255 a_2240_2680# m1_3620_1976# 0.00464f
C256 m1_2240_4540# en 0
C257 vbp_st vbn_ref 0.04246f
C258 m1_2240_4540# a_1580_2680# 0.14562f
C259 hold el 0.02263f
C260 m1_230_7612# aux 0
C261 sub a_2510_1690# 0.05071f
C262 hold t3 0.02418f
C263 a_3844_4734# vbn_ref 0
C264 sta sub_b 0
C265 vbp_st vdd 1.03816f
C266 vbn_prb m1_3360_308# 0.02487f
C267 a_2804_3624# t0 0
C268 abus sub_b 0.01396f
C269 vbn_leak m1_230_7612# 0.91685f
C270 m1_2640_980# a_2510_1690# 0.17487f
C271 hold vreset 0.00784f
C272 a_2240_2680# m1_218_2312# 0.2626f
C273 a_3844_4734# vdd 0.37358f
C274 hold m1_4822_6422# 0.37371f
C275 vbp_st vm 0.10918f
C276 m1_853_6232# vbn_leak 0.00465f
C277 vsrc spk 0.20543f
C278 m1_3212_6232# vbp_syn 0.10492f
C279 a_3844_4734# vm 0
C280 stb hold 0
C281 m1_230_7612# m1_1960_6220# 0.11192f
C282 sub_b a_2160_3542# 0
C283 rsel a_480_5620# 0
C284 m1_853_6232# m1_1960_6220# 0
C285 m1_230_7612# a_1580_2680# 0
C286 m1_2117_7612# t1 0
C287 a_2510_1690# el 0.14932f
C288 vsrc vbn_ref 0.04233f
C289 rsel t0 0
C290 m1_3212_6232# a_3184_3624# 0
C291 rsel vbn_prb 0
C292 spk m1_3620_1976# 0.00781f
C293 mreset m1_3652_6232# 0.02282f
C294 vbp_st m1_4822_412# 0.01194f
C295 m1_2960_1560# abus 0.12604f
C296 vsrc vdd 0.75801f
C297 a_2510_1690# vreset 0.32101f
C298 m1_1728_4540# aux 0
C299 vbn_leak m1_1545_7160# 0.4711f
C300 a_2510_1690# m1_4822_6422# 0.02345f
C301 vsrc vm 0.10688f
C302 m1_2240_4540# a_480_5620# 0.0472f
C303 m1_2117_7612# mreset 0
C304 m1_2117_7612# a_480_5620# 0
C305 vbn_leak m1_1728_4540# 0
C306 t0 m1_3652_6232# 0
C307 vbn_ref m1_3620_1976# 0.00148f
C308 vbn_prb m1_3652_6232# 0
C309 m1_230_7612# t1 0.11648f
C310 sta vbp_st 0.00718f
C311 m1_1545_7160# m1_1960_6220# 0.00456f
C312 m1_218_2312# spk 0.33017f
C313 m1_2240_4540# t0 0
C314 m1_1400_6220# m1_2521_6720# 0
C315 m1_853_6232# t1 0
C316 m1_2117_7612# t0 0.06229f
C317 vbp_st abus 0.02869f
C318 m1_2240_4540# vbn_prb 0
C319 vdd m1_3620_1976# 0.19663f
C320 m1_2640_980# aux 0.03621f
C321 sub vbn_leak 0.26283f
C322 vbn_leak m1_201_7160# 0.82538f
C323 a_280_2680# spk 0.14287f
C324 t2 m1_2521_6720# 0
C325 a_3844_4734# abus 0
C326 m1_2521_6720# vdd 0.04245f
C327 m1_1728_4540# a_1580_2680# 0.06934f
C328 vm m1_3620_1976# 0.00175f
C329 vbn_leak m1_2640_980# 0.05041f
C330 vsrc m1_4822_412# 0.00473f
C331 vbp_syn spk 0.03887f
C332 sub m1_1960_6220# 0.00104f
C333 vbp_st sub_b 0.06679f
C334 mreset m1_230_7612# 0.0013f
C335 m1_1960_6220# m1_201_7160# -0.00348f
C336 m1_230_7612# a_480_5620# 0.08071f
C337 vm m1_2521_6720# 0.05456f
C338 sub en 0
C339 a_3844_4734# a_2160_3542# 0
C340 a_2804_3624# a_2240_2680# 0
C341 a_3844_4734# sub_b 0.0792f
C342 sub a_1580_2680# 0.00338f
C343 m1_201_7160# a_1580_2680# 0.00414f
C344 m1_853_6232# a_480_5620# 0.03858f
C345 m1_218_2312# vdd 0.00167f
C346 aux el 1.56834f
C347 m1_2640_980# en 0.08677f
C348 m1_230_7612# t0 0.0748f
C349 m1_1545_7160# t1 0.11703f
C350 sta vsrc 0
C351 a_280_2680# vdd 0
C352 vm m1_218_2312# 0.21229f
C353 vbp_syn vbn_ref 0.00422f
C354 m1_4822_1769# aux 0.00145f
C355 m1_853_6232# t0 0
C356 vbn_leak el 0.06741f
C357 a_3184_3624# spk 0.18676f
C358 vbn_leak t3 0.17937f
C359 aux vreset 0.02348f
C360 vsrc abus 0.02889f
C361 m1_3212_6232# rsel 0.00326f
C362 hold a_2510_1690# 0.69349f
C363 vm a_280_2680# 0.02837f
C364 aux m1_4822_6422# 0.00219f
C365 vbp_syn vdd 2.76315f
C366 m1_4822_1769# vbn_leak 0.00284f
C367 vbn_leak vreset 0.12335f
C368 stb aux 0
C369 vbn_leak m1_4822_6422# 0.01619f
C370 rsel a_2240_2680# 0.03163f
C371 vm vbp_syn 0.12983f
C372 en el 0
C373 t1 m1_201_7160# 0.03264f
C374 vsrc a_2160_3542# 0.21656f
C375 sub t1 0
C376 a_3184_3624# vbn_ref 0
C377 vsrc sub_b 0.03333f
C378 a_480_5620# m1_1545_7160# 0.005f
C379 el a_1580_2680# 0.03159f
C380 m1_3212_6232# m1_3652_6232# 0.02124f
C381 stb vbn_leak 0.00869f
C382 m1_4822_1769# en 0.0872f
C383 abus m1_3620_1976# 0.08292f
C384 a_3184_3624# vdd 0.39416f
C385 en vreset 1.61003f
C386 m1_1728_4540# a_480_5620# 0.09171f
C387 m1_1545_7160# t0 0.04003f
C388 m1_4822_6422# en 0
C389 vm a_3184_3624# 0
C390 stb m1_1960_6220# 0
C391 a_2804_3624# spk 0.01393f
C392 mreset m1_201_7160# 0
C393 sub a_480_5620# 0.04543f
C394 sub_b m1_3620_1976# 0.50594f
C395 a_3844_4734# vbp_st 0.0019f
C396 m1_1545_7160# m1_1104_8052# -0.0026f
C397 m1_2521_6720# sub_b 0.00865f
C398 abus m1_218_2312# 0
C399 m1_3360_308# vbn_ref 0.03071f
C400 sub t0 0.03494f
C401 t0 m1_201_7160# 0.10154f
C402 sub vbn_prb 0
C403 sta vbp_syn 0.02421f
C404 m1_3360_308# vdd 0.28082f
C405 m1_3212_6232# m1_230_7612# 0.0044f
C406 hold aux 0.02266f
C407 a_2804_3624# vdd 0.46363f
C408 m1_218_2312# a_2160_3542# 0.01019f
C409 m1_218_2312# sub_b 0.18221f
C410 m1_2640_980# vbn_prb 0.11524f
C411 rsel spk 0.06256f
C412 m1_1104_8052# m1_201_7160# 0.01508f
C413 abus vbp_syn 0.13313f
C414 vm m1_3360_308# 0.1919f
C415 stb t1 0
C416 hold vbn_leak 0.04498f
C417 vm a_2804_3624# 0.00131f
C418 mreset el 0.05268f
C419 a_480_5620# el 0.08379f
C420 vbp_st vsrc 1.78319f
C421 a_480_5620# t3 0.2016f
C422 m1_2960_1560# m1_3620_1976# 0
C423 a_3844_4734# vsrc 0.00615f
C424 vbp_syn a_2160_3542# 0
C425 rsel vbn_ref 0
C426 vbp_syn sub_b 0.09812f
C427 spk m1_3652_6232# 0.00384f
C428 mreset vreset 0
C429 t0 el 0
C430 mreset m1_4822_6422# 0
C431 vbn_prb el 0
C432 hold en 0.15747f
C433 hold a_1580_2680# 0.45972f
C434 m1_2240_4540# spk 0.05249f
C435 rsel vdd 0.21148f
C436 stb mreset 0
C437 m1_4822_1769# vbn_prb 0.12869f
C438 stb a_480_5620# 0
C439 a_2510_1690# aux 0.10407f
C440 m1_2960_1560# m1_218_2312# 0
C441 m1_4822_412# m1_3360_308# 0.02239f
C442 vbp_st m1_3620_1976# 0.00423f
C443 vbn_prb vreset 0.04148f
C444 m1_1104_8052# t3 0
C445 vm rsel 0.07774f
C446 vbn_prb m1_4822_6422# 0.15348f
C447 a_3184_3624# a_2160_3542# 0.00549f
C448 a_3184_3624# sub_b 0.09339f
C449 vbn_leak a_2510_1690# 0.18688f
C450 a_3844_4734# m1_3620_1976# 0.02401f
C451 vbp_st m1_2521_6720# 0
C452 stb t0 0.00176f
C453 m1_2240_4540# vbn_ref 0
C454 m1_2117_7612# m1_1400_6220# -0.00319f
C455 vdd m1_3652_6232# 0.18738f
C456 m1_2960_1560# vbp_syn 0.00142f
C457 m1_1728_4540# a_2240_2680# 0
C458 m1_2240_4540# vdd 0.17329f
C459 vm m1_3652_6232# 0.01575f
C460 abus m1_3360_308# 0.05653f
C461 m1_2117_7612# vdd 0
C462 m1_3212_6232# m1_201_7160# 0.00264f
C463 a_2510_1690# en 0.16857f
C464 m1_230_7612# spk 0.01937f
C465 a_2510_1690# a_1580_2680# 0.03411f
C466 a_3844_4734# m1_218_2312# 0.00162f
C467 vm m1_2240_4540# 0.01247f
C468 m1_2117_7612# vm 0
C469 sub a_2240_2680# 0
C470 m1_3360_308# sub_b 0
C471 vsrc m1_3620_1976# 0.00973f
C472 a_2804_3624# a_2160_3542# 0.07346f
C473 vbp_st vbp_syn 0.20022f
C474 a_2804_3624# sub_b 0
C475 m1_230_7612# m1_1400_6220# 0.06175f
C476 m1_2640_980# a_2240_2680# 0
C477 vsrc m1_2521_6720# 0.00102f
C478 hold mreset 0.0013f
C479 hold a_480_5620# 0.53934f
C480 a_3844_4734# vbp_syn 0.15035f
C481 m1_853_6232# m1_1400_6220# 0.00115f
C482 t2 m1_230_7612# 0.07271f
C483 m1_230_7612# vdd 0.07582f
C484 m1_3212_6232# el 0.02221f
C485 rsel abus 0.079f
C486 m1_853_6232# t2 0.03513f
C487 hold t0 0.00446f
C488 m1_853_6232# vdd 0.18994f
C489 vsrc m1_218_2312# 0.01124f
C490 vm m1_230_7612# 0.0064f
C491 vbp_st a_3184_3624# 0.00363f
C492 hold vbn_prb 0.06738f
C493 a_2240_2680# el 0.02725f
C494 vbn_leak aux 1.64929f
C495 vm m1_853_6232# 0.03076f
C496 sta m1_3652_6232# 0.07723f
C497 a_3844_4734# a_3184_3624# 0
C498 m1_3212_6232# m1_4822_6422# -0.01073f
C499 rsel sub_b 0.18129f
C500 rsel a_2160_3542# 0
C501 m1_2960_1560# m1_3360_308# 0.07928f
C502 m1_1728_4540# spk 0.10192f
C503 m1_3212_6232# stb 0.20604f
C504 m1_1545_7160# m1_1400_6220# 0.12394f
C505 vsrc vbp_syn 0.18302f
C506 a_2240_2680# vreset 0.0144f
C507 mreset a_2510_1690# 0.06093f
C508 a_480_5620# a_2510_1690# 0.02283f
C509 aux en 0
C510 sub spk 0.06569f
C511 spk m1_201_7160# 0.00733f
C512 m1_218_2312# m1_3620_1976# 0.08532f
C513 t2 m1_1545_7160# 0
C514 sub_b m1_3652_6232# 0.00309f
C515 m1_1728_4540# vbn_ref 0
C516 vbn_leak m1_1960_6220# 0
C517 m1_1545_7160# vdd 0
C518 vbn_leak en 0
C519 vbp_st m1_3360_308# 0.02322f
C520 vbn_leak a_1580_2680# 0
C521 vbn_prb a_2510_1690# 0.12378f
C522 m1_2240_4540# a_2160_3542# 0.12523f
C523 vm m1_1545_7160# 0
C524 m1_2240_4540# sub_b 0.04389f
C525 vbp_st a_2804_3624# 0.00242f
C526 vsrc a_3184_3624# 0.04241f
C527 m1_1728_4540# vdd 0.58005f
C528 m1_2117_7612# sub_b 0
C529 sub m1_1400_6220# 0
C530 sub vbn_ref 0
C531 m1_1400_6220# m1_201_7160# 0
C532 m1_2960_1560# rsel 0.05365f
C533 vbp_syn m1_3620_1976# 0.22622f
C534 vm m1_1728_4540# 0.05389f
C535 sub t2 0
C536 vbp_syn m1_2521_6720# 0
C537 t2 m1_201_7160# 0.03345f
C538 m1_2640_980# vbn_ref 0.03263f
C539 sub vdd 0.31002f
C540 vdd m1_201_7160# 0.0057f
C541 a_280_2680# m1_218_2312# 0.0732f
C542 spk el 0.10993f
C543 sub vm 0.05465f
C544 vm m1_201_7160# 0.00213f
C545 m1_2640_980# vdd 0.22092f
C546 vbn_leak t1 0.23059f
C547 vbp_syn m1_218_2312# 0.09217f
C548 vbp_st rsel 0.07496f
C549 m1_3212_6232# hold 0
C550 m1_230_7612# sub_b 0.03929f
C551 spk vreset 0.0013f
C552 vm m1_2640_980# 0.3851f
C553 m1_4822_6422# spk 0
C554 vsrc m1_3360_308# 0.02293f
C555 vbn_ref el 0
C556 vsrc a_2804_3624# 0.26788f
C557 m1_1960_6220# t1 0.11171f
C558 mreset aux 0.0341f
C559 stb spk 0.1827f
C560 m1_4822_1769# vbn_ref 0.08364f
C561 t2 t3 0.02665f
C562 el vdd 2.02983f
C563 t1 a_1580_2680# 0
C564 vbp_st m1_3652_6232# 0.021f
C565 t3 vdd 0.21598f
C566 a_3184_3624# m1_218_2312# 0
C567 vbn_ref vreset 0.044f
C568 mreset vbn_leak 0.14679f
C569 m1_4822_6422# vbn_ref 0.09585f
C570 vbn_leak a_480_5620# 0.01406f
C571 a_3844_4734# m1_3652_6232# 0
C572 vm el 0.47318f
C573 vbn_prb aux 0
C574 vm t3 0.05523f
C575 vbp_st m1_2240_4540# 0.18321f
C576 vreset vdd 0.21211f
C577 m1_4822_412# m1_2640_980# 0
C578 m1_3360_308# m1_3620_1976# 0.00893f
C579 m1_4822_6422# vdd 0.06309f
C580 a_3844_4734# m1_2240_4540# 0.00201f
C581 vbn_leak t0 0.21214f
C582 a_480_5620# m1_1960_6220# 0.09099f
C583 vbp_syn a_3184_3624# 0
C584 vbn_leak vbn_prb 0.00382f
C585 vm vreset 0.13899f
C586 vsrc rsel 0.05734f
C587 mreset en 0
C588 vm m1_4822_6422# 0
C589 stb vdd 0.11489f
C590 a_480_5620# a_1580_2680# 0.53347f
C591 a_2510_1690# a_2240_2680# 0.31057f
C592 sub abus 0.01959f
C593 m1_1728_4540# a_2160_3542# 0.0863f
C594 vbn_leak m1_1104_8052# 0.10489f
C595 m1_1728_4540# sub_b 0.10165f
C596 stb vm 0.04193f
C597 t0 m1_1960_6220# 0.05658f
C598 m1_4822_412# el 0.00127f
C599 vbn_prb en 0.01295f
C600 abus m1_2640_980# 0.1008f
C601 t0 a_1580_2680# 0
C602 a_2804_3624# m1_218_2312# 0
C603 vsrc m1_3652_6232# 0.00185f
C604 sub sub_b 0.42649f
C605 sub a_2160_3542# 0
C606 sub_b m1_201_7160# 0.05018f
C607 hold spk 0.03515f
C608 rsel m1_3620_1976# 0.12152f
C609 vsrc m1_2240_4540# 0.13339f
C610 m1_4822_412# vreset 0.00941f
C611 rsel m1_2521_6720# 0.01184f
C612 vbp_syn m1_3360_308# 0.0873f
C613 m1_2640_980# sub_b 0.00854f
C614 sta el 0
C615 a_480_5620# t1 0.18962f
C616 a_2804_3624# vbp_syn 0
C617 abus el 0.04922f
C618 hold vbn_ref 0.16868f
C619 sta vreset 0
C620 t0 t1 0.01868f
C621 rsel m1_218_2312# 0.03219f
C622 sta m1_4822_6422# 0
C623 abus m1_4822_1769# 0.011f
C624 hold t2 0
C625 abus vreset 2.07962f
C626 hold vdd 1.37631f
C627 el a_2160_3542# 0
C628 sub m1_2960_1560# 0.03655f
C629 el sub_b 0.00421f
C630 stb sta 0.00798f
C631 m1_3212_6232# aux 0.00608f
C632 a_2804_3624# a_3184_3624# 0.04419f
C633 a_2510_1690# spk 0.13846f
C634 m1_2240_4540# m1_2521_6720# 0
C635 m1_1104_8052# t1 0.00183f
C636 hold vm 0.68396f
C637 m1_2117_7612# m1_2521_6720# 0.03436f
C638 m1_4822_1769# sub_b 0
C639 m1_3212_6232# vbn_leak 0.02691f
C640 m1_2960_1560# m1_2640_980# 0.0301f
C641 rsel vbp_syn 0.02423f
C642 vreset a_2160_3542# 0
C643 vbp_st m1_1728_4540# 0.03538f
C644 vreset sub_b 0.00437f
C645 mreset t0 0
C646 a_480_5620# t0 0.2129f
C647 mreset vbn_prb 0
C648 a_3844_4734# m1_1728_4540# 0.00712f
C649 vbn_leak a_2240_2680# 0.00476f
C650 a_2510_1690# vbn_ref 0.17248f
C651 stb sub_b 0.05708f
C652 vbp_st m1_201_7160# 0
C653 sub vbp_st 0.04668f
C654 vbp_syn m1_3652_6232# 0.17183f
C655 rsel a_3184_3624# 0.14686f
C656 a_2510_1690# vdd 1.94717f
C657 m1_2960_1560# el 0
C658 vbp_st m1_2640_980# 0.03176f
C659 m1_230_7612# m1_2521_6720# 0.06865f
C660 vbp_syn m1_2240_4540# 0.01863f
C661 vm a_2510_1690# 0.25822f
C662 a_2240_2680# a_1580_2680# 0.26733f
C663 m1_853_6232# m1_2521_6720# 0
C664 m1_2960_1560# vreset 0.00744f
C665 vsrc m1_1728_4540# 0.17442f
C666 hold sta 0
C667 vbp_st el 0.03856f
C668 hold abus 0
C669 m1_2240_4540# a_3184_3624# 0.01057f
C670 aux spk 0
C671 sub vsrc 0.11959f
C672 rsel m1_3360_308# 0.03771f
C673 a_3844_4734# el 0
C674 vbp_st m1_4822_1769# 0.01317f
C675 rsel a_2804_3624# 0.2233f
C676 vbp_syn m1_230_7612# 0
C677 vbp_st vreset 0.02854f
C678 m1_1545_7160# m1_2521_6720# 0
C679 vsrc m1_2640_980# 0.03962f
C680 vbn_leak spk 0.00837f
C681 vbp_st m1_4822_6422# 0.06499f
C682 hold sub_b 0.09526f
C683 hold a_2160_3542# 0.0299f
C684 a_3844_4734# vreset 0
C685 aux vbn_ref 0
C686 stb vbp_st 0
C687 m1_3212_6232# mreset 0.02902f
C688 sta a_2510_1690# 0
C689 sub m1_3620_1976# 0.10111f
C690 en spk 0
C691 vbn_leak m1_1400_6220# 0.07057f
C692 vbn_leak vbn_ref 0.01408f
C693 aux vdd 0.17899f
C694 abus a_2510_1690# 0.09381f
C695 spk a_1580_2680# 0.11186f
C696 vsrc el 0.03768f
C697 a_2804_3624# m1_2240_4540# 0.02776f
C698 sub m1_2521_6720# 0.1829f
C699 m1_2521_6720# m1_201_7160# 0.12199f
C700 a_480_5620# a_2240_2680# 0.09166f
C701 m1_3212_6232# t0 0
C702 m1_1728_4540# m1_218_2312# 0
C703 m1_2640_980# m1_3620_1976# 0.01186f
C704 t2 vbn_leak 0.18933f
C705 vm aux 0
C706 vbn_leak vdd 0.45809f
C707 vsrc m1_4822_1769# 0.00456f
C708 en vbn_ref 1.6485f
C709 vsrc vreset 0.03083f
C710 a_2510_1690# a_2160_3542# 0.01599f
C711 a_2510_1690# sub_b 0.11658f
C712 vm vbn_leak 0.01624f
C713 m1_1400_6220# a_1580_2680# 0
C714 vsrc m1_4822_6422# 0.0165f
C715 sub m1_218_2312# 0.06091f
C716 t2 m1_1960_6220# 0
C717 m1_1960_6220# vdd 0.04212f
C718 vbp_syn m1_1728_4540# 0.0039f
C719 rsel m1_3652_6232# 0
C720 en vdd 0.14235f
C721 t2 a_1580_2680# 0
C722 stb vsrc 0
C723 m1_2640_980# m1_218_2312# 0
C724 vdd a_1580_2680# 0.56263f
C725 el m1_3620_1976# 0.15959f
C726 vm m1_1960_6220# 0.03949f
C727 rsel m1_2240_4540# 0.03975f
C728 vm en 0
C729 m1_4822_412# aux 0.00149f
C730 aux vss 0.33903f
C731 m1_3360_308# vss 0.9795f
C732 m1_2640_980# vss 0.66569f
C733 m1_1104_8052# vss -0.03875f
C734 abus vss 2.1282f
C735 sub vss 0.43014f
C736 mreset vss 0.63001f
C737 hold vss 0.40978f
C738 vdd vss 18.48943f
C739 m1_1545_7160# vss 0.0931f
C740 m1_2117_7612# vss 0.15029f
C741 m1_4822_412# vss 0.2708f
C742 en vss 0.53423f
C743 m1_853_6232# vss 0.06455f
C744 t3 vss 0.29075f
C745 vbn_prb vss 0.84284f
C746 a_3184_3624# vss 0.16059f
C747 m1_1400_6220# vss -0.02823f
C748 t2 vss 0.24703f
C749 a_2804_3624# vss 0.07184f
C750 m1_1960_6220# vss -0.00388f
C751 t1 vss 0.2225f
C752 m1_230_7612# vss 0.83082f
C753 m1_201_7160# vss 2.17544f
C754 spk vss 0.96416f
C755 m1_2521_6720# vss -0.00421f
C756 t0 vss 0.22388f
C757 m1_2960_1560# vss 0.04388f
C758 rsel vss 0.72701f
C759 m1_2240_4540# vss -0.06271f
C760 vm vss 3.51249f
C761 sub_b vss 0.66059f
C762 vbp_st vss 0.35917f
C763 m1_3212_6232# vss 0.09723f
C764 stb vss 0.32333f
C765 sta vss 0.24763f
C766 m1_218_2312# vss 0.59899f
C767 a_2160_3542# vss 0.156f
C768 vsrc vss 0.51629f
C769 vreset vss 0.52516f
C770 a_2510_1690# vss 2.51293f
C771 m1_4822_1769# vss 0.08158f
C772 m1_1728_4540# vss 0.07035f
C773 vbn_ref vss 0.59078f
C774 a_2240_2680# vss 0.26463f
C775 a_1580_2680# vss 0.51675f
C776 a_3844_4734# vss 0.0111f
C777 m1_4822_6422# vss -0.18471f
C778 m1_3652_6232# vss -0.05799f
C779 vbp_syn vss 0.23708f
C780 a_480_5620# vss 0.04043f
C781 a_280_2680# vss 0.0902f
C782 el vss 1.08824f
C783 vbn_leak vss 3.86633f
C784 m1_3620_1976# vss 0.85423f
.ends
