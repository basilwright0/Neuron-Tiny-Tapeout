* NGSPICE file created from slot_ah_h.ext - technology: gf180mcuD

.subckt p_w2_l4 a_400_n200# a_n400_n244# w_n574_n330# a_n488_n200# VSUBS
X0 a_400_n200# a_n400_n244# a_n488_n200# w_n574_n330# pfet_03v3 ad=0.88p pd=4.88u as=0.88p ps=4.88u w=2u l=4u
C0 a_n488_n200# a_400_n200# 0.01073f
C1 w_n574_n330# a_400_n200# 0.07409f
C2 a_n400_n244# a_n488_n200# 0.07019f
C3 w_n574_n330# a_n400_n244# 0.42229f
C4 w_n574_n330# a_n488_n200# 0.07409f
C5 a_n400_n244# a_400_n200# 0.07019f
C6 a_400_n200# VSUBS 0.18936f
C7 a_n488_n200# VSUBS 0.18936f
C8 w_n574_n330# VSUBS 2.27304f
.ends

.subckt p_w0p22_l1 a_100_n22# a_n100_n66# w_n278_n159# a_n192_n36# VSUBS
X0 a_100_n22# a_n100_n66# a_n192_n36# w_n278_n159# pfet_03v3 ad=0.1516p pd=1.64u as=0.1516p ps=1.64u w=0.22u l=1u
C0 a_n100_n66# a_100_n22# 0.00509f
C1 w_n278_n159# a_100_n22# 0.00771f
C2 a_n192_n36# a_n100_n66# 0.00509f
C3 w_n278_n159# a_n192_n36# 0.00771f
C4 w_n278_n159# a_n100_n66# 0.13163f
C5 a_n192_n36# a_100_n22# 0.00453f
C6 a_100_n22# VSUBS 0.05952f
C7 a_n192_n36# VSUBS 0.05952f
C8 w_n278_n159# VSUBS 0.53042f
.ends

.subckt n_w1_l0p28 a_28_n100# a_n28_n144# a_n116_n100# VSUBS
X0 a_28_n100# a_n28_n144# a_n116_n100# VSUBS nfet_03v3 ad=0.44p pd=2.88u as=0.44p ps=2.88u w=1u l=0.28u
C0 a_n116_n100# a_28_n100# 0.04256f
C1 a_n28_n144# a_n116_n100# 0.00769f
C2 a_n28_n144# a_28_n100# 0.00769f
C3 a_28_n100# VSUBS 0.09911f
C4 a_n116_n100# VSUBS 0.09911f
.ends

.subckt n_w2_l2 a_n288_n200# a_200_n200# a_n200_n244# VSUBS
X0 a_200_n200# a_n200_n244# a_n288_n200# VSUBS nfet_03v3 ad=0.88p pd=4.88u as=0.88p ps=4.88u w=2u l=2u
C0 a_n288_n200# a_200_n200# 0.02133f
C1 a_n200_n244# a_n288_n200# 0.0587f
C2 a_n200_n244# a_200_n200# 0.0587f
C3 a_200_n200# VSUBS 0.2667f
C4 a_n288_n200# VSUBS 0.2667f
.ends

.subckt n_w2_l4 a_400_n200# a_n400_n244# a_n488_n200# VSUBS
X0 a_400_n200# a_n400_n244# a_n488_n200# VSUBS nfet_03v3 ad=0.88p pd=4.88u as=0.88p ps=4.88u w=2u l=4u
C0 a_n488_n200# a_400_n200# 0.01073f
C1 a_n400_n244# a_n488_n200# 0.07019f
C2 a_n400_n244# a_400_n200# 0.07019f
C3 a_400_n200# VSUBS 0.41684f
C4 a_n488_n200# VSUBS 0.41684f
.ends

.subckt n_w4_l1 a_n188_n400# a_100_n400# a_n100_n444# VSUBS
X0 a_100_n400# a_n100_n444# a_n188_n400# VSUBS nfet_03v3 ad=1.76p pd=8.88u as=1.76p ps=8.88u w=4u l=1u
C0 a_n188_n400# a_100_n400# 0.07756f
C1 a_n100_n444# a_n188_n400# 0.08505f
C2 a_n100_n444# a_100_n400# 0.08505f
C3 a_100_n400# VSUBS 0.26859f
C4 a_n188_n400# VSUBS 0.26859f
.ends

.subckt n_w0p5_l0p28 a_n28_n94# a_n116_n50# a_28_n50# VSUBS
X0 a_28_n50# a_n28_n94# a_n116_n50# VSUBS nfet_03v3 ad=0.22p pd=1.88u as=0.22p ps=1.88u w=0.5u l=0.28u
C0 a_n116_n50# a_28_n50# 0.02085f
C1 a_n28_n94# a_n116_n50# 0.00377f
C2 a_n28_n94# a_28_n50# 0.00377f
C3 a_28_n50# VSUBS 0.07987f
C4 a_n116_n50# VSUBS 0.07987f
.ends

.subckt p_w1_l0p5 a_n138_n100# a_50_n100# a_n50_n144# w_n224_n230# VSUBS
X0 a_50_n100# a_n50_n144# a_n138_n100# w_n224_n230# pfet_03v3 ad=0.44p pd=2.88u as=0.44p ps=2.88u w=1u l=0.5u
C0 a_n138_n100# a_50_n100# 0.03085f
C1 w_n224_n230# a_50_n100# 0.0205f
C2 a_n50_n144# a_n138_n100# 0.01275f
C3 w_n224_n230# a_n50_n144# 0.07993f
C4 w_n224_n230# a_n138_n100# 0.0205f
C5 a_n50_n144# a_50_n100# 0.01275f
C6 a_50_n100# VSUBS 0.06546f
C7 a_n138_n100# VSUBS 0.06546f
C8 w_n224_n230# VSUBS 0.61824f
.ends

.subckt n_w1_l0p5 a_n138_n100# a_50_n100# a_n50_n144# VSUBS
X0 a_50_n100# a_n50_n144# a_n138_n100# VSUBS nfet_03v3 ad=0.44p pd=2.88u as=0.44p ps=2.88u w=1u l=0.5u
C0 a_n138_n100# a_50_n100# 0.03085f
C1 a_n50_n144# a_n138_n100# 0.01275f
C2 a_n50_n144# a_50_n100# 0.01275f
C3 a_50_n100# VSUBS 0.11563f
C4 a_n138_n100# VSUBS 0.11563f
.ends

.subckt p_w1_l0p28 w_n202_n230# a_28_n100# a_n28_n144# a_n116_n100# VSUBS
X0 a_28_n100# a_n28_n144# a_n116_n100# w_n202_n230# pfet_03v3 ad=0.44p pd=2.88u as=0.44p ps=2.88u w=1u l=0.28u
C0 a_n116_n100# a_28_n100# 0.04256f
C1 w_n202_n230# a_28_n100# 0.01808f
C2 a_n28_n144# a_n116_n100# 0.00769f
C3 w_n202_n230# a_n28_n144# 0.05841f
C4 w_n202_n230# a_n116_n100# 0.01808f
C5 a_n28_n144# a_28_n100# 0.00769f
C6 a_28_n100# VSUBS 0.0597f
C7 a_n116_n100# VSUBS 0.0597f
C8 w_n202_n230# VSUBS 0.55752f
.ends

.subckt n_w4_l2 a_n288_n400# a_200_n400# a_n200_n444# VSUBS
X0 a_200_n400# a_n200_n444# a_n288_n400# VSUBS nfet_03v3 ad=1.76p pd=8.88u as=1.76p ps=8.88u w=4u l=2u
C0 a_n288_n400# a_200_n400# 0.04287f
C1 a_n200_n444# a_n288_n400# 0.11799f
C2 a_n200_n444# a_200_n400# 0.11799f
C3 a_200_n400# VSUBS 0.34365f
C4 a_n288_n400# VSUBS 0.34365f
.ends

.subckt p_w1_l2 w_n374_n230# a_n288_n100# a_200_n100# a_n200_n144# VSUBS
X0 a_200_n100# a_n200_n144# a_n288_n100# w_n374_n230# pfet_03v3 ad=0.44p pd=2.88u as=0.44p ps=2.88u w=1u l=2u
C0 a_n288_n100# a_200_n100# 0.01056f
C1 w_n374_n230# a_200_n100# 0.03135f
C2 a_n200_n144# a_n288_n100# 0.02905f
C3 w_n374_n230# a_n200_n144# 0.22666f
C4 w_n374_n230# a_n288_n100# 0.03135f
C5 a_n200_n144# a_200_n100# 0.02905f
C6 a_200_n100# VSUBS 0.1047f
C7 a_n288_n100# VSUBS 0.1047f
C8 w_n374_n230# VSUBS 1.03224f
.ends

.subckt n_w7p07_l7p07 a_707_n707# a_n795_n707# a_n707_n751# VSUBS
X0 a_707_n707# a_n707_n751# a_n795_n707# VSUBS nfet_03v3 ad=3.1108p pd=15.02u as=3.1108p ps=15.02u w=7.07u l=7.07u
C0 a_n795_n707# a_707_n707# 0.0212f
C1 a_n707_n751# a_n795_n707# 0.27012f
C2 a_n707_n751# a_707_n707# 0.27012f
C3 a_707_n707# VSUBS 0.84237f
C4 a_n795_n707# VSUBS 0.84237f
.ends

.subckt n_w0p5_l1p5 a_150_n50# a_n238_n50# a_n150_n94# VSUBS
X0 a_150_n50# a_n150_n94# a_n238_n50# VSUBS nfet_03v3 ad=0.22p pd=1.88u as=0.22p ps=1.88u w=0.5u l=1.5u
C0 a_n238_n50# a_150_n50# 0.00671f
C1 a_n150_n94# a_n238_n50# 0.01269f
C2 a_n150_n94# a_150_n50# 0.01269f
C3 a_150_n50# VSUBS 0.17146f
C4 a_n238_n50# VSUBS 0.17146f
.ends

.subckt n_w3p54_l3p54 a_354_n354# a_n354_n398# a_n442_n354# VSUBS
X0 a_354_n354# a_n354_n398# a_n442_n354# VSUBS nfet_03v3 ad=1.5576p pd=7.96u as=1.5576p ps=7.96u w=3.54u l=3.54u
C0 a_n442_n354# a_354_n354# 0.02161f
C1 a_n354_n398# a_n442_n354# 0.12189f
C2 a_n354_n398# a_354_n354# 0.12189f
C3 a_354_n354# VSUBS 0.44156f
C4 a_n442_n354# VSUBS 0.44156f
.ends

.subckt n_w0p22_l2 a_200_n22# a_n200_n66# a_n292_n36# VSUBS
X0 a_200_n22# a_n200_n66# a_n292_n36# VSUBS nfet_03v3 ad=0.1516p pd=1.64u as=0.1516p ps=1.64u w=0.22u l=2u
C0 a_n200_n66# a_200_n22# 0.00705f
C1 a_n292_n36# a_n200_n66# 0.00705f
C2 a_n292_n36# a_200_n22# 0.00245f
C3 a_200_n22# VSUBS 0.20767f
C4 a_n292_n36# VSUBS 0.20767f
.ends

.subckt n_w0p5_l3 a_n388_n50# a_300_n50# a_n300_n94# VSUBS
X0 a_300_n50# a_n300_n94# a_n388_n50# VSUBS nfet_03v3 ad=0.22p pd=1.88u as=0.22p ps=1.88u w=0.5u l=3u
C0 a_n388_n50# a_300_n50# 0.00348f
C1 a_n300_n94# a_n388_n50# 0.01602f
C2 a_n300_n94# a_300_n50# 0.01602f
C3 a_300_n50# VSUBS 0.28406f
C4 a_n388_n50# VSUBS 0.28406f
.ends

.subckt n_w0p5_l4 a_n488_n50# a_400_n50# a_n400_n94# VSUBS
X0 a_400_n50# a_n400_n94# a_n488_n50# VSUBS nfet_03v3 ad=0.22p pd=1.88u as=0.22p ps=1.88u w=0.5u l=4u
C0 a_n488_n50# a_400_n50# 0.0026f
C1 a_n400_n94# a_n488_n50# 0.01702f
C2 a_n400_n94# a_400_n50# 0.01702f
C3 a_400_n50# VSUBS 0.35913f
C4 a_n488_n50# VSUBS 0.35913f
.ends

.subckt slot_ah_h vss vbp_syn vdd el aux vbn_leak vsrc vbp_st vbn_prb vbn_ref en vreset
+ abus spk t3 t2 t1 t0 sta stb hold mreset rsel sub sub_b vm
XXL_XP1 a_480_5620# a_480_5620# vdd vdd vss p_w2_l4
XXD_XK a_3184_3624# spk vdd vdd vss p_w0p22_l1
XXPM_XSW m1_4052_1572# rsel m1_3704_1572# vss n_w1_l0p28
XXL_XP2 a_1632_2940# a_480_5620# vdd vdd vss p_w2_l4
XXPR_XMB vss m1_4802_1762# vbn_prb vss n_w2_l2
XXL_XMT m1_644_2312# vbn_leak vss vss n_w2_l4
XXL_XM1 a_288_2940# a_480_5620# el vss n_w4_l1
XXS_XWA m1_4904_6422# vbp_syn vdd m1_3652_6232# vss p_w2_l4
XXR_Xi_XN spk vss a_3844_4734# vss n_w0p5_l0p28
XXL_XM2 a_2528_2940# a_1632_2940# a_1632_2940# vss n_w4_l1
XXS_XWB m1_4904_6422# vbp_syn vdd m1_3212_6232# vss p_w2_l4
XXR_XNR vss vbn_ref a_2510_1740# vss n_w2_l4
XXD_XPI m1_1692_4664# a_2160_3542# vm vdd vss p_w1_l0p5
XXPR_XME m1_2424_756# en m1_4802_1762# vss n_w1_l0p28
XXR_XSW vreset vm a_2510_1740# vss n_w1_l0p5
XXR_Xi_XP vdd a_3844_4734# spk vdd vss p_w1_l0p28
XXD_XNI vsrc a_2160_3542# vm vss n_w1_l0p5
XXPR_XMF m1_2424_756# vdd a_2510_1740# vss n_w4_l2
XXS_XQA vdd m1_3652_6232# sta vss vss p_w1_l0p28
XXS_XQB vdd m1_3212_6232# stb vss vss p_w1_l0p28
XXS_XNA sta vm m1_3652_6232# vss n_w0p5_l0p28
XXS_XNB stb vm m1_3212_6232# vss n_w0p5_l0p28
XXD_XS2 vdd vdd m1_2260_4540# vbp_st vss p_w1_l2
XXD_XPS vdd vdd m1_1692_4664# vbp_st vss p_w1_l2
XXD_XS3 vdd vdd m1_1545_4540# vbp_st vss p_w1_l2
XXL_XD2a m1_644_2312# a_2528_2940# a_2528_2940# vss n_w4_l1
XXPM_XSB abus sub_b m1_4052_1572# vss n_w1_l0p28
XXL_XD2b m1_644_2312# a_2528_2940# a_2528_2940# vss n_w4_l1
XXL_XD1a m1_644_2312# a_288_2940# a_288_2940# vss n_w4_l1
XXPM_XSC m1_3704_1572# en m1_3348_960# vss n_w1_l0p28
XXC_XC vss vss vm vss n_w7p07_l7p07
XXS_XPH vdd m1_4904_6422# vdd hold vss p_w1_l2
XXT_XR1 m1_2105_7600# m1_1557_7120# vbn_leak vss n_w0p5_l1p5
XXD_XP2 vdd a_2804_3624# a_2160_3542# m1_2260_4540# vss p_w1_l0p28
XXL_XD1b m1_644_2312# a_288_2940# a_288_2940# vss n_w4_l1
XXPR_XSW m1_2972_1572# rsel m1_2260_960# vss n_w1_l0p28
XXT_XR2 m1_208_6996# m1_2105_7600# vbn_leak vss n_w0p5_l1p5
XXT_XP0 vdd m1_2436_6996# t0 vm vss p_w1_l0p28
XXD_Xi4_XN a_3184_3624# vss spk vss n_w0p5_l0p28
XXD_XP3 vdd a_3184_3624# a_2804_3624# m1_1545_4540# vss p_w1_l0p28
XXT_XR3 m1_208_7600# m1_208_6996# vbn_leak vss n_w0p5_l1p5
XXT_XP1 vdd m1_1973_6232# t1 vm vss p_w1_l0p28
XXR_XCR_XC vss a_2510_1740# vss vss n_w3p54_l3p54
XXD_XN2 a_2804_3624# a_2160_3542# vsrc vss n_w0p22_l2
XXT_XN0 t0 a_480_5620# m1_2436_6996# vss n_w0p5_l0p28
XXT_XP2 vdd m1_1401_6720# t2 vm vss p_w1_l0p28
XXD_Xi4_XP vdd spk a_3184_3624# vdd vss p_w1_l0p28
XXD_XN3 a_2804_3624# vsrc a_3184_3624# vss n_w0p5_l0p28
XXPM_XMB vss m1_4822_412# vbn_prb vss n_w2_l2
XXT_XN1 t1 a_480_5620# m1_1973_6232# vss n_w0p5_l0p28
XXT_XP3 vdd m1_796_6120# t3 vm vss p_w1_l0p28
XXT_XL0 m1_2436_6996# m1_208_7600# vbn_leak vss n_w0p5_l3
XXT_XN2 t2 a_480_5620# m1_1401_6720# vss n_w0p5_l0p28
XXT_XLT m1_208_7600# vdd vbn_leak vss n_w0p5_l3
XXT_XL1 m1_1973_6232# m1_208_6996# vbn_leak vss n_w0p5_l3
XXT_XN3 t3 a_480_5620# m1_796_6120# vss n_w0p5_l0p28
XXR_XPC vdd a_2510_1740# a_3844_4734# vdd vss p_w1_l0p28
XXPM_XME m1_3348_960# en m1_4822_412# vss n_w1_l0p28
XXT_XL2 m1_1401_6720# m1_2105_7600# vbn_leak vss n_w0p5_l3
XXT_XL3 m1_796_6120# m1_1557_7120# vbn_leak vss n_w0p5_l3
XXPM_XMF m1_3348_960# vdd vm vss n_w4_l2
XXS_XHL vdd vm hold a_1632_2940# vss p_w1_l0p28
XXS_XMR mreset a_2510_1740# vdd vss n_w0p5_l0p28
XXPR_XSB abus sub m1_2972_1572# vss n_w1_l0p28
XXPR_XSC m1_2424_756# en m1_2260_960# vss n_w1_l0p28
XXT_XRB m1_1104_8052# m1_1557_7120# vbn_leak vss n_w0p5_l4
XXT_XRA vss m1_1104_8052# vbn_leak vss n_w0p5_l4
C0 a_3844_4734# a_2510_1740# 0.20872f
C1 vsrc mreset 0.01114f
C2 vreset vbn_ref 0.04932f
C3 sub_b el 0.10714f
C4 m1_4822_412# vdd 0.0096f
C5 t3 m1_208_6996# 0.13726f
C6 vm vbn_ref 0
C7 vbp_st m1_4822_412# 0.0108f
C8 hold mreset 0
C9 m1_1973_6232# spk 0
C10 vbn_leak t1 0.17958f
C11 t0 sta 0
C12 stb m1_3212_6232# 0.18567f
C13 sub_b vbn_leak 0.0817f
C14 m1_3212_6232# m1_208_7600# 0.0038f
C15 vm vreset 0.27595f
C16 t1 m1_1401_6720# 0.07362f
C17 vbp_syn vdd 2.86159f
C18 m1_3348_960# vdd 0.41284f
C19 sub m1_1692_4664# 0.06319f
C20 sub_b aux 0.07451f
C21 rsel stb 0.12542f
C22 vbp_st vbp_syn 0.20604f
C23 vbp_st m1_3348_960# 0.03879f
C24 m1_4822_412# el 0
C25 vm a_288_2940# 0.04745f
C26 vsrc m1_2260_4540# 0
C27 m1_2972_1572# vdd 0.00395f
C28 abus m1_2260_960# 0
C29 vbn_prb spk 0
C30 sub_b a_3844_4734# 0.05377f
C31 m1_4822_412# vbn_leak 0.00192f
C32 en rsel 0.06091f
C33 vbn_prb m1_2424_756# 0.10984f
C34 hold m1_2260_4540# 0.16126f
C35 vm m1_208_6996# 0.01147f
C36 el m1_3348_960# 0.03642f
C37 sta vbn_ref 0
C38 vbp_syn el 0.13814f
C39 m1_644_2312# a_2804_3624# 0
C40 sub spk 0.08056f
C41 sub m1_2424_756# 0
C42 m1_4822_412# aux 0.00115f
C43 a_2804_3624# a_2510_1740# 0
C44 t2 t1 0.07819f
C45 m1_4052_1572# m1_2424_756# 0.01864f
C46 vreset sta 0
C47 a_480_5620# stb 0
C48 vbp_syn vbn_leak 0.25828f
C49 m1_3348_960# vbn_leak 0.03218f
C50 m1_644_2312# vbn_ref 0
C51 a_480_5620# m1_208_7600# 0
C52 stb m1_1557_7120# 0
C53 vsrc vdd 0.22685f
C54 m1_208_7600# m1_1557_7120# 0.00966f
C55 a_1632_2940# m1_2260_4540# 0.03512f
C56 vsrc vbp_st 1.68713f
C57 vm sta 0.04872f
C58 m1_2972_1572# vbn_leak 0
C59 m1_2105_7600# m1_1973_6232# 0.0048f
C60 a_2510_1740# vbn_ref 0.32474f
C61 vbp_syn aux 0.12233f
C62 aux m1_3348_960# 0.03125f
C63 m1_644_2312# vreset 0
C64 hold vdd 1.97062f
C65 hold vbp_st 0.46055f
C66 m1_2436_6996# t1 0
C67 t0 t1 0.04632f
C68 vreset a_2510_1740# 0.09771f
C69 sub_b t0 0
C70 m1_208_6996# sta 0
C71 a_2528_2940# m1_2260_4540# 0
C72 m1_3704_1572# vbp_syn 0.04136f
C73 m1_3704_1572# m1_3348_960# 0.00111f
C74 sub_b m1_2436_6996# 0.00213f
C75 vm m1_644_2312# 0.24474f
C76 m1_644_2312# a_288_2940# 0.51375f
C77 vsrc el 0.06761f
C78 a_3844_4734# vbp_syn 0.11205f
C79 vm a_2510_1740# 0.23084f
C80 abus mreset 0
C81 t3 t1 0
C82 a_1632_2940# vdd 0.73006f
C83 m1_3652_6232# spk 0.00816f
C84 vsrc vbn_leak 1.78855f
C85 hold el 0.0394f
C86 a_1632_2940# vbp_st 0.2412f
C87 sub_b a_2804_3624# 0.00123f
C88 vsrc m1_1545_4540# 0.00157f
C89 rsel m1_1692_4664# 0.00536f
C90 m1_2260_960# sub 0
C91 m1_208_6996# a_2510_1740# 0.00208f
C92 m1_2105_7600# sub 0
C93 m1_2260_960# m1_4052_1572# 0
C94 vsrc aux 0.03767f
C95 hold vbn_leak 0.0804f
C96 a_2528_2940# vdd 0.0022f
C97 a_3184_3624# sub 0.0629f
C98 sub_b vbn_ref 0.00363f
C99 hold m1_1545_4540# 0.0432f
C100 m1_3212_6232# spk 0.10847f
C101 a_1632_2940# el 0.03353f
C102 hold m1_1401_6720# 0.00249f
C103 m1_1692_4664# a_2160_3542# 0.0051f
C104 hold aux 0.0382f
C105 sub_b vreset 0
C106 a_3844_4734# vsrc 0.28359f
C107 t0 vbp_syn 0
C108 m1_2436_6996# vbp_syn 0
C109 rsel spk 0.34479f
C110 m1_796_6120# vdd 0.32268f
C111 sta a_2510_1740# 0
C112 rsel m1_2424_756# 0.00696f
C113 a_1632_2940# vbn_leak 0
C114 vm t1 0.06005f
C115 a_480_5620# m1_1692_4664# 0.15559f
C116 a_2528_2940# el 0.23122f
C117 a_1632_2940# m1_1545_4540# 0.17436f
C118 vm sub_b 0.06978f
C119 a_3844_4734# hold 0.22099f
C120 m1_4822_412# vbn_ref 0.08703f
C121 m1_644_2312# a_2510_1740# 0.17513f
C122 a_2160_3542# spk 0.01268f
C123 m1_208_6996# t1 0.08524f
C124 a_2528_2940# vbn_leak 0.02022f
C125 vbn_prb mreset 0
C126 sub_b m1_208_6996# 0.00404f
C127 a_2528_2940# m1_1545_4540# 0
C128 vreset m1_4822_412# 0.02001f
C129 hold t2 0
C130 abus vdd 0.19859f
C131 a_3844_4734# a_1632_2940# 0.00737f
C132 a_2528_2940# aux 0
C133 vbn_ref m1_3348_960# 0.03356f
C134 vbp_syn vbn_ref 0.00577f
C135 abus vbp_st 0.1157f
C136 a_480_5620# spk 0.07578f
C137 m1_4904_6422# vdd -0.07079f
C138 m1_796_6120# vbn_leak 0.03529f
C139 vm m1_4822_412# 0
C140 m1_4904_6422# vbp_st 0.02925f
C141 stb m1_208_7600# 0.03249f
C142 vreset m1_3348_960# 0.04745f
C143 vreset vbp_syn 0.04129f
C144 m1_796_6120# m1_1401_6720# 0
C145 sub_b sta 0
C146 a_3844_4734# a_2528_2940# 0.03777f
C147 m1_1104_8052# vbn_leak 0.01525f
C148 t0 hold 0.00647f
C149 m1_2436_6996# hold 0.02375f
C150 a_3184_3624# m1_3212_6232# 0
C151 vreset m1_2972_1572# 0
C152 vm m1_3348_960# 0.2229f
C153 abus el 0.03784f
C154 vm vbp_syn 0.11368f
C155 m1_2260_960# rsel 0.06573f
C156 a_2804_3624# vsrc 0.07256f
C157 m1_2105_7600# rsel 0
C158 m1_1973_6232# vdd 0.07111f
C159 en m1_4802_1762# 0.11368f
C160 m1_644_2312# sub_b 0.07618f
C161 vm m1_2972_1572# 0.00716f
C162 rsel a_3184_3624# 0.15677f
C163 abus vbn_leak 0.07074f
C164 sub m1_2260_4540# 0.16212f
C165 hold t3 0.01686f
C166 m1_208_6996# vbp_syn 0
C167 a_2804_3624# hold 0.10403f
C168 sub_b a_2510_1740# 0.11475f
C169 vsrc vbn_ref 0.04621f
C170 t0 a_1632_2940# 0
C171 m1_4904_6422# vbn_leak 0
C172 m1_2260_960# a_2160_3542# 0
C173 abus aux 0.03707f
C174 m1_3652_6232# mreset 0.02141f
C175 m1_796_6120# t2 0.00336f
C176 vsrc vreset 0.0346f
C177 a_3184_3624# a_2160_3542# 0.00161f
C178 hold vbn_ref 0.04997f
C179 vbn_prb vdd 0.09293f
C180 t3 a_1632_2940# 0
C181 m1_3704_1572# abus 0.00665f
C182 m1_2105_7600# a_480_5620# 0
C183 vbn_prb vbp_st 1.71612f
C184 a_2804_3624# a_1632_2940# 0.0023f
C185 sta vbp_syn 0.02674f
C186 vm vsrc 0.12664f
C187 m1_1104_8052# t2 0.03596f
C188 m1_2105_7600# m1_1557_7120# 0.07884f
C189 a_3844_4734# abus 0
C190 hold vreset 0.00188f
C191 a_3184_3624# a_480_5620# 0.00155f
C192 sub vdd 0.31875f
C193 m1_1973_6232# vbn_leak 0.06458f
C194 m1_4052_1572# vdd 0.01699f
C195 mreset m1_3212_6232# 0.03263f
C196 vbp_st sub 0.13823f
C197 m1_1973_6232# m1_1401_6720# 0.00113f
C198 vm hold 0.31488f
C199 m1_644_2312# vbp_syn 0.10157f
C200 m1_644_2312# m1_3348_960# 0
C201 a_2804_3624# a_2528_2940# 0
C202 vbn_prb el 0
C203 vbp_syn a_2510_1740# 0.32753f
C204 a_2510_1740# m1_3348_960# 0.02182f
C205 sub el 0.03583f
C206 hold m1_208_6996# 0.00372f
C207 m1_796_6120# t3 0.18981f
C208 el m1_4052_1572# 0.04092f
C209 vbn_prb vbn_leak 0
C210 m1_2972_1572# a_2510_1740# 0.07005f
C211 vm a_1632_2940# 0.43105f
C212 vsrc sta 0
C213 vreset a_2528_2940# 0
C214 t3 m1_1104_8052# 0
C215 sub vbn_leak 0.12396f
C216 vbn_prb aux 0
C217 m1_4052_1572# vbn_leak 0.00484f
C218 m1_1545_4540# sub 0.18385f
C219 m1_1973_6232# t2 0
C220 stb spk 0.02657f
C221 vm a_2528_2940# 0.09266f
C222 m1_3652_6232# vdd 0.24896f
C223 sub aux 0
C224 a_288_2940# a_2528_2940# 0.00363f
C225 hold sta 0
C226 m1_208_7600# spk 0.00484f
C227 rsel m1_2260_4540# 0.07376f
C228 m1_644_2312# vsrc 0.01167f
C229 m1_4052_1572# aux 0.03612f
C230 vbp_st m1_3652_6232# 0.006f
C231 m1_4802_1762# m1_2424_756# 0.02111f
C232 a_3844_4734# vbn_prb 0
C233 vsrc a_2510_1740# 0.38857f
C234 m1_3704_1572# m1_4052_1572# 0
C235 en spk 0
C236 vm m1_796_6120# 0.08148f
C237 sub_b m1_3348_960# 0
C238 a_3844_4734# sub 0.15818f
C239 sub_b vbp_syn 0.09408f
C240 en m1_2424_756# 0.11395f
C241 vdd m1_3212_6232# 0.18028f
C242 t0 m1_1973_6232# 0.15422f
C243 m1_2436_6996# m1_1973_6232# 0.00433f
C244 a_2160_3542# m1_2260_4540# 0.16455f
C245 el m1_3652_6232# 0.02275f
C246 hold a_2510_1740# 0.56766f
C247 abus vbn_ref 0.09248f
C248 vbp_st m1_3212_6232# 0.00157f
C249 m1_796_6120# m1_208_6996# 0.10816f
C250 m1_4904_6422# vbn_ref 0.11398f
C251 rsel vdd 0.33464f
C252 abus vreset 1.82741f
C253 a_480_5620# m1_2260_4540# 0.06854f
C254 rsel vbp_st 0.04306f
C255 t3 m1_1973_6232# 0
C256 m1_644_2312# a_1632_2940# 0.30753f
C257 m1_3652_6232# vbn_leak 0.00306f
C258 m1_208_6996# m1_1104_8052# 0
C259 el m1_3212_6232# 0.02332f
C260 m1_4822_412# m1_3348_960# 0.07018f
C261 vm abus 0.03247f
C262 m1_3652_6232# aux 0.00645f
C263 a_2160_3542# vdd 0.29248f
C264 m1_644_2312# a_2528_2940# 0.43881f
C265 vbp_st a_2160_3542# 0.00601f
C266 rsel el 0.04467f
C267 sub_b vsrc 0.01409f
C268 m1_2105_7600# stb 0
C269 t0 sub 0.06097f
C270 vbn_leak m1_3212_6232# 0.00653f
C271 m1_2436_6996# sub 0.13959f
C272 m1_2105_7600# m1_208_7600# 0.00943f
C273 a_2528_2940# a_2510_1740# 0.02981f
C274 vbp_syn m1_3348_960# 0.07213f
C275 a_3184_3624# stb 0
C276 a_3844_4734# m1_3652_6232# 0
C277 a_480_5620# vdd 2.28428f
C278 hold t1 0
C279 vdd m1_1557_7120# 0
C280 aux m1_3212_6232# 0.00653f
C281 vbp_st a_480_5620# 0.2038f
C282 sub_b hold 0.20837f
C283 rsel vbn_leak 0.09527f
C284 en m1_2260_960# 0.04366f
C285 m1_2972_1572# m1_3348_960# 0
C286 el a_2160_3542# 0
C287 m1_1692_4664# spk 0.01628f
C288 a_2804_3624# sub 0.18452f
C289 vm m1_1973_6232# 0.07357f
C290 rsel aux 0.00381f
C291 vbn_prb vbn_ref 1.74886f
C292 vsrc m1_4822_412# 0.0037f
C293 a_1632_2940# t1 0
C294 el a_480_5620# 0.18437f
C295 m1_208_6996# m1_1973_6232# 0.1096f
C296 sta m1_4904_6422# 0
C297 vbn_prb vreset 0.04313f
C298 sub vbn_ref 0
C299 m1_3704_1572# rsel 0.0163f
C300 m1_1545_4540# a_2160_3542# 0.11196f
C301 a_3844_4734# rsel 0.07252f
C302 m1_644_2312# abus 0.00378f
C303 vreset sub 0
C304 vsrc vbp_syn 0.18021f
C305 vm vbn_prb 0.00158f
C306 vsrc m1_3348_960# 0.03115f
C307 a_480_5620# vbn_leak 0.01903f
C308 t0 m1_3652_6232# 0
C309 vbn_leak m1_1557_7120# 0.18642f
C310 m1_1545_4540# a_480_5620# 0.06066f
C311 sub_b a_2528_2940# 0
C312 abus a_2510_1740# 0.04722f
C313 mreset stb 0.0015f
C314 a_480_5620# m1_1401_6720# 0.28759f
C315 vm sub 0.04966f
C316 m1_4904_6422# a_2510_1740# 0.36576f
C317 mreset m1_208_7600# 0.00221f
C318 m1_1401_6720# m1_1557_7120# 0.0089f
C319 hold vbp_syn 0.65804f
C320 a_3844_4734# a_2160_3542# 0.14668f
C321 t0 m1_3212_6232# 0
C322 m1_2436_6996# m1_3212_6232# 0.002f
C323 m1_208_6996# sub 0.023f
C324 en mreset 0
C325 a_3844_4734# a_480_5620# 0.00579f
C326 m1_1104_8052# t1 0.00165f
C327 m1_2436_6996# rsel 0.00607f
C328 t0 rsel 0
C329 a_3184_3624# m1_1692_4664# 0.00327f
C330 vbn_prb sta 0
C331 a_480_5620# t2 0.22653f
C332 m1_2260_4540# stb 0
C333 t2 m1_1557_7120# 0
C334 a_2528_2940# vbp_syn 0
C335 sub_b abus 0.05253f
C336 vsrc hold 0.11451f
C337 a_2804_3624# rsel 0.01776f
C338 m1_644_2312# vbn_prb 0.00111f
C339 m1_2260_960# spk 0
C340 vm m1_3652_6232# 0.00843f
C341 m1_2260_960# m1_2424_756# 0.01455f
C342 vbn_prb a_2510_1740# 0.21435f
C343 a_3184_3624# spk 0.22493f
C344 m1_644_2312# sub 0.03896f
C345 rsel vbn_ref 0
C346 t0 a_480_5620# 0.10955f
C347 m1_2436_6996# a_480_5620# 0.01966f
C348 t0 m1_1557_7120# 0.09239f
C349 m1_2436_6996# m1_1557_7120# 0
C350 vsrc a_1632_2940# 0.14308f
C351 a_2510_1740# sub 0.15027f
C352 vdd stb 0.13649f
C353 a_2804_3624# a_2160_3542# 0.02975f
C354 a_2510_1740# m1_4052_1572# 0
C355 vdd m1_208_7600# 0.01002f
C356 vbp_st stb 0
C357 vm m1_3212_6232# 0.02914f
C358 m1_1973_6232# t1 0.07271f
C359 vbp_st m1_208_7600# 0
C360 abus m1_4822_412# 0.01227f
C361 vreset rsel 0
C362 vbp_st m1_4802_1762# 0.00495f
C363 t3 a_480_5620# 0.13045f
C364 hold a_1632_2940# 0.34249f
C365 a_2804_3624# a_480_5620# 0.00624f
C366 vsrc a_2528_2940# 0.15109f
C367 en vdd 0.23193f
C368 vm rsel 0.07803f
C369 m1_208_6996# m1_3212_6232# 0.00246f
C370 en vbp_st 0.03906f
C371 sta m1_3652_6232# 0.0671f
C372 abus m1_3348_960# 0.10889f
C373 abus vbp_syn 0.06436f
C374 el stb 0
C375 el m1_208_7600# 0
C376 m1_4904_6422# vbp_syn -0.07963f
C377 abus m1_2972_1572# 0.01195f
C378 sub_b vbn_prb 0.00243f
C379 vm a_2160_3542# 0.16962f
C380 vbn_leak stb 0.16242f
C381 vbn_leak m1_208_7600# 0.51836f
C382 m1_4802_1762# vbn_leak 0
C383 en el 0.03706f
C384 sta m1_3212_6232# 0.32895f
C385 sub_b sub 0.03832f
C386 hold m1_796_6120# 0.00244f
C387 stb m1_1401_6720# 0
C388 a_2510_1740# m1_3652_6232# 0
C389 m1_1692_4664# m1_2260_4540# 0.08395f
C390 sub_b m1_4052_1572# 0.01339f
C391 aux stb 0
C392 m1_208_7600# m1_1401_6720# 0.00134f
C393 a_2528_2940# a_1632_2940# 0.06219f
C394 vm a_480_5620# 1.16329f
C395 aux m1_208_7600# 0
C396 a_288_2940# a_480_5620# 0.00238f
C397 vm m1_1557_7120# 0.00215f
C398 en vbn_leak 0.04406f
C399 vbn_prb m1_4822_412# 0.11076f
C400 abus vsrc 0.09671f
C401 en aux 0.03632f
C402 m1_208_6996# a_480_5620# 0.06844f
C403 m1_796_6120# a_1632_2940# 0
C404 m1_208_6996# m1_1557_7120# 0.14411f
C405 m1_644_2312# rsel 0.07843f
C406 m1_2260_4540# spk 0.21361f
C407 abus hold 0
C408 m1_3704_1572# en 0.02589f
C409 m1_1692_4664# vdd 0.28596f
C410 rsel a_2510_1740# 0.16878f
C411 vbn_prb vbp_syn 0.03049f
C412 vbn_prb m1_3348_960# 0.04182f
C413 vbp_st m1_1692_4664# 0.46088f
C414 en a_3844_4734# 0
C415 hold m1_4904_6422# 0.69894f
C416 t2 m1_208_7600# 0.0595f
C417 m1_644_2312# a_2160_3542# 0
C418 sub m1_3348_960# 0.00209f
C419 vbp_syn sub 0.05211f
C420 sub_b m1_3652_6232# 0
C421 m1_4052_1572# m1_3348_960# 0
C422 m1_2105_7600# mreset 0
C423 a_2510_1740# a_2160_3542# 0
C424 m1_2972_1572# sub 0
C425 vdd spk 0.87243f
C426 m1_644_2312# a_480_5620# 0.11517f
C427 m1_2436_6996# stb 0.08958f
C428 t0 stb 0.00249f
C429 vdd m1_2424_756# 0.21166f
C430 vbp_st spk 0.12536f
C431 t0 m1_208_7600# 0.07125f
C432 m1_2436_6996# m1_208_7600# -0.00271f
C433 vbp_st m1_2424_756# 0.03031f
C434 a_2510_1740# a_480_5620# 0.00179f
C435 sub_b m1_3212_6232# 0.10497f
C436 m1_1545_4540# m1_1692_4664# 0.0971f
C437 vbn_prb vsrc 0.01206f
C438 t3 m1_208_7600# 0.18955f
C439 sub_b rsel 0.46758f
C440 a_1632_2940# m1_1973_6232# 0
C441 el spk 0.20152f
C442 vsrc sub 0.04387f
C443 el m1_2424_756# 0.03044f
C444 vbn_prb hold 0.14538f
C445 a_3184_3624# m1_2260_4540# 0.02374f
C446 vbp_syn m1_3652_6232# 0.10654f
C447 vbn_leak spk 0.06932f
C448 a_3844_4734# m1_1692_4664# 0
C449 vbn_ref m1_4802_1762# 0.07567f
C450 hold sub 0.34703f
C451 m1_1545_4540# spk 0.00253f
C452 vbn_leak m1_2424_756# 0.04323f
C453 sub_b a_2160_3542# 0
C454 aux spk 0.00113f
C455 vreset m1_4802_1762# 0.00845f
C456 aux m1_2424_756# 0.03215f
C457 en vbn_ref 1.7775f
C458 a_480_5620# t1 0.16686f
C459 sub_b a_480_5620# 0
C460 t1 m1_1557_7120# 0.2089f
C461 vbp_syn m1_3212_6232# 0.1263f
C462 m1_796_6120# m1_1973_6232# 0
C463 m1_2260_960# vdd 0
C464 vm stb 0.04174f
C465 m1_2105_7600# vdd 0
C466 a_1632_2940# sub 0.05048f
C467 vm m1_208_7600# 0
C468 m1_3704_1572# m1_2424_756# 0.02956f
C469 en vreset 1.8638f
C470 a_3184_3624# vdd 0.42073f
C471 a_3844_4734# spk 0.21496f
C472 rsel m1_3348_960# 0.00266f
C473 rsel vbp_syn 0.03843f
C474 vbp_st a_3184_3624# 0.00366f
C475 m1_208_6996# stb 0.03449f
C476 vsrc m1_3652_6232# 0.00154f
C477 vm en 0.10525f
C478 m1_208_6996# m1_208_7600# 0.31602f
C479 a_2528_2940# sub 0
C480 m1_2972_1572# rsel 0.0346f
C481 t0 m1_1692_4664# 0
C482 m1_2260_960# el 0
C483 mreset m1_2260_4540# 0
C484 m1_2105_7600# el 0
C485 vbp_syn a_2160_3542# 0
C486 hold m1_3652_6232# 0.01348f
C487 a_3184_3624# el 0
C488 m1_2260_960# vbn_leak 0
C489 m1_2105_7600# vbn_leak 0.41055f
C490 sta stb 0.00742f
C491 a_2804_3624# m1_1692_4664# 0.00417f
C492 vbp_syn a_480_5620# 0
C493 a_3184_3624# vbn_leak 0.00204f
C494 m1_2105_7600# m1_1401_6720# -0.00348f
C495 m1_2260_960# aux 0
C496 m1_1545_4540# a_3184_3624# 0.02174f
C497 t0 spk 0
C498 m1_2436_6996# spk 0.00145f
C499 vsrc rsel 0.03617f
C500 hold m1_3212_6232# 0
C501 mreset vdd 0.10081f
C502 en sta 0
C503 abus vbn_prb 0.35223f
C504 m1_644_2312# m1_4802_1762# 0
C505 vbp_st mreset 0
C506 m1_3704_1572# m1_2260_960# 0
C507 hold rsel 0.34747f
C508 vbn_prb m1_4904_6422# 0.1006f
C509 a_3844_4734# m1_2260_960# 0.00193f
C510 a_2510_1740# m1_208_7600# 0.0013f
C511 a_2510_1740# m1_4802_1762# 0
C512 abus sub 0.04017f
C513 a_2804_3624# spk 0.00565f
C514 vsrc a_2160_3542# 0.16998f
C515 abus m1_4052_1572# 0.00324f
C516 m1_644_2312# en 0.01835f
C517 a_3844_4734# a_3184_3624# 0.05848f
C518 vm m1_1692_4664# 0.13124f
C519 en a_2510_1740# 0.53513f
C520 el mreset 0.02914f
C521 vbn_ref spk 0
C522 hold a_2160_3542# 0.00479f
C523 vsrc a_480_5620# 0.13021f
C524 a_1632_2940# rsel 0
C525 vbn_ref m1_2424_756# 0.03822f
C526 vdd m1_2260_4540# 0.51842f
C527 mreset vbn_leak 0.14463f
C528 vbp_st m1_2260_4540# 0.26668f
C529 hold a_480_5620# 0.86374f
C530 sub m1_1973_6232# 0.00349f
C531 vreset m1_2424_756# 0.08879f
C532 hold m1_1557_7120# 0
C533 a_2528_2940# rsel 0.02127f
C534 a_1632_2940# a_2160_3542# 0.20541f
C535 mreset aux 0.03441f
C536 vm spk 7.89111f
C537 a_288_2940# spk 0.31512f
C538 t1 stb 0
C539 t0 m1_2105_7600# 0.07342f
C540 m1_2105_7600# m1_2436_6996# 0.00869f
C541 vm m1_2424_756# 0.39126f
C542 t1 m1_208_7600# 0.03518f
C543 sub_b stb 0.1209f
C544 sub_b m1_4802_1762# 0
C545 sub_b m1_208_7600# 0.00319f
C546 a_1632_2940# a_480_5620# 0.41552f
C547 m1_208_6996# spk 0.00884f
C548 a_2528_2940# a_2160_3542# 0.00504f
C549 m1_4904_6422# m1_3652_6232# -0.01073f
C550 a_2804_3624# m1_2260_960# 0
C551 vbp_st vdd 1.71891f
C552 vbn_prb sub 0
C553 sub_b en 0.01373f
C554 m1_1545_4540# m1_2260_4540# 0.01391f
C555 a_2804_3624# a_3184_3624# 0.2629f
C556 a_2528_2940# a_480_5620# 0.40551f
C557 a_2510_1740# m1_1692_4664# 0
C558 m1_4904_6422# m1_3212_6232# -0.01073f
C559 sta spk 0.09062f
C560 el vdd 2.04148f
C561 a_3184_3624# vbn_ref 0
C562 abus rsel 0.00147f
C563 vbp_st el 0.04494f
C564 vreset m1_2260_960# 0.18148f
C565 m1_796_6120# a_480_5620# 0.13805f
C566 m1_796_6120# m1_1557_7120# -0.00167f
C567 en m1_4822_412# 0.08351f
C568 vbp_syn stb 0.00619f
C569 a_3844_4734# m1_2260_4540# 0
C570 vbp_syn m1_208_7600# 0.00151f
C571 m1_644_2312# spk 0.0598f
C572 vbn_leak vdd 0.42469f
C573 t0 mreset 0
C574 vm m1_2260_960# 0.13494f
C575 m1_644_2312# m1_2424_756# 0
C576 m1_1545_4540# vdd 0.31514f
C577 vm m1_2105_7600# 0
C578 vbp_st vbn_leak 0.04086f
C579 vbp_st m1_1545_4540# 0.02577f
C580 a_2510_1740# spk 0.02126f
C581 vdd m1_1401_6720# 0.06422f
C582 m1_1104_8052# m1_1557_7120# -0.0026f
C583 vm a_3184_3624# 0.00142f
C584 aux vdd 0.18345f
C585 a_2510_1740# m1_2424_756# 0.20463f
C586 vbp_st m1_1401_6720# 0
C587 en m1_3348_960# 0.15848f
C588 en vbp_syn 0.08363f
C589 vbp_st aux 0.0417f
C590 m1_2105_7600# m1_208_6996# 0.05245f
C591 m1_3704_1572# vdd 0.03511f
C592 en m1_2972_1572# 0.01609f
C593 el vbn_leak 0.14663f
C594 m1_1692_4664# t1 0
C595 a_3844_4734# vdd 0.59267f
C596 sub_b m1_1692_4664# 0
C597 a_3844_4734# vbp_st 0.00313f
C598 el aux 1.64571f
C599 vsrc stb 0
C600 vbn_ref mreset 0
C601 t0 m1_2260_4540# 0
C602 vsrc m1_208_7600# 0
C603 vsrc m1_4802_1762# 0
C604 vdd t2 0.28683f
C605 vbn_prb rsel 0
C606 vbn_leak m1_1401_6720# 0.21007f
C607 vbp_st t2 0
C608 vreset mreset 0
C609 aux vbn_leak 1.70203f
C610 hold stb 0.01097f
C611 a_3844_4734# el 0.00104f
C612 t1 spk 0
C613 hold m1_208_7600# 0.0057f
C614 en vsrc 0.03704f
C615 a_480_5620# m1_1973_6232# 0.1051f
C616 sub_b spk 0.56334f
C617 m1_1973_6232# m1_1557_7120# 0.06718f
C618 rsel sub 0.41869f
C619 m1_644_2312# m1_2260_960# 0.03124f
C620 a_2804_3624# m1_2260_4540# 0.08448f
C621 vm mreset 0
C622 sub_b m1_2424_756# 0.00906f
C623 rsel m1_4052_1572# 0
C624 m1_3704_1572# vbn_leak 0
C625 m1_644_2312# a_3184_3624# 0
C626 m1_2260_960# a_2510_1740# 0.14485f
C627 a_3844_4734# vbn_leak 0.01126f
C628 m1_2105_7600# a_2510_1740# 0
C629 en hold 0.01354f
C630 t0 vdd 0.10056f
C631 m1_2436_6996# vdd 0.03348f
C632 a_3844_4734# m1_1545_4540# 0.00997f
C633 t0 vbp_st 0
C634 m1_2436_6996# vbp_st 0
C635 m1_208_6996# mreset 0.00115f
C636 a_3184_3624# a_2510_1740# 0.00254f
C637 sub a_2160_3542# 0.01212f
C638 a_3844_4734# aux 0
C639 vbn_leak t2 0.14387f
C640 t3 vdd 0.18084f
C641 a_2804_3624# vdd 0.27486f
C642 t2 m1_1401_6720# 0.10633f
C643 sub a_480_5620# 0.06758f
C644 a_2804_3624# vbp_st 0.00359f
C645 t0 el 0
C646 m1_3652_6232# m1_3212_6232# 0.04772f
C647 vm m1_2260_4540# 0.00579f
C648 sta mreset 0.01507f
C649 vbp_syn spk 0.09009f
C650 vbn_ref vdd 0.31335f
C651 m1_3348_960# m1_2424_756# 0.14487f
C652 vbp_syn m1_2424_756# 0.12655f
C653 en a_2528_2940# 0.00443f
C654 vbp_st vbn_ref 0.04333f
C655 m1_796_6120# m1_208_7600# 0.01948f
C656 t0 vbn_leak 0.19364f
C657 m1_2436_6996# vbn_leak 0.20054f
C658 m1_2105_7600# t1 0
C659 m1_2972_1572# spk 0
C660 sub_b m1_2260_960# 0
C661 a_2804_3624# el 0
C662 vreset vdd 0.37986f
C663 t0 m1_1401_6720# 0
C664 m1_2436_6996# m1_1401_6720# 0
C665 m1_2972_1572# m1_2424_756# 0.00134f
C666 vreset vbp_st 0.03544f
C667 sub_b a_3184_3624# 0.02576f
C668 m1_1104_8052# m1_208_7600# 0.00645f
C669 a_2510_1740# mreset 0.05003f
C670 t3 vbn_leak 0.20601f
C671 vm vdd 2.26238f
C672 a_288_2940# vdd 0.0017f
C673 rsel m1_3212_6232# 0
C674 el vbn_ref 0
C675 hold m1_1692_4664# 0.07608f
C676 a_2804_3624# m1_1545_4540# 0.20376f
C677 vm vbp_st 0.12925f
C678 a_288_2940# vbp_st 0
C679 t3 m1_1401_6720# 0
C680 vreset el 0.03423f
C681 abus m1_4802_1762# 0.30809f
C682 m1_208_6996# vdd 0.04957f
C683 vsrc spk 0.15417f
C684 vbn_ref vbn_leak 0.014f
C685 m1_208_6996# vbp_st 0
C686 vsrc m1_2424_756# 0.03711f
C687 a_1632_2940# m1_1692_4664# 0.09357f
C688 vm el 0.09618f
C689 m1_2436_6996# t2 0
C690 a_288_2940# el 0.07974f
C691 vreset vbn_leak 0.03464f
C692 vbn_ref aux 0
C693 en abus 0.2665f
C694 a_2804_3624# a_3844_4734# 0.18981f
C695 hold spk 0.25952f
C696 rsel a_2160_3542# 0
C697 a_2510_1740# m1_2260_4540# 0.00255f
C698 m1_2260_960# m1_3348_960# 0
C699 m1_2260_960# vbp_syn 0
C700 m1_2105_7600# vbp_syn 0
C701 vreset aux 0.03456f
C702 vm vbn_leak 0.01768f
C703 m1_208_6996# el 0
C704 sta vdd 0.20165f
C705 m1_1973_6232# stb 0
C706 vbp_syn a_3184_3624# 0
C707 vm m1_1545_4540# 0.03028f
C708 t3 t2 0.05739f
C709 sta vbp_st 0.00349f
C710 m1_2260_960# m1_2972_1572# 0.0013f
C711 a_3844_4734# vbn_ref 0.00302f
C712 rsel a_480_5620# 0.00284f
C713 vm m1_1401_6720# 0.02407f
C714 a_1632_2940# spk 0.09119f
C715 vm aux 0.00109f
C716 t0 m1_2436_6996# 0.187f
C717 m1_208_6996# vbn_leak 0.75158f
C718 m1_644_2312# vdd 0.0239f
C719 a_3844_4734# vreset 0
C720 m1_644_2312# vbp_st 0
C721 vm m1_3704_1572# 0
C722 m1_208_6996# m1_1401_6720# 0.07759f
C723 a_2510_1740# vdd 1.63645f
C724 sta el 0
C725 m1_208_6996# aux 0
C726 a_480_5620# a_2160_3542# 0.29014f
C727 vm a_3844_4734# 0.00745f
C728 vbp_st a_2510_1740# 0.27337f
C729 t0 t3 0
C730 a_2528_2940# spk 0.21265f
C731 vbn_prb m1_208_7600# 0
C732 t0 a_2804_3624# 0
C733 a_2528_2940# m1_2424_756# 0
C734 vbn_prb m1_4802_1762# 0.12042f
C735 vsrc m1_2260_960# 0
C736 sta vbn_leak 0
C737 sub stb 0.01482f
C738 m1_644_2312# el 0.24826f
C739 sub_b m1_2260_4540# 0.04999f
C740 vsrc a_3184_3624# 0.03406f
C741 vm t2 0.06186f
C742 a_480_5620# m1_1557_7120# 0
C743 en vbn_prb 0.06545f
C744 m1_2105_7600# hold 0
C745 a_2510_1740# el 0.34103f
C746 sta aux 0
C747 vbp_syn mreset 0.29307f
C748 m1_644_2312# vbn_leak 0.07402f
C749 hold a_3184_3624# 0.16211f
C750 en sub 0.04402f
C751 m1_208_6996# t2 0.05179f
C752 en m1_4052_1572# 0.00567f
C753 a_2510_1740# vbn_leak 0.36726f
C754 m1_644_2312# aux 0
C755 vdd t1 0.11574f
C756 vm m1_2436_6996# 0.13145f
C757 vm t0 0.0619f
C758 sub_b vdd 0.41395f
C759 vbp_st t1 0
C760 a_2510_1740# aux 0.25378f
C761 sub_b vbp_st 0.04519f
C762 a_1632_2940# a_3184_3624# 0
C763 abus m1_2424_756# 0.10221f
C764 m1_1692_4664# m1_1973_6232# 0
C765 m1_644_2312# a_3844_4734# 0.00608f
C766 m1_4904_6422# spk 0
C767 t0 m1_208_6996# 0.07017f
C768 m1_2436_6996# m1_208_6996# 0.20198f
C769 m1_3704_1572# a_2510_1740# 0
C770 vm t3 0.04824f
C771 a_2528_2940# m1_2260_960# 0.06334f
C772 vbp_syn m1_2260_4540# 0.02219f
C773 vm a_2804_3624# 0
C774 aux vss 0.36725f
C775 m1_3348_960# vss 0.80751f
C776 m1_1104_8052# vss -0.00196f
C777 m1_2260_960# vss 0.39253f
C778 en vss 1.1382f
C779 abus vss 2.48947f
C780 sub vss 0.49774f
C781 mreset vss 0.64031f
C782 hold vss 0.97734f
C783 vdd vss 16.99335f
C784 m1_1557_7120# vss 0.13244f
C785 m1_2105_7600# vss 0.12741f
C786 m1_4822_412# vss 0.13826f
C787 m1_796_6120# vss -0.04573f
C788 t3 vss 0.40039f
C789 vbn_prb vss 0.70582f
C790 a_3184_3624# vss 0.18684f
C791 m1_1401_6720# vss 0.03849f
C792 t2 vss 0.30522f
C793 a_2804_3624# vss 0.11006f
C794 m1_1973_6232# vss 0.00346f
C795 t1 vss 0.30178f
C796 m1_208_7600# vss 2.71587f
C797 m1_208_6996# vss 1.22331f
C798 spk vss 0.79507f
C799 m1_2436_6996# vss 0.13276f
C800 t0 vss 0.27403f
C801 m1_2972_1572# vss -0.0561f
C802 rsel vss 0.74365f
C803 m1_2260_4540# vss -0.07483f
C804 vm vss 3.81981f
C805 m1_3704_1572# vss -0.0536f
C806 m1_644_2312# vss 0.42669f
C807 a_288_2940# vss -0.20511f
C808 sub_b vss 1.03926f
C809 m1_1545_4540# vss 0.07282f
C810 vbp_st vss 0.32202f
C811 m1_3212_6232# vss 0.09985f
C812 stb vss 0.91039f
C813 sta vss 0.24375f
C814 m1_2424_756# vss 0.63391f
C815 a_2160_3542# vss 0.32946f
C816 vsrc vss 1.00028f
C817 vreset vss 0.64484f
C818 a_2510_1740# vss 2.37662f
C819 m1_4802_1762# vss -0.01232f
C820 m1_1692_4664# vss -0.08775f
C821 vbn_ref vss 0.70591f
C822 a_2528_2940# vss 0.10776f
C823 a_1632_2940# vss 0.8689f
C824 a_3844_4734# vss 0.72627f
C825 m1_4904_6422# vss -0.2014f
C826 m1_3652_6232# vss -0.06338f
C827 vbp_syn vss 0.34781f
C828 a_480_5620# vss -0.03316f
C829 el vss 0.25207f
C830 vbn_leak vss 4.08559f
C831 m1_4052_1572# vss -0.0427f
.ends
