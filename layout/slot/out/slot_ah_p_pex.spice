* NGSPICE file created from slot_ah_p.ext - technology: gf180mcuD

.subckt p_w2_l4 a_400_n200# a_n400_n244# w_n574_n330# a_n488_n200# VSUBS
X0 a_400_n200# a_n400_n244# a_n488_n200# w_n574_n330# pfet_03v3 ad=0.88p pd=4.88u as=0.88p ps=4.88u w=2u l=4u
C0 a_n488_n200# w_n574_n330# 0.07409f
C1 a_400_n200# a_n400_n244# 0.07019f
C2 w_n574_n330# a_n400_n244# 0.42229f
C3 a_400_n200# w_n574_n330# 0.07409f
C4 a_n488_n200# a_n400_n244# 0.07019f
C5 a_400_n200# a_n488_n200# 0.01073f
C6 a_400_n200# VSUBS 0.18936f
C7 a_n488_n200# VSUBS 0.18936f
C8 w_n574_n330# VSUBS 2.27304f
.ends

.subckt p_w0p22_l1 a_100_n22# a_n100_n66# w_n278_n159# a_n192_n36# VSUBS
X0 a_100_n22# a_n100_n66# a_n192_n36# w_n278_n159# pfet_03v3 ad=0.1516p pd=1.64u as=0.1516p ps=1.64u w=0.22u l=1u
C0 a_n100_n66# w_n278_n159# 0.13163f
C1 a_100_n22# a_n192_n36# 0.00453f
C2 w_n278_n159# a_n192_n36# 0.00771f
C3 a_100_n22# w_n278_n159# 0.00771f
C4 a_n100_n66# a_n192_n36# 0.00509f
C5 a_100_n22# a_n100_n66# 0.00509f
C6 a_100_n22# VSUBS 0.05952f
C7 a_n192_n36# VSUBS 0.05952f
C8 w_n278_n159# VSUBS 0.53042f
.ends

.subckt n_w1_l0p28 a_28_n100# a_n28_n144# a_n116_n100# VSUBS
X0 a_28_n100# a_n28_n144# a_n116_n100# VSUBS nfet_03v3 ad=0.44p pd=2.88u as=0.44p ps=2.88u w=1u l=0.28u
C0 a_28_n100# a_n28_n144# 0.00769f
C1 a_n28_n144# a_n116_n100# 0.00769f
C2 a_28_n100# a_n116_n100# 0.04256f
C3 a_28_n100# VSUBS 0.09911f
C4 a_n116_n100# VSUBS 0.09911f
.ends

.subckt n_w2_l2 a_n288_n200# a_200_n200# a_n200_n244# VSUBS
X0 a_200_n200# a_n200_n244# a_n288_n200# VSUBS nfet_03v3 ad=0.88p pd=4.88u as=0.88p ps=4.88u w=2u l=2u
C0 a_200_n200# a_n200_n244# 0.0587f
C1 a_n200_n244# a_n288_n200# 0.0587f
C2 a_200_n200# a_n288_n200# 0.02133f
C3 a_200_n200# VSUBS 0.2667f
C4 a_n288_n200# VSUBS 0.2667f
.ends

.subckt n_w2_l4 a_400_n200# a_n400_n244# a_n488_n200# VSUBS
X0 a_400_n200# a_n400_n244# a_n488_n200# VSUBS nfet_03v3 ad=0.88p pd=4.88u as=0.88p ps=4.88u w=2u l=4u
C0 a_400_n200# a_n400_n244# 0.07019f
C1 a_n400_n244# a_n488_n200# 0.07019f
C2 a_400_n200# a_n488_n200# 0.01073f
C3 a_400_n200# VSUBS 0.41684f
C4 a_n488_n200# VSUBS 0.41684f
.ends

.subckt n_w4_l1 a_n188_n400# a_100_n400# a_n100_n444# VSUBS
X0 a_100_n400# a_n100_n444# a_n188_n400# VSUBS nfet_03v3 ad=1.76p pd=8.88u as=1.76p ps=8.88u w=4u l=1u
C0 a_100_n400# a_n100_n444# 0.08505f
C1 a_n100_n444# a_n188_n400# 0.08505f
C2 a_100_n400# a_n188_n400# 0.07756f
C3 a_100_n400# VSUBS 0.26859f
C4 a_n188_n400# VSUBS 0.26859f
.ends

.subckt n_w0p5_l0p28 a_n28_n94# a_n116_n50# a_28_n50# VSUBS
X0 a_28_n50# a_n28_n94# a_n116_n50# VSUBS nfet_03v3 ad=0.22p pd=1.88u as=0.22p ps=1.88u w=0.5u l=0.28u
C0 a_28_n50# a_n28_n94# 0.00377f
C1 a_n28_n94# a_n116_n50# 0.00377f
C2 a_28_n50# a_n116_n50# 0.02085f
C3 a_28_n50# VSUBS 0.07987f
C4 a_n116_n50# VSUBS 0.07987f
.ends

.subckt p_w1_l0p5 a_n138_n100# a_50_n100# a_n50_n144# w_n224_n230# VSUBS
X0 a_50_n100# a_n50_n144# a_n138_n100# w_n224_n230# pfet_03v3 ad=0.44p pd=2.88u as=0.44p ps=2.88u w=1u l=0.5u
C0 a_n138_n100# w_n224_n230# 0.0205f
C1 a_50_n100# a_n50_n144# 0.01275f
C2 w_n224_n230# a_n50_n144# 0.07993f
C3 a_50_n100# w_n224_n230# 0.0205f
C4 a_n138_n100# a_n50_n144# 0.01275f
C5 a_50_n100# a_n138_n100# 0.03085f
C6 a_50_n100# VSUBS 0.06546f
C7 a_n138_n100# VSUBS 0.06546f
C8 w_n224_n230# VSUBS 0.61824f
.ends

.subckt n_w0p5_l0p5 a_n138_n50# a_50_n50# a_n50_n94# VSUBS
X0 a_50_n50# a_n50_n94# a_n138_n50# VSUBS nfet_03v3 ad=0.22p pd=1.88u as=0.22p ps=1.88u w=0.5u l=0.5u
C0 a_50_n50# a_n50_n94# 0.00625f
C1 a_n50_n94# a_n138_n50# 0.00625f
C2 a_50_n50# a_n138_n50# 0.01511f
C3 a_50_n50# VSUBS 0.09639f
C4 a_n138_n50# VSUBS 0.09639f
.ends

.subckt p_w1_l0p28 w_n202_n230# a_28_n100# a_n28_n144# a_n116_n100# VSUBS
X0 a_28_n100# a_n28_n144# a_n116_n100# w_n202_n230# pfet_03v3 ad=0.44p pd=2.88u as=0.44p ps=2.88u w=1u l=0.28u
C0 a_n116_n100# w_n202_n230# 0.01808f
C1 a_28_n100# a_n28_n144# 0.00769f
C2 w_n202_n230# a_n28_n144# 0.05841f
C3 a_28_n100# w_n202_n230# 0.01808f
C4 a_n116_n100# a_n28_n144# 0.00769f
C5 a_28_n100# a_n116_n100# 0.04256f
C6 a_28_n100# VSUBS 0.0597f
C7 a_n116_n100# VSUBS 0.0597f
C8 w_n202_n230# VSUBS 0.55752f
.ends

.subckt n_w1_l0p5 a_n138_n100# a_50_n100# a_n50_n144# VSUBS
X0 a_50_n100# a_n50_n144# a_n138_n100# VSUBS nfet_03v3 ad=0.44p pd=2.88u as=0.44p ps=2.88u w=1u l=0.5u
C0 a_50_n100# a_n50_n144# 0.01275f
C1 a_n50_n144# a_n138_n100# 0.01275f
C2 a_50_n100# a_n138_n100# 0.03085f
C3 a_50_n100# VSUBS 0.11563f
C4 a_n138_n100# VSUBS 0.11563f
.ends

.subckt n_w4_l2 a_n288_n400# a_200_n400# a_n200_n444# VSUBS
X0 a_200_n400# a_n200_n444# a_n288_n400# VSUBS nfet_03v3 ad=1.76p pd=8.88u as=1.76p ps=8.88u w=4u l=2u
C0 a_200_n400# a_n200_n444# 0.11799f
C1 a_n200_n444# a_n288_n400# 0.11799f
C2 a_200_n400# a_n288_n400# 0.04287f
C3 a_200_n400# VSUBS 0.34365f
C4 a_n288_n400# VSUBS 0.34365f
.ends

.subckt p_w1_l2 w_n374_n230# a_n288_n100# a_200_n100# a_n200_n144# VSUBS
X0 a_200_n100# a_n200_n144# a_n288_n100# w_n374_n230# pfet_03v3 ad=0.44p pd=2.88u as=0.44p ps=2.88u w=1u l=2u
C0 a_n288_n100# w_n374_n230# 0.03135f
C1 a_200_n100# a_n200_n144# 0.02905f
C2 w_n374_n230# a_n200_n144# 0.22666f
C3 a_200_n100# w_n374_n230# 0.03135f
C4 a_n288_n100# a_n200_n144# 0.02905f
C5 a_200_n100# a_n288_n100# 0.01056f
C6 a_200_n100# VSUBS 0.1047f
C7 a_n288_n100# VSUBS 0.1047f
C8 w_n374_n230# VSUBS 1.03224f
.ends

.subckt n_w7p07_l7p07 a_707_n707# a_n795_n707# a_n707_n751# VSUBS
X0 a_707_n707# a_n707_n751# a_n795_n707# VSUBS nfet_03v3 ad=3.1108p pd=15.02u as=3.1108p ps=15.02u w=7.07u l=7.07u
C0 a_707_n707# a_n707_n751# 0.27012f
C1 a_n707_n751# a_n795_n707# 0.27012f
C2 a_707_n707# a_n795_n707# 0.0212f
C3 a_707_n707# VSUBS 0.84237f
C4 a_n795_n707# VSUBS 0.84237f
.ends

.subckt n_w0p5_l1p5 a_150_n50# a_n238_n50# a_n150_n94# VSUBS
X0 a_150_n50# a_n150_n94# a_n238_n50# VSUBS nfet_03v3 ad=0.22p pd=1.88u as=0.22p ps=1.88u w=0.5u l=1.5u
C0 a_150_n50# a_n150_n94# 0.01269f
C1 a_n150_n94# a_n238_n50# 0.01269f
C2 a_150_n50# a_n238_n50# 0.00671f
C3 a_150_n50# VSUBS 0.17146f
C4 a_n238_n50# VSUBS 0.17146f
.ends

.subckt n_w3p54_l3p54 a_354_n354# a_n354_n398# a_n442_n354# VSUBS
X0 a_354_n354# a_n354_n398# a_n442_n354# VSUBS nfet_03v3 ad=1.5576p pd=7.96u as=1.5576p ps=7.96u w=3.54u l=3.54u
C0 a_354_n354# a_n354_n398# 0.12189f
C1 a_n354_n398# a_n442_n354# 0.12189f
C2 a_354_n354# a_n442_n354# 0.02161f
C3 a_354_n354# VSUBS 0.44156f
C4 a_n442_n354# VSUBS 0.44156f
.ends

.subckt n_w0p22_l2 a_200_n22# a_n200_n66# a_n292_n36# VSUBS
X0 a_200_n22# a_n200_n66# a_n292_n36# VSUBS nfet_03v3 ad=0.1516p pd=1.64u as=0.1516p ps=1.64u w=0.22u l=2u
C0 a_200_n22# a_n292_n36# 0.00245f
C1 a_n292_n36# a_n200_n66# 0.00705f
C2 a_200_n22# a_n200_n66# 0.00705f
C3 a_200_n22# VSUBS 0.20767f
C4 a_n292_n36# VSUBS 0.20767f
.ends

.subckt n_w0p5_l3 a_n388_n50# a_300_n50# a_n300_n94# VSUBS
X0 a_300_n50# a_n300_n94# a_n388_n50# VSUBS nfet_03v3 ad=0.22p pd=1.88u as=0.22p ps=1.88u w=0.5u l=3u
C0 a_300_n50# a_n300_n94# 0.01602f
C1 a_n300_n94# a_n388_n50# 0.01602f
C2 a_300_n50# a_n388_n50# 0.00348f
C3 a_300_n50# VSUBS 0.28406f
C4 a_n388_n50# VSUBS 0.28406f
.ends

.subckt n_w0p5_l4 a_n488_n50# a_400_n50# a_n400_n94# VSUBS
X0 a_400_n50# a_n400_n94# a_n488_n50# VSUBS nfet_03v3 ad=0.22p pd=1.88u as=0.22p ps=1.88u w=0.5u l=4u
C0 a_400_n50# a_n400_n94# 0.01702f
C1 a_n400_n94# a_n488_n50# 0.01702f
C2 a_400_n50# a_n488_n50# 0.0026f
C3 a_400_n50# VSUBS 0.35913f
C4 a_n488_n50# VSUBS 0.35913f
.ends

.subckt slot_ah_p vss vbp_syn vdd el aux vbn_leak vsrc vbp_st vbn_prb vbn_ref en vreset
+ abus spk t3 t2 t1 t0 sta stb hold mreset rsel sub sub_b vm
XXL_XP1 a_480_5620# a_480_5620# vdd vdd vss p_w2_l4
XXD_XK a_3184_3624# spk vdd vdd vss p_w0p22_l1
XXPM_XSW m1_4052_1572# rsel m1_3704_1572# vss n_w1_l0p28
XXL_XP2 a_1632_2940# a_480_5620# vdd vdd vss p_w2_l4
XXPR_XMB vss m1_4822_1769# vbn_prb vss n_w2_l2
XXL_XMT m1_208_2424# aux vss vss n_w2_l4
XXL_XM1 a_288_2940# a_480_5620# el vss n_w4_l1
XXS_XWA m1_4904_6422# vbp_syn vdd m1_3652_6752# vss p_w2_l4
XXR_Xi_XN spk vss a_3844_4734# vss n_w0p5_l0p28
XXL_XM2 a_2080_2940# a_1632_2940# a_1632_2940# vss n_w4_l1
XXS_XWB m1_4904_6422# vbp_syn vdd m1_3160_6220# vss p_w2_l4
XXR_XNR vss vbn_ref a_2510_1690# vss n_w2_l4
XXD_XPI m1_1700_4540# a_2160_3542# vm vdd vss p_w1_l0p5
XXPR_XME m1_2418_960# en m1_4822_1769# vss n_w1_l0p28
XXR_XSW vreset vm a_2510_1690# vss n_w0p5_l0p5
XXR_Xi_XP vdd a_3844_4734# spk vdd vss p_w1_l0p28
XXD_XNI vsrc a_2160_3542# vm vss n_w1_l0p5
XXPR_XMF m1_2418_960# vdd a_2510_1690# vss n_w4_l2
XXS_XQA vdd m1_3652_6752# sta vss vss p_w1_l0p28
XXS_XQB vdd m1_3160_6220# stb vss vss p_w1_l0p28
XXS_XNA sta vm m1_3652_6752# vss n_w0p5_l0p28
XXS_XNB stb vm m1_3160_6220# vss n_w0p5_l0p28
XXD_XS2 vdd vdd m1_2260_4540# vbp_st vss p_w1_l2
XXD_XPS vdd vdd m1_1700_4540# vbp_st vss p_w1_l2
XXD_XS3 vdd vdd m1_1545_4540# vbp_st vss p_w1_l2
XXL_XD2a m1_208_2424# a_2080_2940# a_2080_2940# vss n_w4_l1
XXPM_XSB abus sub_b m1_4052_1572# vss n_w1_l0p28
XXL_XD2b m1_208_2424# a_2080_2940# a_2080_2940# vss n_w4_l1
XXL_XD1a m1_208_2424# a_288_2940# a_288_2940# vss n_w4_l1
XXPM_XSC m1_3704_1572# en m1_3360_972# vss n_w1_l0p28
XXC_XC vss vss vm vss n_w7p07_l7p07
XXS_XPH vdd m1_4904_6422# vdd hold vss p_w1_l2
XXT_XR1 m1_2117_7612# m1_1545_7160# aux vss n_w0p5_l1p5
XXD_XP2 vdd a_2804_3624# a_2160_3542# m1_2260_4540# vss p_w1_l0p28
XXL_XD1b m1_208_2424# a_288_2940# a_288_2940# vss n_w4_l1
XXPR_XSW m1_2972_1572# rsel m1_2180_1416# vss n_w1_l0p28
XXT_XR2 m1_236_6942# m1_2117_7612# aux vss n_w0p5_l1p5
XXT_XP0 vdd m1_2420_7480# t0 vm vss p_w1_l0p28
XXD_Xi4_XN a_3184_3624# vss spk vss n_w0p5_l0p28
XXD_XP3 vdd a_3184_3624# a_2804_3624# m1_1545_4540# vss p_w1_l0p28
XXT_XR3 m1_224_7600# m1_236_6942# aux vss n_w0p5_l1p5
XXT_XP1 vdd m1_1960_6220# t1 vm vss p_w1_l0p28
XXR_XCR_XC vss a_2510_1690# vss vss n_w3p54_l3p54
XXD_XN2 a_2804_3624# a_2160_3542# vsrc vss n_w0p22_l2
XXT_XN0 t0 a_480_5620# m1_2420_7480# vss n_w0p5_l0p28
XXT_XP2 vdd m1_1401_6220# t2 vm vss p_w1_l0p28
XXD_Xi4_XP vdd spk a_3184_3624# vdd vss p_w1_l0p28
XXD_XN3 a_2804_3624# vsrc a_3184_3624# vss n_w0p5_l0p28
XXPM_XMB vss m1_4822_412# vbn_prb vss n_w2_l2
XXT_XN1 t1 a_480_5620# m1_1960_6220# vss n_w0p5_l0p28
XXT_XP3 vdd m1_853_6232# t3 vm vss p_w1_l0p28
XXT_XL0 m1_2420_7480# m1_224_7600# aux vss n_w0p5_l3
XXT_XN2 t2 a_480_5620# m1_1401_6220# vss n_w0p5_l0p28
XXT_XLT m1_224_7600# vdd aux vss n_w0p5_l3
XXT_XL1 m1_1960_6220# m1_236_6942# aux vss n_w0p5_l3
XXT_XN3 t3 a_480_5620# m1_853_6232# vss n_w0p5_l0p28
XXR_XPC vdd a_2510_1690# a_3844_4734# vdd vss p_w1_l0p28
XXPM_XME m1_3360_972# en m1_4822_412# vss n_w1_l0p28
XXT_XL2 m1_1401_6220# m1_2117_7612# aux vss n_w0p5_l3
XXT_XL3 m1_853_6232# m1_1545_7160# aux vss n_w0p5_l3
XXPM_XMF m1_3360_972# vdd vm vss n_w4_l2
XXS_XHL vdd vm hold a_1632_2940# vss p_w1_l0p28
XXS_XMR mreset a_2510_1690# vdd vss n_w0p5_l0p28
XXPR_XSB abus sub m1_2972_1572# vss n_w1_l0p28
XXPR_XSC m1_2418_960# en m1_2180_1416# vss n_w1_l0p28
XXT_XRB m1_1104_8052# m1_1545_7160# aux vss n_w0p5_l4
XXT_XRA vss m1_1104_8052# aux vss n_w0p5_l4
C0 m1_1545_4540# a_1632_2940# 0.08279f
C1 m1_2972_1572# vreset 0.03957f
C2 a_2510_1690# a_480_5620# 0.08484f
C3 a_3184_3624# m1_3160_6220# 0
C4 sub vbn_ref 0
C5 vreset en 1.82334f
C6 m1_1960_6220# hold 0.06796f
C7 vbp_syn m1_208_2424# 0.1108f
C8 vbn_prb vbn_ref 1.6716f
C9 m1_3652_6752# m1_3160_6220# 0.17107f
C10 a_2160_3542# vbp_syn 0
C11 hold a_480_5620# 0.71366f
C12 sub_b aux 0.08828f
C13 m1_3704_1572# en 0.0234f
C14 t3 m1_853_6232# 0.07307f
C15 sta m1_3160_6220# 0.19129f
C16 a_2510_1690# a_2804_3624# 0.14876f
C17 t2 m1_853_6232# 0.01397f
C18 rsel m1_236_6942# 0.01037f
C19 sub_b m1_4052_1572# 0.05151f
C20 t2 t1 0.02693f
C21 sub aux 0.10597f
C22 rsel m1_2972_1572# 0.01007f
C23 vbn_ref vsrc 0.0454f
C24 m1_2180_1416# vreset 0.047f
C25 vbn_prb aux 0.00123f
C26 rsel en 0.19307f
C27 t0 m1_236_6942# 0.05049f
C28 m1_2180_1416# m1_3704_1572# 0
C29 a_3844_4734# abus 0
C30 vbn_ref vbp_syn 0.00562f
C31 m1_1545_7160# m1_853_6232# -0.00348f
C32 vsrc aux 0.08984f
C33 t3 hold 0.02725f
C34 t2 hold 0
C35 t1 m1_1545_7160# 0.14794f
C36 a_3184_3624# m1_1700_4540# 0.00612f
C37 a_3844_4734# m1_1545_4540# 0
C38 m1_2418_960# m1_2972_1572# 0.02661f
C39 vbn_leak vbp_st 0.02541f
C40 rsel m1_2180_1416# 0.00406f
C41 mreset vbn_ref 0
C42 rsel m1_2420_7480# 0.00107f
C43 m1_2418_960# en 0.19266f
C44 t1 m1_1700_4540# 0
C45 m1_1104_8052# m1_236_6942# 0
C46 vbp_syn aux 0.22154f
C47 vm vbp_st 0.48377f
C48 vbn_leak vm 0.10131f
C49 m1_4822_412# vbn_ref 0.07762f
C50 t0 m1_2420_7480# 0.20039f
C51 el abus 0.03219f
C52 a_2510_1690# m1_1700_4540# 0
C53 m1_224_7600# m1_853_6232# 0.01681f
C54 m1_1545_7160# hold 0
C55 mreset aux 0.28045f
C56 t1 m1_224_7600# 0.0961f
C57 m1_2180_1416# m1_2418_960# 0.02085f
C58 vdd vbp_st 1.96962f
C59 m1_1545_4540# el 0
C60 hold m1_1700_4540# 0.00428f
C61 vbn_leak vdd 0.09596f
C62 a_1632_2940# el 0.04699f
C63 m1_4822_412# aux 0.00143f
C64 vm vdd 1.89141f
C65 vm a_2080_2940# 0.07396f
C66 el m1_2117_7612# 0
C67 m1_224_7600# hold 0.18735f
C68 m1_208_2424# en 0
C69 m1_1545_4540# a_480_5620# 0.03738f
C70 sub_b vbp_st 0.05961f
C71 a_1632_2940# a_480_5620# 1.11715f
C72 a_2080_2940# vdd 0.0014f
C73 vbn_leak sub_b 0.03001f
C74 spk a_3184_3624# 0.30683f
C75 sub vbp_st 0.04908f
C76 a_480_5620# m1_2117_7612# 0
C77 vm sub_b 0.10308f
C78 a_2804_3624# m1_1545_4540# 0.14129f
C79 m1_2260_4540# a_3184_3624# 0.03455f
C80 m1_2180_1416# m1_208_2424# 0.01197f
C81 a_2804_3624# a_1632_2940# 0
C82 spk m1_3652_6752# 0
C83 vbn_prb vbp_st 1.61775f
C84 vbn_leak vbn_prb 0
C85 sub vm 0.11441f
C86 spk sta 0.12396f
C87 a_3844_4734# el 0
C88 vbn_ref en 1.68618f
C89 vbn_prb vm 0.27015f
C90 sub_b vdd 0.57538f
C91 spk a_2510_1690# 0.39566f
C92 vsrc vbp_st 1.59838f
C93 t3 a_1632_2940# 0
C94 sub_b a_2080_2940# 0.0036f
C95 t2 a_1632_2940# 0
C96 m1_236_6942# aux 0.68111f
C97 vbn_leak vsrc 1.61833f
C98 m1_2260_4540# a_2510_1690# 0.10939f
C99 sub vdd 0.27802f
C100 m1_2972_1572# aux 0.00431f
C101 sub a_2080_2940# 0.00113f
C102 spk hold 0.0034f
C103 vm vsrc 0.25233f
C104 t2 m1_2117_7612# 0
C105 aux en 0.03996f
C106 m1_4904_6422# el 0
C107 vbn_prb vdd 0.08841f
C108 vbp_syn vbp_st 0.09537f
C109 vreset sta 0
C110 vbn_leak vbp_syn 0.1232f
C111 m1_4052_1572# en 0.00528f
C112 a_2510_1690# vreset 0.19749f
C113 vm vbp_syn 0.26921f
C114 mreset vbp_st 0
C115 vsrc vdd 0.19206f
C116 rsel a_3184_3624# 0.26769f
C117 m1_1960_6220# stb 0
C118 mreset vbn_leak 0.02505f
C119 m1_3360_972# vreset 0.04877f
C120 vsrc a_2080_2940# 0.0772f
C121 a_3844_4734# a_2804_3624# 0.00258f
C122 m1_2180_1416# aux 0
C123 a_2510_1690# m1_3704_1572# 0
C124 m1_1545_4540# m1_1700_4540# 0.09814f
C125 aux m1_2420_7480# 0.17865f
C126 m1_1700_4540# a_1632_2940# 0.17453f
C127 stb a_480_5620# 0
C128 sub sub_b 0.55724f
C129 m1_1545_7160# m1_2117_7612# 0.01219f
C130 hold vreset 0.0018f
C131 mreset vm 0.00223f
C132 m1_4822_412# vbp_st 0.01047f
C133 m1_3360_972# m1_3704_1572# 0.00969f
C134 m1_2180_1416# m1_4052_1572# 0
C135 vbn_leak m1_4822_412# 0.00239f
C136 vbn_prb sub_b 0
C137 vbp_syn vdd 2.7227f
C138 t0 m1_853_6232# 0
C139 a_2080_2940# vbp_syn 0
C140 a_480_5620# el 0.12602f
C141 rsel a_2510_1690# 0.11194f
C142 m1_3652_6752# t0 0
C143 t1 t0 0.02651f
C144 m1_4822_412# vm 0
C145 sub vbn_prb 0
C146 m1_224_7600# a_1632_2940# 0
C147 t0 sta 0
C148 m1_1401_6220# aux 0.13336f
C149 rsel m1_3360_972# 0.00193f
C150 mreset vdd 0.15571f
C151 stb m1_3160_6220# 0.19195f
C152 vsrc sub_b 0.01132f
C153 m1_4904_6422# m1_3160_6220# -0.01073f
C154 rsel hold 0.03241f
C155 a_2804_3624# el 0
C156 m1_224_7600# m1_2117_7612# 0.16273f
C157 sub vsrc 0.02861f
C158 m1_4822_412# vdd 0.01254f
C159 m1_4822_1769# abus 0.13444f
C160 m1_1960_6220# a_480_5620# 0.12613f
C161 m1_3160_6220# el 0.02136f
C162 a_2510_1690# m1_2418_960# 0.30236f
C163 sub_b vbp_syn 0.12576f
C164 vbn_prb vsrc 0.01316f
C165 t1 m1_1104_8052# 0
C166 t0 hold 0.22138f
C167 m1_3360_972# m1_2418_960# 0.07711f
C168 sub vbp_syn 0.04455f
C169 a_2804_3624# a_480_5620# 0.00337f
C170 vbn_prb vbp_syn 0.05779f
C171 m1_236_6942# vbp_st 0
C172 a_3184_3624# m1_208_2424# 0.00245f
C173 a_3184_3624# a_2160_3542# 0
C174 m1_1960_6220# t2 0
C175 spk m1_1545_4540# 0.14069f
C176 stb m1_1700_4540# 0
C177 mreset vbn_prb 0
C178 spk a_1632_2940# 0.17886f
C179 vsrc vbp_syn 0.16956f
C180 t3 a_480_5620# 0.10376f
C181 t2 a_480_5620# 0.14899f
C182 vbp_st en 0.03595f
C183 m1_2260_4540# m1_1545_4540# 0.04043f
C184 vm m1_236_6942# 0.0083f
C185 m1_2260_4540# a_1632_2940# 0.00219f
C186 vbn_leak en 0.03427f
C187 m1_2972_1572# vm 0.0038f
C188 m1_4822_412# vbn_prb 0.05814f
C189 vreset abus 1.79386f
C190 mreset vsrc 0.01061f
C191 vm en 0.26556f
C192 a_2510_1690# m1_208_2424# 0.19507f
C193 m1_224_7600# stb 0
C194 a_2510_1690# a_2160_3542# 0.19553f
C195 m1_224_7600# m1_4904_6422# 0
C196 m1_236_6942# vdd 0.13314f
C197 m1_3704_1572# abus 0.0042f
C198 m1_3360_972# m1_208_2424# 0.0029f
C199 m1_1960_6220# m1_1545_7160# 0
C200 vbp_st m1_2420_7480# 0.0031f
C201 a_3184_3624# vbn_ref 0
C202 m1_4822_412# vsrc 0.00459f
C203 m1_2180_1416# vbn_leak 0
C204 m1_1545_7160# a_480_5620# 0.0046f
C205 m1_224_7600# el 0
C206 mreset vbp_syn 0.27609f
C207 hold a_2160_3542# 0
C208 vdd en 0.2062f
C209 t2 t3 0.02013f
C210 a_2080_2940# en 0.00117f
C211 m1_2180_1416# vm 0.185f
C212 vm m1_2420_7480# 0.05434f
C213 rsel abus 0.00241f
C214 m1_1700_4540# a_480_5620# 0.14434f
C215 vbn_ref sta 0
C216 a_3184_3624# aux 0.00226f
C217 m1_1401_6220# vbp_st 0
C218 a_2510_1690# vbn_ref 0.30364f
C219 m1_853_6232# aux 0.01425f
C220 rsel m1_1545_4540# 0
C221 a_3844_4734# spk 0.29532f
C222 a_288_2940# a_1632_2940# 0
C223 sub_b m1_236_6942# 0.13461f
C224 rsel a_1632_2940# -0
C225 m1_2180_1416# vdd 0
C226 a_2804_3624# m1_1700_4540# 0.01249f
C227 m1_3652_6752# aux 0.00816f
C228 m1_3360_972# vbn_ref 0.03584f
C229 vdd m1_2420_7480# 0.05426f
C230 t1 aux 0.18813f
C231 m1_2180_1416# a_2080_2940# 0.00857f
C232 a_3844_4734# m1_2260_4540# 0.01002f
C233 m1_224_7600# a_480_5620# 0.01286f
C234 m1_1401_6220# vm 0.07044f
C235 sta aux 0
C236 vbn_ref hold 0.05152f
C237 sub m1_236_6942# 0.02809f
C238 t2 m1_1545_7160# 0.00105f
C239 m1_2418_960# abus 0.09716f
C240 sub_b en 0.01298f
C241 sub m1_2972_1572# 0.00159f
C242 t0 a_1632_2940# 0
C243 a_2510_1690# aux 0.13545f
C244 spk stb 0.07052f
C245 spk m1_4904_6422# 0
C246 sub en 0.03234f
C247 m1_3360_972# aux 0.03608f
C248 m1_2260_4540# stb 0
C249 a_2510_1690# m1_4052_1572# 0
C250 m1_1401_6220# vdd 0.05014f
C251 t0 m1_2117_7612# 0.15068f
C252 a_3844_4734# vreset 0
C253 vbn_prb en 0.05868f
C254 hold aux 0.42037f
C255 spk el 0.14541f
C256 m1_2180_1416# sub_b 0
C257 sub_b m1_2420_7480# 0.028f
C258 m1_2260_4540# el 0
C259 t3 m1_224_7600# 0.18495f
C260 t2 m1_224_7600# 0.03362f
C261 m1_2180_1416# sub 0
C262 vsrc en 0.03422f
C263 sub m1_2420_7480# 0.14221f
C264 m1_236_6942# vbp_syn 0
C265 a_3844_4734# rsel 0
C266 m1_2972_1572# vbp_syn 0
C267 m1_1401_6220# sub_b 0
C268 spk a_480_5620# 0.18819f
C269 vreset el 0.03695f
C270 abus m1_208_2424# 0
C271 vbp_syn en 0.06453f
C272 mreset m1_236_6942# 0
C273 m1_2260_4540# a_480_5620# 0.01953f
C274 m1_224_7600# m1_1545_7160# 0.24151f
C275 rsel stb 0.12893f
C276 m1_1545_4540# m1_208_2424# 0
C277 spk a_2804_3624# 0.06362f
C278 mreset en 0
C279 m1_1545_4540# a_2160_3542# 0.09491f
C280 a_1632_2940# m1_208_2424# 0.26017f
C281 a_2160_3542# a_1632_2940# 0.04899f
C282 m1_2260_4540# a_2804_3624# 0.10298f
C283 spk m1_3160_6220# 0.17691f
C284 m1_2180_1416# vbp_syn 0
C285 a_288_2940# el 0.06336f
C286 vbp_syn m1_2420_7480# 0
C287 rsel el 0.0392f
C288 t0 stb 0.00188f
C289 m1_4822_412# en 0.08345f
C290 vbn_ref abus 0.06992f
C291 a_3184_3624# vbp_st 0.00634f
C292 t0 el 0
C293 m1_3652_6752# vbp_st 0
C294 m1_3652_6752# vbn_leak 0.00394f
C295 a_3184_3624# vm 0
C296 sta vbp_st 0.00156f
C297 m1_853_6232# vm 0.04068f
C298 m1_2418_960# el 0.02668f
C299 a_288_2940# a_480_5620# -0.00149f
C300 vbn_leak sta 0
C301 rsel a_480_5620# 0.00413f
C302 abus aux 0.04156f
C303 m1_3652_6752# vm 0.04979f
C304 t1 vm 0.07767f
C305 a_2510_1690# vbp_st 0.14353f
C306 a_2510_1690# vbn_leak 0.12106f
C307 m1_4052_1572# abus 0.00394f
C308 vm sta 0.05095f
C309 m1_1960_6220# t0 0.02292f
C310 m1_3360_972# vbp_st 0.029f
C311 a_3184_3624# vdd 0.36148f
C312 m1_3360_972# vbn_leak 0.02804f
C313 t0 a_480_5620# 0.16941f
C314 a_3844_4734# m1_208_2424# 0.00142f
C315 rsel a_2804_3624# 0.0486f
C316 m1_853_6232# vdd 0.1787f
C317 a_3844_4734# a_2160_3542# 0
C318 a_2510_1690# vm 0.34014f
C319 a_1632_2940# aux 0
C320 hold vbp_st 0.03369f
C321 spk m1_1700_4540# 0.02065f
C322 m1_3652_6752# vdd 0.31219f
C323 vbn_leak hold 0.02595f
C324 t1 vdd 0.11351f
C325 m1_2260_4540# m1_1700_4540# 0.06162f
C326 m1_3360_972# vm 0.287f
C327 rsel m1_3160_6220# 0.00566f
C328 sta vdd 0.13249f
C329 m1_2117_7612# aux 0.28439f
C330 vm hold 0.20344f
C331 a_2804_3624# t0 0
C332 a_2510_1690# vdd 1.93466f
C333 m1_224_7600# spk 0.00693f
C334 a_2510_1690# a_2080_2940# 0.2093f
C335 t0 m1_3160_6220# 0
C336 m1_2972_1572# en 0.0332f
C337 m1_3360_972# vdd 0.2282f
C338 a_3184_3624# sub_b 0.0096f
C339 el m1_208_2424# 0.15601f
C340 a_3844_4734# vbn_ref 0
C341 hold vdd 1.10425f
C342 a_2160_3542# el 0.00211f
C343 m1_3652_6752# sub_b 0.00353f
C344 t1 sub_b 0
C345 sub a_3184_3624# 0.08723f
C346 sub_b sta 0.0025f
C347 m1_236_6942# m1_2420_7480# 0.08756f
C348 m1_2180_1416# m1_2972_1572# 0.00104f
C349 a_2510_1690# sub_b 0.29268f
C350 m1_2180_1416# en 0.03756f
C351 a_3844_4734# aux 0.00186f
C352 m1_4904_6422# vbn_ref 0.11398f
C353 rsel m1_1700_4540# 0.07647f
C354 m1_3360_972# sub_b 0
C355 t3 m1_1104_8052# 0
C356 a_480_5620# m1_208_2424# 0.07626f
C357 a_2510_1690# sub 0.08491f
C358 vbn_prb sta 0
C359 t2 m1_1104_8052# 0.02855f
C360 m1_1545_7160# t0 0.09475f
C361 a_3184_3624# vsrc 0.05859f
C362 a_2160_3542# a_480_5620# 0.1941f
C363 vbn_ref el 0
C364 m1_1401_6220# m1_236_6942# 0.04777f
C365 hold sub_b 0.01581f
C366 m1_3360_972# sub 0
C367 a_2510_1690# vbn_prb 0.21604f
C368 m1_3652_6752# vsrc 0.00123f
C369 t0 m1_1700_4540# 0.00214f
C370 stb aux 0.00154f
C371 sub hold 0.10799f
C372 m1_3360_972# vbn_prb 0.03281f
C373 a_2804_3624# m1_208_2424# 0.01815f
C374 vsrc sta 0
C375 m1_4904_6422# aux 0
C376 a_2804_3624# a_2160_3542# 0.18601f
C377 m1_2260_4540# spk 0.09728f
C378 vreset m1_4822_1769# 0.00947f
C379 vbn_prb hold 0.04424f
C380 a_2510_1690# vsrc 0.23591f
C381 vbp_st abus 0.15901f
C382 el aux 1.84991f
C383 m1_3652_6752# vbp_syn 0.10379f
C384 m1_1104_8052# m1_1545_7160# -0.0026f
C385 vbn_leak abus 0.06822f
C386 m1_224_7600# t0 0.04964f
C387 m1_3360_972# vsrc 0.02757f
C388 vbp_syn sta 0.0153f
C389 m1_4052_1572# el 0.03612f
C390 vsrc hold 0.03089f
C391 vm abus 0.12646f
C392 mreset m1_3652_6752# 0.02075f
C393 m1_1545_4540# vbp_st 0.01412f
C394 m1_1401_6220# m1_2420_7480# 0
C395 a_2510_1690# vbp_syn 0.17059f
C396 a_1632_2940# vbp_st 0.08281f
C397 mreset sta 0.06648f
C398 rsel m1_4822_1769# 0
C399 m1_3360_972# vbp_syn 0.09727f
C400 m1_1960_6220# aux 0.02157f
C401 m1_1545_4540# vm 0.10164f
C402 a_480_5620# aux 0.02606f
C403 vm a_1632_2940# 0.31527f
C404 mreset a_2510_1690# 0.05828f
C405 hold vbp_syn 0.03183f
C406 vbn_leak m1_2117_7612# 0
C407 m1_224_7600# m1_1104_8052# 0.01525f
C408 vdd abus 0.1713f
C409 vm m1_2117_7612# 0
C410 mreset hold 0.02832f
C411 spk a_288_2940# 0.31827f
C412 spk rsel 0.08329f
C413 m1_1545_4540# vdd 0.33208f
C414 a_1632_2940# vdd 0.66248f
C415 m1_1545_4540# a_2080_2940# 0
C416 a_2160_3542# m1_1700_4540# 0.01876f
C417 m1_3360_972# m1_4822_412# 0.05008f
C418 m1_2418_960# m1_4822_1769# 0.01949f
C419 a_1632_2940# a_2080_2940# 0.07855f
C420 m1_2260_4540# rsel 0.05167f
C421 m1_3160_6220# aux 0.00606f
C422 spk t0 0
C423 vdd m1_2117_7612# 0.00155f
C424 t3 aux 0.21138f
C425 sub_b abus 0.03169f
C426 t2 aux 0.32716f
C427 m1_2260_4540# t0 0
C428 a_3844_4734# vbp_st 0.00359f
C429 a_3844_4734# vbn_leak 0
C430 rsel vreset 0.04459f
C431 sub abus 0.01383f
C432 m1_1545_4540# sub_b 0
C433 vbn_prb abus 0.30838f
C434 a_3844_4734# vm 0
C435 rsel m1_3704_1572# 0.04526f
C436 m1_853_6232# m1_236_6942# 0.12947f
C437 sub m1_1545_4540# 0
C438 stb vbp_st 0
C439 sub a_1632_2940# 0.00114f
C440 t1 m1_236_6942# 0.0833f
C441 m1_1545_7160# aux 0.31046f
C442 m1_4904_6422# vbp_st 0.0324f
C443 vbn_leak m1_4904_6422# 0
C444 vsrc abus 0.08939f
C445 m1_2418_960# vreset 0.07305f
C446 a_3844_4734# vdd 0.36912f
C447 el vbp_st 0.02573f
C448 stb vm 0.0741f
C449 sub m1_2117_7612# 0
C450 m1_4904_6422# vm 0.01392f
C451 sta en 0
C452 a_2510_1690# m1_2972_1572# 0.00303f
C453 m1_3704_1572# m1_2418_960# 0.03341f
C454 m1_1545_4540# vsrc 0
C455 vsrc a_1632_2940# 0.09178f
C456 vbp_syn abus 0.03578f
C457 rsel t0 0
C458 vm el 0.24413f
C459 a_2510_1690# en 0.42946f
C460 hold m1_236_6942# 0.17995f
C461 m1_853_6232# m1_2420_7480# 0
C462 stb vdd 0.10546f
C463 m1_224_7600# aux 0.95193f
C464 spk m1_208_2424# 0.08513f
C465 m1_3360_972# en 0.11305f
C466 spk a_2160_3542# 0.06279f
C467 m1_4904_6422# vdd -0.01187f
C468 t1 m1_2420_7480# 0
C469 m1_2260_4540# m1_208_2424# 0
C470 rsel m1_2418_960# 0.01259f
C471 m1_2260_4540# a_2160_3542# 0.1922f
C472 hold en 0.01209f
C473 mreset abus 0
C474 a_480_5620# vbp_st 0.21665f
C475 vbn_ref m1_4822_1769# 0.08321f
C476 a_3844_4734# sub_b 0.16586f
C477 vdd el 1.9517f
C478 a_2080_2940# el 0.21811f
C479 a_2510_1690# m1_2180_1416# 0.17847f
C480 m1_1960_6220# vm 0.04852f
C481 m1_4822_412# abus 0.00589f
C482 vbp_syn m1_2117_7612# 0
C483 m1_1401_6220# m1_853_6232# 0
C484 vm a_480_5620# 0.69417f
C485 a_3844_4734# sub 0.00638f
C486 m1_3360_972# m1_2180_1416# 0
C487 a_2804_3624# vbp_st 0.08537f
C488 m1_1401_6220# t1 0.04143f
C489 vreset m1_208_2424# 0.00213f
C490 a_3844_4734# vbn_prb 0
C491 hold m1_2420_7480# 0.20241f
C492 m1_4822_1769# aux 0
C493 stb sub_b 0.06352f
C494 m1_3160_6220# vbp_st 0
C495 spk vbn_ref 0
C496 mreset m1_2117_7612# 0.00125f
C497 m1_1960_6220# vdd 0.02386f
C498 vbn_leak m1_3160_6220# 0.00283f
C499 a_2804_3624# vm 0.00202f
C500 a_480_5620# vdd 2.50316f
C501 sub stb 0.00236f
C502 a_480_5620# a_2080_2940# 0.34514f
C503 t2 vbp_st 0
C504 sub_b el 0.10099f
C505 a_3844_4734# vsrc 0.00212f
C506 vm m1_3160_6220# 0.08222f
C507 vbn_prb m1_4904_6422# 0.12919f
C508 m1_1401_6220# hold 0
C509 sub el 0.04092f
C510 a_288_2940# m1_208_2424# 0.45696f
C511 spk aux 0.00907f
C512 rsel m1_208_2424# 0.06171f
C513 t3 vm 0.04439f
C514 rsel a_2160_3542# 0
C515 a_2804_3624# vdd 0.32166f
C516 t2 vm 0.06728f
C517 a_2804_3624# a_2080_2940# 0.00385f
C518 m1_2260_4540# aux 0
C519 vbn_prb el 0
C520 vbn_ref vreset 0.04846f
C521 a_3844_4734# vbp_syn 0.24925f
C522 vdd m1_3160_6220# 0.22728f
C523 m1_1960_6220# sub_b 0.00128f
C524 m1_4904_6422# vsrc 0.00188f
C525 t0 a_2160_3542# 0
C526 sub_b a_480_5620# 0
C527 t3 vdd 0.18061f
C528 t2 vdd 0.28255f
C529 vsrc el 0.06064f
C530 stb vbp_syn 0
C531 m1_2418_960# m1_208_2424# 0
C532 m1_1700_4540# vbp_st 0.22524f
C533 sub a_480_5620# 0.02231f
C534 vreset aux 0.03375f
C535 m1_1545_7160# vm 0.00138f
C536 m1_4904_6422# vbp_syn 0.00383f
C537 m1_2972_1572# abus 0.00643f
C538 rsel vbn_ref 0
C539 a_2804_3624# sub_b 0
C540 m1_3704_1572# aux 0
C541 abus en 0.32452f
C542 vm m1_1700_4540# 0.13571f
C543 vbp_syn el 0.12244f
C544 sub_b m1_3160_6220# 0.03175f
C545 m1_236_6942# a_1632_2940# 0.00277f
C546 sub a_2804_3624# 0.00366f
C547 mreset m1_4904_6422# 0
C548 m1_3704_1572# m1_4052_1572# 0
C549 m1_224_7600# vbp_st 0
C550 m1_1545_7160# vdd 0.00349f
C551 m1_224_7600# vbn_leak 0
C552 vsrc a_480_5620# 0.08279f
C553 m1_236_6942# m1_2117_7612# 0.00373f
C554 mreset el 0.02165f
C555 rsel aux 0.06084f
C556 m1_1700_4540# vdd 0.31183f
C557 m1_224_7600# vm 0.00129f
C558 m1_2180_1416# abus 0
C559 m1_2418_960# vbn_ref 0.03821f
C560 rsel m1_4052_1572# 0
C561 m1_4822_412# el 0
C562 a_2804_3624# vsrc 0.09769f
C563 a_480_5620# vbp_syn 0
C564 t0 aux 0.07721f
C565 vsrc m1_3160_6220# 0
C566 t1 m1_853_6232# 0
C567 m1_224_7600# vdd 0.00143f
C568 a_2160_3542# m1_208_2424# 0.00626f
C569 m1_4822_1769# vbp_st 0.00458f
C570 m1_1545_7160# sub_b 0
C571 m1_2418_960# aux 0.02878f
C572 m1_3652_6752# sta 0.01767f
C573 a_2510_1690# a_3184_3624# 0.10499f
C574 m1_2418_960# m1_4052_1572# 0.03342f
C575 m1_2117_7612# m1_2420_7480# 0.0806f
C576 sub_b m1_1700_4540# 0
C577 vm m1_4822_1769# 0.00177f
C578 vbp_syn m1_3160_6220# 0.10137f
C579 m1_1104_8052# aux 0.05314f
C580 a_2510_1690# sta 0
C581 sub m1_1700_4540# 0.0539f
C582 spk vbp_st 0.20053f
C583 m1_853_6232# hold 0.00247f
C584 spk vbn_leak 0
C585 mreset m1_3160_6220# 0.04966f
C586 m1_2260_4540# vbp_st 0.08969f
C587 a_3844_4734# en 0
C588 t1 hold 0.01701f
C589 m1_224_7600# sub_b 0.03719f
C590 m1_1401_6220# m1_2117_7612# -0.00348f
C591 hold sta 0
C592 spk vm 7.9201f
C593 stb m1_236_6942# 0.00267f
C594 a_2510_1690# m1_3360_972# 0.00294f
C595 m1_4904_6422# m1_236_6942# 0
C596 m1_224_7600# sub 0
C597 m1_2260_4540# vm 0.01137f
C598 a_2510_1690# hold 0.23994f
C599 m1_236_6942# el 0
C600 m1_4904_6422# en 0
C601 vreset vbp_st 0.0335f
C602 aux m1_208_2424# 0.13502f
C603 spk vdd 0.93625f
C604 m1_2972_1572# el 0
C605 vbn_leak vreset 0.0334f
C606 spk a_2080_2940# 0.06203f
C607 m1_2260_4540# vdd 0.18495f
C608 el en 0.03422f
C609 m1_1700_4540# vbp_syn 0
C610 m1_2260_4540# a_2080_2940# 0
C611 sub_b m1_4822_1769# 0
C612 vm vreset 0.34593f
C613 m1_224_7600# vsrc 0
C614 stb m1_2420_7480# 0
C615 m1_1960_6220# m1_236_6942# 0.11833f
C616 m1_3704_1572# vm 0.00124f
C617 a_288_2940# vbp_st 0
C618 m1_236_6942# a_480_5620# 0.15111f
C619 rsel vbp_st 0.128f
C620 rsel vbn_leak 0
C621 vbn_prb m1_4822_1769# 0.11722f
C622 m1_224_7600# vbp_syn 0
C623 m1_2180_1416# el 0
C624 vreset vdd 0.36458f
C625 vbn_ref aux 0
C626 vreset a_2080_2940# 0.00594f
C627 spk sub_b 0.46748f
C628 a_288_2940# vm 0.04247f
C629 rsel vm 0.22666f
C630 m1_2260_4540# sub_b 0.13476f
C631 m1_3704_1572# vdd 0.03146f
C632 t0 vbp_st 0
C633 m1_224_7600# mreset 0
C634 spk sub 0.15294f
C635 vsrc m1_4822_1769# 0
C636 m1_236_6942# m1_3160_6220# 0
C637 m1_2260_4540# sub 0.08044f
C638 spk vbn_prb 0
C639 m1_2418_960# vbp_st 0.03833f
C640 t0 vm 0.06768f
C641 a_288_2940# vdd 0.0017f
C642 vbn_leak m1_2418_960# 0.02909f
C643 m1_1960_6220# m1_2420_7480# 0.00505f
C644 rsel vdd 0.35378f
C645 a_288_2940# a_2080_2940# 0.0036f
C646 t3 m1_236_6942# 0.15972f
C647 rsel a_2080_2940# 0.03683f
C648 a_480_5620# m1_2420_7480# 0.01103f
C649 t2 m1_236_6942# 0.11349f
C650 m1_4052_1572# aux 0.02986f
C651 sub_b vreset 0
C652 m1_2418_960# vm 0.18337f
C653 spk vsrc 0.15514f
C654 a_3184_3624# m1_1545_4540# 0.02064f
C655 a_3184_3624# a_1632_2940# 0
C656 t0 vdd 0.11083f
C657 m1_2260_4540# vsrc 0
C658 sub vreset 0
C659 m1_853_6232# a_1632_2940# 0
C660 a_2510_1690# abus 0.02191f
C661 m1_1960_6220# m1_1401_6220# 0
C662 vbn_prb vreset 0.04778f
C663 m1_2418_960# vdd 0.11962f
C664 m1_1401_6220# a_480_5620# 0.17466f
C665 m1_3360_972# abus 0.12825f
C666 spk vbp_syn 0.03582f
C667 m1_2418_960# a_2080_2940# 0
C668 m1_1545_7160# m1_236_6942# 0.08254f
C669 rsel sub_b 0.18764f
C670 m1_2260_4540# vbp_syn 0.03656f
C671 hold abus 0
C672 a_2510_1690# m1_1545_4540# 0.04088f
C673 t1 m1_2117_7612# 0
C674 a_2510_1690# a_1632_2940# 0.00574f
C675 t2 m1_2420_7480# 0
C676 vsrc vreset 0.03343f
C677 spk mreset 0.02865f
C678 rsel sub 0.95078f
C679 vbp_st m1_208_2424# 0
C680 a_2160_3542# vbp_st 0.08423f
C681 m1_1545_4540# hold 0
C682 t0 sub_b 0.00652f
C683 vbn_leak m1_208_2424# 0
C684 rsel vbn_prb 0
C685 hold a_1632_2940# 0.36941f
C686 sub t0 0.00318f
C687 vreset vbp_syn 0.036f
C688 vm m1_208_2424# 0.15059f
C689 m1_2418_960# sub_b 0.01246f
C690 vm a_2160_3542# 0.036f
C691 m1_224_7600# m1_236_6942# 0.27641f
C692 hold m1_2117_7612# 0.13174f
C693 t2 m1_1401_6220# 0.11936f
C694 m1_3704_1572# vbp_syn 0.03855f
C695 rsel vsrc 0.04462f
C696 a_3844_4734# a_3184_3624# 0.0024f
C697 sub m1_2418_960# 0.01064f
C698 mreset vreset 0
C699 a_3844_4734# m1_3652_6752# 0
C700 vdd m1_208_2424# 0.01837f
C701 m1_1700_4540# m1_2420_7480# 0
C702 vbn_prb m1_2418_960# 0.14867f
C703 a_2160_3542# vdd 0.33454f
C704 vbn_ref vbp_st 0.04037f
C705 a_2080_2940# m1_208_2424# 0.49393f
C706 a_2160_3542# a_2080_2940# 0.00884f
C707 vbn_leak vbn_ref 0.01413f
C708 rsel vbp_syn 0.07099f
C709 m1_4822_412# vreset 0.02041f
C710 a_3184_3624# stb 0
C711 m1_1401_6220# m1_1545_7160# 0.07523f
C712 a_3844_4734# a_2510_1690# 0.42001f
C713 vbn_ref vm 0.38496f
C714 m1_2418_960# vsrc 0.02743f
C715 m1_3652_6752# stb 0
C716 t1 stb 0
C717 m1_224_7600# m1_2420_7480# 0.00484f
C718 t0 vbp_syn 0
C719 m1_3652_6752# m1_4904_6422# -0.01073f
C720 vbp_st aux 0.02628f
C721 a_3184_3624# el 0
C722 stb sta 0.01153f
C723 vbn_leak aux 1.58464f
C724 m1_4822_1769# en 0.09726f
C725 m1_4904_6422# sta 0
C726 m1_3652_6752# el 0.03012f
C727 m1_2418_960# vbp_syn 0.03197f
C728 sub_b m1_208_2424# 0.18881f
C729 vbn_ref vdd 0.3162f
C730 vbn_leak m1_4052_1572# 0.00484f
C731 sub_b a_2160_3542# 0
C732 mreset t0 0
C733 vm aux 0.17993f
C734 a_2510_1690# m1_4904_6422# 0.25695f
C735 sta el 0
C736 spk m1_236_6942# 0.02752f
C737 sub m1_208_2424# 0.06346f
C738 m1_1401_6220# m1_224_7600# 0.00218f
C739 sub a_2160_3542# 0
C740 stb hold 0
C741 a_2510_1690# el 0.12826f
C742 m1_4904_6422# hold 0.07151f
C743 vbn_prb m1_208_2424# 0
C744 spk en 0
C745 m1_1960_6220# m1_853_6232# 0
C746 a_3184_3624# a_480_5620# 0
C747 m1_3360_972# el 0.03714f
C748 vdd aux 0.42618f
C749 m1_853_6232# a_480_5620# 0.11453f
C750 m1_1960_6220# t1 0.10195f
C751 a_2080_2940# aux 0.01674f
C752 hold el 0.02741f
C753 t1 a_480_5620# 0.14125f
C754 vdd m1_4052_1572# 0.01699f
C755 vsrc m1_208_2424# 0.21305f
C756 vbn_ref sub_b 0.00154f
C757 vsrc a_2160_3542# 0.26445f
C758 a_2804_3624# a_3184_3624# 0.28769f
C759 vbn_leak vss 0.67268f
C760 m1_3360_972# vss 0.87849f
C761 m1_3652_6752# vss 0.04478f
C762 m1_1104_8052# vss -0.02371f
C763 m1_2180_1416# vss 0.21621f
C764 en vss 0.92805f
C765 abus vss 2.67689f
C766 sub vss 0.33833f
C767 mreset vss 0.47089f
C768 hold vss 0.93172f
C769 vdd vss 17.65263f
C770 m1_1545_7160# vss 0.10557f
C771 m1_2117_7612# vss 0.27084f
C772 m1_4822_412# vss 0.31983f
C773 m1_853_6232# vss 0.04261f
C774 t3 vss 0.25568f
C775 vbn_prb vss 0.79747f
C776 a_3184_3624# vss 0.13223f
C777 m1_1401_6220# vss -0.02549f
C778 t2 vss 0.19887f
C779 a_2804_3624# vss 0.10861f
C780 m1_1960_6220# vss -0.02044f
C781 t1 vss 0.21798f
C782 m1_224_7600# vss 1.70785f
C783 m1_236_6942# vss 0.64919f
C784 spk vss 0.53011f
C785 m1_2420_7480# vss 0.08035f
C786 t0 vss 0.22106f
C787 m1_2972_1572# vss -0.0377f
C788 rsel vss 0.715f
C789 m1_2260_4540# vss 0.00321f
C790 vm vss 4.66896f
C791 m1_3704_1572# vss -0.06813f
C792 m1_208_2424# vss 0.71089f
C793 a_288_2940# vss -0.17607f
C794 sub_b vss 1.2853f
C795 m1_1545_4540# vss -0.00719f
C796 vbp_st vss 0.72752f
C797 m1_3160_6220# vss 0.15545f
C798 stb vss 0.19214f
C799 sta vss 0.27115f
C800 m1_2418_960# vss 0.57957f
C801 a_2160_3542# vss 0.17295f
C802 vsrc vss 1.11169f
C803 vreset vss 0.49272f
C804 a_2510_1690# vss 2.41016f
C805 m1_4822_1769# vss 0.0108f
C806 m1_1700_4540# vss -0.07631f
C807 vbn_ref vss 0.65792f
C808 a_2080_2940# vss 0.3479f
C809 a_1632_2940# vss 0.20862f
C810 a_3844_4734# vss 0.07344f
C811 m1_4904_6422# vss 0.05408f
C812 vbp_syn vss 1.35979f
C813 el vss 0.66895f
C814 aux vss 3.55067f
C815 m1_4052_1572# vss -0.06831f
C816 a_480_5620# vss 0.29671f
.ends
