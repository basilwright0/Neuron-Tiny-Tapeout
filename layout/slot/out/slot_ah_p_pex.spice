* NGSPICE file created from slot_ah_p.ext - technology: gf180mcuD

.subckt p_w2_l4 a_400_n200# a_n400_n244# w_n574_n330# a_n488_n200# VSUBS
X0 a_400_n200# a_n400_n244# a_n488_n200# w_n574_n330# pfet_03v3 ad=0.88p pd=4.88u as=0.88p ps=4.88u w=2u l=4u
C0 w_n574_n330# a_n400_n244# 0.42229f
C1 a_400_n200# w_n574_n330# 0.07409f
C2 a_n488_n200# a_n400_n244# 0.07019f
C3 a_n488_n200# a_400_n200# 0.01073f
C4 a_n488_n200# w_n574_n330# 0.07409f
C5 a_400_n200# a_n400_n244# 0.07019f
C6 a_400_n200# VSUBS 0.18936f
C7 a_n488_n200# VSUBS 0.18936f
C8 w_n574_n330# VSUBS 2.27304f
.ends

.subckt n_w1_l0p28 a_28_n100# a_n28_n144# a_n116_n100# VSUBS
X0 a_28_n100# a_n28_n144# a_n116_n100# VSUBS nfet_03v3 ad=0.44p pd=2.88u as=0.44p ps=2.88u w=1u l=0.28u
C0 a_n28_n144# a_n116_n100# 0.00769f
C1 a_28_n100# a_n116_n100# 0.04256f
C2 a_28_n100# a_n28_n144# 0.00769f
C3 a_28_n100# VSUBS 0.09911f
C4 a_n116_n100# VSUBS 0.09911f
.ends

.subckt n_w2_l2 a_n288_n200# a_200_n200# a_n200_n244# VSUBS
X0 a_200_n200# a_n200_n244# a_n288_n200# VSUBS nfet_03v3 ad=0.88p pd=4.88u as=0.88p ps=4.88u w=2u l=2u
C0 a_n200_n244# a_n288_n200# 0.0587f
C1 a_200_n200# a_n288_n200# 0.02133f
C2 a_200_n200# a_n200_n244# 0.0587f
C3 a_200_n200# VSUBS 0.2667f
C4 a_n288_n200# VSUBS 0.2667f
.ends

.subckt n_w2_l4 a_400_n200# a_n400_n244# a_n488_n200# VSUBS
X0 a_400_n200# a_n400_n244# a_n488_n200# VSUBS nfet_03v3 ad=0.88p pd=4.88u as=0.88p ps=4.88u w=2u l=4u
C0 a_n400_n244# a_n488_n200# 0.07019f
C1 a_400_n200# a_n488_n200# 0.01073f
C2 a_400_n200# a_n400_n244# 0.07019f
C3 a_400_n200# VSUBS 0.41684f
C4 a_n488_n200# VSUBS 0.41684f
.ends

.subckt n_w0p5_l0p28 a_n28_n94# a_n116_n50# a_28_n50# VSUBS
X0 a_28_n50# a_n28_n94# a_n116_n50# VSUBS nfet_03v3 ad=0.22p pd=1.88u as=0.22p ps=1.88u w=0.5u l=0.28u
C0 a_n28_n94# a_n116_n50# 0.00377f
C1 a_28_n50# a_n116_n50# 0.02085f
C2 a_28_n50# a_n28_n94# 0.00377f
C3 a_28_n50# VSUBS 0.07987f
C4 a_n116_n50# VSUBS 0.07987f
.ends

.subckt p_w1_l0p5 a_n138_n100# a_50_n100# a_n50_n144# w_n224_n230# VSUBS
X0 a_50_n100# a_n50_n144# a_n138_n100# w_n224_n230# pfet_03v3 ad=0.44p pd=2.88u as=0.44p ps=2.88u w=1u l=0.5u
C0 w_n224_n230# a_n50_n144# 0.07993f
C1 a_50_n100# w_n224_n230# 0.0205f
C2 a_n138_n100# a_n50_n144# 0.01275f
C3 a_n138_n100# a_50_n100# 0.03085f
C4 a_n138_n100# w_n224_n230# 0.0205f
C5 a_50_n100# a_n50_n144# 0.01275f
C6 a_50_n100# VSUBS 0.06546f
C7 a_n138_n100# VSUBS 0.06546f
C8 w_n224_n230# VSUBS 0.61824f
.ends

.subckt n_w0p5_l0p5 a_n138_n50# a_50_n50# a_n50_n94# VSUBS
X0 a_50_n50# a_n50_n94# a_n138_n50# VSUBS nfet_03v3 ad=0.22p pd=1.88u as=0.22p ps=1.88u w=0.5u l=0.5u
C0 a_n50_n94# a_n138_n50# 0.00625f
C1 a_50_n50# a_n138_n50# 0.01511f
C2 a_50_n50# a_n50_n94# 0.00625f
C3 a_50_n50# VSUBS 0.09639f
C4 a_n138_n50# VSUBS 0.09639f
.ends

.subckt p_w1_l0p28 w_n202_n230# a_28_n100# a_n28_n144# a_n116_n100# VSUBS
X0 a_28_n100# a_n28_n144# a_n116_n100# w_n202_n230# pfet_03v3 ad=0.44p pd=2.88u as=0.44p ps=2.88u w=1u l=0.28u
C0 w_n202_n230# a_n28_n144# 0.05841f
C1 a_28_n100# w_n202_n230# 0.01808f
C2 a_n116_n100# a_n28_n144# 0.00769f
C3 a_n116_n100# a_28_n100# 0.04256f
C4 a_n116_n100# w_n202_n230# 0.01808f
C5 a_28_n100# a_n28_n144# 0.00769f
C6 a_28_n100# VSUBS 0.0597f
C7 a_n116_n100# VSUBS 0.0597f
C8 w_n202_n230# VSUBS 0.55752f
.ends

.subckt n_w1_l0p5 a_n138_n100# a_50_n100# a_n50_n144# VSUBS
X0 a_50_n100# a_n50_n144# a_n138_n100# VSUBS nfet_03v3 ad=0.44p pd=2.88u as=0.44p ps=2.88u w=1u l=0.5u
C0 a_n50_n144# a_n138_n100# 0.01275f
C1 a_50_n100# a_n138_n100# 0.03085f
C2 a_50_n100# a_n50_n144# 0.01275f
C3 a_50_n100# VSUBS 0.11563f
C4 a_n138_n100# VSUBS 0.11563f
.ends

.subckt n_w4_l2 a_n288_n400# a_200_n400# a_n200_n444# VSUBS
X0 a_200_n400# a_n200_n444# a_n288_n400# VSUBS nfet_03v3 ad=1.76p pd=8.88u as=1.76p ps=8.88u w=4u l=2u
C0 a_n200_n444# a_n288_n400# 0.11799f
C1 a_200_n400# a_n288_n400# 0.04287f
C2 a_200_n400# a_n200_n444# 0.11799f
C3 a_200_n400# VSUBS 0.34365f
C4 a_n288_n400# VSUBS 0.34365f
.ends

.subckt p_w1_l2 w_n374_n230# a_n288_n100# a_200_n100# a_n200_n144# VSUBS
X0 a_200_n100# a_n200_n144# a_n288_n100# w_n374_n230# pfet_03v3 ad=0.44p pd=2.88u as=0.44p ps=2.88u w=1u l=2u
C0 w_n374_n230# a_n200_n144# 0.22666f
C1 a_200_n100# w_n374_n230# 0.03135f
C2 a_n288_n100# a_n200_n144# 0.02905f
C3 a_n288_n100# a_200_n100# 0.01056f
C4 a_n288_n100# w_n374_n230# 0.03135f
C5 a_200_n100# a_n200_n144# 0.02905f
C6 a_200_n100# VSUBS 0.1047f
C7 a_n288_n100# VSUBS 0.1047f
C8 w_n374_n230# VSUBS 1.03224f
.ends

.subckt n_w7p07_l7p07 a_707_n707# a_n795_n707# a_n707_n751# VSUBS
X0 a_707_n707# a_n707_n751# a_n795_n707# VSUBS nfet_03v3 ad=3.1108p pd=15.02u as=3.1108p ps=15.02u w=7.07u l=7.07u
C0 a_n707_n751# a_n795_n707# 0.27012f
C1 a_707_n707# a_n795_n707# 0.0212f
C2 a_707_n707# a_n707_n751# 0.27012f
C3 a_707_n707# VSUBS 0.84237f
C4 a_n795_n707# VSUBS 0.84237f
.ends

.subckt n_w0p5_l1p5 a_150_n50# a_n238_n50# a_n150_n94# VSUBS
X0 a_150_n50# a_n150_n94# a_n238_n50# VSUBS nfet_03v3 ad=0.22p pd=1.88u as=0.22p ps=1.88u w=0.5u l=1.5u
C0 a_n150_n94# a_n238_n50# 0.01269f
C1 a_150_n50# a_n238_n50# 0.00671f
C2 a_150_n50# a_n150_n94# 0.01269f
C3 a_150_n50# VSUBS 0.17146f
C4 a_n238_n50# VSUBS 0.17146f
.ends

.subckt n_w3p54_l3p54 a_354_n354# a_n354_n398# a_n442_n354# VSUBS
X0 a_354_n354# a_n354_n398# a_n442_n354# VSUBS nfet_03v3 ad=1.5576p pd=7.96u as=1.5576p ps=7.96u w=3.54u l=3.54u
C0 a_n354_n398# a_n442_n354# 0.12189f
C1 a_354_n354# a_n442_n354# 0.02161f
C2 a_354_n354# a_n354_n398# 0.12189f
C3 a_354_n354# VSUBS 0.44156f
C4 a_n442_n354# VSUBS 0.44156f
.ends

.subckt n_w0p22_l2 a_200_n22# a_n200_n66# a_n292_n36# VSUBS
X0 a_200_n22# a_n200_n66# a_n292_n36# VSUBS nfet_03v3 ad=0.1516p pd=1.64u as=0.1516p ps=1.64u w=0.22u l=2u
C0 a_n292_n36# a_n200_n66# 0.00705f
C1 a_200_n22# a_n200_n66# 0.00705f
C2 a_200_n22# a_n292_n36# 0.00245f
C3 a_200_n22# VSUBS 0.20767f
C4 a_n292_n36# VSUBS 0.20767f
.ends

.subckt n_w0p5_l3 a_n388_n50# a_300_n50# a_n300_n94# VSUBS
X0 a_300_n50# a_n300_n94# a_n388_n50# VSUBS nfet_03v3 ad=0.22p pd=1.88u as=0.22p ps=1.88u w=0.5u l=3u
C0 a_n300_n94# a_n388_n50# 0.01602f
C1 a_300_n50# a_n388_n50# 0.00348f
C2 a_300_n50# a_n300_n94# 0.01602f
C3 a_300_n50# VSUBS 0.28406f
C4 a_n388_n50# VSUBS 0.28406f
.ends

.subckt n_w0p5_l4 a_n488_n50# a_400_n50# a_n400_n94# VSUBS
X0 a_400_n50# a_n400_n94# a_n488_n50# VSUBS nfet_03v3 ad=0.22p pd=1.88u as=0.22p ps=1.88u w=0.5u l=4u
C0 a_n400_n94# a_n488_n50# 0.01702f
C1 a_400_n50# a_n488_n50# 0.0026f
C2 a_400_n50# a_n400_n94# 0.01702f
C3 a_400_n50# VSUBS 0.35913f
C4 a_n488_n50# VSUBS 0.35913f
.ends

.subckt slot_ah_p vss vbp_syn vdd el aux vbn_leak vsrc vbp_st vbn_prb vbn_ref en vreset
+ abus spk t3 t2 t1 t0 sta stb hold mreset rsel sub sub_b vm
XXL_XP1 a_480_5620# a_480_5620# vdd vdd vss p_w2_l4
XXPM_XSW m1_3620_1976# rsel m1_3360_308# vss n_w1_l0p28
XXL_XP2 a_1580_2680# a_480_5620# vdd vdd vss p_w2_l4
XXPR_XMB vss m1_4822_1769# vbn_prb vss n_w2_l2
XXL_XMT m1_218_2312# aux vss vss n_w2_l4
XXL_XM1 a_280_2680# a_480_5620# el vss n_w2_l2
XXS_XWA m1_4822_6422# vbp_syn vdd m1_3652_6232# vss p_w2_l4
XXR_Xi_XN spk vss a_3844_4734# vss n_w0p5_l0p28
XXL_XM2 a_2240_2680# a_1580_2680# a_1580_2680# vss n_w2_l2
XXS_XWB m1_4822_6422# vbp_syn vdd m1_3212_6232# vss p_w2_l4
XXR_XNR vss vbn_ref a_2510_1690# vss n_w2_l4
XXD_XPI m1_1728_4540# a_2160_3542# vm vdd vss p_w1_l0p5
XXPR_XME m1_2640_980# en m1_4822_1769# vss n_w1_l0p28
XXR_XSW vreset vm a_2510_1690# vss n_w0p5_l0p5
XXR_Xi_XP vdd a_3844_4734# spk vdd vss p_w1_l0p28
XXD_XNI vsrc a_2160_3542# vm vss n_w1_l0p5
XXPR_XMF m1_2640_980# vdd a_2510_1690# vss n_w4_l2
XXS_XQA vdd m1_3652_6232# sta vss vss p_w1_l0p28
XXS_XQB vdd m1_3212_6232# stb vss vss p_w1_l0p28
XXL_XD1 m1_218_2312# a_280_2680# a_280_2680# vss n_w2_l2
XXS_XNA sta vm m1_3652_6232# vss n_w0p5_l0p28
XXL_XD2 m1_218_2312# a_2240_2680# a_2240_2680# vss n_w2_l2
XXS_XNB stb vm m1_3212_6232# vss n_w0p5_l0p28
XXD_XS2 vdd vdd m1_2240_4540# vbp_st vss p_w1_l2
XXD_XPS vdd vdd m1_1728_4540# vbp_st vss p_w1_l2
XXPM_XSB m1_3620_1976# sub_b abus vss n_w1_l0p28
XXC_XC vss vss vm vss n_w7p07_l7p07
XXS_XPH vdd m1_4822_6422# vdd hold vss p_w1_l2
XXT_XR1 m1_2117_7612# m1_1545_7160# aux vss n_w0p5_l1p5
XXD_XP2 vdd a_2804_3624# a_2160_3542# m1_2240_4540# vss p_w1_l0p28
XXPR_XSW m1_2960_1560# rsel m1_2640_980# vss n_w1_l0p28
XXT_XR2 m1_201_7160# m1_2117_7612# aux vss n_w0p5_l1p5
XXT_XP0 vdd m1_2521_6720# t0 vm vss p_w1_l0p28
XXD_Xi4_XN a_3184_3624# vss spk vss n_w0p5_l0p28
XXD_XP3 vdd a_3184_3624# a_2804_3624# vdd vss p_w1_l0p28
XXT_XR3 m1_230_7612# m1_201_7160# aux vss n_w0p5_l1p5
XXT_XP1 vdd m1_1960_6220# t1 vm vss p_w1_l0p28
XXR_XCR_XC vss a_2510_1690# vss vss n_w3p54_l3p54
XXD_XN2 a_2804_3624# a_2160_3542# vsrc vss n_w0p22_l2
XXT_XN0 t0 a_480_5620# m1_2521_6720# vss n_w0p5_l0p28
XXT_XP2 vdd m1_1400_6220# t2 vm vss p_w1_l0p28
XXD_Xi4_XP vdd spk a_3184_3624# vdd vss p_w1_l0p28
XXD_XN3 a_2804_3624# vsrc a_3184_3624# vss n_w0p5_l0p28
XXPM_XMB vss m1_4822_412# vbn_prb vss n_w2_l2
XXT_XN1 t1 a_480_5620# m1_1960_6220# vss n_w0p5_l0p28
XXT_XP3 vdd m1_853_6232# t3 vm vss p_w1_l0p28
XXT_XL0 m1_2521_6720# m1_230_7612# aux vss n_w0p5_l3
XXT_XN2 t2 a_480_5620# m1_1400_6220# vss n_w0p5_l0p28
XXT_XLT m1_230_7612# vdd aux vss n_w0p5_l3
XXT_XL1 m1_1960_6220# m1_201_7160# aux vss n_w0p5_l3
XXT_XN3 t3 a_480_5620# m1_853_6232# vss n_w0p5_l0p28
XXR_XPC vdd a_2510_1690# a_3844_4734# vdd vss p_w1_l0p28
XXPM_XME m1_3360_308# en m1_4822_412# vss n_w1_l0p28
XXT_XL2 m1_1400_6220# m1_2117_7612# aux vss n_w0p5_l3
XXT_XL3 m1_853_6232# m1_1545_7160# aux vss n_w0p5_l3
XXPM_XMF m1_3360_308# vdd vm vss n_w4_l2
XXS_XHL vdd vm hold a_1580_2680# vss p_w1_l0p28
XXS_XMR mreset a_2510_1690# vdd vss n_w0p5_l0p28
XXPR_XSB m1_2960_1560# sub abus vss n_w1_l0p28
XXT_XRB m1_1104_8052# m1_1545_7160# aux vss n_w0p5_l4
XXT_XRA vss m1_1104_8052# aux vss n_w0p5_l4
C0 rsel vbn_prb 0
C1 m1_853_6232# a_480_5620# 0.03858f
C2 rsel m1_230_7612# 0
C3 m1_4822_412# vbp_st 0.01194f
C4 t1 stb 0
C5 sub_b abus 0.01396f
C6 a_1580_2680# m1_2240_4540# 0.14562f
C7 hold vbn_leak 0.02876f
C8 m1_1960_6220# stb 0
C9 m1_3652_6232# m1_3212_6232# 0.02124f
C10 stb m1_3212_6232# 0.20604f
C11 aux m1_2117_7612# 0.17249f
C12 hold m1_2240_4540# 0.28632f
C13 a_2510_1690# vm 0.25822f
C14 aux a_480_5620# 0.01406f
C15 aux mreset 0.15485f
C16 m1_218_2312# a_2804_3624# 0
C17 a_2510_1690# spk 0.13846f
C18 rsel m1_2240_4540# 0.03975f
C19 aux m1_853_6232# 0.00465f
C20 m1_1400_6220# m1_201_7160# 0
C21 a_2240_2680# m1_3620_1976# 0.00464f
C22 vbn_prb m1_4822_6422# 0.15348f
C23 m1_3652_6232# vm 0.01575f
C24 vbp_st vbp_syn 0.20022f
C25 aux m1_4822_1769# 0.00181f
C26 a_2160_3542# m1_2240_4540# 0.12523f
C27 vm stb 0.04193f
C28 sub_b a_2510_1690# 0.11658f
C29 m1_3652_6232# spk 0.00384f
C30 vsrc a_2240_2680# 0.01126f
C31 spk stb 0.1827f
C32 vbn_prb m1_2640_980# 0.11524f
C33 vbn_leak m1_1728_4540# 0
C34 a_1580_2680# vbp_syn 0
C35 vbp_st m1_3620_1976# 0.00423f
C36 m1_218_2312# vdd 0.00167f
C37 vbn_prb el 0
C38 m1_230_7612# el 0
C39 m1_4822_6422# vbn_leak 0.00651f
C40 m1_1728_4540# m1_2240_4540# 0.03258f
C41 t1 vdd 0.10525f
C42 a_1580_2680# a_280_2680# 0
C43 m1_1545_7160# m1_1104_8052# -0.0026f
C44 hold vbp_syn 0.11153f
C45 a_1580_2680# m1_3620_1976# 0
C46 vsrc vbp_st 1.78319f
C47 vm a_2804_3624# 0.00131f
C48 abus mreset 0
C49 m1_1960_6220# vdd 0.04212f
C50 vbn_leak m1_2640_980# 0.05009f
C51 sta t0 0
C52 m1_3652_6232# sub_b 0.00309f
C53 vdd m1_3212_6232# 0.21007f
C54 spk a_2804_3624# 0.01393f
C55 sub_b stb 0.05708f
C56 el vbn_leak 0.00148f
C57 vbn_ref vm 0
C58 vbn_prb vreset 0.04148f
C59 rsel vbp_syn 0.02423f
C60 vbn_ref spk 0.00118f
C61 vsrc a_1580_2680# 0.16575f
C62 m1_201_7160# stb 0.00809f
C63 el m1_2240_4540# 0
C64 m1_1400_6220# m1_2117_7612# -0.00319f
C65 m1_1400_6220# a_480_5620# 0.21177f
C66 m1_4822_412# m1_2640_980# 0
C67 t1 m1_2521_6720# 0
C68 t1 m1_1545_7160# 0.11703f
C69 rsel m1_3620_1976# 0.12152f
C70 m1_4822_412# el 0.00127f
C71 t0 t2 0
C72 vsrc hold 0.09385f
C73 vbn_prb sub 0
C74 abus m1_4822_1769# 0.011f
C75 vbp_syn a_2160_3542# 0
C76 sub_b a_2804_3624# 0
C77 vreset vbn_leak 0.02775f
C78 m1_230_7612# sub 0.00443f
C79 aux abus 0.03605f
C80 m1_1400_6220# m1_853_6232# 0.00115f
C81 m1_1960_6220# m1_2521_6720# 0
C82 m1_1960_6220# m1_1545_7160# 0.00456f
C83 vreset m1_2240_4540# 0
C84 rsel vsrc 0.05734f
C85 vbn_ref sub_b 0.00409f
C86 vm vdd 2.3694f
C87 spk vdd 0.58558f
C88 a_2510_1690# a_480_5620# 0.02283f
C89 vbp_syn m1_1728_4540# 0.0039f
C90 a_2510_1690# mreset 0.06093f
C91 m1_4822_412# vreset 0.00941f
C92 a_3184_3624# m1_2240_4540# 0.01057f
C93 m1_1400_6220# aux 0.07057f
C94 m1_4822_6422# vbp_syn 0.16563f
C95 sub m1_2240_4540# 0.05232f
C96 vsrc a_2160_3542# 0.21656f
C97 m1_2960_1560# rsel 0.05365f
C98 vbp_syn m1_2640_980# 0.07767f
C99 vm m1_2521_6720# 0.05456f
C100 sub_b vdd 0.50644f
C101 vm m1_1545_7160# 0
C102 el vbp_syn 0.14079f
C103 en vm 0
C104 m1_3652_6232# mreset 0.02282f
C105 vsrc m1_1728_4540# 0.17442f
C106 stb mreset 0
C107 m1_3360_308# vbp_st 0.02322f
C108 stb a_480_5620# 0
C109 aux a_2510_1690# 0.13278f
C110 el a_280_2680# 0.05819f
C111 m1_201_7160# vdd 0.0057f
C112 m1_2640_980# m1_3620_1976# 0.01186f
C113 en spk 0
C114 vsrc m1_4822_6422# 0.0165f
C115 el m1_3620_1976# 0.15959f
C116 t0 vbp_st 0
C117 vbp_st a_3844_4734# 0.0019f
C118 vreset vbp_syn 0.02804f
C119 vsrc m1_2640_980# 0.03962f
C120 vsrc el 0.03768f
C121 t0 a_1580_2680# 0
C122 sub_b m1_2521_6720# 0.00865f
C123 a_3184_3624# vbp_syn 0
C124 aux m1_3652_6232# 0.00563f
C125 sub_b en 0
C126 t3 t2 0.02665f
C127 aux stb 0.00874f
C128 vreset m1_3620_1976# 0.04597f
C129 m1_201_7160# m1_2521_6720# 0.12199f
C130 m1_201_7160# m1_1545_7160# 0.01734f
C131 vbn_ref mreset 0
C132 sta vbp_st 0.00718f
C133 t0 hold 0.00446f
C134 sub vbp_syn 0.02072f
C135 rsel m1_3360_308# 0.03771f
C136 hold a_3844_4734# 0
C137 m1_2960_1560# m1_2640_980# 0.0301f
C138 vsrc vreset 0.03083f
C139 rsel t0 0
C140 m1_2960_1560# el 0
C141 sub m1_3620_1976# 0.10111f
C142 vsrc a_3184_3624# 0.04241f
C143 abus a_2510_1690# 0.09381f
C144 sta hold 0
C145 m1_2117_7612# vdd 0
C146 vbn_ref m1_4822_1769# 0.08364f
C147 vbn_prb m1_218_2312# 0
C148 aux vbn_ref 0
C149 vsrc sub 0.11959f
C150 mreset vdd 0.17559f
C151 a_480_5620# vdd 2.32292f
C152 m1_230_7612# t1 0.11648f
C153 a_3844_4734# a_2160_3542# 0
C154 a_1580_2680# t2 0
C155 m1_2960_1560# vreset 0.00744f
C156 m1_853_6232# vdd 0.18994f
C157 m1_230_7612# m1_1960_6220# 0.11192f
C158 m1_230_7612# m1_3212_6232# 0.0044f
C159 hold t2 0
C160 a_3844_4734# m1_1728_4540# 0.00712f
C161 m1_2117_7612# m1_2521_6720# 0.03436f
C162 m1_2960_1560# sub 0.03655f
C163 m1_1545_7160# m1_2117_7612# 0.05367f
C164 m1_3360_308# m1_2640_980# 0.07414f
C165 a_480_5620# m1_2521_6720# 0.04673f
C166 aux vdd 0.51318f
C167 m1_1545_7160# a_480_5620# 0.005f
C168 el m1_3360_308# 0.04269f
C169 en mreset 0
C170 m1_853_6232# m1_2521_6720# 0
C171 m1_853_6232# m1_1545_7160# -0.00348f
C172 a_2240_2680# a_1580_2680# 0.26733f
C173 t0 el 0
C174 el a_3844_4734# 0
C175 t3 hold 0.02418f
C176 vbn_prb vm 0
C177 m1_230_7612# vm 0.0064f
C178 sta m1_4822_6422# 0
C179 vbn_ref abus 0.02917f
C180 m1_3360_308# vreset 0.00925f
C181 vbn_prb spk 0
C182 m1_230_7612# spk 0.01937f
C183 aux m1_2521_6720# 0.02945f
C184 aux m1_1545_7160# 0.4711f
C185 en m1_4822_1769# 0.0872f
C186 aux en 0
C187 a_1580_2680# vbp_st 0.00503f
C188 sta el 0
C189 rsel a_2240_2680# 0.03163f
C190 vreset a_3844_4734# 0
C191 vm vbn_leak 0
C192 m1_3360_308# sub 0.00347f
C193 vbn_leak spk 0
C194 vm m1_2240_4540# 0.01247f
C195 vbp_st hold 0.2718f
C196 m1_218_2312# vbp_syn 0.09217f
C197 vbn_prb sub_b 0.00108f
C198 a_3184_3624# a_3844_4734# 0
C199 m1_230_7612# sub_b 0.03929f
C200 spk m1_2240_4540# 0.05249f
C201 t0 sub 0.03494f
C202 abus vdd 0.23054f
C203 m1_4822_412# vm 0
C204 m1_218_2312# a_280_2680# 0.0732f
C205 a_2240_2680# a_2160_3542# 0.00291f
C206 sta vreset 0
C207 m1_201_7160# m1_230_7612# 0.50203f
C208 rsel vbp_st 0.07496f
C209 a_1580_2680# hold 0.45972f
C210 a_2510_1690# a_2804_3624# 0.12508f
C211 m1_3652_6232# stb 0
C212 m1_218_2312# m1_3620_1976# 0.08532f
C213 vbp_syn m1_3212_6232# 0.10492f
C214 sub_b vbn_leak 0.00188f
C215 vbn_ref a_2510_1690# 0.17248f
C216 rsel a_1580_2680# 0.00135f
C217 m1_1400_6220# vdd 0.04552f
C218 a_2240_2680# m1_1728_4540# 0
C219 sub_b m1_2240_4540# 0.04389f
C220 vsrc m1_218_2312# 0.01124f
C221 rsel hold 0.23716f
C222 abus en 0.03536f
C223 a_1580_2680# a_2160_3542# 0.26798f
C224 a_2240_2680# m1_2640_980# 0
C225 vbp_st m1_1728_4540# 0.03538f
C226 a_2240_2680# el 0.02725f
C227 a_2510_1690# vdd 1.95093f
C228 vm vbp_syn 0.12983f
C229 m1_1400_6220# m1_2521_6720# 0
C230 sub t2 0
C231 m1_4822_6422# vbp_st 0.06499f
C232 m1_2960_1560# m1_218_2312# 0
C233 hold a_2160_3542# 0.0299f
C234 m1_1400_6220# m1_1545_7160# 0.12394f
C235 spk vbp_syn 0.03887f
C236 vm a_280_2680# 0.02837f
C237 a_1580_2680# m1_1728_4540# 0.06934f
C238 spk a_280_2680# 0.14287f
C239 vbp_st m1_2640_980# 0.03176f
C240 vm m1_3620_1976# 0.00175f
C241 rsel a_2160_3542# 0
C242 m1_230_7612# m1_2117_7612# 0.00585f
C243 a_2240_2680# vreset 0.0144f
C244 el vbp_st 0.03856f
C245 m1_230_7612# a_480_5620# 0.08071f
C246 m1_230_7612# mreset 0.0013f
C247 vbn_prb mreset 0
C248 spk m1_3620_1976# 0.00781f
C249 hold m1_1728_4540# 0.05346f
C250 m1_3652_6232# vdd 0.18738f
C251 stb vdd 0.11489f
C252 m1_4822_6422# hold 0.37371f
C253 vsrc vm 0.10688f
C254 sub_b vbp_syn 0.09812f
C255 m1_230_7612# m1_853_6232# 0.09056f
C256 el a_1580_2680# 0.03159f
C257 rsel m1_1728_4540# 0.17042f
C258 vsrc spk 0.20543f
C259 en a_2510_1690# 0.16857f
C260 a_2240_2680# sub 0
C261 m1_201_7160# vbp_syn 0
C262 vbn_leak mreset 0.02419f
C263 vreset vbp_st 0.02854f
C264 sub_b m1_3620_1976# 0.50594f
C265 el hold 0.02263f
C266 a_480_5620# m1_2240_4540# 0.0472f
C267 vbn_prb m1_4822_1769# 0.12869f
C268 aux m1_230_7612# 0.91693f
C269 vbn_prb aux 0.00328f
C270 rsel m1_2640_980# 0.00391f
C271 a_2160_3542# m1_1728_4540# 0.0863f
C272 a_3184_3624# vbp_st 0.00363f
C273 a_2804_3624# vdd 0.46363f
C274 m1_2960_1560# vm 0.09723f
C275 rsel el 0
C276 stb m1_2521_6720# 0.00179f
C277 vsrc sub_b 0.03333f
C278 m1_2960_1560# spk 0
C279 sub vbp_st 0.04668f
C280 vbn_ref vdd 0.31646f
C281 a_1580_2680# a_3184_3624# 0
C282 vbn_leak m1_4822_1769# 0.00241f
C283 m1_218_2312# a_3844_4734# 0.00162f
C284 t0 t1 0.01868f
C285 vreset hold 0.00784f
C286 aux vbn_leak 1.57471f
C287 a_1580_2680# sub 0.00338f
C288 el a_2160_3542# 0
C289 aux m1_2240_4540# 0
C290 t0 m1_1960_6220# 0.05658f
C291 a_3184_3624# hold 0
C292 rsel vreset 0.06949f
C293 t0 m1_3212_6232# 0
C294 sub hold 0.2117f
C295 m1_1104_8052# t2 0.02879f
C296 m1_4822_412# aux 0.00149f
C297 rsel a_3184_3624# 0.14686f
C298 el m1_1728_4540# 0
C299 vbn_ref en 1.6485f
C300 vreset a_2160_3542# 0
C301 rsel sub 0.54399f
C302 el m1_4822_6422# 0.00143f
C303 vbp_syn a_480_5620# 0
C304 mreset vbp_syn 0.23624f
C305 sta m1_3212_6232# 0.31685f
C306 m1_3360_308# vm 0.1919f
C307 vbn_prb abus 0.03858f
C308 a_280_2680# a_480_5620# 0.00389f
C309 a_3184_3624# a_2160_3542# 0.00549f
C310 el m1_2640_980# 0.28956f
C311 t0 vm 0.06116f
C312 t3 m1_1104_8052# 0
C313 t1 t2 0.04763f
C314 vm a_3844_4734# 0
C315 sub a_2160_3542# 0
C316 t0 spk 0
C317 m1_2521_6720# vdd 0.04245f
C318 m1_1400_6220# m1_230_7612# 0.06175f
C319 abus vbn_leak 0.02965f
C320 a_3844_4734# spk 0.22523f
C321 m1_1545_7160# vdd 0
C322 m1_1960_6220# t2 0
C323 a_3184_3624# m1_1728_4540# 0.15326f
C324 en vdd 0.14235f
C325 vsrc a_480_5620# 0.05638f
C326 vsrc mreset 0.01081f
C327 aux vbp_syn 0.26325f
C328 m1_3360_308# sub_b 0
C329 vreset m1_2640_980# 0.03286f
C330 sub m1_1728_4540# 0.04807f
C331 sta vm 0.08266f
C332 el vreset 0.03567f
C333 m1_4822_412# abus 0.00732f
C334 sta spk 0.06781f
C335 m1_4822_1769# m1_3620_1976# 0.01584f
C336 t0 sub_b 0.00188f
C337 aux m1_3620_1976# 0.19932f
C338 a_2240_2680# m1_218_2312# 0.2626f
C339 sub_b a_3844_4734# 0.0792f
C340 vbn_prb a_2510_1690# 0.12378f
C341 t0 m1_201_7160# 0.10154f
C342 sub m1_2640_980# 0.00108f
C343 m1_1545_7160# m1_2521_6720# 0
C344 el sub 0
C345 vsrc m1_4822_1769# 0.00456f
C346 vsrc aux 0.04206f
C347 vm t2 0.03629f
C348 sta sub_b 0
C349 a_2510_1690# vbn_leak 0.15358f
C350 vreset a_3184_3624# 0
C351 a_2510_1690# m1_2240_4540# 0.02307f
C352 vbn_prb m1_3652_6232# 0
C353 m1_230_7612# stb 0.02199f
C354 sub vreset 0.01775f
C355 a_1580_2680# m1_218_2312# 0.15408f
C356 m1_2960_1560# aux 0.00407f
C357 vbp_st m1_3212_6232# 0.00283f
C358 a_1580_2680# t1 0
C359 abus vbp_syn 0.13313f
C360 sub a_3184_3624# 0.19954f
C361 t3 vm 0.05523f
C362 m1_3652_6232# vbn_leak 0.00277f
C363 vbn_leak stb 0
C364 a_2240_2680# vm 0.12055f
C365 abus m1_3620_1976# 0.08292f
C366 m1_201_7160# t2 0.03345f
C367 a_2240_2680# spk 0.06522f
C368 rsel m1_218_2312# 0.03219f
C369 stb m1_2240_4540# 0
C370 vbn_prb vbn_ref 1.67186f
C371 hold m1_3212_6232# 0
C372 t0 m1_2117_7612# 0.06229f
C373 vsrc abus 0.02889f
C374 t0 a_480_5620# 0.2129f
C375 t0 mreset 0
C376 vbp_st vm 0.10918f
C377 rsel m1_3212_6232# 0.00326f
C378 m1_218_2312# a_2160_3542# 0.01019f
C379 t0 m1_853_6232# 0
C380 vbp_st spk 0.1518f
C381 a_2240_2680# sub_b 0
C382 t3 m1_201_7160# 0.07954f
C383 a_2804_3624# m1_2240_4540# 0.02776f
C384 vbn_ref vbn_leak 0.01359f
C385 a_2510_1690# vbp_syn 0.21108f
C386 a_1580_2680# vm 0.46957f
C387 aux m1_3360_308# 0.02589f
C388 sta a_480_5620# 0
C389 sta mreset 0.01631f
C390 a_1580_2680# spk 0.11186f
C391 vbn_ref m1_2240_4540# 0
C392 m1_2960_1560# abus 0.12604f
C393 vbn_prb vdd 0.09485f
C394 m1_218_2312# m1_1728_4540# 0
C395 m1_230_7612# vdd 0.0757f
C396 t0 aux 0.21214f
C397 a_2510_1690# m1_3620_1976# 0.03353f
C398 hold vm 0.68396f
C399 aux a_3844_4734# 0.00117f
C400 m1_4822_412# vbn_ref 0.07811f
C401 sub_b vbp_st 0.06679f
C402 hold spk 0.03515f
C403 rsel vm 0.07774f
C404 m1_201_7160# vbp_st 0
C405 m1_3652_6232# vbp_syn 0.17183f
C406 vsrc a_2510_1690# 0.34407f
C407 stb vbp_syn 0.00159f
C408 m1_218_2312# m1_2640_980# 0
C409 vbn_leak vdd 0.10538f
C410 rsel spk 0.06256f
C411 a_1580_2680# sub_b 0
C412 a_480_5620# t2 0.12476f
C413 el m1_218_2312# 0.10292f
C414 m1_4822_6422# m1_3212_6232# -0.01073f
C415 sta aux 0
C416 m1_2240_4540# vdd 0.17329f
C417 m1_201_7160# a_1580_2680# 0.00414f
C418 m1_230_7612# m1_2521_6720# 0.06865f
C419 m1_853_6232# t2 0.03513f
C420 m1_230_7612# m1_1545_7160# 0.07205f
C421 sub_b hold 0.09526f
C422 vm a_2160_3542# 0.15014f
C423 vbn_prb en 0.01295f
C424 m1_4822_412# vdd 0.01273f
C425 spk a_2160_3542# 0.02364f
C426 el m1_3212_6232# 0.02221f
C427 m1_201_7160# hold 0
C428 vbp_syn a_2804_3624# 0
C429 m1_2960_1560# a_2510_1690# 0.06672f
C430 rsel sub_b 0.18129f
C431 vsrc m1_3652_6232# 0.00185f
C432 vreset m1_218_2312# 0.00184f
C433 m1_3360_308# abus 0.05653f
C434 vsrc stb 0
C435 t3 a_480_5620# 0.2016f
C436 aux t2 0.18933f
C437 vbn_ref vbp_syn 0.00422f
C438 vm m1_1728_4540# 0.05389f
C439 en vbn_leak 0
C440 m1_2521_6720# m1_2240_4540# 0
C441 a_2240_2680# a_480_5620# 0.09166f
C442 m1_218_2312# a_3184_3624# 0
C443 spk m1_1728_4540# 0.10192f
C444 m1_4822_6422# vm 0
C445 t3 m1_853_6232# 0.06546f
C446 abus a_3844_4734# 0
C447 en m1_2240_4540# 0
C448 m1_4822_6422# spk 0
C449 sub m1_218_2312# 0.06091f
C450 sub_b a_2160_3542# 0
C451 vbn_ref m1_3620_1976# 0.00148f
C452 vm m1_2640_980# 0.3851f
C453 sub t1 0
C454 vsrc a_2804_3624# 0.26788f
C455 m1_4822_412# en 0.0834f
C456 a_3184_3624# m1_3212_6232# 0
C457 el vm 0.47318f
C458 t3 aux 0.17937f
C459 vsrc vbn_ref 0.04233f
C460 sub m1_1960_6220# 0.00104f
C461 vbp_st a_480_5620# 0.00556f
C462 vbp_st mreset 0.00276f
C463 el spk 0.10993f
C464 sub_b m1_1728_4540# 0.10165f
C465 vbp_syn vdd 2.76699f
C466 a_2240_2680# aux 0.00476f
C467 a_280_2680# vdd 0
C468 m1_3360_308# a_2510_1690# 0.01778f
C469 a_1580_2680# a_480_5620# 0.53347f
C470 vdd m1_3620_1976# 0.19663f
C471 vreset vm 0.13899f
C472 sub_b m1_2640_980# 0.00854f
C473 vreset spk 0.0013f
C474 hold a_480_5620# 0.53934f
C475 hold mreset 0.0013f
C476 el sub_b 0.00421f
C477 vbp_st m1_4822_1769# 0.01317f
C478 a_2510_1690# a_3844_4734# 0.26052f
C479 a_3184_3624# vm 0
C480 aux vbp_st 0.04057f
C481 vsrc vdd 0.75801f
C482 vbp_syn m1_2521_6720# 0
C483 a_3184_3624# spk 0.18676f
C484 m1_853_6232# hold 0
C485 rsel a_480_5620# 0
C486 sub vm 0.05465f
C487 en vbp_syn 0
C488 sub spk 0.06569f
C489 aux a_1580_2680# 0
C490 m1_1400_6220# t2 0.14209f
C491 sta a_2510_1690# 0
C492 vreset sub_b 0.00437f
C493 t0 m1_3652_6232# 0
C494 en m1_3620_1976# 0.0014f
C495 t0 stb 0.00176f
C496 m1_3652_6232# a_3844_4734# 0
C497 aux hold 0.03888f
C498 a_2160_3542# a_480_5620# 0.12547f
C499 m1_2960_1560# vdd 0.00688f
C500 sub_b a_3184_3624# 0.09339f
C501 vsrc m1_2521_6720# 0.00102f
C502 vsrc en 0.00107f
C503 rsel aux 0.11684f
C504 sub sub_b 0.42649f
C505 a_480_5620# m1_1728_4540# 0.09171f
C506 sta m1_3652_6232# 0.07723f
C507 m1_3360_308# vbn_ref 0.03071f
C508 t1 m1_1104_8052# 0.00183f
C509 sta stb 0.00798f
C510 m1_201_7160# sub 0.02979f
C511 t0 a_2804_3624# 0
C512 m1_4822_6422# mreset 0
C513 vbp_st abus 0.02869f
C514 vbn_ref a_3844_4734# 0
C515 m1_230_7612# vbn_leak 0
C516 vbn_prb vbn_leak 0
C517 m1_2960_1560# en 0
C518 el a_480_5620# 0.08379f
C519 el mreset 0.05268f
C520 vbn_prb m1_2240_4540# 0
C521 aux m1_1728_4540# 0
C522 m1_3360_308# vdd 0.28082f
C523 a_2240_2680# a_2510_1690# 0.31057f
C524 sta vbn_ref 0
C525 m1_4822_412# vbn_prb 0.07515f
C526 abus hold 0
C527 aux m1_4822_6422# 0.01007f
C528 t1 m1_1960_6220# 0.11171f
C529 m1_1400_6220# a_1580_2680# 0
C530 t0 vdd 0.10571f
C531 vbn_leak m1_2240_4540# 0
C532 vreset mreset 0
C533 m1_4822_1769# m1_2640_980# 0.01707f
C534 a_3844_4734# vdd 0.37358f
C535 rsel abus 0.079f
C536 aux m1_2640_980# 0.03643f
C537 el m1_4822_1769# 0
C538 aux el 1.64032f
C539 m1_4822_412# vbn_leak 0.00248f
C540 vbp_st a_2510_1690# 0.1301f
C541 sub m1_2117_7612# 0
C542 sub a_480_5620# 0.04543f
C543 sta vdd 0.20005f
C544 m1_3360_308# en 0.08721f
C545 a_1580_2680# a_2510_1690# 0.03411f
C546 t0 m1_2521_6720# 0.14038f
C547 m1_218_2312# vm 0.21229f
C548 vreset m1_4822_1769# 0.01888f
C549 t0 m1_1545_7160# 0.04003f
C550 aux vreset 0.11095f
C551 vm t1 0.05793f
C552 m1_218_2312# spk 0.33017f
C553 m1_230_7612# vbp_syn 0
C554 vbn_prb vbp_syn 0.05137f
C555 en a_3844_4734# 0
C556 a_2510_1690# hold 0.69349f
C557 m1_3652_6232# vbp_st 0.021f
C558 aux a_3184_3624# 0.00174f
C559 vm m1_1960_6220# 0.03949f
C560 vbp_st stb 0
C561 m1_201_7160# m1_1104_8052# 0.01508f
C562 a_2240_2680# a_2804_3624# 0
C563 vm m1_3212_6232# 0.02826f
C564 t2 vdd 0.27922f
C565 rsel a_2510_1690# 0.24001f
C566 aux sub 0.26283f
C567 vbn_prb m1_3620_1976# 0.00782f
C568 spk m1_3212_6232# 0.12201f
C569 vbn_leak vbp_syn 0.15821f
C570 sta en 0
C571 abus m1_2640_980# 0.1008f
C572 m1_218_2312# sub_b 0.18221f
C573 el abus 0.04922f
C574 vbp_syn m1_2240_4540# 0.01863f
C575 vbn_prb vsrc 0.01277f
C576 m1_3652_6232# hold 0
C577 vbp_st a_2804_3624# 0.00242f
C578 hold stb 0
C579 a_2510_1690# a_2160_3542# 0.01599f
C580 vbn_leak m1_3620_1976# 0.02074f
C581 m1_201_7160# t1 0.03264f
C582 sub_b m1_1960_6220# 0.00259f
C583 vbn_ref vbp_st 0.04246f
C584 sub_b m1_3212_6232# 0.01974f
C585 m1_2521_6720# t2 0
C586 t3 vdd 0.21598f
C587 rsel m1_3652_6232# 0
C588 m1_1545_7160# t2 0
C589 a_1580_2680# a_2804_3624# 0.01318f
C590 rsel stb 0.10644f
C591 m1_201_7160# m1_1960_6220# -0.00348f
C592 a_2240_2680# vdd 0
C593 m1_201_7160# m1_3212_6232# 0.00264f
C594 vsrc vbn_leak 1.60265f
C595 vreset abus 2.07962f
C596 vm spk 7.88647f
C597 a_2510_1690# m1_1728_4540# 0.20124f
C598 m1_2960_1560# vbn_prb 0
C599 vsrc m1_2240_4540# 0.13339f
C600 hold a_2804_3624# 0.00574f
C601 m1_4822_6422# a_2510_1690# 0.02345f
C602 vbn_ref hold 0.16868f
C603 m1_4822_412# vsrc 0.00473f
C604 rsel a_2804_3624# 0.2233f
C605 sub abus 0.01959f
C606 a_2510_1690# m1_2640_980# 0.17487f
C607 vbp_st vdd 1.03826f
C608 sub_b vm 0.06926f
C609 el a_2510_1690# 0.14932f
C610 rsel vbn_ref 0
C611 stb m1_1728_4540# 0
C612 sub_b spk 0.37758f
C613 m1_201_7160# vm 0.00213f
C614 a_1580_2680# vdd 0.56263f
C615 m1_3652_6232# m1_4822_6422# 0.00109f
C616 m1_4822_6422# stb 0.00106f
C617 a_2804_3624# a_2160_3542# 0.07346f
C618 m1_1400_6220# sub 0
C619 m1_201_7160# spk 0.00733f
C620 m1_218_2312# a_480_5620# 0.04294f
C621 hold vdd 1.37631f
C622 t1 m1_2117_7612# 0
C623 vreset a_2510_1690# 0.32101f
C624 vbp_syn m1_3620_1976# 0.22622f
C625 aux m1_1104_8052# 0.10489f
C626 t1 a_480_5620# 0.18962f
C627 vbp_st m1_2521_6720# 0
C628 el m1_3652_6232# 0.02119f
C629 el stb 0
C630 vbn_prb m1_3360_308# 0.02487f
C631 a_2804_3624# m1_1728_4540# 0.04055f
C632 vbp_st en 0.00173f
C633 rsel vdd 0.21148f
C634 a_3184_3624# a_2510_1690# 0.05316f
C635 m1_1960_6220# a_480_5620# 0.09099f
C636 m1_853_6232# t1 0
C637 mreset m1_3212_6232# 0.02902f
C638 vsrc vbp_syn 0.18302f
C639 vbn_ref m1_1728_4540# 0
C640 m1_201_7160# sub_b 0.05018f
C641 t0 m1_230_7612# 0.0748f
C642 sub a_2510_1690# 0.05071f
C643 vbn_prb a_3844_4734# 0
C644 m1_853_6232# m1_1960_6220# 0
C645 vbn_ref m1_4822_6422# 0.09585f
C646 m1_3360_308# vbn_leak 0.02315f
C647 aux m1_218_2312# 0.22445f
C648 hold m1_2521_6720# 0.06259f
C649 vsrc m1_3620_1976# 0.00973f
C650 a_2160_3542# vdd 0.41999f
C651 aux t1 0.23059f
C652 en hold 0.15747f
C653 vbn_ref m1_2640_980# 0.03263f
C654 rsel m1_2521_6720# 0.01184f
C655 el vbn_ref 0
C656 a_3844_4734# vbn_leak 0
C657 a_3184_3624# stb 0
C658 sta vbn_prb 0
C659 aux m1_1960_6220# 0
C660 m1_2960_1560# vbp_syn 0.00142f
C661 aux m1_3212_6232# 0.03299f
C662 m1_4822_412# m1_3360_308# 0.02239f
C663 t0 m1_2240_4540# 0
C664 rsel en 0
C665 vm m1_2117_7612# 0
C666 a_3844_4734# m1_2240_4540# 0.00201f
C667 sub stb 0.00852f
C668 m1_1728_4540# vdd 0.58005f
C669 vm mreset 0
C670 vm a_480_5620# 1.80313f
C671 m1_4822_6422# vdd 0.06525f
C672 vreset a_2804_3624# 0
C673 spk a_480_5620# 0.10956f
C674 m1_2960_1560# m1_3620_1976# 0
C675 m1_853_6232# vm 0.03076f
C676 sta vbn_leak 0
C677 vbn_ref vreset 0.044f
C678 a_3184_3624# a_2804_3624# 0.04419f
C679 vdd m1_2640_980# 0.22092f
C680 m1_230_7612# t2 0.07271f
C681 el vdd 2.02949f
C682 vbn_ref a_3184_3624# 0
C683 sub a_2804_3624# 0.03282f
C684 sub_b m1_2117_7612# 0
C685 aux vm 0.01639f
C686 sub_b a_480_5620# 0
C687 vbn_ref sub 0
C688 m1_218_2312# abus 0
C689 aux spk 0.00853f
C690 m1_201_7160# m1_2117_7612# 0.13635f
C691 m1_201_7160# mreset 0
C692 m1_4822_6422# en 0
C693 m1_3360_308# vbp_syn 0.0873f
C694 vreset vdd 0.21211f
C695 t3 m1_230_7612# 0.19826f
C696 m1_201_7160# m1_853_6232# 0
C697 t0 vbp_syn 0
C698 en m1_2640_980# 0.08677f
C699 m1_3360_308# m1_3620_1976# 0.00893f
C700 a_3184_3624# vdd 0.39416f
C701 a_3844_4734# vbp_syn 0.15035f
C702 el en 0
C703 m1_1400_6220# t1 0.02894f
C704 sub_b m1_4822_1769# 0
C705 aux sub_b 0.05796f
C706 sub vdd 0.31002f
C707 aux m1_201_7160# 0.82538f
C708 vsrc m1_3360_308# 0.02293f
C709 a_3844_4734# m1_3620_1976# 0.02401f
C710 sta vbp_syn 0.02421f
C711 vbn_prb vbp_st 1.63942f
C712 vreset en 1.61003f
C713 m1_218_2312# a_2510_1690# 0.05021f
C714 vsrc a_3844_4734# 0.00615f
C715 abus vm 0.0413f
C716 m1_230_7612# a_1580_2680# 0
C717 abus spk 0
C718 sub m1_2521_6720# 0.1829f
C719 vbp_st vbn_leak 0.03806f
C720 m1_2960_1560# m1_3360_308# 0.07928f
C721 sub en 0
C722 a_480_5620# m1_2117_7612# 0
C723 mreset m1_2117_7612# 0
C724 vbn_prb hold 0.06738f
C725 m1_230_7612# hold 0.00379f
C726 sta vsrc 0
C727 vbp_st m1_2240_4540# 0.18321f
C728 m1_1400_6220# vm 0.05245f
C729 vbn_leak vss 0.43759f
C730 m1_3360_308# vss 0.9795f
C731 m1_2640_980# vss 0.66569f
C732 m1_1104_8052# vss -0.03875f
C733 abus vss 2.1282f
C734 sub vss 0.43014f
C735 mreset vss 0.63106f
C736 hold vss 0.40978f
C737 vdd vss 18.48943f
C738 m1_1545_7160# vss 0.0931f
C739 m1_2117_7612# vss 0.15029f
C740 m1_4822_412# vss 0.2708f
C741 en vss 0.53423f
C742 m1_853_6232# vss 0.06455f
C743 t3 vss 0.29075f
C744 vbn_prb vss 0.84284f
C745 a_3184_3624# vss 0.16059f
C746 m1_1400_6220# vss -0.02823f
C747 t2 vss 0.24703f
C748 a_2804_3624# vss 0.07184f
C749 m1_1960_6220# vss -0.00388f
C750 t1 vss 0.2225f
C751 m1_230_7612# vss 0.83082f
C752 m1_201_7160# vss 2.17544f
C753 spk vss 0.96416f
C754 m1_2521_6720# vss -0.00421f
C755 t0 vss 0.22388f
C756 m1_2960_1560# vss 0.04388f
C757 rsel vss 0.72701f
C758 m1_2240_4540# vss -0.06271f
C759 vm vss 3.51249f
C760 sub_b vss 0.66059f
C761 vbp_st vss 0.35917f
C762 m1_3212_6232# vss 0.09723f
C763 stb vss 0.32333f
C764 sta vss 0.24763f
C765 m1_218_2312# vss 0.59899f
C766 a_2160_3542# vss 0.156f
C767 vsrc vss 0.51629f
C768 vreset vss 0.52516f
C769 a_2510_1690# vss 2.51293f
C770 m1_4822_1769# vss 0.08158f
C771 m1_1728_4540# vss 0.07035f
C772 vbn_ref vss 0.59078f
C773 a_2240_2680# vss 0.26463f
C774 a_1580_2680# vss 0.51675f
C775 a_3844_4734# vss 0.0111f
C776 m1_4822_6422# vss -0.18471f
C777 m1_3652_6232# vss -0.05799f
C778 vbp_syn vss 0.23928f
C779 a_480_5620# vss 0.04043f
C780 a_280_2680# vss 0.0902f
C781 el vss 1.08825f
C782 aux vss 3.80129f
C783 m1_3620_1976# vss 0.85423f
.ends
