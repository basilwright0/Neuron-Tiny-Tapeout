* NGSPICE file created from slot_ah_p.ext - technology: gf180mcuD

.subckt p_w2_l4 a_400_n200# a_n400_n244# w_n574_n330# a_n488_n200# VSUBS
X0 a_400_n200# a_n400_n244# a_n488_n200# w_n574_n330# pfet_03v3 ad=0.88p pd=4.88u as=0.88p ps=4.88u w=2u l=4u
C0 a_n400_n244# a_400_n200# 0.07019f
C1 a_n400_n244# a_n488_n200# 0.07019f
C2 a_400_n200# w_n574_n330# 0.07409f
C3 a_n488_n200# w_n574_n330# 0.07409f
C4 a_n488_n200# a_400_n200# 0.01073f
C5 a_n400_n244# w_n574_n330# 0.42229f
C6 a_400_n200# VSUBS 0.18936f
C7 a_n488_n200# VSUBS 0.18936f
C8 w_n574_n330# VSUBS 2.27304f
.ends

.subckt p_w0p22_l1 a_100_n22# a_n100_n66# w_n278_n159# a_n192_n36# VSUBS
X0 a_100_n22# a_n100_n66# a_n192_n36# w_n278_n159# pfet_03v3 ad=0.1516p pd=1.64u as=0.1516p ps=1.64u w=0.22u l=1u
C0 a_n192_n36# a_100_n22# 0.00453f
C1 a_n192_n36# a_n100_n66# 0.00509f
C2 a_100_n22# w_n278_n159# 0.00771f
C3 a_n100_n66# w_n278_n159# 0.13163f
C4 a_n100_n66# a_100_n22# 0.00509f
C5 a_n192_n36# w_n278_n159# 0.00771f
C6 a_100_n22# VSUBS 0.05952f
C7 a_n192_n36# VSUBS 0.05952f
C8 w_n278_n159# VSUBS 0.53042f
.ends

.subckt n_w1_l0p28 a_28_n100# a_n28_n144# a_n116_n100# VSUBS
X0 a_28_n100# a_n28_n144# a_n116_n100# VSUBS nfet_03v3 ad=0.44p pd=2.88u as=0.44p ps=2.88u w=1u l=0.28u
C0 a_n116_n100# a_28_n100# 0.04256f
C1 a_28_n100# a_n28_n144# 0.00769f
C2 a_n116_n100# a_n28_n144# 0.00769f
C3 a_28_n100# VSUBS 0.09911f
C4 a_n116_n100# VSUBS 0.09911f
.ends

.subckt n_w2_l2 a_n288_n200# a_200_n200# a_n200_n244# VSUBS
X0 a_200_n200# a_n200_n244# a_n288_n200# VSUBS nfet_03v3 ad=0.88p pd=4.88u as=0.88p ps=4.88u w=2u l=2u
C0 a_n288_n200# a_200_n200# 0.02133f
C1 a_200_n200# a_n200_n244# 0.0587f
C2 a_n288_n200# a_n200_n244# 0.0587f
C3 a_200_n200# VSUBS 0.2667f
C4 a_n288_n200# VSUBS 0.2667f
.ends

.subckt n_w2_l4 a_400_n200# a_n400_n244# a_n488_n200# VSUBS
X0 a_400_n200# a_n400_n244# a_n488_n200# VSUBS nfet_03v3 ad=0.88p pd=4.88u as=0.88p ps=4.88u w=2u l=4u
C0 a_n488_n200# a_400_n200# 0.01073f
C1 a_400_n200# a_n400_n244# 0.07019f
C2 a_n488_n200# a_n400_n244# 0.07019f
C3 a_400_n200# VSUBS 0.41684f
C4 a_n488_n200# VSUBS 0.41684f
.ends

.subckt n_w4_l0p5_k1 a_n188_n400# a_50_n400# a_n50_n444# VSUBS
X0 a_50_n400# a_n50_n444# a_n188_n400# VSUBS nfet_03v3 ad=2.76p pd=9.38u as=2.76p ps=9.38u w=4u l=0.5u
C0 a_n188_n400# a_50_n400# 0.10174f
C1 a_50_n400# a_n50_n444# 0.04238f
C2 a_n188_n400# a_n50_n444# 0.04238f
C3 a_50_n400# VSUBS 0.23105f
C4 a_n188_n400# VSUBS 0.23105f
.ends

.subckt n_w0p5_l0p28 a_n28_n94# a_n116_n50# a_28_n50# VSUBS
X0 a_28_n50# a_n28_n94# a_n116_n50# VSUBS nfet_03v3 ad=0.22p pd=1.88u as=0.22p ps=1.88u w=0.5u l=0.28u
C0 a_n116_n50# a_28_n50# 0.02085f
C1 a_28_n50# a_n28_n94# 0.00377f
C2 a_n116_n50# a_n28_n94# 0.00377f
C3 a_28_n50# VSUBS 0.07987f
C4 a_n116_n50# VSUBS 0.07987f
.ends

.subckt p_w1_l0p5 a_n138_n100# a_50_n100# a_n50_n144# w_n224_n230# VSUBS
X0 a_50_n100# a_n50_n144# a_n138_n100# w_n224_n230# pfet_03v3 ad=0.44p pd=2.88u as=0.44p ps=2.88u w=1u l=0.5u
C0 a_n50_n144# a_50_n100# 0.01275f
C1 a_n50_n144# a_n138_n100# 0.01275f
C2 a_50_n100# w_n224_n230# 0.0205f
C3 a_n138_n100# w_n224_n230# 0.0205f
C4 a_n138_n100# a_50_n100# 0.03085f
C5 a_n50_n144# w_n224_n230# 0.07993f
C6 a_50_n100# VSUBS 0.06546f
C7 a_n138_n100# VSUBS 0.06546f
C8 w_n224_n230# VSUBS 0.61824f
.ends

.subckt n_w1_l0p5 a_n138_n100# a_50_n100# a_n50_n144# VSUBS
X0 a_50_n100# a_n50_n144# a_n138_n100# VSUBS nfet_03v3 ad=0.44p pd=2.88u as=0.44p ps=2.88u w=1u l=0.5u
C0 a_n138_n100# a_50_n100# 0.03085f
C1 a_50_n100# a_n50_n144# 0.01275f
C2 a_n138_n100# a_n50_n144# 0.01275f
C3 a_50_n100# VSUBS 0.11563f
C4 a_n138_n100# VSUBS 0.11563f
.ends

.subckt p_w1_l0p28 w_n202_n230# a_28_n100# a_n28_n144# a_n116_n100# VSUBS
X0 a_28_n100# a_n28_n144# a_n116_n100# w_n202_n230# pfet_03v3 ad=0.44p pd=2.88u as=0.44p ps=2.88u w=1u l=0.28u
C0 a_n28_n144# a_28_n100# 0.00769f
C1 a_n28_n144# a_n116_n100# 0.00769f
C2 a_28_n100# w_n202_n230# 0.01808f
C3 a_n116_n100# w_n202_n230# 0.01808f
C4 a_n116_n100# a_28_n100# 0.04256f
C5 a_n28_n144# w_n202_n230# 0.05841f
C6 a_28_n100# VSUBS 0.0597f
C7 a_n116_n100# VSUBS 0.0597f
C8 w_n202_n230# VSUBS 0.55752f
.ends

.subckt n_w4_l2 a_n288_n400# a_200_n400# a_n200_n444# VSUBS
X0 a_200_n400# a_n200_n444# a_n288_n400# VSUBS nfet_03v3 ad=1.76p pd=8.88u as=1.76p ps=8.88u w=4u l=2u
C0 a_n288_n400# a_200_n400# 0.04287f
C1 a_200_n400# a_n200_n444# 0.11799f
C2 a_n288_n400# a_n200_n444# 0.11799f
C3 a_200_n400# VSUBS 0.34365f
C4 a_n288_n400# VSUBS 0.34365f
.ends

.subckt p_w1_l2 w_n374_n230# a_n288_n100# a_200_n100# a_n200_n144# VSUBS
X0 a_200_n100# a_n200_n144# a_n288_n100# w_n374_n230# pfet_03v3 ad=0.44p pd=2.88u as=0.44p ps=2.88u w=1u l=2u
C0 a_n200_n144# a_200_n100# 0.02905f
C1 a_n200_n144# a_n288_n100# 0.02905f
C2 a_200_n100# w_n374_n230# 0.03135f
C3 a_n288_n100# w_n374_n230# 0.03135f
C4 a_n288_n100# a_200_n100# 0.01056f
C5 a_n200_n144# w_n374_n230# 0.22666f
C6 a_200_n100# VSUBS 0.1047f
C7 a_n288_n100# VSUBS 0.1047f
C8 w_n374_n230# VSUBS 1.03224f
.ends

.subckt n_w7p07_l7p07 a_707_n707# a_n795_n707# a_n707_n751# VSUBS
X0 a_707_n707# a_n707_n751# a_n795_n707# VSUBS nfet_03v3 ad=3.1108p pd=15.02u as=3.1108p ps=15.02u w=7.07u l=7.07u
C0 a_n795_n707# a_707_n707# 0.0212f
C1 a_707_n707# a_n707_n751# 0.27012f
C2 a_n795_n707# a_n707_n751# 0.27012f
C3 a_707_n707# VSUBS 0.84237f
C4 a_n795_n707# VSUBS 0.84237f
.ends

.subckt n_w0p5_l1p5 a_150_n50# a_n238_n50# a_n150_n94# VSUBS
X0 a_150_n50# a_n150_n94# a_n238_n50# VSUBS nfet_03v3 ad=0.22p pd=1.88u as=0.22p ps=1.88u w=0.5u l=1.5u
C0 a_n238_n50# a_150_n50# 0.00671f
C1 a_150_n50# a_n150_n94# 0.01269f
C2 a_n238_n50# a_n150_n94# 0.01269f
C3 a_150_n50# VSUBS 0.17146f
C4 a_n238_n50# VSUBS 0.17146f
.ends

.subckt n_w3p54_l3p54 a_354_n354# a_n354_n398# a_n442_n354# VSUBS
X0 a_354_n354# a_n354_n398# a_n442_n354# VSUBS nfet_03v3 ad=1.5576p pd=7.96u as=1.5576p ps=7.96u w=3.54u l=3.54u
C0 a_n442_n354# a_354_n354# 0.02161f
C1 a_354_n354# a_n354_n398# 0.12189f
C2 a_n442_n354# a_n354_n398# 0.12189f
C3 a_354_n354# VSUBS 0.44156f
C4 a_n442_n354# VSUBS 0.44156f
.ends

.subckt n_w0p22_l2 a_200_n22# a_n200_n66# a_n292_n36# VSUBS
X0 a_200_n22# a_n200_n66# a_n292_n36# VSUBS nfet_03v3 ad=0.1516p pd=1.64u as=0.1516p ps=1.64u w=0.22u l=2u
C0 a_n200_n66# a_200_n22# 0.00705f
C1 a_200_n22# a_n292_n36# 0.00245f
C2 a_n200_n66# a_n292_n36# 0.00705f
C3 a_200_n22# VSUBS 0.20767f
C4 a_n292_n36# VSUBS 0.20767f
.ends

.subckt n_w0p5_l3 a_n388_n50# a_300_n50# a_n300_n94# VSUBS
X0 a_300_n50# a_n300_n94# a_n388_n50# VSUBS nfet_03v3 ad=0.22p pd=1.88u as=0.22p ps=1.88u w=0.5u l=3u
C0 a_n388_n50# a_300_n50# 0.00348f
C1 a_300_n50# a_n300_n94# 0.01602f
C2 a_n388_n50# a_n300_n94# 0.01602f
C3 a_300_n50# VSUBS 0.28406f
C4 a_n388_n50# VSUBS 0.28406f
.ends

.subckt n_w0p5_l4 a_n488_n50# a_400_n50# a_n400_n94# VSUBS
X0 a_400_n50# a_n400_n94# a_n488_n50# VSUBS nfet_03v3 ad=0.22p pd=1.88u as=0.22p ps=1.88u w=0.5u l=4u
C0 a_n488_n50# a_400_n50# 0.0026f
C1 a_400_n50# a_n400_n94# 0.01702f
C2 a_n488_n50# a_n400_n94# 0.01702f
C3 a_400_n50# VSUBS 0.35913f
C4 a_n488_n50# VSUBS 0.35913f
.ends

.subckt slot_ah_p vss vbp_syn vdd el aux vbn_leak vsrc vbp_st vbn_prb vbn_ref en vreset
+ abus spk t3 t2 t1 t0 sta stb hold mreset rsel sub sub_b vm
XXL_XP1 a_480_5620# a_480_5620# vdd vdd vss p_w2_l4
XXD_XK a_3184_3624# spk vdd vdd vss p_w0p22_l1
XXPM_XSW m1_4052_1572# rsel m1_3704_1572# vss n_w1_l0p28
XXL_XP2 a_1682_2940# a_480_5620# vdd vdd vss p_w2_l4
XXPR_XMB vss m1_4802_1762# vbn_prb vss n_w2_l2
XXL_XMT m1_644_2312# aux vss vss n_w2_l4
XXL_XM1 a_338_2940# a_480_5620# el vss n_w4_l0p5_k1
XXS_XWA m1_4904_6422# vbp_syn vdd m1_3652_6232# vss p_w2_l4
XXR_Xi_XN spk vss a_3844_4734# vss n_w0p5_l0p28
XXL_XM2 a_2578_2940# a_1682_2940# a_1682_2940# vss n_w4_l0p5_k1
XXS_XWB m1_4904_6422# vbp_syn vdd m1_3212_6232# vss p_w2_l4
XXR_XNR vss vbn_ref a_2510_1740# vss n_w2_l4
XXD_XPI m1_1692_4664# a_2160_3542# vm vdd vss p_w1_l0p5
XXPR_XME m1_2424_756# en m1_4802_1762# vss n_w1_l0p28
XXR_XSW vreset vm a_2510_1740# vss n_w1_l0p5
XXR_Xi_XP vdd a_3844_4734# spk vdd vss p_w1_l0p28
XXD_XNI vsrc a_2160_3542# vm vss n_w1_l0p5
XXPR_XMF m1_2424_756# vdd a_2510_1740# vss n_w4_l2
XXS_XQA vdd m1_3652_6232# sta vss vss p_w1_l0p28
XXS_XQB vdd m1_3212_6232# stb vss vss p_w1_l0p28
XXS_XNA sta vm m1_3652_6232# vss n_w0p5_l0p28
XXS_XNB stb vm m1_3212_6232# vss n_w0p5_l0p28
XXD_XS2 vdd vdd m1_2260_4540# vbp_st vss p_w1_l2
XXD_XPS vdd vdd m1_1692_4664# vbp_st vss p_w1_l2
XXD_XS3 vdd vdd m1_1545_4540# vbp_st vss p_w1_l2
XXL_XD2a m1_644_2312# a_2578_2940# a_2578_2940# vss n_w4_l0p5_k1
XXPM_XSB abus sub_b m1_4052_1572# vss n_w1_l0p28
XXL_XD2b m1_644_2312# a_2578_2940# a_2578_2940# vss n_w4_l0p5_k1
XXL_XD1a m1_644_2312# a_338_2940# a_338_2940# vss n_w4_l0p5_k1
XXPM_XSC m1_3704_1572# en m1_3348_960# vss n_w1_l0p28
XXC_XC vss vss vm vss n_w7p07_l7p07
XXS_XPH vdd m1_4904_6422# vdd hold vss p_w1_l2
XXT_XR1 m1_2105_7600# m1_1557_7120# aux vss n_w0p5_l1p5
XXD_XP2 vdd a_2804_3624# a_2160_3542# m1_2260_4540# vss p_w1_l0p28
XXL_XD1b m1_644_2312# a_338_2940# a_338_2940# vss n_w4_l0p5_k1
XXPR_XSW m1_2972_1572# rsel m1_2260_960# vss n_w1_l0p28
XXT_XR2 m1_208_6996# m1_2105_7600# aux vss n_w0p5_l1p5
XXT_XP0 vdd m1_2436_6996# t0 vm vss p_w1_l0p28
XXD_Xi4_XN a_3184_3624# vss spk vss n_w0p5_l0p28
XXD_XP3 vdd a_3184_3624# a_2804_3624# m1_1545_4540# vss p_w1_l0p28
XXT_XR3 m1_208_7600# m1_208_6996# aux vss n_w0p5_l1p5
XXT_XP1 vdd m1_1973_6232# t1 vm vss p_w1_l0p28
XXR_XCR_XC vss a_2510_1740# vss vss n_w3p54_l3p54
XXD_XN2 a_2804_3624# a_2160_3542# vsrc vss n_w0p22_l2
XXT_XN0 t0 a_480_5620# m1_2436_6996# vss n_w0p5_l0p28
XXT_XP2 vdd m1_1401_6720# t2 vm vss p_w1_l0p28
XXD_Xi4_XP vdd spk a_3184_3624# vdd vss p_w1_l0p28
XXD_XN3 a_2804_3624# vsrc a_3184_3624# vss n_w0p5_l0p28
XXPM_XMB vss m1_4822_412# vbn_prb vss n_w2_l2
XXT_XN1 t1 a_480_5620# m1_1973_6232# vss n_w0p5_l0p28
XXT_XP3 vdd m1_796_6120# t3 vm vss p_w1_l0p28
XXT_XL0 m1_2436_6996# m1_208_7600# aux vss n_w0p5_l3
XXT_XN2 t2 a_480_5620# m1_1401_6720# vss n_w0p5_l0p28
XXT_XLT m1_208_7600# vdd aux vss n_w0p5_l3
XXT_XL1 m1_1973_6232# m1_208_6996# aux vss n_w0p5_l3
XXT_XN3 t3 a_480_5620# m1_796_6120# vss n_w0p5_l0p28
XXR_XPC vdd a_2510_1740# a_3844_4734# vdd vss p_w1_l0p28
XXPM_XME m1_3348_960# en m1_4822_412# vss n_w1_l0p28
XXT_XL2 m1_1401_6720# m1_2105_7600# aux vss n_w0p5_l3
XXT_XL3 m1_796_6120# m1_1557_7120# aux vss n_w0p5_l3
XXPM_XMF m1_3348_960# vdd vm vss n_w4_l2
XXS_XHL vdd vm hold a_1682_2940# vss p_w1_l0p28
XXS_XMR mreset a_2510_1740# vdd vss n_w0p5_l0p28
XXPR_XSB abus sub m1_2972_1572# vss n_w1_l0p28
XXPR_XSC m1_2424_756# en m1_2260_960# vss n_w1_l0p28
XXT_XRB m1_1104_8052# m1_1557_7120# aux vss n_w0p5_l4
XXT_XRA vss m1_1104_8052# aux vss n_w0p5_l4
C0 rsel vreset 0
C1 vm stb 0.04174f
C2 vbp_syn en 0.08363f
C3 a_2804_3624# rsel 0.01776f
C4 m1_2436_6996# aux 0.20054f
C5 m1_2436_6996# vdd 0.03348f
C6 m1_208_7600# vbp_syn 0.00151f
C7 vreset abus 1.82741f
C8 spk t1 0
C9 a_1682_2940# spk 0.08861f
C10 m1_2436_6996# a_480_5620# 0.01966f
C11 m1_1545_4540# vbp_st 0.02577f
C12 a_2510_1740# vbp_st 0.27337f
C13 m1_2260_960# sub_b 0
C14 sub_b a_2578_2940# 0
C15 m1_644_2312# sub 0.03896f
C16 a_2510_1740# a_3184_3624# 0.00254f
C17 m1_4802_1762# vbn_prb 0.12042f
C18 m1_1545_4540# a_3184_3624# 0.02174f
C19 hold t1 0
C20 m1_2260_960# spk 0
C21 spk a_2578_2940# 0.20707f
C22 a_1682_2940# hold 0.34249f
C23 vbn_leak vsrc 1.6831f
C24 m1_644_2312# vbn_prb 0.00111f
C25 vbp_st m1_3348_960# 0.03879f
C26 aux vbp_st 0.04198f
C27 vdd vbp_st 1.71891f
C28 mreset en 0
C29 aux a_3184_3624# 0.00204f
C30 vdd a_3184_3624# 0.42073f
C31 a_480_5620# vbp_st 0.2038f
C32 t3 t1 0
C33 a_2160_3542# vsrc 0.16998f
C34 m1_2260_4540# m1_1692_4664# 0.08395f
C35 a_1682_2940# t3 0
C36 a_2510_1740# sub_b 0.11475f
C37 a_480_5620# a_3184_3624# 0.00155f
C38 mreset m1_208_7600# 0.00221f
C39 t0 m1_1973_6232# 0.15422f
C40 m1_4822_412# m1_3348_960# 0.07018f
C41 vbp_st a_3844_4734# 0.00313f
C42 aux m1_4822_412# 0.00115f
C43 vdd m1_4822_412# 0.0096f
C44 a_2510_1740# spk 0.02128f
C45 rsel m1_2105_7600# 0
C46 spk m1_1545_4540# 0.00253f
C47 vm t0 0.0619f
C48 aux m1_1104_8052# 0.01525f
C49 a_3844_4734# a_3184_3624# 0.05848f
C50 en m1_2424_756# 0.11395f
C51 en el 0.03706f
C52 mreset vbp_syn 0.29307f
C53 sub_b m1_3348_960# 0
C54 sub_b aux 0.0965f
C55 sub_b vdd 0.41395f
C56 a_2510_1740# vbn_ref 0.32474f
C57 m1_1545_4540# hold 0.0432f
C58 a_2510_1740# hold 0.56766f
C59 m1_2260_4540# vbp_syn 0.02219f
C60 m1_208_7600# el 0
C61 a_480_5620# sub_b 0
C62 vdd spk 0.87243f
C63 aux spk 0.06957f
C64 a_480_5620# spk 0.0866f
C65 sub_b a_3844_4734# 0.05377f
C66 a_1682_2940# m1_796_6120# 0
C67 vbn_ref m1_3348_960# 0.03356f
C68 vbp_syn m1_2424_756# 0.12655f
C69 aux vbn_ref 0
C70 vbp_syn el 0.13814f
C71 vdd vbn_ref 0.31335f
C72 vm m1_3212_6232# 0.02914f
C73 aux hold 0.04257f
C74 vdd hold 1.97062f
C75 a_1682_2940# sub 0.05048f
C76 spk a_3844_4734# 0.21496f
C77 a_480_5620# hold 0.86374f
C78 stb m1_2105_7600# 0
C79 m1_208_6996# t1 0.08524f
C80 m1_2260_960# sub 0
C81 vbn_ref a_3844_4734# 0.00302f
C82 sub a_2578_2940# 0
C83 a_3844_4734# hold 0.22099f
C84 t3 aux 0.20601f
C85 t3 vdd 0.18084f
C86 t0 a_2804_3624# 0
C87 m1_2260_4540# mreset 0
C88 vbp_st vbn_leak 0.04057f
C89 t3 a_480_5620# 0.13045f
C90 m1_2436_6996# m1_1557_7120# 0
C91 mreset el 0.02914f
C92 a_2160_3542# vbp_st 0.00601f
C93 m1_644_2312# rsel 0.08058f
C94 m1_4822_412# vbn_leak 0.00192f
C95 m1_2260_960# m1_2972_1572# 0.0013f
C96 m1_4802_1762# abus 0.30809f
C97 a_2510_1740# sub 0.15027f
C98 m1_1545_4540# sub 0.18385f
C99 a_2160_3542# a_3184_3624# 0.00161f
C100 m1_1401_6720# m1_1973_6232# 0.00113f
C101 a_2510_1740# sta 0
C102 vbp_st vsrc 1.68713f
C103 m1_644_2312# abus 0.00378f
C104 vm m1_1401_6720# 0.02407f
C105 sub_b vbn_leak 0.05904f
C106 a_2510_1740# vbn_prb 0.21435f
C107 a_2510_1740# m1_208_6996# 0.00208f
C108 aux m1_796_6120# 0.03529f
C109 vdd m1_796_6120# 0.32268f
C110 m1_2424_756# el 0.03044f
C111 a_3184_3624# vsrc 0.03406f
C112 sub m1_3348_960# 0.00209f
C113 spk vbn_leak 0
C114 aux sub 0.12397f
C115 vdd sub 0.31875f
C116 a_480_5620# m1_796_6120# 0.13805f
C117 aux sta 0
C118 vdd sta 0.20165f
C119 sub_b a_2160_3542# 0
C120 m1_1973_6232# m1_1692_4664# 0
C121 t0 m1_2105_7600# 0.07342f
C122 m1_4822_412# vsrc 0.0037f
C123 a_480_5620# sub 0.06758f
C124 vbn_prb m1_3348_960# 0.04182f
C125 a_2510_1740# m1_2972_1572# 0.07005f
C126 vm m1_1692_4664# 0.13124f
C127 vbn_ref vbn_leak 0.01391f
C128 aux vbn_prb 0
C129 vm en 0.10525f
C130 vdd vbn_prb 0.09293f
C131 t2 t1 0.07819f
C132 vbn_leak hold 0.07603f
C133 m1_208_6996# aux 0.75171f
C134 m1_208_6996# vdd 0.04957f
C135 a_2160_3542# spk 0.01271f
C136 a_338_2940# m1_644_2312# 0.49492f
C137 a_3844_4734# sub 0.15818f
C138 sub_b vsrc 0.01409f
C139 vm m1_208_7600# 0
C140 m1_1557_7120# m1_1104_8052# -0.0026f
C141 m1_208_6996# a_480_5620# 0.06844f
C142 a_2160_3542# hold 0.00479f
C143 spk vsrc 0.15417f
C144 m1_2972_1572# m1_3348_960# 0
C145 vbn_prb a_3844_4734# 0
C146 m1_2972_1572# aux 0
C147 m1_2972_1572# vdd 0.00395f
C148 vm vbp_syn 0.11368f
C149 vbn_ref vsrc 0.04621f
C150 vsrc hold 0.11451f
C151 m1_2436_6996# vbp_st 0
C152 a_1682_2940# rsel 0
C153 a_2510_1740# m1_3652_6232# 0
C154 m1_1557_7120# hold 0
C155 en vreset 1.8638f
C156 m1_2260_960# rsel 0.06573f
C157 rsel a_2578_2940# 0.01905f
C158 a_2804_3624# m1_1692_4664# 0.00417f
C159 vdd m1_3652_6232# 0.24896f
C160 aux m1_3652_6232# 0.00645f
C161 a_2510_1740# m1_4904_6422# 0.36576f
C162 m1_2260_960# abus 0
C163 m1_2436_6996# sub_b 0.00213f
C164 vm mreset 0
C165 t2 aux 0.14387f
C166 t2 vdd 0.28683f
C167 sub vbn_leak 0
C168 vbp_st a_3184_3624# 0.00366f
C169 vbp_syn vreset 0.04129f
C170 m1_2260_4540# vm 0.00579f
C171 a_480_5620# t2 0.22653f
C172 vbn_leak sta 0
C173 m1_2436_6996# spk 0.00145f
C174 a_3844_4734# m1_3652_6232# 0
C175 vbn_prb vbn_leak 0
C176 a_2510_1740# rsel 0.16878f
C177 vbp_st m1_4822_412# 0.0108f
C178 stb t1 0
C179 m1_1401_6720# m1_2105_7600# -0.00348f
C180 m1_4904_6422# aux 0
C181 m1_4904_6422# vdd -0.07079f
C182 a_2160_3542# sub 0.01212f
C183 vm m1_2424_756# 0.39126f
C184 m1_2436_6996# hold 0.02375f
C185 vm el 0.07838f
C186 a_338_2940# a_2578_2940# 0.00359f
C187 sub_b vbp_st 0.04519f
C188 a_2510_1740# abus 0.04722f
C189 sub vsrc 0.04387f
C190 rsel m1_3348_960# 0.00266f
C191 rsel vdd 0.33464f
C192 m1_1557_7120# m1_796_6120# -0.00167f
C193 rsel aux 0.09908f
C194 sub_b a_3184_3624# 0.02576f
C195 m1_3704_1572# rsel 0.0163f
C196 vsrc sta 0
C197 spk vbp_st 0.12536f
C198 a_480_5620# rsel 0.00284f
C199 vbn_prb vsrc 0.01206f
C200 spk a_3184_3624# 0.22493f
C201 mreset vreset 0
C202 abus m1_3348_960# 0.10889f
C203 m1_208_7600# m1_2105_7600# 0.00943f
C204 aux abus 0.03821f
C205 vbn_ref vbp_st 0.04333f
C206 vdd abus 0.19859f
C207 m1_3704_1572# abus 0.00665f
C208 vbp_st hold 0.46055f
C209 rsel a_3844_4734# 0.07252f
C210 m1_1557_7120# m1_208_6996# 0.14411f
C211 vbn_ref a_3184_3624# 0
C212 a_3184_3624# hold 0.16211f
C213 m1_2260_4540# a_2804_3624# 0.08448f
C214 vbp_syn m1_2105_7600# 0
C215 abus a_3844_4734# 0
C216 vbn_ref m1_4822_412# 0.08703f
C217 m1_2424_756# vreset 0.08879f
C218 vreset el 0.03423f
C219 sub_b spk 0.56334f
C220 vbn_leak m1_3652_6232# 0.00306f
C221 a_2804_3624# el 0
C222 a_338_2940# vdd 0
C223 t0 t1 0.04632f
C224 t0 a_1682_2940# 0
C225 m1_2260_960# m1_4052_1572# 0
C226 sub_b vbn_ref 0.00363f
C227 aux stb 0.16246f
C228 vdd stb 0.13649f
C229 sub_b hold 0.20837f
C230 a_338_2940# a_480_5620# 0
C231 a_480_5620# stb 0
C232 vbn_ref spk 0
C233 m1_2436_6996# sub 0.13959f
C234 spk hold 0.25952f
C235 t3 m1_1104_8052# 0
C236 vsrc m1_3652_6232# 0.00154f
C237 m1_2436_6996# m1_208_6996# 0.20198f
C238 vbn_ref hold 0.04997f
C239 mreset m1_2105_7600# 0
C240 m1_4802_1762# en 0.11368f
C241 a_2510_1740# m1_4052_1572# 0
C242 m1_644_2312# en 0.01881f
C243 vbp_st sub 0.13823f
C244 m1_1557_7120# t2 0
C245 vm m1_1973_6232# 0.07357f
C246 vbp_st sta 0.00349f
C247 t3 hold 0.01686f
C248 sub a_3184_3624# 0.0629f
C249 rsel a_2160_3542# 0
C250 m1_4052_1572# m1_3348_960# 0
C251 abus vbn_leak 0.06961f
C252 aux m1_4052_1572# 0.03617f
C253 vbp_st vbn_prb 1.71612f
C254 m1_2105_7600# el 0
C255 vdd m1_4052_1572# 0.01699f
C256 m1_208_6996# vbp_st 0
C257 m1_3704_1572# m1_4052_1572# 0
C258 m1_644_2312# vbp_syn 0.10157f
C259 t0 vdd 0.10056f
C260 t0 aux 0.19364f
C261 rsel vsrc 0.03617f
C262 vbn_prb m1_4822_412# 0.11076f
C263 t0 a_480_5620# 0.10955f
C264 sub_b sub 0.03832f
C265 sub_b sta 0
C266 m1_208_6996# m1_1104_8052# 0
C267 abus vsrc 0.09671f
C268 spk sub 0.08056f
C269 sub_b vbn_prb 0.00243f
C270 stb vbn_leak 0
C271 spk sta 0.09062f
C272 m1_208_6996# sub_b 0.00404f
C273 hold m1_796_6120# 0.00244f
C274 m1_1401_6720# t1 0.07362f
C275 m1_2436_6996# t2 0
C276 spk vbn_prb 0
C277 vbn_ref sub 0
C278 sub hold 0.34703f
C279 m1_208_6996# spk 0.00884f
C280 vm vreset 0.27595f
C281 m1_3212_6232# vdd 0.18028f
C282 m1_3212_6232# aux 0.01135f
C283 vbn_ref sta 0
C284 hold sta 0
C285 vm a_2804_3624# 0
C286 vbn_ref vbn_prb 1.74886f
C287 vbn_prb hold 0.14538f
C288 m1_208_6996# hold 0.00372f
C289 t3 m1_796_6120# 0.18981f
C290 m1_1692_4664# t1 0
C291 a_1682_2940# m1_1692_4664# 0.09357f
C292 vbp_st m1_3652_6232# 0.006f
C293 m1_2972_1572# spk 0
C294 stb vsrc 0
C295 m1_4802_1762# m1_2424_756# 0.02111f
C296 t2 vbp_st 0
C297 m1_208_7600# t1 0.03518f
C298 m1_1557_7120# stb 0
C299 m1_2436_6996# rsel 0.00607f
C300 m1_644_2312# m1_2424_756# 0
C301 m1_2260_960# en 0.04366f
C302 m1_644_2312# el 0.23298f
C303 en a_2578_2940# 0.00362f
C304 t3 m1_208_6996# 0.13726f
C305 m1_4052_1572# vbn_leak 0.00484f
C306 m1_4904_6422# vbp_st 0.02925f
C307 sub_b m1_3652_6232# 0
C308 t2 m1_1104_8052# 0.03596f
C309 vbp_syn m1_2260_960# 0
C310 vbp_syn a_2578_2940# 0
C311 m1_1973_6232# m1_2105_7600# 0.0048f
C312 spk m1_3652_6232# 0.00816f
C313 rsel vbp_st 0.04306f
C314 m1_1401_6720# vdd 0.06422f
C315 m1_1401_6720# aux 0.21007f
C316 a_2510_1740# m1_1692_4664# 0
C317 m1_1545_4540# m1_1692_4664# 0.0971f
C318 a_2510_1740# en 0.53513f
C319 vm m1_2105_7600# 0
C320 rsel a_3184_3624# 0.15677f
C321 m1_1401_6720# a_480_5620# 0.28759f
C322 m1_208_7600# a_2510_1740# 0.0013f
C323 hold m1_3652_6232# 0.01348f
C324 vbp_st abus 0.1157f
C325 m1_208_6996# m1_796_6120# 0.10816f
C326 m1_2436_6996# stb 0.08958f
C327 t2 hold 0
C328 vbn_prb sub 0
C329 en m1_3348_960# 0.15848f
C330 vdd m1_1692_4664# 0.28596f
C331 aux en 0.04317f
C332 m1_4904_6422# spk 0
C333 m1_208_6996# sub 0.023f
C334 m1_3212_6232# vbn_leak 0.00171f
C335 en vdd 0.23193f
C336 vbn_prb sta 0
C337 m1_3704_1572# en 0.02589f
C338 vbp_syn a_2510_1740# 0.32753f
C339 m1_208_6996# sta 0
C340 a_480_5620# m1_1692_4664# 0.15559f
C341 rsel sub_b 0.46758f
C342 m1_2260_4540# a_1682_2940# 0.03512f
C343 t0 m1_1557_7120# 0.09239f
C344 m1_208_7600# vdd 0.01002f
C345 m1_208_7600# aux 0.51853f
C346 abus m1_4822_412# 0.01227f
C347 m1_4904_6422# vbn_ref 0.11398f
C348 m1_208_7600# a_480_5620# 0
C349 m1_4904_6422# hold 0.69894f
C350 a_3844_4734# m1_1692_4664# 0
C351 m1_2972_1572# sub 0
C352 rsel spk 0.34479f
C353 t3 t2 0.05739f
C354 en a_3844_4734# 0
C355 a_338_2940# vbp_st 0
C356 m1_2260_4540# a_2578_2940# 0
C357 vbp_syn m1_3348_960# 0.07213f
C358 sub_b abus 0.05253f
C359 vbp_syn aux 0.23212f
C360 stb vbp_st 0
C361 vbp_syn vdd 2.86159f
C362 a_1682_2940# el 0.02486f
C363 vbp_syn m1_3704_1572# 0.04136f
C364 rsel vbn_ref 0
C365 vbp_syn a_480_5620# 0
C366 rsel hold 0.34747f
C367 stb a_3184_3624# 0
C368 m1_2260_960# m1_2424_756# 0.01455f
C369 m1_2424_756# a_2578_2940# 0
C370 m1_2260_960# el 0
C371 el a_2578_2940# 0.22663f
C372 vbp_syn a_3844_4734# 0.11205f
C373 vbn_ref abus 0.09248f
C374 mreset a_2510_1740# 0.05003f
C375 abus hold 0
C376 m1_2260_4540# m1_1545_4540# 0.01391f
C377 m1_2260_4540# a_2510_1740# 0.00255f
C378 sub_b stb 0.1209f
C379 vm m1_644_2312# 0.24751f
C380 m1_2436_6996# t0 0.187f
C381 t2 m1_796_6120# 0.00336f
C382 a_338_2940# spk 0.28037f
C383 m1_3652_6232# sta 0.0671f
C384 stb spk 0.02657f
C385 mreset aux 0.13148f
C386 mreset vdd 0.10833f
C387 a_2510_1740# m1_2424_756# 0.20463f
C388 a_2510_1740# el 0.34103f
C389 m1_2260_4540# vdd 0.51842f
C390 m1_2260_4540# a_480_5620# 0.06854f
C391 stb hold 0.01097f
C392 m1_208_6996# t2 0.05179f
C393 en vbn_leak 0.03721f
C394 t0 vbp_st 0
C395 m1_2424_756# m1_3348_960# 0.14487f
C396 m1_4904_6422# sta 0
C397 el m1_3348_960# 0.03642f
C398 aux m1_2424_756# 0.03279f
C399 m1_2436_6996# m1_3212_6232# 0.002f
C400 vdd m1_2424_756# 0.21166f
C401 aux el 1.79485f
C402 m1_208_7600# vbn_leak 0
C403 m1_2260_4540# a_3844_4734# 0
C404 vdd el 2.04122f
C405 m1_3704_1572# m1_2424_756# 0.02956f
C406 m1_4904_6422# vbn_prb 0.1006f
C407 m1_4802_1762# vreset 0.00845f
C408 a_480_5620# el 0.19264f
C409 a_2160_3542# m1_1692_4664# 0.0051f
C410 m1_1557_7120# m1_1401_6720# 0.0089f
C411 rsel sub 0.41869f
C412 m1_644_2312# vreset 0
C413 sub_b m1_4052_1572# 0.01339f
C414 vbp_syn vbn_leak 0.14859f
C415 el a_3844_4734# 0.00104f
C416 m1_644_2312# a_2804_3624# 0
C417 en vsrc 0.03704f
C418 rsel vbn_prb 0
C419 abus sub 0.04017f
C420 t0 sub_b 0
C421 m1_3212_6232# vbp_st 0.00157f
C422 m1_208_7600# vsrc 0
C423 vbp_syn a_2160_3542# 0
C424 m1_3212_6232# a_3184_3624# 0
C425 m1_1973_6232# t1 0.07271f
C426 abus vbn_prb 0.35223f
C427 m1_1973_6232# a_1682_2940# 0
C428 t0 spk 0
C429 m1_1557_7120# m1_208_7600# 0.00966f
C430 m1_2972_1572# rsel 0.0346f
C431 vm t1 0.06005f
C432 vm a_1682_2940# 0.41408f
C433 vbp_syn vsrc 0.18021f
C434 t0 hold 0.00647f
C435 vm m1_2260_960# 0.13494f
C436 m1_2972_1572# abus 0.01195f
C437 vm a_2578_2940# 0.09896f
C438 m1_2436_6996# m1_1401_6720# 0
C439 stb sub 0.01482f
C440 mreset vbn_leak 0.02934f
C441 m1_3212_6232# sub_b 0.10497f
C442 stb sta 0.00742f
C443 m1_4904_6422# m1_3652_6232# -0.01073f
C444 m1_3212_6232# spk 0.10847f
C445 m1_208_6996# stb 0.03449f
C446 t0 t3 0
C447 m1_2260_4540# a_2160_3542# 0.16455f
C448 m1_2424_756# vbn_leak 0.04259f
C449 m1_3212_6232# hold 0
C450 vm a_2510_1740# 0.23084f
C451 vm m1_1545_4540# 0.03028f
C452 m1_1401_6720# vbp_st 0
C453 mreset vsrc 0.01114f
C454 m1_2436_6996# m1_208_7600# -0.00271f
C455 m1_2260_4540# vsrc 0
C456 a_1682_2940# a_2804_3624# 0.0023f
C457 a_2160_3542# el 0
C458 m1_1973_6232# vdd 0.07111f
C459 m1_1973_6232# aux 0.06458f
C460 m1_2260_960# vreset 0.18148f
C461 vreset a_2578_2940# 0
C462 m1_2436_6996# vbp_syn 0
C463 vm m1_3348_960# 0.2229f
C464 vm vdd 2.26238f
C465 vm aux 0.01801f
C466 m1_1973_6232# a_480_5620# 0.1051f
C467 vbp_st m1_1692_4664# 0.46088f
C468 vm m1_3704_1572# 0
C469 m1_2260_960# a_2804_3624# 0
C470 en vbp_st 0.03906f
C471 m1_2424_756# vsrc 0.03711f
C472 a_2804_3624# a_2578_2940# 0
C473 el vsrc 0.06761f
C474 vm a_480_5620# 1.16981f
C475 a_3184_3624# m1_1692_4664# 0.00327f
C476 m1_208_7600# vbp_st 0
C477 t0 sub 0.06097f
C478 t0 sta 0
C479 vm a_3844_4734# 0.00745f
C480 en m1_4822_412# 0.08351f
C481 a_2510_1740# vreset 0.09771f
C482 vbp_syn vbp_st 0.20604f
C483 t0 m1_208_6996# 0.07017f
C484 rsel abus 0.00147f
C485 vbp_syn a_3184_3624# 0
C486 a_2804_3624# a_2510_1740# 0
C487 a_2804_3624# m1_1545_4540# 0.20376f
C488 sub_b m1_1692_4664# 0
C489 sub_b en 0.01373f
C490 m1_1401_6720# hold 0.00249f
C491 m1_208_7600# m1_1104_8052# 0.00645f
C492 m1_644_2312# m1_4802_1762# 0
C493 m1_2105_7600# t1 0
C494 spk m1_1692_4664# 0.01628f
C495 m1_208_7600# sub_b 0.00319f
C496 vreset m1_3348_960# 0.04745f
C497 en spk 0
C498 aux vreset 0.03462f
C499 vdd vreset 0.37986f
C500 m1_3212_6232# sta 0.32895f
C501 m1_208_7600# spk 0.00484f
C502 a_2804_3624# vdd 0.27486f
C503 m1_1401_6720# t3 0
C504 en vbn_ref 1.7775f
C505 hold m1_1692_4664# 0.07608f
C506 vbp_syn sub_b 0.09408f
C507 en hold 0.01354f
C508 m1_208_6996# m1_3212_6232# 0.00246f
C509 a_2804_3624# a_480_5620# 0.00624f
C510 rsel stb 0.12542f
C511 vreset a_3844_4734# 0
C512 m1_208_7600# hold 0.0057f
C513 vbp_syn spk 0.09009f
C514 mreset vbp_st 0
C515 a_2804_3624# a_3844_4734# 0.18981f
C516 m1_2260_4540# vbp_st 0.26668f
C517 vbp_syn vbn_ref 0.00577f
C518 vbp_syn hold 0.65804f
C519 m1_2260_4540# a_3184_3624# 0.02374f
C520 vm vbn_leak 0
C521 t0 m1_3652_6232# 0
C522 m1_208_7600# t3 0.18955f
C523 a_2510_1740# m1_2105_7600# 0
C524 m1_2424_756# vbp_st 0.03031f
C525 vbp_st el 0.04453f
C526 vm a_2160_3542# 0.16962f
C527 m1_1401_6720# m1_796_6120# 0
C528 el a_3184_3624# 0
C529 m1_2260_4540# sub_b 0.04999f
C530 aux m1_2105_7600# 0.41055f
C531 vdd m1_2105_7600# 0
C532 el m1_4822_412# 0
C533 vm vsrc 0.12664f
C534 a_480_5620# m1_2105_7600# 0
C535 rsel m1_4052_1572# 0
C536 m1_1557_7120# m1_1973_6232# 0.06718f
C537 m1_2260_4540# spk 0.21361f
C538 m1_1401_6720# m1_208_6996# 0.07759f
C539 m1_3212_6232# m1_3652_6232# 0.04772f
C540 m1_644_2312# a_1682_2940# 0.2917f
C541 vm m1_1557_7120# 0.00215f
C542 mreset vbn_ref 0
C543 sub_b m1_2424_756# 0.00906f
C544 sub_b el 0.10714f
C545 mreset hold 0
C546 sub m1_1692_4664# 0.06319f
C547 en sub 0.04402f
C548 t0 rsel 0
C549 vreset vbn_leak 0.03458f
C550 m1_208_7600# m1_796_6120# 0.01948f
C551 m1_4052_1572# abus 0.00324f
C552 m1_2260_4540# hold 0.16126f
C553 en sta 0
C554 m1_644_2312# m1_2260_960# 0.03702f
C555 m1_644_2312# a_2578_2940# 0.4287f
C556 spk el 0.16218f
C557 en vbn_prb 0.06545f
C558 m1_4904_6422# m1_3212_6232# -0.01073f
C559 m1_2424_756# vbn_ref 0.03822f
C560 m1_208_7600# vbn_prb 0
C561 vbn_ref el 0
C562 el hold 0.0394f
C563 m1_208_7600# m1_208_6996# 0.31602f
C564 vbp_syn sub 0.05211f
C565 a_2804_3624# a_2160_3542# 0.02975f
C566 a_2510_1740# m1_4802_1762# 0
C567 vbp_syn sta 0.02674f
C568 vreset vsrc 0.0346f
C569 m1_2972_1572# en 0.01609f
C570 m1_3212_6232# rsel 0
C571 vbp_syn vbn_prb 0.03049f
C572 m1_644_2312# a_2510_1740# 0.17672f
C573 m1_2436_6996# m1_1973_6232# 0.00433f
C574 vbp_syn m1_208_6996# 0
C575 a_2804_3624# vsrc 0.07256f
C576 vm m1_2436_6996# 0.13145f
C577 t0 stb 0.00249f
C578 m1_4802_1762# aux 0
C579 m1_1401_6720# t2 0.10633f
C580 m1_644_2312# m1_3348_960# 0
C581 m1_644_2312# aux 0.07419f
C582 m1_644_2312# vdd 0.0239f
C583 m1_644_2312# a_480_5620# 0.13781f
C584 a_1682_2940# t1 0
C585 mreset sta 0.01507f
C586 m1_2260_4540# sub 0.16212f
C587 vm vbp_st 0.12925f
C588 m1_644_2312# a_3844_4734# 0.00926f
C589 mreset vbn_prb 0
C590 vm a_3184_3624# 0.00142f
C591 m1_3212_6232# stb 0.18567f
C592 mreset m1_208_6996# 0.00115f
C593 a_1682_2940# a_2578_2940# 0.0512f
C594 m1_208_7600# t2 0.0595f
C595 m1_2424_756# sub 0
C596 el sub 0.03583f
C597 vm m1_4822_412# 0
C598 el sta 0
C599 vbp_syn m1_3652_6232# 0.10654f
C600 m1_2260_960# a_2578_2940# 0.05203f
C601 m1_2424_756# vbn_prb 0.10984f
C602 el vbn_prb 0
C603 m1_1557_7120# m1_2105_7600# 0.07884f
C604 vm sub_b 0.06978f
C605 m1_208_6996# el 0
C606 m1_1973_6232# spk 0
C607 a_1682_2940# m1_1545_4540# 0.17434f
C608 rsel m1_1692_4664# 0.00536f
C609 rsel en 0.06091f
C610 vm spk 7.89141f
C611 vreset vbp_st 0.03544f
C612 m1_2972_1572# m1_2424_756# 0.00134f
C613 vbp_syn m1_4904_6422# -0.07963f
C614 m1_2260_960# a_2510_1740# 0.14485f
C615 vm vbn_ref 0
C616 a_2510_1740# a_2578_2940# 0.02619f
C617 a_2804_3624# vbp_st 0.00359f
C618 m1_1545_4540# a_2578_2940# 0
C619 en abus 0.2665f
C620 vm hold 0.31488f
C621 vdd t1 0.11574f
C622 aux t1 0.17958f
C623 a_1682_2940# vdd 0.72944f
C624 a_1682_2940# aux 0
C625 a_2804_3624# a_3184_3624# 0.2629f
C626 vbp_syn rsel 0.03843f
C627 mreset m1_3652_6232# 0.02141f
C628 m1_1401_6720# stb 0
C629 vreset m1_4822_412# 0.02001f
C630 a_480_5620# t1 0.16686f
C631 m1_644_2312# vbn_leak 0
C632 a_1682_2940# a_480_5620# 0.40965f
C633 m1_1973_6232# t3 0
C634 t0 m1_3212_6232# 0
C635 m1_2260_960# m1_3348_960# 0
C636 m1_2260_960# aux 0
C637 m1_2260_960# vdd 0
C638 aux a_2578_2940# 0.02019f
C639 vdd a_2578_2940# 0.00199f
C640 vm t3 0.04824f
C641 m1_2260_960# m1_3704_1572# 0
C642 a_1682_2940# a_3844_4734# 0.00737f
C643 sub_b vreset 0
C644 vbp_syn abus 0.06436f
C645 m1_2436_6996# m1_2105_7600# 0.00869f
C646 a_480_5620# a_2578_2940# 0.39121f
C647 m1_644_2312# a_2160_3542# 0
C648 a_2804_3624# sub_b 0.00123f
C649 m1_4802_1762# vsrc 0
C650 el m1_3652_6232# 0.02275f
C651 m1_2260_960# a_3844_4734# 0.00193f
C652 a_3844_4734# a_2578_2940# 0.03162f
C653 a_2804_3624# spk 0.00565f
C654 m1_208_7600# stb 0.03249f
C655 m1_644_2312# vsrc 0.01829f
C656 vreset vbn_ref 0.04932f
C657 vreset hold 0.00188f
C658 a_2510_1740# m1_3348_960# 0.02182f
C659 a_2510_1740# aux 0.34031f
C660 a_2510_1740# vdd 1.63645f
C661 vdd m1_1545_4540# 0.31514f
C662 a_2510_1740# m1_3704_1572# 0
C663 a_2804_3624# hold 0.10403f
C664 a_2510_1740# a_480_5620# 0.00179f
C665 vbp_syn stb 0.00619f
C666 m1_1973_6232# m1_796_6120# 0
C667 a_480_5620# m1_1545_4540# 0.06066f
C668 m1_2260_4540# rsel 0.07376f
C669 vm m1_796_6120# 0.08148f
C670 m1_1973_6232# sub 0.00349f
C671 mreset abus 0
C672 m1_1545_4540# a_3844_4734# 0.00997f
C673 aux m1_3348_960# 0.03296f
C674 vdd m1_3348_960# 0.41284f
C675 a_2510_1740# a_3844_4734# 0.20873f
C676 vm sub 0.04966f
C677 aux vdd 0.48021f
C678 t0 m1_1401_6720# 0
C679 m1_3704_1572# m1_3348_960# 0.00111f
C680 m1_3704_1572# aux 0
C681 m1_3704_1572# vdd 0.03511f
C682 vm sta 0.04872f
C683 rsel m1_2424_756# 0.00696f
C684 rsel el 0.04467f
C685 a_480_5620# vdd 2.28428f
C686 m1_1973_6232# m1_208_6996# 0.1096f
C687 a_480_5620# aux 0.01903f
C688 vm vbn_prb 0.00158f
C689 vm m1_208_6996# 0.01147f
C690 en m1_4052_1572# 0.00567f
C691 aux a_3844_4734# 0.01149f
C692 m1_2424_756# abus 0.10221f
C693 vdd a_3844_4734# 0.59267f
C694 el abus 0.03784f
C695 t0 m1_1692_4664# 0
C696 a_480_5620# a_3844_4734# 0.00579f
C697 m1_2260_960# vbn_leak 0
C698 mreset stb 0.0015f
C699 vm m1_2972_1572# 0.00716f
C700 a_1682_2940# a_2160_3542# 0.20541f
C701 t0 m1_208_7600# 0.07125f
C702 m1_2260_4540# stb 0
C703 m1_2105_7600# hold 0
C704 vreset sub 0
C705 m1_2260_960# a_2160_3542# 0
C706 a_1682_2940# vsrc 0.14205f
C707 a_2160_3542# a_2578_2940# 0.00405f
C708 t0 vbp_syn 0
C709 vreset sta 0
C710 m1_4802_1762# vbp_st 0.00495f
C711 a_338_2940# el 0.07883f
C712 a_2804_3624# sub 0.18452f
C713 stb el 0
C714 m1_1557_7120# t1 0.2089f
C715 vreset vbn_prb 0.04313f
C716 m1_644_2312# vbp_st 0
C717 m1_2260_960# vsrc 0
C718 vsrc a_2578_2940# 0.13779f
C719 a_2510_1740# vbn_leak 0.26348f
C720 m1_208_7600# m1_3212_6232# 0.0038f
C721 m1_644_2312# a_3184_3624# 0
C722 vm m1_3652_6232# 0.00843f
C723 m1_1973_6232# t2 0
C724 a_2510_1740# a_2160_3542# 0
C725 m1_2972_1572# vreset 0
C726 a_2160_3542# m1_1545_4540# 0.11196f
C727 vm t2 0.06186f
C728 vbn_leak m1_3348_960# 0.03047f
C729 aux vbn_leak 1.65264f
C730 vbp_syn m1_3212_6232# 0.1263f
C731 vdd vbn_leak 0.1122f
C732 m1_4802_1762# sub_b 0
C733 m1_1545_4540# vsrc 0.00157f
C734 m1_644_2312# sub_b 0.07618f
C735 a_2510_1740# vsrc 0.39434f
C736 t0 mreset 0
C737 vdd a_2160_3542# 0.29248f
C738 m1_2260_4540# t0 0
C739 m1_644_2312# spk 0.0792f
C740 a_3844_4734# vbn_leak 0
C741 m1_2424_756# m1_4052_1572# 0.01864f
C742 m1_2436_6996# t1 0
C743 m1_4052_1572# el 0.04092f
C744 m1_4802_1762# vbn_ref 0.07567f
C745 a_480_5620# a_2160_3542# 0.29014f
C746 m1_2105_7600# sub 0
C747 m1_3348_960# vsrc 0.03115f
C748 aux vsrc 0.13514f
C749 vdd vsrc 0.22685f
C750 m1_644_2312# vbn_ref 0
C751 vm rsel 0.07803f
C752 a_2160_3542# a_3844_4734# 0.14668f
C753 t0 el 0
C754 a_480_5620# vsrc 0.13021f
C755 m1_1557_7120# aux 0.18642f
C756 m1_1557_7120# vdd 0
C757 m1_208_6996# m1_2105_7600# 0.05245f
C758 m1_1401_6720# m1_208_7600# 0.00134f
C759 mreset m1_3212_6232# 0.03263f
C760 vm abus 0.03247f
C761 m1_1557_7120# a_480_5620# 0
C762 a_3844_4734# vsrc 0.28359f
C763 vbp_st t1 0
C764 a_1682_2940# vbp_st 0.2412f
C765 a_1682_2940# a_3184_3624# 0
C766 m1_3212_6232# el 0.02332f
C767 m1_1973_6232# stb 0
C768 vm a_338_2940# 0.04589f
C769 m1_1104_8052# t1 0.00165f
C770 vbn_leak vss 0.55016f
C771 m1_3348_960# vss 0.80751f
C772 m1_1104_8052# vss -0.00196f
C773 m1_2260_960# vss 0.39421f
C774 en vss 1.13846f
C775 abus vss 2.48947f
C776 sub vss 0.49774f
C777 mreset vss 0.64739f
C778 hold vss 0.97734f
C779 vdd vss 17.00155f
C780 m1_1557_7120# vss 0.13244f
C781 m1_2105_7600# vss 0.12741f
C782 m1_4822_412# vss 0.13826f
C783 m1_796_6120# vss -0.04573f
C784 t3 vss 0.40039f
C785 vbn_prb vss 0.70582f
C786 a_3184_3624# vss 0.18684f
C787 m1_1401_6720# vss 0.03849f
C788 t2 vss 0.30522f
C789 a_2804_3624# vss 0.11006f
C790 m1_1973_6232# vss 0.00346f
C791 t1 vss 0.30178f
C792 m1_208_7600# vss 2.71583f
C793 m1_208_6996# vss 1.22331f
C794 spk vss 0.80109f
C795 m1_2436_6996# vss 0.13276f
C796 t0 vss 0.27403f
C797 m1_2972_1572# vss -0.0561f
C798 rsel vss 0.74365f
C799 m1_2260_4540# vss -0.0748f
C800 vm vss 3.84719f
C801 m1_3704_1572# vss -0.0536f
C802 m1_644_2312# vss 0.4485f
C803 a_338_2940# vss -0.21724f
C804 sub_b vss 1.03926f
C805 m1_1545_4540# vss 0.07284f
C806 vbp_st vss 0.32309f
C807 m1_3212_6232# vss 0.09985f
C808 stb vss 0.91039f
C809 sta vss 0.24375f
C810 m1_2424_756# vss 0.63391f
C811 a_2160_3542# vss 0.33226f
C812 vsrc vss 1.00451f
C813 vreset vss 0.64484f
C814 a_2510_1740# vss 2.38369f
C815 m1_4802_1762# vss -0.01232f
C816 m1_1692_4664# vss -0.08775f
C817 vbn_ref vss 0.70591f
C818 a_2578_2940# vss 0.08247f
C819 a_1682_2940# vss 0.86564f
C820 a_3844_4734# vss 0.72818f
C821 m1_4904_6422# vss -0.2014f
C822 m1_3652_6232# vss -0.06338f
C823 vbp_syn vss 0.34781f
C824 a_480_5620# vss -0.02907f
C825 el vss 0.39202f
C826 aux vss 3.91719f
C827 m1_4052_1572# vss -0.0427f
.ends
