* NGSPICE file created from slot_ah_p.ext - technology: gf180mcuD

.subckt p_w2_l4 a_400_n200# a_n400_n244# w_n574_n330# a_n488_n200# VSUBS
X0 a_400_n200# a_n400_n244# a_n488_n200# w_n574_n330# pfet_03v3 ad=0.88p pd=4.88u as=0.88p ps=4.88u w=2u l=4u
C0 a_400_n200# a_n488_n200# 0.01073f
C1 a_400_n200# a_n400_n244# 0.07019f
C2 a_400_n200# w_n574_n330# 0.07409f
C3 a_n488_n200# a_n400_n244# 0.07019f
C4 a_n488_n200# w_n574_n330# 0.07409f
C5 a_n400_n244# w_n574_n330# 0.42229f
C6 a_400_n200# VSUBS 0.18936f
C7 a_n488_n200# VSUBS 0.18936f
C8 w_n574_n330# VSUBS 2.27304f
.ends

.subckt p_w0p22_l1 a_100_n22# a_n100_n66# w_n278_n159# a_n192_n36# VSUBS
X0 a_100_n22# a_n100_n66# a_n192_n36# w_n278_n159# pfet_03v3 ad=0.1516p pd=1.64u as=0.1516p ps=1.64u w=0.22u l=1u
C0 a_100_n22# a_n100_n66# 0.00509f
C1 a_100_n22# a_n192_n36# 0.00453f
C2 a_100_n22# w_n278_n159# 0.00771f
C3 a_n100_n66# a_n192_n36# 0.00509f
C4 a_n100_n66# w_n278_n159# 0.13163f
C5 a_n192_n36# w_n278_n159# 0.00771f
C6 a_100_n22# VSUBS 0.05952f
C7 a_n192_n36# VSUBS 0.05952f
C8 w_n278_n159# VSUBS 0.53042f
.ends

.subckt n_w1_l0p28 a_28_n100# a_n28_n144# a_n116_n100# VSUBS
X0 a_28_n100# a_n28_n144# a_n116_n100# VSUBS nfet_03v3 ad=0.44p pd=2.88u as=0.44p ps=2.88u w=1u l=0.28u
C0 a_28_n100# a_n116_n100# 0.04256f
C1 a_28_n100# a_n28_n144# 0.00769f
C2 a_n116_n100# a_n28_n144# 0.00769f
C3 a_28_n100# VSUBS 0.09911f
C4 a_n116_n100# VSUBS 0.09911f
.ends

.subckt n_w2_l2 a_n288_n200# a_200_n200# a_n200_n244# VSUBS
X0 a_200_n200# a_n200_n244# a_n288_n200# VSUBS nfet_03v3 ad=0.88p pd=4.88u as=0.88p ps=4.88u w=2u l=2u
C0 a_200_n200# a_n288_n200# 0.02133f
C1 a_200_n200# a_n200_n244# 0.0587f
C2 a_n288_n200# a_n200_n244# 0.0587f
C3 a_200_n200# VSUBS 0.2667f
C4 a_n288_n200# VSUBS 0.2667f
.ends

.subckt n_w2_l4 a_400_n200# a_n400_n244# a_n488_n200# VSUBS
X0 a_400_n200# a_n400_n244# a_n488_n200# VSUBS nfet_03v3 ad=0.88p pd=4.88u as=0.88p ps=4.88u w=2u l=4u
C0 a_400_n200# a_n488_n200# 0.01073f
C1 a_400_n200# a_n400_n244# 0.07019f
C2 a_n488_n200# a_n400_n244# 0.07019f
C3 a_400_n200# VSUBS 0.41684f
C4 a_n488_n200# VSUBS 0.41684f
.ends

.subckt n_w4_l1 a_n188_n400# a_100_n400# a_n100_n444# VSUBS
X0 a_100_n400# a_n100_n444# a_n188_n400# VSUBS nfet_03v3 ad=1.76p pd=8.88u as=1.76p ps=8.88u w=4u l=1u
C0 a_100_n400# a_n188_n400# 0.07756f
C1 a_100_n400# a_n100_n444# 0.08505f
C2 a_n188_n400# a_n100_n444# 0.08505f
C3 a_100_n400# VSUBS 0.26859f
C4 a_n188_n400# VSUBS 0.26859f
.ends

.subckt n_w0p5_l0p28 a_n28_n94# a_n116_n50# a_28_n50# VSUBS
X0 a_28_n50# a_n28_n94# a_n116_n50# VSUBS nfet_03v3 ad=0.22p pd=1.88u as=0.22p ps=1.88u w=0.5u l=0.28u
C0 a_28_n50# a_n116_n50# 0.02085f
C1 a_28_n50# a_n28_n94# 0.00377f
C2 a_n116_n50# a_n28_n94# 0.00377f
C3 a_28_n50# VSUBS 0.07987f
C4 a_n116_n50# VSUBS 0.07987f
.ends

.subckt p_w1_l0p5 a_n138_n100# a_50_n100# a_n50_n144# w_n224_n230# VSUBS
X0 a_50_n100# a_n50_n144# a_n138_n100# w_n224_n230# pfet_03v3 ad=0.44p pd=2.88u as=0.44p ps=2.88u w=1u l=0.5u
C0 a_50_n100# a_n138_n100# 0.03085f
C1 a_50_n100# a_n50_n144# 0.01275f
C2 a_50_n100# w_n224_n230# 0.0205f
C3 a_n138_n100# a_n50_n144# 0.01275f
C4 a_n138_n100# w_n224_n230# 0.0205f
C5 a_n50_n144# w_n224_n230# 0.07993f
C6 a_50_n100# VSUBS 0.06546f
C7 a_n138_n100# VSUBS 0.06546f
C8 w_n224_n230# VSUBS 0.61824f
.ends

.subckt n_w1_l0p5 a_n138_n100# a_50_n100# a_n50_n144# VSUBS
X0 a_50_n100# a_n50_n144# a_n138_n100# VSUBS nfet_03v3 ad=0.44p pd=2.88u as=0.44p ps=2.88u w=1u l=0.5u
C0 a_50_n100# a_n138_n100# 0.03085f
C1 a_50_n100# a_n50_n144# 0.01275f
C2 a_n138_n100# a_n50_n144# 0.01275f
C3 a_50_n100# VSUBS 0.11563f
C4 a_n138_n100# VSUBS 0.11563f
.ends

.subckt p_w1_l0p28 w_n202_n230# a_28_n100# a_n28_n144# a_n116_n100# VSUBS
X0 a_28_n100# a_n28_n144# a_n116_n100# w_n202_n230# pfet_03v3 ad=0.44p pd=2.88u as=0.44p ps=2.88u w=1u l=0.28u
C0 a_28_n100# a_n116_n100# 0.04256f
C1 a_28_n100# a_n28_n144# 0.00769f
C2 a_28_n100# w_n202_n230# 0.01808f
C3 a_n116_n100# a_n28_n144# 0.00769f
C4 a_n116_n100# w_n202_n230# 0.01808f
C5 a_n28_n144# w_n202_n230# 0.05841f
C6 a_28_n100# VSUBS 0.0597f
C7 a_n116_n100# VSUBS 0.0597f
C8 w_n202_n230# VSUBS 0.55752f
.ends

.subckt n_w4_l2 a_n288_n400# a_200_n400# a_n200_n444# VSUBS
X0 a_200_n400# a_n200_n444# a_n288_n400# VSUBS nfet_03v3 ad=1.76p pd=8.88u as=1.76p ps=8.88u w=4u l=2u
C0 a_200_n400# a_n288_n400# 0.04287f
C1 a_200_n400# a_n200_n444# 0.11799f
C2 a_n288_n400# a_n200_n444# 0.11799f
C3 a_200_n400# VSUBS 0.34365f
C4 a_n288_n400# VSUBS 0.34365f
.ends

.subckt p_w1_l2 w_n374_n230# a_n288_n100# a_200_n100# a_n200_n144# VSUBS
X0 a_200_n100# a_n200_n144# a_n288_n100# w_n374_n230# pfet_03v3 ad=0.44p pd=2.88u as=0.44p ps=2.88u w=1u l=2u
C0 a_200_n100# a_n288_n100# 0.01056f
C1 a_200_n100# a_n200_n144# 0.02905f
C2 a_200_n100# w_n374_n230# 0.03135f
C3 a_n288_n100# a_n200_n144# 0.02905f
C4 a_n288_n100# w_n374_n230# 0.03135f
C5 a_n200_n144# w_n374_n230# 0.22666f
C6 a_200_n100# VSUBS 0.1047f
C7 a_n288_n100# VSUBS 0.1047f
C8 w_n374_n230# VSUBS 1.03224f
.ends

.subckt n_w7p07_l7p07 a_707_n707# a_n795_n707# a_n707_n751# VSUBS
X0 a_707_n707# a_n707_n751# a_n795_n707# VSUBS nfet_03v3 ad=3.1108p pd=15.02u as=3.1108p ps=15.02u w=7.07u l=7.07u
C0 a_707_n707# a_n795_n707# 0.0212f
C1 a_707_n707# a_n707_n751# 0.27012f
C2 a_n795_n707# a_n707_n751# 0.27012f
C3 a_707_n707# VSUBS 0.84237f
C4 a_n795_n707# VSUBS 0.84237f
.ends

.subckt n_w0p5_l1p5 a_150_n50# a_n238_n50# a_n150_n94# VSUBS
X0 a_150_n50# a_n150_n94# a_n238_n50# VSUBS nfet_03v3 ad=0.22p pd=1.88u as=0.22p ps=1.88u w=0.5u l=1.5u
C0 a_150_n50# a_n238_n50# 0.00671f
C1 a_150_n50# a_n150_n94# 0.01269f
C2 a_n238_n50# a_n150_n94# 0.01269f
C3 a_150_n50# VSUBS 0.17146f
C4 a_n238_n50# VSUBS 0.17146f
.ends

.subckt n_w3p54_l3p54 a_354_n354# a_n354_n398# a_n442_n354# VSUBS
X0 a_354_n354# a_n354_n398# a_n442_n354# VSUBS nfet_03v3 ad=1.5576p pd=7.96u as=1.5576p ps=7.96u w=3.54u l=3.54u
C0 a_354_n354# a_n442_n354# 0.02161f
C1 a_354_n354# a_n354_n398# 0.12189f
C2 a_n442_n354# a_n354_n398# 0.12189f
C3 a_354_n354# VSUBS 0.44156f
C4 a_n442_n354# VSUBS 0.44156f
.ends

.subckt n_w0p22_l2 a_200_n22# a_n200_n66# a_n292_n36# VSUBS
X0 a_200_n22# a_n200_n66# a_n292_n36# VSUBS nfet_03v3 ad=0.1516p pd=1.64u as=0.1516p ps=1.64u w=0.22u l=2u
C0 a_200_n22# a_n200_n66# 0.00705f
C1 a_200_n22# a_n292_n36# 0.00245f
C2 a_n200_n66# a_n292_n36# 0.00705f
C3 a_200_n22# VSUBS 0.20767f
C4 a_n292_n36# VSUBS 0.20767f
.ends

.subckt n_w0p5_l3 a_n388_n50# a_300_n50# a_n300_n94# VSUBS
X0 a_300_n50# a_n300_n94# a_n388_n50# VSUBS nfet_03v3 ad=0.22p pd=1.88u as=0.22p ps=1.88u w=0.5u l=3u
C0 a_300_n50# a_n388_n50# 0.00348f
C1 a_300_n50# a_n300_n94# 0.01602f
C2 a_n388_n50# a_n300_n94# 0.01602f
C3 a_300_n50# VSUBS 0.28406f
C4 a_n388_n50# VSUBS 0.28406f
.ends

.subckt n_w0p5_l4 a_n488_n50# a_400_n50# a_n400_n94# VSUBS
X0 a_400_n50# a_n400_n94# a_n488_n50# VSUBS nfet_03v3 ad=0.22p pd=1.88u as=0.22p ps=1.88u w=0.5u l=4u
C0 a_400_n50# a_n488_n50# 0.0026f
C1 a_400_n50# a_n400_n94# 0.01702f
C2 a_n488_n50# a_n400_n94# 0.01702f
C3 a_400_n50# VSUBS 0.35913f
C4 a_n488_n50# VSUBS 0.35913f
.ends

.subckt slot_ah_p vss vbp_syn vdd el aux vbn_leak vsrc vbp_st vbn_prb vbn_ref en vreset
+ abus spk t3 t2 t1 t0 sta stb hold mreset rsel sub sub_b vm
XXL_XP1 a_480_5620# a_480_5620# vdd vdd vss p_w2_l4
XXD_XK a_3184_3624# spk vdd vdd vss p_w0p22_l1
XXPM_XSW m1_4052_1572# rsel m1_3704_1572# vss n_w1_l0p28
XXL_XP2 a_1632_2940# a_480_5620# vdd vdd vss p_w2_l4
XXPR_XMB vss m1_4802_1762# vbn_prb vss n_w2_l2
XXL_XMT m1_644_2312# aux vss vss n_w2_l4
XXL_XM1 a_288_2940# a_480_5620# el vss n_w4_l1
XXS_XWA m1_4904_6422# vbp_syn vdd m1_3652_6232# vss p_w2_l4
XXR_Xi_XN spk vss a_3844_4734# vss n_w0p5_l0p28
XXL_XM2 a_2528_2940# a_1632_2940# a_1632_2940# vss n_w4_l1
XXS_XWB m1_4904_6422# vbp_syn vdd m1_3212_6232# vss p_w2_l4
XXR_XNR vss vbn_ref a_2510_1740# vss n_w2_l4
XXD_XPI m1_1692_4664# a_2160_3542# vm vdd vss p_w1_l0p5
XXPR_XME m1_2424_756# en m1_4802_1762# vss n_w1_l0p28
XXR_XSW vreset vm a_2510_1740# vss n_w1_l0p5
XXR_Xi_XP vdd a_3844_4734# spk vdd vss p_w1_l0p28
XXD_XNI vsrc a_2160_3542# vm vss n_w1_l0p5
XXPR_XMF m1_2424_756# vdd a_2510_1740# vss n_w4_l2
XXS_XQA vdd m1_3652_6232# sta vss vss p_w1_l0p28
XXS_XQB vdd m1_3212_6232# stb vss vss p_w1_l0p28
XXS_XNA sta vm m1_3652_6232# vss n_w0p5_l0p28
XXS_XNB stb vm m1_3212_6232# vss n_w0p5_l0p28
XXD_XS2 vdd vdd m1_2260_4540# vbp_st vss p_w1_l2
XXD_XPS vdd vdd m1_1692_4664# vbp_st vss p_w1_l2
XXD_XS3 vdd vdd m1_1545_4540# vbp_st vss p_w1_l2
XXL_XD2a m1_644_2312# a_2528_2940# a_2528_2940# vss n_w4_l1
XXPM_XSB abus sub_b m1_4052_1572# vss n_w1_l0p28
XXL_XD2b m1_644_2312# a_2528_2940# a_2528_2940# vss n_w4_l1
XXL_XD1a m1_644_2312# a_288_2940# a_288_2940# vss n_w4_l1
XXPM_XSC m1_3704_1572# en m1_3348_960# vss n_w1_l0p28
XXC_XC vss vss vm vss n_w7p07_l7p07
XXS_XPH vdd m1_4904_6422# vdd hold vss p_w1_l2
XXT_XR1 m1_2105_7600# m1_1557_7120# aux vss n_w0p5_l1p5
XXD_XP2 vdd a_2804_3624# a_2160_3542# m1_2260_4540# vss p_w1_l0p28
XXL_XD1b m1_644_2312# a_288_2940# a_288_2940# vss n_w4_l1
XXPR_XSW m1_2972_1572# rsel m1_2260_960# vss n_w1_l0p28
XXT_XR2 m1_208_6996# m1_2105_7600# aux vss n_w0p5_l1p5
XXT_XP0 vdd m1_2436_6996# t0 vm vss p_w1_l0p28
XXD_Xi4_XN a_3184_3624# vss spk vss n_w0p5_l0p28
XXD_XP3 vdd a_3184_3624# a_2804_3624# m1_1545_4540# vss p_w1_l0p28
XXT_XR3 m1_208_7600# m1_208_6996# aux vss n_w0p5_l1p5
XXT_XP1 vdd m1_1973_6232# t1 vm vss p_w1_l0p28
XXR_XCR_XC vss a_2510_1740# vss vss n_w3p54_l3p54
XXD_XN2 a_2804_3624# a_2160_3542# vsrc vss n_w0p22_l2
XXT_XN0 t0 a_480_5620# m1_2436_6996# vss n_w0p5_l0p28
XXT_XP2 vdd m1_1401_6720# t2 vm vss p_w1_l0p28
XXD_Xi4_XP vdd spk a_3184_3624# vdd vss p_w1_l0p28
XXD_XN3 a_2804_3624# vsrc a_3184_3624# vss n_w0p5_l0p28
XXPM_XMB vss m1_4822_412# vbn_prb vss n_w2_l2
XXT_XN1 t1 a_480_5620# m1_1973_6232# vss n_w0p5_l0p28
XXT_XP3 vdd m1_796_6120# t3 vm vss p_w1_l0p28
XXT_XL0 m1_2436_6996# m1_208_7600# aux vss n_w0p5_l3
XXT_XN2 t2 a_480_5620# m1_1401_6720# vss n_w0p5_l0p28
XXT_XLT m1_208_7600# vdd aux vss n_w0p5_l3
XXT_XL1 m1_1973_6232# m1_208_6996# aux vss n_w0p5_l3
XXT_XN3 t3 a_480_5620# m1_796_6120# vss n_w0p5_l0p28
XXR_XPC vdd a_2510_1740# a_3844_4734# vdd vss p_w1_l0p28
XXPM_XME m1_3348_960# en m1_4822_412# vss n_w1_l0p28
XXT_XL2 m1_1401_6720# m1_2105_7600# aux vss n_w0p5_l3
XXT_XL3 m1_796_6120# m1_1557_7120# aux vss n_w0p5_l3
XXPM_XMF m1_3348_960# vdd vm vss n_w4_l2
XXS_XHL vdd vm hold a_1632_2940# vss p_w1_l0p28
XXS_XMR mreset a_2510_1740# vdd vss n_w0p5_l0p28
XXPR_XSB abus sub m1_2972_1572# vss n_w1_l0p28
XXPR_XSC m1_2424_756# en m1_2260_960# vss n_w1_l0p28
XXT_XRB m1_1104_8052# m1_1557_7120# aux vss n_w0p5_l4
XXT_XRA vss m1_1104_8052# aux vss n_w0p5_l4
C0 vm en 0.10525f
C1 el vbp_syn 0.13814f
C2 m1_644_2312# a_3844_4734# 0.00608f
C3 m1_644_2312# abus 0.00378f
C4 en spk 0
C5 mreset sta 0.01507f
C6 rsel a_2160_3542# 0
C7 t2 m1_1104_8052# 0.03596f
C8 m1_4052_1572# abus 0.00324f
C9 vm m1_1692_4664# 0.13124f
C10 t0 m1_208_7600# 0.07125f
C11 a_2528_2940# aux 0.02026f
C12 spk m1_1692_4664# 0.01628f
C13 sub m1_3348_960# 0.00209f
C14 vdd a_480_5620# 2.28428f
C15 vm m1_2260_4540# 0.00579f
C16 sub_b m1_2424_756# 0.00906f
C17 m1_644_2312# a_2804_3624# 0
C18 spk m1_2260_4540# 0.21361f
C19 sub_b sta 0
C20 el vreset 0.03423f
C21 vm m1_4822_412# 0
C22 m1_2436_6996# sub 0.13959f
C23 vbp_syn m1_3704_1572# 0.04136f
C24 a_1632_2940# rsel 0
C25 rsel hold 0.34747f
C26 vsrc vbp_st 1.68713f
C27 el vbn_ref 0
C28 vdd stb 0.13649f
C29 rsel a_2510_1740# 0.16878f
C30 abus mreset 0
C31 m1_644_2312# sub 0.03896f
C32 vdd m1_1973_6232# 0.07111f
C33 vdd vbp_syn 2.86159f
C34 vsrc m1_3348_960# 0.03115f
C35 m1_208_7600# m1_1104_8052# 0.00645f
C36 t0 vm 0.0619f
C37 sub_b a_3844_4734# 0.05377f
C38 el a_2528_2940# 0.23122f
C39 t0 spk 0
C40 sub_b abus 0.05253f
C41 vbn_prb m1_2424_756# 0.10984f
C42 en vbp_st 0.03906f
C43 vbn_prb sta 0
C44 m1_2105_7600# m1_208_6996# 0.05245f
C45 vdd m1_1557_7120# 0
C46 a_2510_1740# m1_4802_1762# 0
C47 vdd vreset 0.37986f
C48 m1_644_2312# vsrc 0.01167f
C49 a_2160_3542# a_480_5620# 0.29014f
C50 vbp_st m1_1692_4664# 0.46088f
C51 sub_b a_2804_3624# 0.00123f
C52 m1_3212_6232# stb 0.18567f
C53 el aux 1.79485f
C54 vdd vbn_ref 0.31335f
C55 m1_2260_960# rsel 0.06573f
C56 en m1_3348_960# 0.15848f
C57 vbp_st m1_2260_4540# 0.26668f
C58 vdd m1_4904_6422# -0.07079f
C59 vbp_st m1_4822_412# 0.0108f
C60 vbp_syn m1_3212_6232# 0.1263f
C61 sub_b sub 0.03832f
C62 a_480_5620# hold 0.86374f
C63 a_1632_2940# a_480_5620# 0.41552f
C64 vbn_prb a_3844_4734# 0
C65 vbn_prb abus 0.35223f
C66 t2 a_480_5620# 0.22653f
C67 vbp_syn a_2160_3542# 0
C68 vdd a_2528_2940# 0.0022f
C69 a_2510_1740# a_480_5620# 0.00179f
C70 aux m1_3704_1572# 0
C71 m1_644_2312# en 0.01835f
C72 m1_4822_412# m1_3348_960# 0.07018f
C73 vsrc mreset 0.01114f
C74 en m1_4052_1572# 0.00567f
C75 t1 m1_1692_4664# 0
C76 stb hold 0.01097f
C77 m1_208_6996# sta 0
C78 m1_1401_6720# a_480_5620# 0.28759f
C79 a_480_5620# m1_796_6120# 0.13805f
C80 vm rsel 0.07803f
C81 t0 vbp_st 0
C82 a_1632_2940# m1_1973_6232# 0
C83 spk rsel 0.34479f
C84 t2 m1_1973_6232# 0
C85 vdd aux 0.48021f
C86 vbp_syn hold 0.65804f
C87 sub_b vsrc 0.01409f
C88 m1_3212_6232# m1_4904_6422# -0.01073f
C89 m1_1401_6720# stb 0
C90 vbp_syn a_2510_1740# 0.32753f
C91 vbn_prb sub 0
C92 m1_1401_6720# m1_1973_6232# 0.00113f
C93 m1_1973_6232# m1_796_6120# 0
C94 m1_208_7600# a_480_5620# 0
C95 en mreset 0
C96 m1_2436_6996# t0 0.187f
C97 m1_1557_7120# hold 0
C98 vreset hold 0.00188f
C99 t2 m1_1557_7120# 0
C100 t0 t1 0.04632f
C101 a_2510_1740# vreset 0.09771f
C102 m1_208_7600# stb 0.03249f
C103 vbn_ref hold 0.04997f
C104 a_2528_2940# a_2160_3542# 0.00504f
C105 sub_b en 0.01373f
C106 m1_2260_4540# mreset 0
C107 a_2510_1740# vbn_ref 0.32474f
C108 m1_4904_6422# hold 0.69894f
C109 m1_1557_7120# m1_1401_6720# 0.0089f
C110 vdd el 2.04148f
C111 aux m1_3212_6232# 0.01135f
C112 vbn_prb vsrc 0.01206f
C113 m1_3652_6232# sta 0.0671f
C114 m1_1557_7120# m1_796_6120# -0.00167f
C115 stb vbn_leak 0
C116 m1_208_7600# vbp_syn 0.00151f
C117 a_2510_1740# m1_4904_6422# 0.36576f
C118 sub_b m1_1692_4664# 0
C119 m1_2260_960# vbp_syn 0
C120 sub_b m1_2260_4540# 0.04999f
C121 rsel vbp_st 0.04306f
C122 a_2528_2940# a_1632_2940# 0.06219f
C123 vm a_480_5620# 1.16329f
C124 vbp_syn vbn_leak 0.14859f
C125 m1_2972_1572# m1_2424_756# 0.00134f
C126 sub m1_208_6996# 0.023f
C127 spk a_480_5620# 0.07578f
C128 a_2528_2940# a_2510_1740# 0.02981f
C129 vdd m1_3704_1572# 0.03511f
C130 m1_1557_7120# m1_208_7600# 0.00966f
C131 t0 mreset 0
C132 t1 m1_1104_8052# 0.00165f
C133 vm stb 0.04174f
C134 rsel m1_3348_960# 0.00266f
C135 vbn_prb en 0.06545f
C136 a_3844_4734# m1_3652_6232# 0
C137 m1_2260_960# vreset 0.18148f
C138 a_1632_2940# aux 0
C139 aux hold 0.04257f
C140 spk stb 0.02657f
C141 t2 aux 0.14387f
C142 vbn_leak vreset 0.03458f
C143 vm m1_1973_6232# 0.07357f
C144 m1_2436_6996# rsel 0.00607f
C145 a_3844_4734# a_3184_3624# 0.05848f
C146 el m1_3212_6232# 0.02332f
C147 aux a_2510_1740# 0.34031f
C148 vm vbp_syn 0.11368f
C149 spk m1_1973_6232# 0
C150 vbp_st m1_4802_1762# 0.00495f
C151 vbn_ref vbn_leak 0.01391f
C152 sub_b t0 0
C153 spk vbp_syn 0.09009f
C154 m1_1401_6720# aux 0.21007f
C155 m1_2972_1572# abus 0.01195f
C156 aux m1_796_6120# 0.03529f
C157 m1_644_2312# rsel 0.07843f
C158 el a_2160_3542# 0
C159 vbn_prb m1_4822_412# 0.11076f
C160 m1_4052_1572# rsel 0
C161 m1_2105_7600# sub 0
C162 a_3184_3624# a_2804_3624# 0.2629f
C163 m1_2260_960# a_2528_2940# 0.06334f
C164 vm m1_1557_7120# 0.00215f
C165 vm vreset 0.27595f
C166 a_288_2940# a_480_5620# 0.00238f
C167 abus m1_2424_756# 0.10221f
C168 vm vbn_ref 0
C169 el a_1632_2940# 0.03353f
C170 el hold 0.0394f
C171 vbp_st a_480_5620# 0.2038f
C172 sub a_3184_3624# 0.0629f
C173 spk vbn_ref 0
C174 m1_208_7600# aux 0.51853f
C175 m1_1545_4540# a_3184_3624# 0.02174f
C176 t0 t3 0
C177 el a_2510_1740# 0.34103f
C178 m1_2260_960# aux 0
C179 spk m1_4904_6422# 0
C180 m1_644_2312# m1_4802_1762# 0
C181 vdd m1_3212_6232# 0.18028f
C182 m1_2972_1572# sub 0
C183 aux vbn_leak 1.65264f
C184 vbp_st stb 0
C185 vm a_2528_2940# 0.09266f
C186 vdd a_2160_3542# 0.29248f
C187 spk a_2528_2940# 0.21265f
C188 vsrc m1_3652_6232# 0.00154f
C189 m1_2436_6996# a_480_5620# 0.01966f
C190 sub m1_2424_756# 0
C191 vbp_syn vbp_st 0.20604f
C192 abus a_3844_4734# 0
C193 sub_b rsel 0.46758f
C194 m1_3704_1572# a_2510_1740# 0
C195 vsrc a_3184_3624# 0.03406f
C196 t1 a_480_5620# 0.16686f
C197 vm aux 0.01801f
C198 m1_644_2312# a_480_5620# 0.11517f
C199 el m1_208_7600# 0
C200 vdd a_1632_2940# 0.73006f
C201 m1_1104_8052# t3 0
C202 m1_2436_6996# stb 0.08958f
C203 vdd hold 1.97062f
C204 vdd t2 0.28683f
C205 spk aux 0.06957f
C206 vbp_syn m1_3348_960# 0.07213f
C207 a_3844_4734# a_2804_3624# 0.18981f
C208 m1_2260_960# el 0
C209 vdd a_2510_1740# 1.63645f
C210 vbp_st vreset 0.03544f
C211 m1_2436_6996# m1_1973_6232# 0.00433f
C212 t1 stb 0
C213 t0 m1_208_6996# 0.07017f
C214 m1_2436_6996# vbp_syn 0
C215 vbp_st vbn_ref 0.04333f
C216 vsrc m1_2424_756# 0.03711f
C217 sub_b m1_4802_1762# 0
C218 vdd m1_1401_6720# 0.06422f
C219 t1 m1_1973_6232# 0.07271f
C220 a_3844_4734# sub 0.15818f
C221 vdd m1_796_6120# 0.32268f
C222 m1_1545_4540# a_3844_4734# 0.00997f
C223 vsrc sta 0
C224 abus sub 0.04017f
C225 vbp_st m1_4904_6422# 0.02925f
C226 vbn_prb rsel 0
C227 m1_644_2312# vbp_syn 0.10157f
C228 m1_3348_960# vreset 0.04745f
C229 a_288_2940# a_2528_2940# 0.00363f
C230 m1_2260_960# m1_3704_1572# 0
C231 en m1_2972_1572# 0.01609f
C232 m1_2436_6996# m1_1557_7120# 0
C233 a_3184_3624# m1_1692_4664# 0.00327f
C234 vbn_ref m1_3348_960# 0.03356f
C235 vm el 0.09618f
C236 sub a_2804_3624# 0.18452f
C237 m1_1545_4540# a_2804_3624# 0.20376f
C238 a_3184_3624# m1_2260_4540# 0.02374f
C239 m1_3212_6232# hold 0
C240 spk el 0.20152f
C241 t1 m1_1557_7120# 0.2089f
C242 vdd m1_208_7600# 0.01002f
C243 stb mreset 0.0015f
C244 m1_644_2312# vreset 0
C245 en m1_2424_756# 0.11395f
C246 m1_2260_960# vdd 0
C247 sub_b a_480_5620# 0
C248 en sta 0
C249 vsrc a_3844_4734# 0.28359f
C250 m1_1104_8052# m1_208_6996# 0
C251 abus vsrc 0.09671f
C252 a_1632_2940# a_2160_3542# 0.20541f
C253 a_2160_3542# hold 0.00479f
C254 vdd vbn_leak 0.1122f
C255 m1_1545_4540# sub 0.18385f
C256 t0 m1_2105_7600# 0.07342f
C257 m1_644_2312# vbn_ref 0
C258 vbn_prb m1_4802_1762# 0.12042f
C259 aux vbp_st 0.04198f
C260 vbp_syn mreset 0.29307f
C261 a_2160_3542# a_2510_1740# 0
C262 vm m1_3704_1572# 0
C263 t0 m1_3652_6232# 0
C264 sub_b stb 0.1209f
C265 vsrc a_2804_3624# 0.07256f
C266 a_1632_2940# hold 0.34249f
C267 aux m1_3348_960# 0.03296f
C268 t2 hold 0
C269 sub_b vbp_syn 0.09408f
C270 m1_644_2312# a_2528_2940# 0.43881f
C271 mreset vreset 0
C272 en a_3844_4734# 0
C273 vm vdd 2.26238f
C274 a_2510_1740# hold 0.56766f
C275 en abus 0.2665f
C276 a_480_5620# t3 0.13045f
C277 m1_208_7600# m1_3212_6232# 0.0038f
C278 vdd spk 0.87243f
C279 m1_2436_6996# aux 0.20054f
C280 vsrc sub 0.04387f
C281 vsrc m1_1545_4540# 0.00157f
C282 a_288_2940# el 0.07974f
C283 vbn_ref mreset 0
C284 m1_1401_6720# hold 0.00249f
C285 a_3844_4734# m1_1692_4664# 0
C286 a_1632_2940# m1_796_6120# 0
C287 m1_796_6120# hold 0.00244f
C288 t2 m1_1401_6720# 0.10633f
C289 t1 aux 0.17958f
C290 t2 m1_796_6120# 0.00336f
C291 m1_3212_6232# vbn_leak 0.00171f
C292 m1_644_2312# aux 0.07419f
C293 sub_b vreset 0
C294 el vbp_st 0.04494f
C295 a_3844_4734# m1_2260_4540# 0
C296 t0 sta 0
C297 m1_2260_960# a_2160_3542# 0
C298 m1_4052_1572# aux 0.03617f
C299 sub_b vbn_ref 0.00363f
C300 abus m1_4822_412# 0.01227f
C301 m1_1973_6232# t3 0
C302 m1_1401_6720# m1_796_6120# 0
C303 m1_1692_4664# a_2804_3624# 0.00417f
C304 m1_2105_7600# rsel 0
C305 vbn_prb vbp_syn 0.03049f
C306 m1_208_7600# hold 0.0057f
C307 en sub 0.04402f
C308 el m1_3348_960# 0.03642f
C309 m1_2260_4540# a_2804_3624# 0.08448f
C310 t2 m1_208_7600# 0.0595f
C311 vm m1_3212_6232# 0.02914f
C312 m1_208_7600# a_2510_1740# 0.0013f
C313 spk m1_3212_6232# 0.10847f
C314 sub m1_1692_4664# 0.06319f
C315 m1_1545_4540# m1_1692_4664# 0.0971f
C316 vbn_leak hold 0.07603f
C317 sub_b a_2528_2940# 0
C318 m1_2260_960# a_2510_1740# 0.14485f
C319 rsel a_3184_3624# 0.15677f
C320 aux mreset 0.13148f
C321 a_288_2940# vdd 0.0017f
C322 m1_1401_6720# m1_208_7600# 0.00134f
C323 a_480_5620# m1_208_6996# 0.06844f
C324 m1_1545_4540# m1_2260_4540# 0.01391f
C325 sub m1_2260_4540# 0.16212f
C326 vm a_2160_3542# 0.16962f
C327 m1_208_7600# m1_796_6120# 0.01948f
C328 a_2510_1740# vbn_leak 0.26348f
C329 vbn_prb vreset 0.04313f
C330 m1_644_2312# el 0.24826f
C331 spk a_2160_3542# 0.01268f
C332 m1_2972_1572# rsel 0.0346f
C333 vdd vbp_st 1.71891f
C334 m1_3704_1572# m1_3348_960# 0.00111f
C335 el m1_4052_1572# 0.04092f
C336 vbn_prb vbn_ref 1.74886f
C337 en vsrc 0.03704f
C338 sub_b aux 0.0965f
C339 stb m1_208_6996# 0.03449f
C340 vbn_prb m1_4904_6422# 0.1006f
C341 t0 a_2804_3624# 0
C342 vm a_1632_2940# 0.43105f
C343 vm hold 0.31488f
C344 rsel m1_2424_756# 0.00696f
C345 vm t2 0.06186f
C346 m1_1973_6232# m1_208_6996# 0.1096f
C347 spk a_1632_2940# 0.09119f
C348 spk hold 0.25952f
C349 vdd m1_3348_960# 0.41284f
C350 vm a_2510_1740# 0.23084f
C351 vbp_syn m1_208_6996# 0
C352 vsrc m1_2260_4540# 0
C353 spk a_2510_1740# 0.02126f
C354 t0 sub 0.06097f
C355 m1_2436_6996# vdd 0.03348f
C356 m1_4052_1572# m1_3704_1572# 0
C357 m1_208_7600# vbn_leak 0
C358 vsrc m1_4822_412# 0.0037f
C359 vm m1_1401_6720# 0.02407f
C360 el mreset 0.02914f
C361 vm m1_796_6120# 0.08148f
C362 m1_2105_7600# a_480_5620# 0
C363 vdd t1 0.11574f
C364 m1_2260_960# vbn_leak 0
C365 m1_644_2312# vdd 0.0239f
C366 m1_3212_6232# vbp_st 0.00157f
C367 m1_1557_7120# m1_208_6996# 0.14411f
C368 aux t3 0.20601f
C369 vbn_prb aux 0
C370 vdd m1_4052_1572# 0.01699f
C371 m1_4802_1762# m1_2424_756# 0.02111f
C372 sub_b el 0.10714f
C373 rsel a_3844_4734# 0.07252f
C374 m1_2105_7600# stb 0
C375 rsel abus 0.00147f
C376 a_480_5620# a_3184_3624# 0.00155f
C377 a_2160_3542# vbp_st 0.00601f
C378 vm m1_208_7600# 0
C379 m1_2105_7600# m1_1973_6232# 0.0048f
C380 en m1_4822_412# 0.08351f
C381 spk m1_208_7600# 0.00484f
C382 m1_2105_7600# vbp_syn 0
C383 vm m1_2260_960# 0.13494f
C384 m1_2260_960# spk 0
C385 m1_2260_4540# m1_1692_4664# 0.08395f
C386 stb a_3184_3624# 0
C387 m1_2436_6996# m1_3212_6232# 0.002f
C388 vm vbn_leak 0
C389 rsel a_2804_3624# 0.01776f
C390 vbp_syn m1_3652_6232# 0.10654f
C391 spk vbn_leak 0
C392 vdd mreset 0.10833f
C393 a_1632_2940# vbp_st 0.2412f
C394 vbp_st hold 0.46055f
C395 t2 vbp_st 0
C396 vbp_syn a_3184_3624# 0
C397 vbp_st a_2510_1740# 0.27337f
C398 abus m1_4802_1762# 0.30809f
C399 m1_2105_7600# m1_1557_7120# 0.07884f
C400 rsel sub 0.41869f
C401 vbn_prb el 0
C402 sub_b vdd 0.41395f
C403 m1_1401_6720# vbp_st 0
C404 m1_644_2312# a_2160_3542# 0
C405 aux m1_208_6996# 0.75171f
C406 stb sta 0.00742f
C407 vm spk 7.89111f
C408 t0 m1_1692_4664# 0
C409 a_2510_1740# m1_3348_960# 0.02182f
C410 m1_2436_6996# hold 0.02375f
C411 m1_2436_6996# t2 0
C412 vbp_syn m1_2424_756# 0.12655f
C413 t0 m1_2260_4540# 0
C414 m1_4904_6422# m1_3652_6232# -0.01073f
C415 vbp_syn sta 0.02674f
C416 vbn_ref a_3184_3624# 0
C417 t1 a_1632_2940# 0
C418 t1 hold 0
C419 m1_2972_1572# vreset 0
C420 a_3844_4734# a_480_5620# 0.00579f
C421 t2 t1 0.07819f
C422 m1_644_2312# a_1632_2940# 0.30753f
C423 m1_3212_6232# mreset 0.03263f
C424 m1_208_7600# vbp_st 0
C425 m1_2436_6996# m1_1401_6720# 0
C426 rsel vsrc 0.03617f
C427 m1_644_2312# a_2510_1740# 0.17513f
C428 vdd t3 0.18084f
C429 t1 m1_1401_6720# 0.07362f
C430 vreset m1_2424_756# 0.08879f
C431 m1_4052_1572# a_2510_1740# 0
C432 vbp_st vbn_leak 0.04057f
C433 vdd vbn_prb 0.09293f
C434 vreset sta 0
C435 a_480_5620# a_2804_3624# 0.00624f
C436 sub_b m1_3212_6232# 0.10497f
C437 el m1_208_6996# 0
C438 m1_2105_7600# aux 0.41055f
C439 vbn_ref m1_2424_756# 0.03822f
C440 vbn_ref sta 0
C441 vbp_syn a_3844_4734# 0.11205f
C442 abus vbp_syn 0.06436f
C443 m1_2260_960# m1_3348_960# 0
C444 aux m1_3652_6232# 0.00645f
C445 m1_2436_6996# m1_208_7600# -0.00271f
C446 sub_b a_2160_3542# 0
C447 m1_4904_6422# sta 0
C448 vm a_288_2940# 0.04745f
C449 a_480_5620# sub 0.06758f
C450 en rsel 0.06091f
C451 vbn_leak m1_3348_960# 0.03047f
C452 vsrc m1_4802_1762# 0
C453 m1_1545_4540# a_480_5620# 0.06066f
C454 mreset hold 0
C455 a_288_2940# spk 0.31512f
C456 aux a_3184_3624# 0.00204f
C457 t1 m1_208_7600# 0.03518f
C458 a_2510_1740# mreset 0.05003f
C459 vm vbp_st 0.12925f
C460 a_2528_2940# m1_2424_756# 0
C461 spk vbp_st 0.12536f
C462 rsel m1_1692_4664# 0.00536f
C463 m1_2972_1572# aux 0
C464 a_3844_4734# vreset 0
C465 stb sub 0.01482f
C466 abus vreset 1.82741f
C467 m1_644_2312# m1_2260_960# 0.03124f
C468 sub_b hold 0.20837f
C469 rsel m1_2260_4540# 0.07376f
C470 m1_644_2312# vbn_leak 0
C471 m1_2260_960# m1_4052_1572# 0
C472 a_3844_4734# vbn_ref 0.00302f
C473 sub m1_1973_6232# 0.00349f
C474 abus vbn_ref 0.09248f
C475 sub_b a_2510_1740# 0.11475f
C476 vm m1_3348_960# 0.2229f
C477 m1_4052_1572# vbn_leak 0.00484f
C478 vbp_syn sub 0.05211f
C479 m1_2105_7600# el 0
C480 vdd m1_208_6996# 0.04957f
C481 aux m1_2424_756# 0.03279f
C482 en m1_4802_1762# 0.11368f
C483 vsrc a_480_5620# 0.13021f
C484 aux sta 0
C485 m1_2436_6996# vm 0.13145f
C486 el m1_3652_6232# 0.02275f
C487 m1_2436_6996# spk 0.00145f
C488 m1_208_7600# mreset 0.00221f
C489 vm t1 0.06005f
C490 el a_3184_3624# 0
C491 a_2528_2940# a_3844_4734# 0.03777f
C492 m1_644_2312# vm 0.24474f
C493 t1 spk 0
C494 vsrc stb 0
C495 sub vreset 0
C496 t0 rsel 0
C497 m1_644_2312# spk 0.0598f
C498 a_1632_2940# t3 0
C499 t3 hold 0.01686f
C500 t2 t3 0.05739f
C501 mreset vbn_leak 0.02934f
C502 vbn_prb hold 0.14538f
C503 vbn_ref sub 0
C504 a_288_2940# vbp_st 0
C505 sub_b m1_208_7600# 0.00319f
C506 vbp_syn vsrc 0.18021f
C507 vbn_prb a_2510_1740# 0.21435f
C508 aux a_3844_4734# 0.01149f
C509 a_2528_2940# a_2804_3624# 0
C510 abus aux 0.03821f
C511 sub_b m1_2260_960# 0
C512 m1_1401_6720# t3 0
C513 m1_3212_6232# m1_208_6996# 0.00246f
C514 el m1_2424_756# 0.03044f
C515 t3 m1_796_6120# 0.18981f
C516 vdd m1_2105_7600# 0
C517 sub_b vbn_leak 0.05904f
C518 a_480_5620# m1_1692_4664# 0.15559f
C519 el sta 0
C520 vdd m1_3652_6232# 0.24896f
C521 vm mreset 0
C522 a_2528_2940# sub 0
C523 a_480_5620# m1_2260_4540# 0.06854f
C524 vsrc vreset 0.0346f
C525 a_2528_2940# m1_1545_4540# 0
C526 vbp_st m1_3348_960# 0.03879f
C527 vdd a_3184_3624# 0.42073f
C528 vsrc vbn_ref 0.04621f
C529 en vbp_syn 0.08363f
C530 m1_2436_6996# vbp_st 0
C531 m1_208_7600# t3 0.18955f
C532 m1_3704_1572# m1_2424_756# 0.02956f
C533 stb m1_2260_4540# 0
C534 vbn_prb m1_208_7600# 0
C535 m1_1973_6232# m1_1692_4664# 0
C536 vdd m1_2972_1572# 0.00395f
C537 m1_644_2312# a_288_2940# 0.51375f
C538 sub_b vm 0.06978f
C539 aux sub 0.12397f
C540 sub_b spk 0.56334f
C541 m1_208_6996# hold 0.00372f
C542 t1 vbp_st 0
C543 el a_3844_4734# 0.00104f
C544 t2 m1_208_6996# 0.05179f
C545 el abus 0.03784f
C546 vbp_syn m1_2260_4540# 0.02219f
C547 m1_644_2312# vbp_st 0
C548 vbn_prb vbn_leak 0
C549 a_2510_1740# m1_208_6996# 0.00208f
C550 en vreset 1.8638f
C551 a_2528_2940# vsrc 0.15109f
C552 t0 a_480_5620# 0.10955f
C553 vdd m1_2424_756# 0.21166f
C554 vdd sta 0.20165f
C555 en vbn_ref 1.7775f
C556 m1_1401_6720# m1_208_6996# 0.07759f
C557 m1_3212_6232# m1_3652_6232# 0.04772f
C558 m1_208_6996# m1_796_6120# 0.10816f
C559 el a_2804_3624# 0
C560 m1_644_2312# m1_3348_960# 0
C561 t0 stb 0.00249f
C562 m1_3212_6232# a_3184_3624# 0
C563 m1_2436_6996# t1 0
C564 abus m1_3704_1572# 0.00665f
C565 vsrc aux 0.13514f
C566 m1_4052_1572# m1_3348_960# 0
C567 vm t3 0.04824f
C568 m1_4822_412# vreset 0.02001f
C569 t0 m1_1973_6232# 0.15422f
C570 vm vbn_prb 0.00158f
C571 el sub 0.03583f
C572 vbn_prb spk 0
C573 t0 vbp_syn 0
C574 a_2160_3542# a_3184_3624# 0.00161f
C575 vbp_st mreset 0
C576 vbn_ref m1_4822_412# 0.08703f
C577 en a_2528_2940# 0.00443f
C578 m1_2105_7600# hold 0
C579 m1_208_7600# m1_208_6996# 0.31602f
C580 vdd a_3844_4734# 0.59267f
C581 vdd abus 0.19859f
C582 m1_2105_7600# a_2510_1740# 0
C583 m1_3652_6232# hold 0.01348f
C584 sub_b vbp_st 0.04519f
C585 m1_3212_6232# sta 0.32895f
C586 a_2528_2940# m1_2260_4540# 0
C587 a_2510_1740# m1_3652_6232# 0
C588 m1_2105_7600# m1_1401_6720# -0.00348f
C589 t0 m1_1557_7120# 0.09239f
C590 en aux 0.04317f
C591 a_1632_2940# a_3184_3624# 0
C592 a_3184_3624# hold 0.16211f
C593 vdd a_2804_3624# 0.27486f
C594 a_2510_1740# a_3184_3624# 0.00254f
C595 el vsrc 0.06761f
C596 rsel a_480_5620# 0.00284f
C597 sub_b m1_3348_960# 0
C598 m1_2972_1572# a_2510_1740# 0.07005f
C599 vdd sub 0.31875f
C600 vdd m1_1545_4540# 0.31514f
C601 vm m1_208_6996# 0.01147f
C602 aux m1_4822_412# 0.00115f
C603 m1_2436_6996# sub_b 0.00213f
C604 m1_2105_7600# m1_208_7600# 0.00943f
C605 rsel stb 0.12542f
C606 spk m1_208_6996# 0.00884f
C607 sta hold 0
C608 a_2510_1740# m1_2424_756# 0.20463f
C609 vbn_prb vbp_st 1.71612f
C610 a_2510_1740# sta 0
C611 m1_644_2312# sub_b 0.07618f
C612 rsel vbp_syn 0.03843f
C613 m1_1557_7120# m1_1104_8052# -0.0026f
C614 a_2160_3542# a_3844_4734# 0.14668f
C615 en el 0.03706f
C616 sub_b m1_4052_1572# 0.01339f
C617 m1_3652_6232# vbn_leak 0.00306f
C618 t0 aux 0.19364f
C619 vdd vsrc 0.22685f
C620 vbn_prb m1_3348_960# 0.04182f
C621 rsel vreset 0
C622 m1_2260_960# m1_2972_1572# 0.0013f
C623 a_2160_3542# a_2804_3624# 0.02975f
C624 a_1632_2940# a_3844_4734# 0.00737f
C625 a_3844_4734# hold 0.22099f
C626 abus hold 0
C627 el m1_4822_412# 0
C628 vm m1_2105_7600# 0
C629 en m1_3704_1572# 0.02589f
C630 t1 t3 0
C631 rsel vbn_ref 0
C632 a_3844_4734# a_2510_1740# 0.20872f
C633 abus a_2510_1740# 0.04722f
C634 vm m1_3652_6232# 0.00843f
C635 m1_644_2312# vbn_prb 0.00111f
C636 a_2160_3542# sub 0.01212f
C637 a_2160_3542# m1_1545_4540# 0.11196f
C638 m1_2260_960# m1_2424_756# 0.01455f
C639 spk m1_3652_6232# 0.00816f
C640 vbn_leak m1_2424_756# 0.04259f
C641 a_1632_2940# a_2804_3624# 0.0023f
C642 a_2804_3624# hold 0.10403f
C643 vm a_3184_3624# 0.00142f
C644 vbp_st m1_208_6996# 0
C645 vbn_leak sta 0
C646 vdd en 0.23193f
C647 spk a_3184_3624# 0.22493f
C648 a_2510_1740# a_2804_3624# 0
C649 stb a_480_5620# 0
C650 aux m1_1104_8052# 0.01525f
C651 vm m1_2972_1572# 0.00716f
C652 m1_4802_1762# vreset 0.00845f
C653 a_2528_2940# rsel 0.02127f
C654 t0 el 0
C655 spk m1_2972_1572# 0
C656 a_1632_2940# m1_1545_4540# 0.17436f
C657 a_480_5620# m1_1973_6232# 0.1051f
C658 sub hold 0.34703f
C659 a_1632_2940# sub 0.05048f
C660 vdd m1_1692_4664# 0.28596f
C661 m1_1545_4540# hold 0.0432f
C662 vbn_ref m1_4802_1762# 0.07567f
C663 vbp_syn a_480_5620# 0
C664 vdd m1_2260_4540# 0.51842f
C665 a_2510_1740# sub 0.15027f
C666 vdd m1_4822_412# 0.0096f
C667 vm m1_2424_756# 0.39126f
C668 a_2160_3542# vsrc 0.16998f
C669 vbn_prb mreset 0
C670 m1_2260_960# a_3844_4734# 0.00193f
C671 m1_2436_6996# m1_208_6996# 0.20198f
C672 vm sta 0.04872f
C673 rsel aux 0.09908f
C674 m1_2260_960# abus 0
C675 stb m1_1973_6232# 0
C676 a_3844_4734# vbn_leak 0
C677 spk sta 0.09062f
C678 vbp_syn stb 0.00619f
C679 abus vbn_leak 0.06961f
C680 t1 m1_208_6996# 0.08524f
C681 m1_1557_7120# a_480_5620# 0
C682 sub_b vbn_prb 0.00243f
C683 a_1632_2940# vsrc 0.14308f
C684 vsrc hold 0.11451f
C685 m1_2260_960# a_2804_3624# 0
C686 vbp_st m1_3652_6232# 0.006f
C687 t0 vdd 0.10056f
C688 vsrc a_2510_1740# 0.39432f
C689 m1_1557_7120# stb 0
C690 aux m1_4802_1762# 0
C691 vbp_st a_3184_3624# 0.00366f
C692 vm a_3844_4734# 0.00745f
C693 vm abus 0.03247f
C694 m1_2260_960# sub 0
C695 m1_1557_7120# m1_1973_6232# 0.06718f
C696 spk a_3844_4734# 0.21496f
C697 a_2160_3542# m1_1692_4664# 0.0051f
C698 vbp_syn vreset 0.04129f
C699 sub vbn_leak 0
C700 el rsel 0.04467f
C701 m1_2436_6996# m1_2105_7600# 0.00869f
C702 a_2528_2940# a_480_5620# 0.40551f
C703 a_2160_3542# m1_2260_4540# 0.16455f
C704 mreset m1_208_6996# 0.00115f
C705 vbp_syn vbn_ref 0.00577f
C706 en hold 0.01354f
C707 t1 m1_2105_7600# 0
C708 vm a_2804_3624# 0
C709 vbp_syn m1_4904_6422# -0.07963f
C710 spk a_2804_3624# 0.00565f
C711 en a_2510_1740# 0.53513f
C712 vbp_st m1_2424_756# 0.03031f
C713 a_1632_2940# m1_1692_4664# 0.09357f
C714 m1_1692_4664# hold 0.07608f
C715 m1_208_7600# vsrc 0
C716 m1_2972_1572# m1_3348_960# 0
C717 vbp_st sta 0.00349f
C718 aux a_480_5620# 0.01903f
C719 sub_b m1_208_6996# 0.00404f
C720 rsel m1_3704_1572# 0.0163f
C721 a_1632_2940# m1_2260_4540# 0.03512f
C722 m1_2260_4540# hold 0.16126f
C723 t0 m1_3212_6232# 0
C724 m1_2260_960# vsrc 0
C725 vm m1_1545_4540# 0.03028f
C726 a_2510_1740# m1_1692_4664# 0
C727 vm sub 0.04966f
C728 vbn_ref vreset 0.04932f
C729 a_2528_2940# vbp_syn 0
C730 spk m1_1545_4540# 0.00253f
C731 m1_644_2312# a_3184_3624# 0
C732 spk sub 0.08056f
C733 vsrc vbn_leak 1.6831f
C734 a_2510_1740# m1_2260_4540# 0.00255f
C735 m1_3348_960# m1_2424_756# 0.14487f
C736 aux stb 0.16246f
C737 vdd rsel 0.33464f
C738 vbn_ref m1_4904_6422# 0.11398f
C739 aux m1_1973_6232# 0.06458f
C740 m1_2105_7600# mreset 0
C741 vbp_syn aux 0.23212f
C742 vbp_st a_3844_4734# 0.00313f
C743 a_2528_2940# vreset 0
C744 abus vbp_st 0.1157f
C745 m1_3652_6232# mreset 0.02141f
C746 m1_2260_960# en 0.04366f
C747 m1_644_2312# m1_2424_756# 0
C748 t0 hold 0.00647f
C749 t0 a_1632_2940# 0
C750 vm vsrc 0.12664f
C751 t3 m1_208_6996# 0.13726f
C752 en vbn_leak 0.03721f
C753 el a_480_5620# 0.18437f
C754 spk vsrc 0.15417f
C755 m1_4052_1572# m1_2424_756# 0.01864f
C756 m1_1557_7120# aux 0.18642f
C757 aux vreset 0.03462f
C758 vbp_st a_2804_3624# 0.00359f
C759 abus m1_3348_960# 0.10889f
C760 sub_b m1_3652_6232# 0
C761 t0 m1_1401_6720# 0
C762 el stb 0
C763 aux vbn_ref 0
C764 sub_b a_3184_3624# 0.02576f
C765 m1_4822_412# vbn_leak 0.00192f
C766 rsel m1_3212_6232# 0
C767 aux m1_4904_6422# 0
C768 vbp_st sub 0.13823f
C769 m1_1545_4540# vbp_st 0.02577f
C770 vbn_leak vss 0.55016f
C771 m1_3348_960# vss 0.80751f
C772 m1_1104_8052# vss -0.00196f
C773 m1_2260_960# vss 0.39253f
C774 en vss 1.1382f
C775 abus vss 2.48947f
C776 sub vss 0.49774f
C777 mreset vss 0.64739f
C778 hold vss 0.97734f
C779 vdd vss 17.00135f
C780 m1_1557_7120# vss 0.13244f
C781 m1_2105_7600# vss 0.12741f
C782 m1_4822_412# vss 0.13826f
C783 m1_796_6120# vss -0.04573f
C784 t3 vss 0.40039f
C785 vbn_prb vss 0.70582f
C786 a_3184_3624# vss 0.18684f
C787 m1_1401_6720# vss 0.03849f
C788 t2 vss 0.30522f
C789 a_2804_3624# vss 0.11006f
C790 m1_1973_6232# vss 0.00346f
C791 t1 vss 0.30178f
C792 m1_208_7600# vss 2.71583f
C793 m1_208_6996# vss 1.22331f
C794 spk vss 0.79507f
C795 m1_2436_6996# vss 0.13276f
C796 t0 vss 0.27403f
C797 m1_2972_1572# vss -0.0561f
C798 rsel vss 0.74365f
C799 m1_2260_4540# vss -0.07483f
C800 vm vss 3.81981f
C801 m1_3704_1572# vss -0.0536f
C802 m1_644_2312# vss 0.42669f
C803 a_288_2940# vss -0.20511f
C804 sub_b vss 1.03926f
C805 m1_1545_4540# vss 0.07282f
C806 vbp_st vss 0.32202f
C807 m1_3212_6232# vss 0.09985f
C808 stb vss 0.91039f
C809 sta vss 0.24375f
C810 m1_2424_756# vss 0.63391f
C811 a_2160_3542# vss 0.32946f
C812 vsrc vss 1.00127f
C813 vreset vss 0.64484f
C814 a_2510_1740# vss 2.38028f
C815 m1_4802_1762# vss -0.01232f
C816 m1_1692_4664# vss -0.08775f
C817 vbn_ref vss 0.70591f
C818 a_2528_2940# vss 0.10776f
C819 a_1632_2940# vss 0.8689f
C820 a_3844_4734# vss 0.72627f
C821 m1_4904_6422# vss -0.2014f
C822 m1_3652_6232# vss -0.06338f
C823 vbp_syn vss 0.34781f
C824 a_480_5620# vss -0.03316f
C825 el vss 0.25207f
C826 aux vss 3.91715f
C827 m1_4052_1572# vss -0.0427f
.ends
