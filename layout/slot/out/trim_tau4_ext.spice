* NGSPICE file created from trim_tau4.ext - technology: gf180mcuD

.subckt p_w0p83_l2 w_n374_n213# a_n288_n83# a_200_n83# a_n200_n127#
X0 a_200_n83# a_n200_n127# a_n288_n83# w_n374_n213# pfet_03v3 ad=0.3652p pd=2.54u as=0.3652p ps=2.54u w=0.83u l=2u
.ends

.subckt n_w1_l4 a_n488_n100# a_400_n100# a_n400_n144# VSUBS
X0 a_400_n100# a_n400_n144# a_n488_n100# VSUBS nfet_03v3 ad=0.44p pd=2.88u as=0.44p ps=2.88u w=1u l=4u
.ends

.subckt n_w2_l4 a_400_n200# a_n400_n244# a_n488_n200# VSUBS
X0 a_400_n200# a_n400_n244# a_n488_n200# VSUBS nfet_03v3 ad=0.88p pd=4.88u as=0.88p ps=4.88u w=2u l=4u
.ends

.subckt n_w0p5_l0p5 a_n138_n50# a_50_n50# a_n50_n94# VSUBS
X0 a_50_n50# a_n50_n94# a_n138_n50# VSUBS nfet_03v3 ad=0.22p pd=1.88u as=0.22p ps=1.88u w=0.5u l=0.5u
.ends

.subckt n_w4_l4 a_n488_n400# a_400_n400# a_n400_n444# VSUBS
X0 a_400_n400# a_n400_n444# a_n488_n400# VSUBS nfet_03v3 ad=1.76p pd=8.88u as=1.76p ps=8.88u w=4u l=4u
.ends

.subckt p_w1_l2 w_n374_n230# a_n288_n100# a_200_n100# a_n200_n144#
X0 a_200_n100# a_n200_n144# a_n288_n100# w_n374_n230# pfet_03v3 ad=0.44p pd=2.88u as=0.44p ps=2.88u w=1u l=2u
.ends

.subckt trim_tau4 vss aux vbn_leak c2 c3 c1 c0 vdd
XXPM vdd vdd aux m1_6882_530# p_w0p83_l2
XXU0 m1_5978_958# m1_6882_530# vbn_leak vss n_w1_l4
XXU1 m1_6882_530# vbn_leak m1_5572_1070# vss n_w2_l4
XXS0 vss m1_5978_958# c0 vss n_w0p5_l0p5
XXU2 m1_2488_800# m1_6882_530# vbn_leak vss n_w4_l4
XXS1 vss m1_5572_1070# c1 vss n_w0p5_l0p5
XXS2 vss m1_2488_800# c2 vss n_w0p5_l0p5
XXS3 vss m1_3648_240# c3 vss n_w0p5_l0p5
XXNDa aux aux vss vss n_w2_l4
XXNDb aux aux vss vss n_w2_l4
XXB0 vss m1_6882_530# vbn_leak vss n_w4_l4
XXB1 vss m1_6882_530# vbn_leak vss n_w4_l4
XXPD0 vdd vdd m1_6882_530# m1_6882_530# p_w1_l2
XXPD1 vdd vdd m1_6882_530# m1_6882_530# p_w1_l2
XXPD2 vdd vdd m1_6882_530# m1_6882_530# p_w1_l2
XXPD3 vdd vdd m1_6882_530# m1_6882_530# p_w1_l2
XXU3a m1_3648_240# m1_6882_530# vbn_leak vss n_w4_l4
XXU3b m1_3648_240# m1_6882_530# vbn_leak vss n_w4_l4
.ends
