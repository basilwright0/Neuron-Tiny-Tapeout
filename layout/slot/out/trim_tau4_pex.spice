* NGSPICE file created from trim_tau4.ext - technology: gf180mcuD

.subckt p_w0p83_l2 w_n374_n213# a_n288_n83# a_200_n83# a_n200_n127# VSUBS
X0 a_200_n83# a_n200_n127# a_n288_n83# w_n374_n213# pfet_03v3 ad=0.3652p pd=2.54u as=0.3652p ps=2.54u w=0.83u l=2u
C0 w_n374_n213# a_n288_n83# 0.02618f
C1 a_n288_n83# a_200_n83# 0.00872f
C2 w_n374_n213# a_200_n83# 0.02618f
C3 a_n288_n83# a_n200_n127# 0.02401f
C4 w_n374_n213# a_n200_n127# 0.22666f
C5 a_n200_n127# a_200_n83# 0.02401f
C6 a_200_n83# VSUBS 0.0992f
C7 a_n288_n83# VSUBS 0.0992f
C8 w_n374_n213# VSUBS 0.95594f
.ends

.subckt n_w1_l4 a_n488_n100# a_400_n100# a_n400_n144# VSUBS
X0 a_400_n100# a_n400_n144# a_n488_n100# VSUBS nfet_03v3 ad=0.44p pd=2.88u as=0.44p ps=2.88u w=1u l=4u
C0 a_n400_n144# a_400_n100# 0.03474f
C1 a_400_n100# a_n488_n100# 0.00531f
C2 a_n400_n144# a_n488_n100# 0.03474f
C3 a_400_n100# VSUBS 0.37836f
C4 a_n488_n100# VSUBS 0.37836f
.ends

.subckt n_w2_l4 a_400_n200# a_n400_n244# a_n488_n200# VSUBS
X0 a_400_n200# a_n400_n244# a_n488_n200# VSUBS nfet_03v3 ad=0.88p pd=4.88u as=0.88p ps=4.88u w=2u l=4u
C0 a_n400_n244# a_400_n200# 0.07019f
C1 a_400_n200# a_n488_n200# 0.01073f
C2 a_n400_n244# a_n488_n200# 0.07019f
C3 a_400_n200# VSUBS 0.41684f
C4 a_n488_n200# VSUBS 0.41684f
.ends

.subckt n_w0p5_l0p5 a_n138_n50# a_50_n50# a_n50_n94# VSUBS
X0 a_50_n50# a_n50_n94# a_n138_n50# VSUBS nfet_03v3 ad=0.22p pd=1.88u as=0.22p ps=1.88u w=0.5u l=0.5u
C0 a_n50_n94# a_50_n50# 0.00625f
C1 a_50_n50# a_n138_n50# 0.01511f
C2 a_n50_n94# a_n138_n50# 0.00625f
C3 a_50_n50# VSUBS 0.09639f
C4 a_n138_n50# VSUBS 0.09639f
.ends

.subckt n_w4_l4 a_n488_n400# a_400_n400# a_n400_n444# VSUBS
X0 a_400_n400# a_n400_n444# a_n488_n400# VSUBS nfet_03v3 ad=1.76p pd=8.88u as=1.76p ps=8.88u w=4u l=4u
C0 a_n400_n444# a_400_n400# 0.14108f
C1 a_400_n400# a_n488_n400# 0.02157f
C2 a_n400_n444# a_n488_n400# 0.14108f
C3 a_400_n400# VSUBS 0.49379f
C4 a_n488_n400# VSUBS 0.49379f
.ends

.subckt p_w1_l2 w_n374_n230# a_n288_n100# a_200_n100# a_n200_n144# VSUBS
X0 a_200_n100# a_n200_n144# a_n288_n100# w_n374_n230# pfet_03v3 ad=0.44p pd=2.88u as=0.44p ps=2.88u w=1u l=2u
C0 w_n374_n230# a_n288_n100# 0.03135f
C1 a_n288_n100# a_200_n100# 0.01056f
C2 w_n374_n230# a_200_n100# 0.03135f
C3 a_n288_n100# a_n200_n144# 0.02905f
C4 w_n374_n230# a_n200_n144# 0.22666f
C5 a_n200_n144# a_200_n100# 0.02905f
C6 a_200_n100# VSUBS 0.1047f
C7 a_n288_n100# VSUBS 0.1047f
C8 w_n374_n230# VSUBS 1.03224f
.ends

.subckt trim_tau4 vss aux vbn_leak c2 c3 c1 c0 vdd
XXPM vdd vdd aux m1_6882_530# vss p_w0p83_l2
XXU0 m1_5978_958# m1_6882_530# vbn_leak vss n_w1_l4
XXU1 m1_6882_530# vbn_leak m1_5572_1070# vss n_w2_l4
XXS0 vss m1_5978_958# c0 vss n_w0p5_l0p5
XXU2 m1_2488_800# m1_6882_530# vbn_leak vss n_w4_l4
XXS1 vss m1_5572_1070# c1 vss n_w0p5_l0p5
XXS2 vss m1_2488_800# c2 vss n_w0p5_l0p5
XXS3 vss m1_3648_240# c3 vss n_w0p5_l0p5
XXNDa aux aux vss vss n_w2_l4
XXNDb aux aux vss vss n_w2_l4
XXB0 vss m1_6882_530# vbn_leak vss n_w4_l4
XXB1 vss m1_6882_530# vbn_leak vss n_w4_l4
XXPD0 vdd vdd m1_6882_530# m1_6882_530# vss p_w1_l2
XXPD1 vdd vdd m1_6882_530# m1_6882_530# vss p_w1_l2
XXPD2 vdd vdd m1_6882_530# m1_6882_530# vss p_w1_l2
XXPD3 vdd vdd m1_6882_530# m1_6882_530# vss p_w1_l2
XXU3a m1_3648_240# m1_6882_530# vbn_leak vss n_w4_l4
XXU3b m1_3648_240# m1_6882_530# vbn_leak vss n_w4_l4
C0 vdd c1 0.11037f
C1 aux m1_6882_530# 0.07903f
C2 vdd c2 0.11738f
C3 m1_3648_240# c1 0
C4 m1_2488_800# m1_6882_530# 0.23217f
C5 aux c3 0
C6 m1_5978_958# vdd 0.00484f
C7 m1_2488_800# c3 0.00275f
C8 m1_5978_958# m1_3648_240# 0
C9 vdd m1_3648_240# 0.02986f
C10 c1 m1_5572_1070# 0.02021f
C11 c1 m1_6882_530# 0.16197f
C12 c2 m1_6882_530# 0.07236f
C13 c1 c3 0.00701f
C14 m1_5978_958# m1_5572_1070# 0.0326f
C15 vdd m1_5572_1070# 0.01107f
C16 m1_5978_958# m1_6882_530# 0.02533f
C17 c2 c3 0.0145f
C18 vdd m1_6882_530# 1.73511f
C19 vbn_leak c0 0.02851f
C20 m1_3648_240# m1_5572_1070# 0
C21 vdd c3 0.15124f
C22 m1_3648_240# m1_6882_530# 0.50251f
C23 m1_3648_240# c3 0.02293f
C24 m1_6882_530# m1_5572_1070# 0.18891f
C25 c3 m1_5572_1070# 0
C26 c3 m1_6882_530# 0.13961f
C27 aux vbn_leak 0.30263f
C28 vbn_leak m1_2488_800# 0.30087f
C29 c1 c0 0.03516f
C30 vbn_leak c1 0.02044f
C31 c2 vbn_leak 0.03439f
C32 m1_5978_958# c0 0.02922f
C33 m1_5978_958# vbn_leak 0.21696f
C34 vdd c0 0.15246f
C35 vdd vbn_leak 0.113f
C36 vbn_leak m1_3648_240# 0.19401f
C37 aux m1_2488_800# 0.00727f
C38 c0 m1_5572_1070# 0.00139f
C39 vbn_leak m1_5572_1070# 0.22663f
C40 c0 m1_6882_530# 0.10589f
C41 vbn_leak m1_6882_530# 1.11959f
C42 aux c2 0.05619f
C43 vbn_leak c3 0.02044f
C44 c2 m1_2488_800# 0.03276f
C45 vdd aux 0.10055f
C46 vdd m1_2488_800# 0.03084f
C47 m1_3648_240# m1_2488_800# 0.00686f
C48 m1_6882_530# vss 1.81378f
C49 vbn_leak vss 3.84423f
C50 aux vss 1.59997f
C51 m1_3648_240# vss 0.28772f
C52 c3 vss 0.29824f
C53 c2 vss 0.32075f
C54 m1_5572_1070# vss 0.13835f
C55 c1 vss 0.27443f
C56 m1_2488_800# vss 0.10282f
C57 c0 vss 0.24838f
C58 m1_5978_958# vss 0.04813f
C59 vdd vss 2.52101f
.ends
