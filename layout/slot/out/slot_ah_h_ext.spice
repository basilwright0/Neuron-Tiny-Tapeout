* NGSPICE file created from slot_ah_h.ext - technology: gf180mcuD

.subckt p_w2_l4 a_400_n200# a_n400_n244# w_n574_n330# a_n488_n200#
X0 a_400_n200# a_n400_n244# a_n488_n200# w_n574_n330# pfet_03v3 ad=0.88p pd=4.88u as=0.88p ps=4.88u w=2u l=4u
.ends

.subckt n_w1_l0p28 a_28_n100# a_n28_n144# a_n116_n100# VSUBS
X0 a_28_n100# a_n28_n144# a_n116_n100# VSUBS nfet_03v3 ad=0.44p pd=2.88u as=0.44p ps=2.88u w=1u l=0.28u
.ends

.subckt n_w2_l2 a_n288_n200# a_200_n200# a_n200_n244# VSUBS
X0 a_200_n200# a_n200_n244# a_n288_n200# VSUBS nfet_03v3 ad=0.88p pd=4.88u as=0.88p ps=4.88u w=2u l=2u
.ends

.subckt n_w2_l4 a_400_n200# a_n400_n244# a_n488_n200# VSUBS
X0 a_400_n200# a_n400_n244# a_n488_n200# VSUBS nfet_03v3 ad=0.88p pd=4.88u as=0.88p ps=4.88u w=2u l=4u
.ends

.subckt n_w0p5_l0p28 a_n28_n94# a_n116_n50# a_28_n50# VSUBS
X0 a_28_n50# a_n28_n94# a_n116_n50# VSUBS nfet_03v3 ad=0.22p pd=1.88u as=0.22p ps=1.88u w=0.5u l=0.28u
.ends

.subckt p_w1_l0p5 a_n138_n100# a_50_n100# a_n50_n144# w_n224_n230#
X0 a_50_n100# a_n50_n144# a_n138_n100# w_n224_n230# pfet_03v3 ad=0.44p pd=2.88u as=0.44p ps=2.88u w=1u l=0.5u
.ends

.subckt n_w0p5_l0p5 a_n138_n50# a_50_n50# a_n50_n94# VSUBS
X0 a_50_n50# a_n50_n94# a_n138_n50# VSUBS nfet_03v3 ad=0.22p pd=1.88u as=0.22p ps=1.88u w=0.5u l=0.5u
.ends

.subckt p_w1_l0p28 w_n202_n230# a_28_n100# a_n28_n144# a_n116_n100#
X0 a_28_n100# a_n28_n144# a_n116_n100# w_n202_n230# pfet_03v3 ad=0.44p pd=2.88u as=0.44p ps=2.88u w=1u l=0.28u
.ends

.subckt n_w1_l0p5 a_n138_n100# a_50_n100# a_n50_n144# VSUBS
X0 a_50_n100# a_n50_n144# a_n138_n100# VSUBS nfet_03v3 ad=0.44p pd=2.88u as=0.44p ps=2.88u w=1u l=0.5u
.ends

.subckt n_w4_l2 a_n288_n400# a_200_n400# a_n200_n444# VSUBS
X0 a_200_n400# a_n200_n444# a_n288_n400# VSUBS nfet_03v3 ad=1.76p pd=8.88u as=1.76p ps=8.88u w=4u l=2u
.ends

.subckt p_w1_l2 w_n374_n230# a_n288_n100# a_200_n100# a_n200_n144#
X0 a_200_n100# a_n200_n144# a_n288_n100# w_n374_n230# pfet_03v3 ad=0.44p pd=2.88u as=0.44p ps=2.88u w=1u l=2u
.ends

.subckt n_w7p07_l7p07 a_707_n707# a_n795_n707# a_n707_n751# VSUBS
X0 a_707_n707# a_n707_n751# a_n795_n707# VSUBS nfet_03v3 ad=3.1108p pd=15.02u as=3.1108p ps=15.02u w=7.07u l=7.07u
.ends

.subckt n_w0p5_l1p5 a_150_n50# a_n238_n50# a_n150_n94# VSUBS
X0 a_150_n50# a_n150_n94# a_n238_n50# VSUBS nfet_03v3 ad=0.22p pd=1.88u as=0.22p ps=1.88u w=0.5u l=1.5u
.ends

.subckt n_w3p54_l3p54 a_354_n354# a_n354_n398# a_n442_n354# VSUBS
X0 a_354_n354# a_n354_n398# a_n442_n354# VSUBS nfet_03v3 ad=1.5576p pd=7.96u as=1.5576p ps=7.96u w=3.54u l=3.54u
.ends

.subckt n_w0p22_l2 a_200_n22# a_n200_n66# a_n292_n36# VSUBS
X0 a_200_n22# a_n200_n66# a_n292_n36# VSUBS nfet_03v3 ad=0.1516p pd=1.64u as=0.1516p ps=1.64u w=0.22u l=2u
.ends

.subckt n_w0p5_l3 a_n388_n50# a_300_n50# a_n300_n94# VSUBS
X0 a_300_n50# a_n300_n94# a_n388_n50# VSUBS nfet_03v3 ad=0.22p pd=1.88u as=0.22p ps=1.88u w=0.5u l=3u
.ends

.subckt n_w0p5_l4 a_n488_n50# a_400_n50# a_n400_n94# VSUBS
X0 a_400_n50# a_n400_n94# a_n488_n50# VSUBS nfet_03v3 ad=0.22p pd=1.88u as=0.22p ps=1.88u w=0.5u l=4u
.ends

.subckt slot_ah_h vss vbp_syn vdd el aux vbn_leak vsrc vbp_st vbn_prb vbn_ref en vreset
+ abus spk t3 t2 t1 t0 sta stb hold mreset rsel sub sub_b vm
XXL_XP1 a_480_5620# a_480_5620# vdd vdd p_w2_l4
XXPM_XSW m1_3620_1976# rsel m1_3360_308# vss n_w1_l0p28
XXL_XP2 a_1580_2680# a_480_5620# vdd vdd p_w2_l4
XXPR_XMB vss m1_4822_1769# vbn_prb vss n_w2_l2
XXL_XMT m1_218_2312# vbn_leak vss vss n_w2_l4
XXL_XM1 a_280_2680# a_480_5620# el vss n_w2_l2
XXS_XWA m1_4822_6422# vbp_syn vdd m1_3652_6232# p_w2_l4
XXR_Xi_XN spk vss a_3844_4734# vss n_w0p5_l0p28
XXL_XM2 a_2240_2680# a_1580_2680# a_1580_2680# vss n_w2_l2
XXS_XWB m1_4822_6422# vbp_syn vdd m1_3212_6232# p_w2_l4
XXR_XNR vss vbn_ref a_2510_1690# vss n_w2_l4
XXD_XPI m1_1728_4540# a_2160_3542# vm vdd p_w1_l0p5
XXPR_XME m1_2640_980# en m1_4822_1769# vss n_w1_l0p28
XXR_XSW vreset vm a_2510_1690# vss n_w0p5_l0p5
XXR_Xi_XP vdd a_3844_4734# spk vdd p_w1_l0p28
XXD_XNI vsrc a_2160_3542# vm vss n_w1_l0p5
XXPR_XMF m1_2640_980# vdd a_2510_1690# vss n_w4_l2
XXS_XQA vdd m1_3652_6232# sta vss p_w1_l0p28
XXS_XQB vdd m1_3212_6232# stb vss p_w1_l0p28
XXL_XD1 m1_218_2312# a_280_2680# a_280_2680# vss n_w2_l2
XXS_XNA sta vm m1_3652_6232# vss n_w0p5_l0p28
XXL_XD2 m1_218_2312# a_2240_2680# a_2240_2680# vss n_w2_l2
XXS_XNB stb vm m1_3212_6232# vss n_w0p5_l0p28
XXD_XS2 vdd vdd m1_2240_4540# vbp_st p_w1_l2
XXD_XPS vdd vdd m1_1728_4540# vbp_st p_w1_l2
XXPM_XSB m1_3620_1976# sub_b abus vss n_w1_l0p28
XXC_XC vss vss vm vss n_w7p07_l7p07
XXS_XPH vdd m1_4822_6422# vdd hold p_w1_l2
XXT_XR1 m1_2117_7612# m1_1545_7160# vbn_leak vss n_w0p5_l1p5
XXD_XP2 vdd a_2804_3624# a_2160_3542# m1_2240_4540# p_w1_l0p28
XXPR_XSW m1_2960_1560# rsel m1_2640_980# vss n_w1_l0p28
XXT_XR2 m1_201_7160# m1_2117_7612# vbn_leak vss n_w0p5_l1p5
XXT_XP0 vdd m1_2521_6720# t0 vm p_w1_l0p28
XXD_Xi4_XN a_3184_3624# vss spk vss n_w0p5_l0p28
XXD_XP3 vdd a_3184_3624# a_2804_3624# vdd p_w1_l0p28
XXT_XR3 m1_230_7612# m1_201_7160# vbn_leak vss n_w0p5_l1p5
XXT_XP1 vdd m1_1960_6220# t1 vm p_w1_l0p28
XXR_XCR_XC vss a_2510_1690# vss vss n_w3p54_l3p54
XXD_XN2 a_2804_3624# a_2160_3542# vsrc vss n_w0p22_l2
XXT_XN0 t0 a_480_5620# m1_2521_6720# vss n_w0p5_l0p28
XXT_XP2 vdd m1_1400_6220# t2 vm p_w1_l0p28
XXD_Xi4_XP vdd spk a_3184_3624# vdd p_w1_l0p28
XXD_XN3 a_2804_3624# vsrc a_3184_3624# vss n_w0p5_l0p28
XXPM_XMB vss m1_4822_412# vbn_prb vss n_w2_l2
XXT_XN1 t1 a_480_5620# m1_1960_6220# vss n_w0p5_l0p28
XXT_XP3 vdd m1_853_6232# t3 vm p_w1_l0p28
XXT_XL0 m1_2521_6720# m1_230_7612# vbn_leak vss n_w0p5_l3
XXT_XN2 t2 a_480_5620# m1_1400_6220# vss n_w0p5_l0p28
XXT_XLT m1_230_7612# vdd vbn_leak vss n_w0p5_l3
XXT_XL1 m1_1960_6220# m1_201_7160# vbn_leak vss n_w0p5_l3
XXT_XN3 t3 a_480_5620# m1_853_6232# vss n_w0p5_l0p28
XXR_XPC vdd a_2510_1690# a_3844_4734# vdd p_w1_l0p28
XXPM_XME m1_3360_308# en m1_4822_412# vss n_w1_l0p28
XXT_XL2 m1_1400_6220# m1_2117_7612# vbn_leak vss n_w0p5_l3
XXT_XL3 m1_853_6232# m1_1545_7160# vbn_leak vss n_w0p5_l3
XXPM_XMF m1_3360_308# vdd vm vss n_w4_l2
XXS_XHL vdd vm hold a_1580_2680# p_w1_l0p28
XXS_XMR mreset a_2510_1690# vdd vss n_w0p5_l0p28
XXPR_XSB m1_2960_1560# sub abus vss n_w1_l0p28
XXT_XRB m1_1104_8052# m1_1545_7160# vbn_leak vss n_w0p5_l4
XXT_XRA vss m1_1104_8052# vbn_leak vss n_w0p5_l4
.ends
