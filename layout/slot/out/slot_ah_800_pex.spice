* NGSPICE file created from slot_ah_800.ext - technology: gf180mcuD

.subckt p_w0p22_l1 a_100_n22# a_n100_n66# w_n278_n159# a_n192_n36# VSUBS
X0 a_100_n22# a_n100_n66# a_n192_n36# w_n278_n159# pfet_03v3 ad=0.1516p pd=1.64u as=0.1516p ps=1.64u w=0.22u l=1u
C0 w_n278_n159# a_n100_n66# 0.13163f
C1 a_n192_n36# a_n100_n66# 0.00509f
C2 w_n278_n159# a_100_n22# 0.00771f
C3 a_100_n22# a_n192_n36# 0.00453f
C4 a_100_n22# a_n100_n66# 0.00509f
C5 w_n278_n159# a_n192_n36# 0.00771f
C6 a_100_n22# VSUBS 0.05952f
C7 a_n192_n36# VSUBS 0.05952f
C8 w_n278_n159# VSUBS 0.53042f
.ends

.subckt p_w2_l4 a_400_n200# a_n400_n244# w_n574_n330# a_n488_n200# VSUBS
X0 a_400_n200# a_n400_n244# a_n488_n200# w_n574_n330# pfet_03v3 ad=0.88p pd=4.88u as=0.88p ps=4.88u w=2u l=4u
C0 w_n574_n330# a_n488_n200# 0.07409f
C1 a_n400_n244# a_n488_n200# 0.07019f
C2 w_n574_n330# a_400_n200# 0.07409f
C3 a_400_n200# a_n400_n244# 0.07019f
C4 a_400_n200# a_n488_n200# 0.01073f
C5 w_n574_n330# a_n400_n244# 0.42229f
C6 a_400_n200# VSUBS 0.18936f
C7 a_n488_n200# VSUBS 0.18936f
C8 w_n574_n330# VSUBS 2.27304f
.ends

.subckt n_w1_l0p28 a_28_n100# a_n28_n144# a_n116_n100# VSUBS
X0 a_28_n100# a_n28_n144# a_n116_n100# VSUBS nfet_03v3 ad=0.44p pd=2.88u as=0.44p ps=2.88u w=1u l=0.28u
C0 a_n28_n144# a_28_n100# 0.00769f
C1 a_n116_n100# a_28_n100# 0.04256f
C2 a_n28_n144# a_n116_n100# 0.00769f
C3 a_28_n100# VSUBS 0.09911f
C4 a_n116_n100# VSUBS 0.09911f
.ends

.subckt n_w2_l4 a_400_n200# a_n400_n244# a_n488_n200# VSUBS
X0 a_400_n200# a_n400_n244# a_n488_n200# VSUBS nfet_03v3 ad=0.88p pd=4.88u as=0.88p ps=4.88u w=2u l=4u
C0 a_n400_n244# a_400_n200# 0.07019f
C1 a_n488_n200# a_400_n200# 0.01073f
C2 a_n400_n244# a_n488_n200# 0.07019f
C3 a_400_n200# VSUBS 0.41684f
C4 a_n488_n200# VSUBS 0.41684f
.ends

.subckt n_w2_l2 a_n288_n200# a_200_n200# a_n200_n244# VSUBS
X0 a_200_n200# a_n200_n244# a_n288_n200# VSUBS nfet_03v3 ad=0.88p pd=4.88u as=0.88p ps=4.88u w=2u l=2u
C0 a_n200_n244# a_200_n200# 0.0587f
C1 a_n288_n200# a_200_n200# 0.02133f
C2 a_n200_n244# a_n288_n200# 0.0587f
C3 a_200_n200# VSUBS 0.2667f
C4 a_n288_n200# VSUBS 0.2667f
.ends

.subckt n_w4_l1 a_n188_n400# a_100_n400# a_n100_n444# VSUBS
X0 a_100_n400# a_n100_n444# a_n188_n400# VSUBS nfet_03v3 ad=1.76p pd=8.88u as=1.76p ps=8.88u w=4u l=1u
C0 a_n100_n444# a_100_n400# 0.08505f
C1 a_n188_n400# a_100_n400# 0.07756f
C2 a_n100_n444# a_n188_n400# 0.08505f
C3 a_100_n400# VSUBS 0.26859f
C4 a_n188_n400# VSUBS 0.26859f
.ends

.subckt n_w0p5_l0p28 a_n28_n94# a_n116_n50# a_28_n50# VSUBS
X0 a_28_n50# a_n28_n94# a_n116_n50# VSUBS nfet_03v3 ad=0.22p pd=1.88u as=0.22p ps=1.88u w=0.5u l=0.28u
C0 a_n28_n94# a_28_n50# 0.00377f
C1 a_n116_n50# a_28_n50# 0.02085f
C2 a_n28_n94# a_n116_n50# 0.00377f
C3 a_28_n50# VSUBS 0.07987f
C4 a_n116_n50# VSUBS 0.07987f
.ends

.subckt p_w1_l0p5 a_n138_n100# a_50_n100# a_n50_n144# w_n224_n230# VSUBS
X0 a_50_n100# a_n50_n144# a_n138_n100# w_n224_n230# pfet_03v3 ad=0.44p pd=2.88u as=0.44p ps=2.88u w=1u l=0.5u
C0 w_n224_n230# a_n138_n100# 0.0205f
C1 a_n50_n144# a_n138_n100# 0.01275f
C2 w_n224_n230# a_50_n100# 0.0205f
C3 a_50_n100# a_n50_n144# 0.01275f
C4 a_50_n100# a_n138_n100# 0.03085f
C5 w_n224_n230# a_n50_n144# 0.07993f
C6 a_50_n100# VSUBS 0.06546f
C7 a_n138_n100# VSUBS 0.06546f
C8 w_n224_n230# VSUBS 0.61824f
.ends

.subckt n_w1_l0p5 a_n138_n100# a_50_n100# a_n50_n144# VSUBS
X0 a_50_n100# a_n50_n144# a_n138_n100# VSUBS nfet_03v3 ad=0.44p pd=2.88u as=0.44p ps=2.88u w=1u l=0.5u
C0 a_n50_n144# a_50_n100# 0.01275f
C1 a_n138_n100# a_50_n100# 0.03085f
C2 a_n50_n144# a_n138_n100# 0.01275f
C3 a_50_n100# VSUBS 0.11563f
C4 a_n138_n100# VSUBS 0.11563f
.ends

.subckt p_w1_l0p28 w_n202_n230# a_28_n100# a_n28_n144# a_n116_n100# VSUBS
X0 a_28_n100# a_n28_n144# a_n116_n100# w_n202_n230# pfet_03v3 ad=0.44p pd=2.88u as=0.44p ps=2.88u w=1u l=0.28u
C0 w_n202_n230# a_n116_n100# 0.01808f
C1 a_n28_n144# a_n116_n100# 0.00769f
C2 w_n202_n230# a_28_n100# 0.01808f
C3 a_28_n100# a_n28_n144# 0.00769f
C4 a_28_n100# a_n116_n100# 0.04256f
C5 w_n202_n230# a_n28_n144# 0.05841f
C6 a_28_n100# VSUBS 0.0597f
C7 a_n116_n100# VSUBS 0.0597f
C8 w_n202_n230# VSUBS 0.55752f
.ends

.subckt n_w4_l2 a_n288_n400# a_200_n400# a_n200_n444# VSUBS
X0 a_200_n400# a_n200_n444# a_n288_n400# VSUBS nfet_03v3 ad=1.76p pd=8.88u as=1.76p ps=8.88u w=4u l=2u
C0 a_n200_n444# a_200_n400# 0.11799f
C1 a_n288_n400# a_200_n400# 0.04287f
C2 a_n200_n444# a_n288_n400# 0.11799f
C3 a_200_n400# VSUBS 0.34365f
C4 a_n288_n400# VSUBS 0.34365f
.ends

.subckt p_w1_l2 w_n374_n230# a_n288_n100# a_200_n100# a_n200_n144# VSUBS
X0 a_200_n100# a_n200_n144# a_n288_n100# w_n374_n230# pfet_03v3 ad=0.44p pd=2.88u as=0.44p ps=2.88u w=1u l=2u
C0 w_n374_n230# a_n288_n100# 0.03135f
C1 a_n200_n144# a_n288_n100# 0.02905f
C2 w_n374_n230# a_200_n100# 0.03135f
C3 a_200_n100# a_n200_n144# 0.02905f
C4 a_200_n100# a_n288_n100# 0.01056f
C5 w_n374_n230# a_n200_n144# 0.22666f
C6 a_200_n100# VSUBS 0.1047f
C7 a_n288_n100# VSUBS 0.1047f
C8 w_n374_n230# VSUBS 1.03224f
.ends

.subckt n_w7p07_l7p07 a_707_n707# a_n795_n707# a_n707_n751# VSUBS
X0 a_707_n707# a_n707_n751# a_n795_n707# VSUBS nfet_03v3 ad=3.1108p pd=15.02u as=3.1108p ps=15.02u w=7.07u l=7.07u
C0 a_n707_n751# a_707_n707# 0.27012f
C1 a_n795_n707# a_707_n707# 0.0212f
C2 a_n707_n751# a_n795_n707# 0.27012f
C3 a_707_n707# VSUBS 0.84237f
C4 a_n795_n707# VSUBS 0.84237f
.ends

.subckt n_w3p54_l3p54 a_354_n354# a_n354_n398# a_n442_n354# VSUBS
X0 a_354_n354# a_n354_n398# a_n442_n354# VSUBS nfet_03v3 ad=1.5576p pd=7.96u as=1.5576p ps=7.96u w=3.54u l=3.54u
C0 a_n354_n398# a_354_n354# 0.12189f
C1 a_n442_n354# a_354_n354# 0.02161f
C2 a_n354_n398# a_n442_n354# 0.12189f
C3 a_354_n354# VSUBS 0.44156f
C4 a_n442_n354# VSUBS 0.44156f
.ends

.subckt n_w0p22_l2 a_200_n22# a_n200_n66# a_n292_n36# VSUBS
X0 a_200_n22# a_n200_n66# a_n292_n36# VSUBS nfet_03v3 ad=0.1516p pd=1.64u as=0.1516p ps=1.64u w=0.22u l=2u
C0 a_n292_n36# a_200_n22# 0.00245f
C1 a_n200_n66# a_200_n22# 0.00705f
C2 a_n292_n36# a_n200_n66# 0.00705f
C3 a_200_n22# VSUBS 0.20767f
C4 a_n292_n36# VSUBS 0.20767f
.ends

.subckt n_w11p7_l11p6 a_n1248_n1170# a_1160_n1170# a_n1160_n1214# VSUBS
X0 a_1160_n1170# a_n1160_n1214# a_n1248_n1170# VSUBS nfet_03v3 ad=5.148p pd=24.28u as=5.148p ps=24.28u w=11.7u l=11.6u
C0 a_n1160_n1214# a_1160_n1170# 0.45204f
C1 a_n1160_n1214# a_n1248_n1170# 0.45204f
C2 a_1160_n1170# VSUBS 1.42218f
C3 a_n1248_n1170# VSUBS 1.42218f
.ends

.subckt slot_ah_800 vss vbp_syn vdd el aux vbn_leak vsrc vbp_st vbn_prb vbn_ref en
+ vreset abus spk sta stb hold mreset rsel sub sub_b vm
XXD_XK a_3184_3624# spk vdd vdd vss p_w0p22_l1
XXL_XP1 a_480_5620# a_480_5620# vdd vdd vss p_w2_l4
XXPM_XSW m1_4052_1572# rsel m1_3704_1572# vss n_w1_l0p28
XXL_XP2 m1_388_4540# a_480_5620# vdd vdd vss p_w2_l4
XXL_XMT m1_201_2424# vbn_leak vss vss n_w2_l4
XXPR_XMB vss m1_4802_1762# vbn_prb vss n_w2_l2
XXL_XM1 a_288_2940# a_480_5620# el vss n_w4_l1
XXS_XWA m1_4902_6372# vbp_syn vdd m1_3652_6232# vss p_w2_l4
XXR_Xi_XN spk vss a_3844_4734# vss n_w0p5_l0p28
XXL_XM2 a_2080_2940# m1_388_4540# m1_388_4540# vss n_w4_l1
XXS_XWB m1_4902_6372# vbp_syn vdd m1_3212_6232# vss p_w2_l4
XXR_XNR vss vbn_ref a_2510_1740# vss n_w2_l4
XXD_XPI m1_1692_4540# a_2160_3542# vm vdd vss p_w1_l0p5
XXPR_XME m1_2628_744# en m1_4802_1762# vss n_w1_l0p28
XXR_XSW vreset vm a_2510_1740# vss n_w1_l0p5
XXR_Xi_XP vdd a_3844_4734# spk vdd vss p_w1_l0p28
XXD_XNI vsrc a_2160_3542# vm vss n_w1_l0p5
XXPR_XMF m1_2628_744# vdd a_2510_1740# vss n_w4_l2
XXS_XQA vdd m1_3652_6232# sta vss vss p_w1_l0p28
XXS_XQB vdd m1_3212_6232# stb vss vss p_w1_l0p28
XXS_XNA sta vm m1_3652_6232# vss n_w0p5_l0p28
XXS_XNB stb vm m1_3212_6232# vss n_w0p5_l0p28
XXD_XS2 vdd vdd m1_2140_4540# vbp_st vss p_w1_l2
XXD_XPS vdd vdd m1_1692_4540# vbp_st vss p_w1_l2
XXD_XS3 vdd vdd m1_1532_4440# vbp_st vss p_w1_l2
XXPM_XSB abus sub_b m1_4052_1572# vss n_w1_l0p28
XXL_XD2a m1_201_2424# a_2080_2940# a_2080_2940# vss n_w4_l1
XXPM_XSC m1_3704_1572# en m1_3360_172# vss n_w1_l0p28
XXC_XC vss vss vm vss n_w7p07_l7p07
XXL_XD1a m1_201_2424# a_288_2940# a_288_2940# vss n_w4_l1
XXL_XD2b m1_201_2424# a_2080_2940# a_2080_2940# vss n_w4_l1
XXS_XPH vdd m1_4902_6372# vdd hold vss p_w1_l2
XXD_XP2 vdd a_2804_3624# a_2160_3542# m1_2140_4540# vss p_w1_l0p28
XXPR_XSW m1_2972_1572# rsel m1_2240_960# vss n_w1_l0p28
XXL_XD1b m1_201_2424# a_288_2940# a_288_2940# vss n_w4_l1
XXD_Xi4_XN a_3184_3624# vss spk vss n_w0p5_l0p28
XXD_XP3 vdd a_3184_3624# a_2804_3624# m1_1532_4440# vss p_w1_l0p28
XXR_XCR_XC vss a_2510_1740# vss vss n_w3p54_l3p54
XXD_XN2 a_2804_3624# a_2160_3542# vsrc vss n_w0p22_l2
XXD_Xi4_XP vdd spk a_3184_3624# vdd vss p_w1_l0p28
XXD_XN3 a_2804_3624# vsrc a_3184_3624# vss n_w0p5_l0p28
XXPM_XMB vss m1_4822_412# vbn_prb vss n_w2_l2
XXR_XPC vdd a_2510_1740# a_3844_4734# vdd vss p_w1_l0p28
XXPM_XME m1_3360_172# en m1_4822_412# vss n_w1_l0p28
XXPM_XMF m1_3360_172# vdd vm vss n_w4_l2
XXS_XHL vdd vm hold m1_388_4540# vss p_w1_l0p28
XXS_XMR mreset a_2510_1740# vdd vss n_w0p5_l0p28
XXPR_XSB abus sub m1_2972_1572# vss n_w1_l0p28
XXPR_XSC m1_2628_744# en m1_2240_960# vss n_w1_l0p28
XXC2_XC vss vss vm vss n_w11p7_l11p6
C0 a_3844_4734# a_2510_1740# 0.43779f
C1 aux a_3844_4734# 0.0025f
C2 vbn_ref vbn_leak 0.01455f
C3 m1_3652_6232# vm 0.00955f
C4 a_2510_1740# vbp_st 0.16667f
C5 m1_2972_1572# vbn_leak 0
C6 vbp_syn spk 0.04795f
C7 a_480_5620# vdd 1.70901f
C8 vsrc vbp_syn 0.19464f
C9 en vdd 0.29276f
C10 aux vbp_st 0.04328f
C11 el abus 0.03404f
C12 a_3844_4734# vbn_leak 0.00407f
C13 sub a_2510_1740# 0.12139f
C14 vm sta 0.03383f
C15 vsrc m1_4902_6372# 0.01523f
C16 rsel abus 0.00745f
C17 sub aux 0
C18 el rsel 0.00525f
C19 a_2160_3542# m1_1532_4440# 0.11234f
C20 m1_2628_744# m1_3360_172# 0.11902f
C21 m1_3704_1572# abus 0.00594f
C22 m1_201_2424# spk 0.26505f
C23 m1_2140_4540# a_3184_3624# 0.11106f
C24 vsrc m1_201_2424# 0.06277f
C25 m1_3704_1572# rsel 0.0495f
C26 a_2080_2940# sub 0.22175f
C27 vbn_leak vbp_st 0.048f
C28 m1_3212_6232# sub_b 0.80514f
C29 sub vbn_leak 0.01957f
C30 m1_2240_960# abus 0
C31 vbn_ref spk 0
C32 el m1_2240_960# 0.00833f
C33 vsrc vbn_ref 0.04416f
C34 m1_3212_6232# hold 0.8591f
C35 a_3184_3624# m1_388_4540# 0
C36 vm abus 0.03496f
C37 m1_2240_960# rsel 0.02493f
C38 el vm 0.36752f
C39 m1_2240_960# m1_3704_1572# 0
C40 vreset en 2.20971f
C41 a_2804_3624# sub_b 0.00102f
C42 vm rsel 0.06671f
C43 m1_3704_1572# vm 0
C44 mreset sub_b 0.15693f
C45 a_3844_4734# spk 0.16837f
C46 m1_2628_744# vbp_syn 0.11508f
C47 a_288_2940# a_480_5620# -0.07177f
C48 vsrc a_3844_4734# 0
C49 vreset vdd 0.22097f
C50 m1_1692_4540# sub_b 0.01594f
C51 en m1_4802_1762# 0.08432f
C52 hold mreset 0.37417f
C53 a_288_2940# vdd 0.0017f
C54 m1_1692_4540# hold 0
C55 m1_2140_4540# m1_1532_4440# 0.06162f
C56 a_2160_3542# a_480_5620# 0.02105f
C57 vbn_prb sub_b 0.01139f
C58 vbp_st spk 0.25422f
C59 m1_2240_960# vm 0.14578f
C60 vsrc vbp_st 1.70292f
C61 stb vbp_syn 0
C62 m1_3212_6232# a_2510_1740# 0.23231f
C63 m1_2628_744# m1_201_2424# 0
C64 aux m1_3212_6232# 0
C65 a_2160_3542# vdd 0.42238f
C66 vbn_prb hold 0.08475f
C67 sub spk 0.10799f
C68 vsrc sub 0.11888f
C69 m1_388_4540# m1_1532_4440# 0.02423f
C70 vbn_ref m1_2628_744# 0.0373f
C71 vbn_ref a_3184_3624# 0
C72 m1_3212_6232# vbn_leak 0
C73 a_2510_1740# mreset 0.04101f
C74 en m1_4822_412# 0.09094f
C75 m1_2972_1572# m1_2628_744# 0
C76 aux mreset 0.02835f
C77 m1_1692_4540# a_2510_1740# 0.00283f
C78 a_2080_2940# a_2804_3624# 0.00768f
C79 vdd m1_4822_412# 0.01221f
C80 vreset m1_4802_1762# 0.00744f
C81 vbn_prb a_2510_1740# 0.10648f
C82 a_3844_4734# a_3184_3624# 0.02458f
C83 vbn_prb aux 0
C84 m1_2140_4540# a_480_5620# 0.0052f
C85 en m1_3360_172# 0.14766f
C86 vbn_leak mreset 0.03775f
C87 m1_2628_744# vbp_st 0.02945f
C88 m1_1532_4440# m1_201_2424# 0
C89 a_3184_3624# vbp_st 0.0078f
C90 m1_2140_4540# vdd 0.45277f
C91 m1_3360_172# vdd 0.31559f
C92 sub m1_2628_744# 0
C93 sub_b sta 0.001f
C94 a_480_5620# m1_388_4540# 0.71704f
C95 vbn_prb vbn_leak 0.00103f
C96 sub a_3184_3624# 0.00235f
C97 stb vbp_st 0.0029f
C98 m1_3212_6232# spk 0.1953f
C99 vsrc m1_3212_6232# 0
C100 vdd m1_388_4540# 0.59355f
C101 stb sub 0.01742f
C102 vreset m1_4822_412# 0.01887f
C103 a_480_5620# vbp_syn 0
C104 en vbp_syn 0.0837f
C105 a_2804_3624# spk 0.01178f
C106 vsrc a_2804_3624# 0.11197f
C107 m1_3652_6232# a_2510_1740# 0.0633f
C108 sub_b abus 0.04187f
C109 spk mreset 0.12446f
C110 el sub_b 0.13592f
C111 m1_3652_6232# aux 0
C112 vsrc mreset 0.04164f
C113 en m1_4902_6372# 0.02251f
C114 vdd vbp_syn 2.92995f
C115 m1_1692_4540# spk 0.0629f
C116 rsel sub_b 0.25309f
C117 vsrc m1_1692_4540# 0.00178f
C118 vbp_st m1_1532_4440# 0.01244f
C119 vreset m1_3360_172# 0.02305f
C120 hold abus 0.00697f
C121 m1_3704_1572# sub_b 0
C122 el hold 0.02081f
C123 en m1_201_2424# 0
C124 a_480_5620# m1_201_2424# 0.01234f
C125 m1_4902_6372# vdd 0.2413f
C126 rsel hold 0.30549f
C127 vbn_prb spk 0
C128 a_2510_1740# sta 0.00126f
C129 vsrc vbn_prb 0.01069f
C130 sub m1_1532_4440# 0.07168f
C131 aux sta 0
C132 vdd m1_201_2424# 0.02421f
C133 vbn_ref en 1.79771f
C134 m1_2140_4540# a_2160_3542# 0.08627f
C135 m1_2240_960# sub_b 0
C136 a_288_2940# m1_388_4540# 0
C137 vm sub_b 0.05333f
C138 m1_3212_6232# a_3184_3624# 0
C139 vbn_ref vdd 0.31976f
C140 m1_2972_1572# en 0
C141 vbn_leak sta 0
C142 vm hold 0.06951f
C143 a_2160_3542# m1_388_4540# 0.16546f
C144 en a_3844_4734# 0
C145 a_2510_1740# abus 0.08438f
C146 vreset vbp_syn 0.02971f
C147 stb m1_3212_6232# 0.0999f
C148 el a_2510_1740# 0.24557f
C149 m1_4052_1572# abus 0.00443f
C150 m1_2972_1572# vdd 0.00397f
C151 m1_4052_1572# el 0.0395f
C152 aux abus 0.03413f
C153 el aux 1.64886f
C154 rsel a_2510_1740# 0.19705f
C155 m1_4052_1572# rsel 0
C156 a_3184_3624# a_2804_3624# 0.16023f
C157 aux rsel 0
C158 vreset m1_4902_6372# 0.01045f
C159 m1_3704_1572# a_2510_1740# 0
C160 a_3844_4734# vdd 0.45926f
C161 m1_4052_1572# m1_3704_1572# 0
C162 a_2080_2940# el 0.05061f
C163 en vbp_st 0.06671f
C164 a_480_5620# vbp_st 0.2875f
C165 m1_3360_172# m1_4822_412# 0.05008f
C166 a_2080_2940# rsel 0.01297f
C167 m1_1692_4540# a_3184_3624# 0.00321f
C168 vreset m1_201_2424# 0.00549f
C169 m1_3652_6232# spk 0
C170 a_2160_3542# vbp_syn 0
C171 vbn_leak abus 0.07624f
C172 el vbn_leak 0.02131f
C173 vbn_prb m1_2628_744# 0.1063f
C174 en sub 0.01848f
C175 sub a_480_5620# 0.04655f
C176 vbp_st vdd 1.9873f
C177 stb mreset 0.01845f
C178 m1_2240_960# a_2510_1740# 0.04071f
C179 rsel vbn_leak 0.176f
C180 m1_4052_1572# m1_2240_960# 0
C181 a_288_2940# m1_201_2424# 0.38608f
C182 m1_2240_960# aux 0
C183 m1_3704_1572# vbn_leak 0
C184 vreset vbn_ref 0.04104f
C185 sub vdd 0.29433f
C186 vm a_2510_1740# 0.34921f
C187 m1_4052_1572# vm 0
C188 spk sta 0.04285f
C189 aux vm 0
C190 vsrc sta 0
C191 a_2080_2940# m1_2240_960# 0.00563f
C192 a_2160_3542# m1_201_2424# 0.00841f
C193 m1_2972_1572# vreset 0.00129f
C194 a_2080_2940# vm 0.23878f
C195 vbn_ref m1_4802_1762# 0.07631f
C196 m1_2240_960# vbn_leak 0
C197 m1_2140_4540# m1_388_4540# 0.09804f
C198 m1_1532_4440# a_2804_3624# 0.21724f
C199 vreset a_3844_4734# 0
C200 vm vbn_leak 0.00252f
C201 m1_1692_4540# m1_1532_4440# 0.05798f
C202 vreset vbp_st 0.02708f
C203 el spk 0.14719f
C204 vsrc abus 0.09578f
C205 vsrc el 0.02425f
C206 rsel spk 0.34526f
C207 m1_2140_4540# vbp_syn 0.05617f
C208 a_2160_3542# a_3844_4734# 0.00112f
C209 m1_3360_172# vbp_syn 0.06805f
C210 vsrc rsel 0.07507f
C211 vreset sub 0.00144f
C212 a_288_2940# vbp_st 0
C213 m1_4802_1762# vbp_st 0.00495f
C214 m1_3212_6232# a_480_5620# 0.13072f
C215 vbn_ref m1_4822_412# 0.08626f
C216 a_2160_3542# vbp_st 0.00763f
C217 m1_388_4540# vbp_syn 0
C218 m1_2240_960# spk 0
C219 m1_3360_172# m1_201_2424# 0
C220 m1_3212_6232# vdd 0.3142f
C221 a_2160_3542# sub 0.19134f
C222 vm spk 7.82638f
C223 vsrc vm 0.12206f
C224 a_480_5620# a_2804_3624# 0
C225 vbn_ref m1_2140_4540# 0
C226 vbn_ref m1_3360_172# 0.03584f
C227 stb sta 0.00537f
C228 m1_388_4540# m1_201_2424# 0.28593f
C229 en mreset 0
C230 vdd a_2804_3624# 0.30709f
C231 m1_1692_4540# a_480_5620# 0.09584f
C232 vbp_st m1_4822_412# 0.01272f
C233 m1_2972_1572# m1_3360_172# 0.00217f
C234 m1_2628_744# abus 0.11059f
C235 vdd mreset 0.27232f
C236 el m1_2628_744# 0.04726f
C237 hold sub_b 0.13844f
C238 m1_4902_6372# vbp_syn 0.194f
C239 m1_2140_4540# a_3844_4734# 0.09191f
C240 m1_1692_4540# vdd 0.50639f
C241 vbn_prb en 0.09094f
C242 rsel m1_2628_744# 0.01218f
C243 m1_3704_1572# m1_2628_744# 0.03629f
C244 vbp_syn m1_201_2424# 0.05892f
C245 a_3184_3624# rsel 0.15623f
C246 vbn_prb vdd 0.15866f
C247 m1_2140_4540# vbp_st 0.12596f
C248 vbp_st m1_3360_172# 0.02967f
C249 stb rsel 0.04803f
C250 vbn_ref vbp_syn 0.00586f
C251 m1_2240_960# m1_2628_744# 0.00933f
C252 m1_2140_4540# sub 0.1127f
C253 sub m1_3360_172# 0.00185f
C254 vm m1_2628_744# 0.25919f
C255 vbn_ref m1_4902_6372# 0.10158f
C256 vbp_st m1_388_4540# 0.22941f
C257 m1_2972_1572# vbp_syn 0
C258 a_2510_1740# sub_b 0.31755f
C259 a_2160_3542# m1_3212_6232# 0
C260 m1_4052_1572# sub_b 0.02796f
C261 vm a_3184_3624# 0
C262 aux sub_b 0.10292f
C263 vreset mreset 0
C264 a_3844_4734# vbp_syn 0.20687f
C265 sub m1_388_4540# 0.12427f
C266 a_2510_1740# hold 0
C267 a_2080_2940# sub_b 0
C268 aux hold 0.02049f
C269 stb vm 0.01906f
C270 rsel m1_1532_4440# 0.00281f
C271 vreset vbn_prb 0.03589f
C272 a_2160_3542# a_2804_3624# 0.04808f
C273 vbp_st vbp_syn 0.17805f
C274 vbn_leak sub_b 0.14985f
C275 m1_3652_6232# vdd 0.214f
C276 m1_4902_6372# vbp_st 0.0733f
C277 sub vbp_syn 0.00856f
C278 a_2160_3542# m1_1692_4540# 0.07831f
C279 vbn_leak hold 0.02044f
C280 vbn_prb m1_4802_1762# 0.14133f
C281 en sta 0
C282 vbn_ref a_3844_4734# 0.00368f
C283 vdd sta 0.15097f
C284 m1_4052_1572# a_2510_1740# 0
C285 vm m1_1532_4440# 0.16487f
C286 aux a_2510_1740# 0.255f
C287 m1_4052_1572# aux 0.03062f
C288 sub m1_201_2424# 0.1508f
C289 vbn_ref vbp_st 0.04597f
C290 a_2080_2940# a_2510_1740# 0.01383f
C291 a_2080_2940# aux 0
C292 en abus 0.18705f
C293 el en 0.49816f
C294 el a_480_5620# 0.34909f
C295 spk sub_b 0.14146f
C296 vsrc sub_b 0.03659f
C297 a_2510_1740# vbn_leak 0.51934f
C298 m1_4052_1572# vbn_leak 0.00484f
C299 m1_3212_6232# m1_388_4540# 0
C300 aux vbn_leak 1.66661f
C301 en rsel 0.05176f
C302 rsel a_480_5620# 0.10026f
C303 m1_2140_4540# a_2804_3624# 0.21597f
C304 a_3844_4734# vbp_st 0.00568f
C305 vbn_prb m1_4822_412# 0.1097f
C306 m1_3704_1572# en 0.00704f
C307 m1_2972_1572# sub 0.04369f
C308 vdd abus 0.15657f
C309 hold spk 0.00826f
C310 el vdd 2.12267f
C311 vsrc hold 0.02121f
C312 a_2080_2940# vbn_leak 0.01624f
C313 rsel vdd 0.3104f
C314 m1_2140_4540# m1_1692_4540# 0.00749f
C315 sub a_3844_4734# 0
C316 m1_3704_1572# vdd 0.03146f
C317 vreset sta 0
C318 m1_388_4540# a_2804_3624# 0.00435f
C319 m1_2240_960# en 0.1237f
C320 m1_3212_6232# vbp_syn 0.32594f
C321 vbn_prb m1_3360_172# 0.0368f
C322 sub vbp_st 0.0525f
C323 en vm 0.05301f
C324 m1_1692_4540# m1_388_4540# 0.21296f
C325 vm a_480_5620# 0.75662f
C326 m1_3212_6232# m1_4902_6372# -0.0106f
C327 m1_2240_960# vdd 0
C328 vm vdd 2.69591f
C329 a_2510_1740# spk 0.07007f
C330 vsrc a_2510_1740# 0.13072f
C331 aux spk 0
C332 vsrc aux 0.02405f
C333 vreset abus 1.88811f
C334 vbp_syn mreset 0.03745f
C335 vreset el 0.02722f
C336 m1_2628_744# sub_b 0.01542f
C337 m1_1692_4540# vbp_syn 0
C338 vreset rsel 0.00163f
C339 a_2080_2940# spk 0.16828f
C340 vbn_ref m1_3212_6232# 0
C341 vsrc a_2080_2940# 0.09877f
C342 a_3184_3624# sub_b 0.00901f
C343 el a_288_2940# 0.11728f
C344 m1_4802_1762# abus 0.28337f
C345 a_2804_3624# m1_201_2424# 0
C346 vbn_prb vbp_syn 0.05999f
C347 vbn_leak spk 0.01915f
C348 vsrc vbn_leak 2.06803f
C349 stb sub_b 0.00223f
C350 el a_2160_3542# 0
C351 vbn_prb m1_4902_6372# 0.10654f
C352 vreset m1_2240_960# 0.13588f
C353 a_2160_3542# rsel 0.00395f
C354 stb hold 0.14469f
C355 vbn_ref mreset 0
C356 vreset vm 0.2025f
C357 vbn_prb m1_201_2424# 0
C358 m1_3212_6232# vbp_st 0.03714f
C359 m1_2140_4540# sta 0.00105f
C360 a_288_2940# vm 0.06959f
C361 a_3844_4734# a_2804_3624# 0
C362 a_2510_1740# m1_2628_744# 0.07885f
C363 vbn_ref vbn_prb 1.75069f
C364 m1_4052_1572# m1_2628_744# 0.03342f
C365 aux m1_2628_744# 0.02714f
C366 sub m1_3212_6232# 0.04046f
C367 m1_4822_412# abus 0.01191f
C368 el m1_4822_412# 0.00159f
C369 a_3184_3624# a_2510_1740# 0.0037f
C370 a_2160_3542# vm 0.08979f
C371 a_2080_2940# m1_2628_744# 0
C372 vbp_st a_2804_3624# 0.004f
C373 vsrc spk 0.16842f
C374 m1_3652_6232# vbp_syn 0.0728f
C375 vbp_st mreset 0.00308f
C376 vbn_prb a_3844_4734# 0
C377 vbn_leak m1_2628_744# 0.03114f
C378 sub a_2804_3624# 0.13986f
C379 m1_1692_4540# vbp_st 0.20212f
C380 m1_3652_6232# m1_4902_6372# -0.01073f
C381 m1_3360_172# abus 0.15198f
C382 sub mreset 0
C383 el m1_3360_172# 0.0538f
C384 a_3184_3624# vbn_leak 0
C385 m1_2140_4540# rsel 0.11902f
C386 rsel m1_3360_172# 0.00474f
C387 m1_1692_4540# sub 0.04437f
C388 vbn_prb vbp_st 1.71478f
C389 vbp_syn sta 0.09897f
C390 m1_3704_1572# m1_3360_172# 0.01359f
C391 vm m1_4822_412# 0
C392 el m1_388_4540# 0.05437f
C393 vbn_prb sub 0
C394 m1_4902_6372# sta 0
C395 rsel m1_388_4540# 0.07193f
C396 m1_2240_960# m1_3360_172# 0.00207f
C397 en sub_b 0.03389f
C398 a_480_5620# sub_b 0.34733f
C399 m1_2140_4540# vm 0.00346f
C400 vm m1_3360_172# 0.1922f
C401 a_2080_2940# m1_1532_4440# 0.00373f
C402 vbp_syn abus 0.03685f
C403 el vbp_syn 0.12085f
C404 a_480_5620# hold 0.20654f
C405 en hold 0.04799f
C406 vsrc m1_2628_744# 0.03087f
C407 vdd sub_b 1.05673f
C408 vbn_ref sta 0
C409 rsel vbp_syn 0.07625f
C410 a_3184_3624# spk 0.31051f
C411 m1_4902_6372# abus 0.00564f
C412 vsrc a_3184_3624# 0.03209f
C413 m1_3704_1572# vbp_syn 0.03849f
C414 vm m1_388_4540# 0.38878f
C415 vdd hold 1.03441f
C416 m1_3652_6232# vbp_st 0.00309f
C417 m1_3212_6232# a_2804_3624# 0
C418 m1_201_2424# abus 0
C419 el m1_201_2424# 0.03715f
C420 stb spk 0.0672f
C421 m1_3212_6232# mreset 0.15654f
C422 rsel m1_201_2424# 0.24913f
C423 m1_2240_960# vbp_syn 0
C424 m1_1692_4540# m1_3212_6232# 0
C425 vbn_ref abus 0.07474f
C426 vbn_ref el 0
C427 vm vbp_syn 0.11104f
C428 vbp_st sta 0.00825f
C429 a_2510_1740# a_480_5620# 0
C430 en a_2510_1740# 0.10385f
C431 vbn_ref rsel 0
C432 m1_4052_1572# en 0.00573f
C433 vbn_prb m1_3212_6232# 0
C434 en aux 0.06443f
C435 m1_2972_1572# abus 0.00644f
C436 vreset sub_b 0.00308f
C437 m1_2972_1572# el 0
C438 m1_2240_960# m1_201_2424# 0.00645f
C439 a_2510_1740# vdd 1.31653f
C440 m1_1692_4540# a_2804_3624# 0.01352f
C441 a_2080_2940# en 0.00204f
C442 m1_4052_1572# vdd 0.01699f
C443 a_2080_2940# a_480_5620# 0.23562f
C444 m1_2972_1572# rsel 0.01559f
C445 aux vdd 0.19097f
C446 a_3844_4734# abus 0
C447 m1_1532_4440# spk 0
C448 el a_3844_4734# 0.00398f
C449 vsrc m1_1532_4440# 0.00732f
C450 vm m1_201_2424# 0.15509f
C451 vreset hold 0.01444f
C452 m1_4802_1762# sub_b 0.00105f
C453 a_3844_4734# rsel 0.00286f
C454 en vbn_leak 0.07244f
C455 a_2080_2940# vdd 0.00232f
C456 a_480_5620# vbn_leak 0
C457 a_288_2940# hold 0
C458 vbn_prb mreset 0
C459 a_2160_3542# sub_b 0
C460 vbp_st abus 0.11985f
C461 vbn_ref vm 0
C462 el vbp_st 0.0433f
C463 vbn_leak vdd 0.13613f
C464 rsel vbp_st 0.08798f
C465 m1_2972_1572# m1_2240_960# 0.00101f
C466 a_2160_3542# hold 0
C467 sub abus 0.003f
C468 el sub 0
C469 m1_2972_1572# vm 0.01258f
C470 stb a_3184_3624# 0
C471 sub rsel 0.46555f
C472 vm a_3844_4734# 0.00139f
C473 m1_3652_6232# m1_3212_6232# 0.06928f
C474 vreset a_2510_1740# 0.08113f
C475 vreset aux 0.02593f
C476 vm vbp_st 0.31603f
C477 a_2080_2940# vreset 0
C478 a_2510_1740# m1_4802_1762# 0
C479 m1_2240_960# sub 0.00305f
C480 en spk 0
C481 a_480_5620# spk 0.1688f
C482 vsrc en 0.06524f
C483 vsrc a_480_5620# 0.04145f
C484 m1_3212_6232# sta 0.04306f
C485 sub vm 0.09873f
C486 a_2160_3542# a_2510_1740# 0
C487 a_3184_3624# m1_1532_4440# 0.08806f
C488 a_2080_2940# a_288_2940# 0.01225f
C489 vreset vbn_leak 0.02609f
C490 vdd spk 0.88571f
C491 vsrc vdd 0.19162f
C492 m1_2140_4540# sub_b 0.06724f
C493 m1_3360_172# sub_b 0
C494 a_2080_2940# a_2160_3542# 0.03028f
C495 m1_4802_1762# vbn_leak 0
C496 mreset sta 0.03455f
C497 m1_388_4540# sub_b 0.18271f
C498 el m1_3212_6232# 0.01607f
C499 m1_388_4540# hold 0.08027f
C500 m1_3212_6232# rsel 0.04621f
C501 aux m1_4822_412# 0.00143f
C502 vbn_prb sta 0
C503 vreset spk 0
C504 vbp_syn sub_b 0.24998f
C505 en m1_2628_744# 0.14945f
C506 vsrc vreset 0.02597f
C507 mreset abus 0
C508 rsel a_2804_3624# 0.01616f
C509 m1_2140_4540# a_2510_1740# 0.2422f
C510 el mreset 0.02718f
C511 a_2510_1740# m1_3360_172# 0.01626f
C512 vbp_syn hold 0.04274f
C513 vbn_leak m1_4822_412# 0.00239f
C514 m1_2628_744# vdd 0.13245f
C515 a_288_2940# spk 0.33822f
C516 rsel mreset 0.01954f
C517 aux m1_3360_172# 0.02912f
C518 vm m1_3212_6232# 0.21364f
C519 m1_1692_4540# rsel 0.02203f
C520 a_3184_3624# vdd 0.37341f
C521 a_2080_2940# m1_2140_4540# 0
C522 m1_4902_6372# hold -0.01954f
C523 m1_201_2424# sub_b 0.07002f
C524 vbn_prb abus 0.34249f
C525 el vbn_prb 0
C526 a_2160_3542# spk 0.01651f
C527 vsrc a_2160_3542# 0.15598f
C528 a_2510_1740# m1_388_4540# 0
C529 vbn_prb rsel 0
C530 m1_2140_4540# vbn_leak 0
C531 hold m1_201_2424# 0
C532 stb vdd 0.12975f
C533 vbn_leak m1_3360_172# 0.03345f
C534 vbn_ref sub_b 0.02226f
C535 vm a_2804_3624# 0
C536 a_2080_2940# m1_388_4540# 0.07976f
C537 vm mreset 0
C538 m1_3652_6232# sta 0.1146f
C539 vbn_ref hold 0.1315f
C540 m1_1692_4540# vm 0.12417f
C541 vbn_leak m1_388_4540# 0
C542 a_2510_1740# vbp_syn 1.06788f
C543 aux vbp_syn 0.0929f
C544 a_480_5620# m1_1532_4440# 0.07898f
C545 a_3844_4734# sub_b 0.02357f
C546 vreset m1_2628_744# 0.17967f
C547 m1_4902_6372# a_2510_1740# 0.02149f
C548 vbn_prb vm 0
C549 vsrc m1_4822_412# 0.00459f
C550 a_2080_2940# vbp_syn 0
C551 aux m1_4902_6372# 0
C552 vdd m1_1532_4440# 0.42112f
C553 a_2510_1740# m1_201_2424# 0.09174f
C554 m1_4802_1762# m1_2628_744# 0.02111f
C555 vbp_st sub_b 0.38534f
C556 aux m1_201_2424# 0.00202f
C557 vbn_leak vbp_syn 0.24921f
C558 m1_3652_6232# el 0.02484f
C559 m1_2140_4540# spk 0.16869f
C560 vsrc m1_2140_4540# 0.05615f
C561 vbp_st hold 0.03351f
C562 sub sub_b 0.03525f
C563 vsrc m1_3360_172# 0.02766f
C564 a_2080_2940# m1_201_2424# 0.5419f
C565 m1_4902_6372# vbn_leak 0.0017f
C566 vbn_ref a_2510_1740# 0.09023f
C567 a_2160_3542# a_3184_3624# 0.00508f
C568 vbn_ref aux 0
C569 sub hold 0.05794f
C570 vbn_leak m1_201_2424# 0.37513f
C571 el sta 0
C572 m1_388_4540# spk 0.12049f
C573 m1_2972_1572# a_2510_1740# 0.03323f
C574 vsrc m1_388_4540# 0.06491f
C575 aux vss 0.34557f
C576 m1_3360_172# vss 0.89028f
C577 m1_201_2424# vss 0.17238f
C578 m1_2628_744# vss 0.52484f
C579 m1_2240_960# vss 0.18751f
C580 en vss 1.31603f
C581 abus vss 2.5185f
C582 sub vss 0.94332f
C583 mreset vss 1.05033f
C584 hold vss 3.16434f
C585 m1_4822_412# vss 0.16054f
C586 vbn_prb vss 0.70352f
C587 a_3184_3624# vss 0.36316f
C588 a_2804_3624# vss 0.16164f
C589 a_2160_3542# vss 0.32945f
C590 vsrc vss 1.01186f
C591 spk vss 0.91659f
C592 a_288_2940# vss -0.17739f
C593 m1_2972_1572# vss -0.05022f
C594 rsel vss 1.94858f
C595 m1_2140_4540# vss 0.2396f
C596 a_2080_2940# vss 0.13626f
C597 m1_3704_1572# vss -0.06753f
C598 m1_4052_1572# vss -0.05514f
C599 sub_b vss 3.1006f
C600 m1_1532_4440# vss 0.16511f
C601 vbp_st vss 0.42698f
C602 stb vss 0.55456f
C603 sta vss 0.17029f
C604 vdd vss 14.26474f
C605 a_2510_1740# vss 2.09323f
C606 vm vss 10.20288f
C607 vreset vss 0.49992f
C608 m1_1692_4540# vss -0.03638f
C609 vbn_ref vss 0.58844f
C610 m1_3212_6232# vss 2.27684f
C611 m1_388_4540# vss 0.12673f
C612 a_3844_4734# vss 0.14216f
C613 m1_4902_6372# vss -0.12668f
C614 m1_3652_6232# vss -0.07143f
C615 vbp_syn vss 0.29492f
C616 a_480_5620# vss -0.44667f
C617 el vss 0.67604f
C618 m1_4802_1762# vss -0.00998f
C619 vbn_leak vss 0.79563f
.ends
