* NGSPICE file created from slot_ah_800.ext - technology: gf180mcuD

.subckt p_w0p22_l1 a_100_n22# a_n100_n66# w_n278_n159# a_n192_n36# VSUBS
X0 a_100_n22# a_n100_n66# a_n192_n36# w_n278_n159# pfet_03v3 ad=0.1516p pd=1.64u as=0.1516p ps=1.64u w=0.22u l=1u
C0 w_n278_n159# a_n100_n66# 0.13163f
C1 w_n278_n159# a_100_n22# 0.00771f
C2 a_n100_n66# a_n192_n36# 0.00509f
C3 a_100_n22# a_n192_n36# 0.00453f
C4 w_n278_n159# a_n192_n36# 0.00771f
C5 a_100_n22# a_n100_n66# 0.00509f
C6 a_100_n22# VSUBS 0.05952f
C7 a_n192_n36# VSUBS 0.05952f
C8 w_n278_n159# VSUBS 0.53042f
.ends

.subckt p_w2_l4 a_400_n200# a_n400_n244# w_n574_n330# a_n488_n200# VSUBS
X0 a_400_n200# a_n400_n244# a_n488_n200# w_n574_n330# pfet_03v3 ad=0.88p pd=4.88u as=0.88p ps=4.88u w=2u l=4u
C0 w_n574_n330# a_n488_n200# 0.07409f
C1 w_n574_n330# a_400_n200# 0.07409f
C2 a_n488_n200# a_n400_n244# 0.07019f
C3 a_400_n200# a_n400_n244# 0.07019f
C4 w_n574_n330# a_n400_n244# 0.42229f
C5 a_400_n200# a_n488_n200# 0.01073f
C6 a_400_n200# VSUBS 0.18936f
C7 a_n488_n200# VSUBS 0.18936f
C8 w_n574_n330# VSUBS 2.27304f
.ends

.subckt n_w1_l0p28 a_28_n100# a_n28_n144# a_n116_n100# VSUBS
X0 a_28_n100# a_n28_n144# a_n116_n100# VSUBS nfet_03v3 ad=0.44p pd=2.88u as=0.44p ps=2.88u w=1u l=0.28u
C0 a_n28_n144# a_28_n100# 0.00769f
C1 a_28_n100# a_n116_n100# 0.04256f
C2 a_n28_n144# a_n116_n100# 0.00769f
C3 a_28_n100# VSUBS 0.09911f
C4 a_n116_n100# VSUBS 0.09911f
.ends

.subckt n_w2_l4 a_400_n200# a_n400_n244# a_n488_n200# VSUBS
X0 a_400_n200# a_n400_n244# a_n488_n200# VSUBS nfet_03v3 ad=0.88p pd=4.88u as=0.88p ps=4.88u w=2u l=4u
C0 a_n400_n244# a_400_n200# 0.07019f
C1 a_400_n200# a_n488_n200# 0.01073f
C2 a_n400_n244# a_n488_n200# 0.07019f
C3 a_400_n200# VSUBS 0.41684f
C4 a_n488_n200# VSUBS 0.41684f
.ends

.subckt n_w2_l2 a_n288_n200# a_200_n200# a_n200_n244# VSUBS
X0 a_200_n200# a_n200_n244# a_n288_n200# VSUBS nfet_03v3 ad=0.88p pd=4.88u as=0.88p ps=4.88u w=2u l=2u
C0 a_n200_n244# a_200_n200# 0.0587f
C1 a_200_n200# a_n288_n200# 0.02133f
C2 a_n200_n244# a_n288_n200# 0.0587f
C3 a_200_n200# VSUBS 0.2667f
C4 a_n288_n200# VSUBS 0.2667f
.ends

.subckt n_w4_l1 a_n188_n400# a_100_n400# a_n100_n444# VSUBS
X0 a_100_n400# a_n100_n444# a_n188_n400# VSUBS nfet_03v3 ad=1.76p pd=8.88u as=1.76p ps=8.88u w=4u l=1u
C0 a_n100_n444# a_100_n400# 0.08505f
C1 a_100_n400# a_n188_n400# 0.07756f
C2 a_n100_n444# a_n188_n400# 0.08505f
C3 a_100_n400# VSUBS 0.26859f
C4 a_n188_n400# VSUBS 0.26859f
.ends

.subckt n_w0p5_l0p28 a_n28_n94# a_n116_n50# a_28_n50# VSUBS
X0 a_28_n50# a_n28_n94# a_n116_n50# VSUBS nfet_03v3 ad=0.22p pd=1.88u as=0.22p ps=1.88u w=0.5u l=0.28u
C0 a_n28_n94# a_28_n50# 0.00377f
C1 a_28_n50# a_n116_n50# 0.02085f
C2 a_n28_n94# a_n116_n50# 0.00377f
C3 a_28_n50# VSUBS 0.07987f
C4 a_n116_n50# VSUBS 0.07987f
.ends

.subckt p_w1_l0p5 a_n138_n100# a_50_n100# a_n50_n144# w_n224_n230# VSUBS
X0 a_50_n100# a_n50_n144# a_n138_n100# w_n224_n230# pfet_03v3 ad=0.44p pd=2.88u as=0.44p ps=2.88u w=1u l=0.5u
C0 w_n224_n230# a_n138_n100# 0.0205f
C1 w_n224_n230# a_50_n100# 0.0205f
C2 a_n138_n100# a_n50_n144# 0.01275f
C3 a_50_n100# a_n50_n144# 0.01275f
C4 w_n224_n230# a_n50_n144# 0.07993f
C5 a_50_n100# a_n138_n100# 0.03085f
C6 a_50_n100# VSUBS 0.06546f
C7 a_n138_n100# VSUBS 0.06546f
C8 w_n224_n230# VSUBS 0.61824f
.ends

.subckt n_w0p5_l0p5 a_n138_n50# a_50_n50# a_n50_n94# VSUBS
X0 a_50_n50# a_n50_n94# a_n138_n50# VSUBS nfet_03v3 ad=0.22p pd=1.88u as=0.22p ps=1.88u w=0.5u l=0.5u
C0 a_n50_n94# a_50_n50# 0.00625f
C1 a_50_n50# a_n138_n50# 0.01511f
C2 a_n50_n94# a_n138_n50# 0.00625f
C3 a_50_n50# VSUBS 0.09639f
C4 a_n138_n50# VSUBS 0.09639f
.ends

.subckt p_w1_l0p28 w_n202_n230# a_28_n100# a_n28_n144# a_n116_n100# VSUBS
X0 a_28_n100# a_n28_n144# a_n116_n100# w_n202_n230# pfet_03v3 ad=0.44p pd=2.88u as=0.44p ps=2.88u w=1u l=0.28u
C0 w_n202_n230# a_n116_n100# 0.01808f
C1 w_n202_n230# a_28_n100# 0.01808f
C2 a_n116_n100# a_n28_n144# 0.00769f
C3 a_28_n100# a_n28_n144# 0.00769f
C4 w_n202_n230# a_n28_n144# 0.05841f
C5 a_28_n100# a_n116_n100# 0.04256f
C6 a_28_n100# VSUBS 0.0597f
C7 a_n116_n100# VSUBS 0.0597f
C8 w_n202_n230# VSUBS 0.55752f
.ends

.subckt n_w1_l0p5 a_n138_n100# a_50_n100# a_n50_n144# VSUBS
X0 a_50_n100# a_n50_n144# a_n138_n100# VSUBS nfet_03v3 ad=0.44p pd=2.88u as=0.44p ps=2.88u w=1u l=0.5u
C0 a_n50_n144# a_50_n100# 0.01275f
C1 a_50_n100# a_n138_n100# 0.03085f
C2 a_n50_n144# a_n138_n100# 0.01275f
C3 a_50_n100# VSUBS 0.11563f
C4 a_n138_n100# VSUBS 0.11563f
.ends

.subckt n_w4_l2 a_n288_n400# a_200_n400# a_n200_n444# VSUBS
X0 a_200_n400# a_n200_n444# a_n288_n400# VSUBS nfet_03v3 ad=1.76p pd=8.88u as=1.76p ps=8.88u w=4u l=2u
C0 a_n200_n444# a_200_n400# 0.11799f
C1 a_200_n400# a_n288_n400# 0.04287f
C2 a_n200_n444# a_n288_n400# 0.11799f
C3 a_200_n400# VSUBS 0.34365f
C4 a_n288_n400# VSUBS 0.34365f
.ends

.subckt p_w1_l2 w_n374_n230# a_n288_n100# a_200_n100# a_n200_n144# VSUBS
X0 a_200_n100# a_n200_n144# a_n288_n100# w_n374_n230# pfet_03v3 ad=0.44p pd=2.88u as=0.44p ps=2.88u w=1u l=2u
C0 w_n374_n230# a_n288_n100# 0.03135f
C1 w_n374_n230# a_200_n100# 0.03135f
C2 a_n288_n100# a_n200_n144# 0.02905f
C3 a_200_n100# a_n200_n144# 0.02905f
C4 w_n374_n230# a_n200_n144# 0.22666f
C5 a_200_n100# a_n288_n100# 0.01056f
C6 a_200_n100# VSUBS 0.1047f
C7 a_n288_n100# VSUBS 0.1047f
C8 w_n374_n230# VSUBS 1.03224f
.ends

.subckt n_w7p07_l7p07 a_707_n707# a_n795_n707# a_n707_n751# VSUBS
X0 a_707_n707# a_n707_n751# a_n795_n707# VSUBS nfet_03v3 ad=3.1108p pd=15.02u as=3.1108p ps=15.02u w=7.07u l=7.07u
C0 a_n707_n751# a_707_n707# 0.27012f
C1 a_707_n707# a_n795_n707# 0.0212f
C2 a_n707_n751# a_n795_n707# 0.27012f
C3 a_707_n707# VSUBS 0.84237f
C4 a_n795_n707# VSUBS 0.84237f
.ends

.subckt n_w3p54_l3p54 a_354_n354# a_n354_n398# a_n442_n354# VSUBS
X0 a_354_n354# a_n354_n398# a_n442_n354# VSUBS nfet_03v3 ad=1.5576p pd=7.96u as=1.5576p ps=7.96u w=3.54u l=3.54u
C0 a_n354_n398# a_354_n354# 0.12189f
C1 a_354_n354# a_n442_n354# 0.02161f
C2 a_n354_n398# a_n442_n354# 0.12189f
C3 a_354_n354# VSUBS 0.44156f
C4 a_n442_n354# VSUBS 0.44156f
.ends

.subckt n_w0p22_l2 a_200_n22# a_n200_n66# a_n292_n36# VSUBS
X0 a_200_n22# a_n200_n66# a_n292_n36# VSUBS nfet_03v3 ad=0.1516p pd=1.64u as=0.1516p ps=1.64u w=0.22u l=2u
C0 a_n292_n36# a_200_n22# 0.00245f
C1 a_200_n22# a_n200_n66# 0.00705f
C2 a_n292_n36# a_n200_n66# 0.00705f
C3 a_200_n22# VSUBS 0.20767f
C4 a_n292_n36# VSUBS 0.20767f
.ends

.subckt n_w11p7_l11p6 a_n1248_n1170# a_1160_n1170# a_n1160_n1214# VSUBS
X0 a_1160_n1170# a_n1160_n1214# a_n1248_n1170# VSUBS nfet_03v3 ad=5.148p pd=24.28u as=5.148p ps=24.28u w=11.7u l=11.6u
C0 a_n1160_n1214# a_1160_n1170# 0.45204f
C1 a_n1160_n1214# a_n1248_n1170# 0.45204f
C2 a_1160_n1170# VSUBS 1.42218f
C3 a_n1248_n1170# VSUBS 1.42218f
.ends

.subckt slot_ah_800 vss vbp_syn vdd el aux vbn_leak vsrc vbp_st vbn_prb vbn_ref en
+ vreset abus spk sta stb hold mreset rsel sub sub_b vm
XXD_XK a_3184_3624# spk vdd vdd vss p_w0p22_l1
XXL_XP1 a_480_5620# a_480_5620# vdd vdd vss p_w2_l4
XXPM_XSW m1_4052_1572# rsel m1_3704_1572# vss n_w1_l0p28
XXL_XP2 a_1632_2940# a_480_5620# vdd vdd vss p_w2_l4
XXL_XMT m1_196_2424# vbn_leak vss vss n_w2_l4
XXPR_XMB vss m1_4802_1762# vbn_prb vss n_w2_l2
XXL_XM1 a_288_2940# a_480_5620# el vss n_w4_l1
XXS_XWA m1_4902_6372# vbp_syn vdd m1_3440_5086# vss p_w2_l4
XXR_Xi_XN spk vss a_3844_4734# vss n_w0p5_l0p28
XXL_XM2 a_2080_2940# a_1632_2940# a_1632_2940# vss n_w4_l1
XXS_XWB m1_4902_6372# vbp_syn vdd m1_3212_6232# vss p_w2_l4
XXR_XNR vss vbn_ref a_2510_1690# vss n_w2_l4
XXD_XPI m1_1692_4540# a_2160_3542# vm vdd vss p_w1_l0p5
XXPR_XME m1_2436_960# en m1_4802_1762# vss n_w1_l0p28
XXR_XSW vreset vm a_2510_1690# vss n_w0p5_l0p5
XXR_Xi_XP vdd a_3844_4734# spk vdd vss p_w1_l0p28
XXD_XNI vsrc a_2160_3542# vm vss n_w1_l0p5
XXPR_XMF m1_2436_960# vdd a_2510_1690# vss n_w4_l2
XXS_XQA vdd m1_3440_5086# sta vss vss p_w1_l0p28
XXS_XQB vdd m1_3212_6232# stb vss vss p_w1_l0p28
XXS_XNA sta vm m1_3440_5086# vss n_w0p5_l0p28
XXS_XNB stb vm m1_3212_6232# vss n_w0p5_l0p28
XXD_XS2 vdd vdd m1_2260_4540# vbp_st vss p_w1_l2
XXD_XPS vdd vdd m1_1692_4540# vbp_st vss p_w1_l2
XXD_XS3 vdd vdd m1_1540_4540# vbp_st vss p_w1_l2
XXPM_XSB abus sub_b m1_4052_1572# vss n_w1_l0p28
XXL_XD2a m1_196_2424# a_2080_2940# a_2080_2940# vss n_w4_l1
XXPM_XSC m1_3704_1572# en m1_3360_172# vss n_w1_l0p28
XXC_XC vss vss vm vss n_w7p07_l7p07
XXL_XD1a m1_196_2424# a_288_2940# a_288_2940# vss n_w4_l1
XXL_XD2b m1_196_2424# a_2080_2940# a_2080_2940# vss n_w4_l1
XXS_XPH vdd m1_4902_6372# vdd hold vss p_w1_l2
XXD_XP2 vdd a_2804_3624# a_2160_3542# m1_2260_4540# vss p_w1_l0p28
XXPR_XSW m1_2972_1572# rsel m1_2272_972# vss n_w1_l0p28
XXL_XD1b m1_196_2424# a_288_2940# a_288_2940# vss n_w4_l1
XXD_Xi4_XN a_3184_3624# vss spk vss n_w0p5_l0p28
XXD_XP3 vdd a_3184_3624# a_2804_3624# m1_1540_4540# vss p_w1_l0p28
XXR_XCR_XC vss a_2510_1690# vss vss n_w3p54_l3p54
XXD_XN2 a_2804_3624# a_2160_3542# vsrc vss n_w0p22_l2
XXD_Xi4_XP vdd spk a_3184_3624# vdd vss p_w1_l0p28
XXD_XN3 a_2804_3624# vsrc a_3184_3624# vss n_w0p5_l0p28
XXPM_XMB vss m1_4822_412# vbn_prb vss n_w2_l2
XXR_XPC vdd a_2510_1690# a_3844_4734# vdd vss p_w1_l0p28
XXPM_XME m1_3360_172# en m1_4822_412# vss n_w1_l0p28
XXPM_XMF m1_3360_172# vdd vm vss n_w4_l2
XXS_XHL vdd vm hold a_1632_2940# vss p_w1_l0p28
XXS_XMR mreset a_2510_1690# vdd vss n_w0p5_l0p28
XXPR_XSB abus sub m1_2972_1572# vss n_w1_l0p28
XXPR_XSC m1_2436_960# en m1_2272_972# vss n_w1_l0p28
XXC2_XC vss vss vm vss n_w11p7_l11p6
C0 vbp_syn m1_2972_1572# 0
C1 rsel m1_4052_1572# 0
C2 vm a_2510_1690# 0.30676f
C3 vbp_st a_3844_4734# 0.0063f
C4 a_3184_3624# m1_196_2424# 0
C5 m1_4802_1762# vbn_leak 0
C6 stb m1_3212_6232# 0.08616f
C7 a_2080_2940# vsrc 0.0574f
C8 vreset m1_2436_960# 0.11092f
C9 sub_b spk 0.20897f
C10 a_480_5620# rsel 0.01329f
C11 aux a_2080_2940# 0
C12 vbn_prb m1_196_2424# 0
C13 vdd m1_2436_960# 0.08678f
C14 a_3184_3624# a_480_5620# 0.00198f
C15 vbp_syn m1_1692_4540# 0
C16 sub_b sta 0.02558f
C17 hold vbn_leak 0.02503f
C18 vbp_st en 0.07103f
C19 a_3844_4734# en 0
C20 el m1_2272_972# 0.01674f
C21 m1_3440_5086# a_1632_2940# 0
C22 m1_1540_4540# vm 0.10257f
C23 abus m1_2436_960# 0.05267f
C24 a_1632_2940# vsrc 0.10777f
C25 a_2160_3542# sub_b 0.19508f
C26 m1_3440_5086# mreset 0
C27 spk rsel 0.30556f
C28 m1_1540_4540# a_2510_1690# 0.02836f
C29 vbn_leak vbn_ref 0.01314f
C30 mreset vsrc 0.01141f
C31 vreset m1_196_2424# 0
C32 sub hold 0.08207f
C33 m1_3704_1572# rsel 0.02603f
C34 aux mreset 0.0442f
C35 vreset m1_4052_1572# 0.00428f
C36 vdd m1_196_2424# 0.02443f
C37 a_3184_3624# spk 0.22758f
C38 vbp_st m1_4822_412# 0.01159f
C39 m1_2260_4540# vbn_ref 0.01664f
C40 mreset m1_3212_6232# 0.0165f
C41 vdd m1_4052_1572# 0.01699f
C42 a_2080_2940# el 0.02948f
C43 vsrc m1_3360_172# 0.02767f
C44 a_2080_2940# a_2804_3624# 0.00106f
C45 mreset m1_4902_6372# 0.00299f
C46 aux m1_3360_172# 0.02912f
C47 a_2160_3542# rsel 0
C48 vbn_prb spk 0
C49 abus m1_196_2424# 0
C50 vbp_syn m1_3440_5086# 0.30704f
C51 a_480_5620# vdd 1.5569f
C52 abus m1_4052_1572# 0.00714f
C53 vbp_st m1_1692_4540# 0.19373f
C54 vbp_syn vsrc 0.19095f
C55 a_2160_3542# a_3184_3624# 0.00219f
C56 aux vbp_syn 0.11156f
C57 sub a_288_2940# 0
C58 en m1_4822_412# 0.09616f
C59 vbn_prb sta 0
C60 sub_b vm 0.74197f
C61 el a_1632_2940# 0.07263f
C62 vbp_syn m1_3212_6232# 0.13423f
C63 a_2804_3624# a_1632_2940# 0.0048f
C64 el mreset 0.03234f
C65 sub_b a_2510_1690# 0.07651f
C66 vbp_syn m1_4902_6372# 0.17053f
C67 m1_2436_960# vbn_leak 0.03106f
C68 spk vdd 0.9198f
C69 m1_3704_1572# vreset 0.00421f
C70 m1_3704_1572# vdd 0.03276f
C71 el m1_3360_172# 0.06557f
C72 vreset sta 0
C73 sub m1_2436_960# 0
C74 vm rsel 0.08683f
C75 vbp_st m1_3440_5086# 0.19274f
C76 a_3844_4734# m1_3440_5086# 0.00398f
C77 vdd sta 0.14047f
C78 vbp_st vsrc 1.60924f
C79 a_3844_4734# vsrc 0.00197f
C80 rsel a_2510_1690# 0.049f
C81 hold stb 0.21815f
C82 vbp_syn el 0.14329f
C83 vm a_3184_3624# 0
C84 m1_3704_1572# abus 0.01018f
C85 aux a_3844_4734# 0
C86 aux vbp_st 0.04001f
C87 a_2160_3542# vdd 0.3598f
C88 m1_1540_4540# sub_b 0.10958f
C89 vbn_leak m1_196_2424# 0.3525f
C90 a_3184_3624# a_2510_1690# 0.09855f
C91 a_3844_4734# m1_3212_6232# 0
C92 vbp_st m1_3212_6232# 0.00926f
C93 vbn_leak m1_4052_1572# 0.00484f
C94 vm vbn_prb 0
C95 vbp_st m1_4902_6372# 0.07214f
C96 m1_2260_4540# m1_196_2424# 0
C97 sub m1_196_2424# 0.09704f
C98 vbn_prb a_2510_1690# 0.1169f
C99 m1_3440_5086# en 0.00119f
C100 a_480_5620# vbn_leak 0
C101 en vsrc 0.10334f
C102 aux en 0.06876f
C103 m1_1540_4540# rsel 0.00115f
C104 hold a_1632_2940# 0.03411f
C105 a_480_5620# m1_2260_4540# 0.00426f
C106 vm vreset 0.14387f
C107 sub a_480_5620# 0.06578f
C108 hold mreset 0.26483f
C109 m1_1540_4540# a_3184_3624# 0.03186f
C110 vbp_st el 0.04181f
C111 a_3844_4734# el 0
C112 a_2080_2940# a_288_2940# 0.00262f
C113 en m1_4902_6372# 0.02089f
C114 m1_4822_412# vsrc 0.00459f
C115 vm vdd 2.50493f
C116 vbp_st a_2804_3624# 0.00469f
C117 vreset a_2510_1690# 0.3134f
C118 m1_2272_972# m1_2436_960# 0.05781f
C119 aux m1_4822_412# 0.00143f
C120 mreset vbn_ref 0
C121 spk vbn_leak 0.01116f
C122 vdd a_2510_1690# 1.9494f
C123 m1_3704_1572# vbn_leak 0
C124 vm abus 0.01182f
C125 m1_3440_5086# m1_1692_4540# 0.00231f
C126 spk m1_2260_4540# 0.12344f
C127 m1_1692_4540# vsrc 0
C128 sub spk 0.02385f
C129 m1_3360_172# vbn_ref 0.03584f
C130 vbn_leak sta 0
C131 abus a_2510_1690# 0.05501f
C132 a_288_2940# a_1632_2940# 0
C133 hold vbp_syn 0.07005f
C134 a_2080_2940# m1_2436_960# 0
C135 el en 0.25324f
C136 sub_b rsel 0.23327f
C137 m1_2272_972# m1_196_2424# 0
C138 vbp_syn vbn_ref 0.00572f
C139 m1_2272_972# m1_4052_1572# 0
C140 sub_b a_3184_3624# 0
C141 m1_1540_4540# vdd 0.44953f
C142 a_2160_3542# m1_2260_4540# 0.07335f
C143 sub a_2160_3542# 0.08981f
C144 el m1_4822_412# 0
C145 vbp_st m1_4802_1762# 0.00773f
C146 a_2080_2940# m1_196_2424# 0.51961f
C147 sub_b vbn_prb 0.0025f
C148 m1_3440_5086# vsrc 0.01101f
C149 aux m1_3440_5086# 0.06605f
C150 vbp_st hold 0.03521f
C151 aux vsrc 0.03728f
C152 a_2804_3624# m1_1692_4540# 0.01582f
C153 a_3184_3624# rsel 0.12503f
C154 m1_3440_5086# m1_3212_6232# 0.28622f
C155 m1_2436_960# m1_3360_172# 0.09362f
C156 vm vbn_leak 0.00206f
C157 a_2080_2940# a_480_5620# 0.4837f
C158 m1_3212_6232# vsrc 0
C159 m1_4802_1762# en 0.09315f
C160 vbp_st vbn_ref 0.03994f
C161 a_3844_4734# vbn_ref 0
C162 m1_3440_5086# m1_4902_6372# 0
C163 m1_2272_972# spk 0
C164 aux m1_3212_6232# 0.00778f
C165 sub_b vreset 0.00478f
C166 vbn_leak a_2510_1690# 0.13623f
C167 a_1632_2940# m1_196_2424# 0.24476f
C168 vsrc m1_4902_6372# 0.01261f
C169 vbn_prb rsel 0
C170 vm m1_2260_4540# 0.00968f
C171 m1_3704_1572# m1_2272_972# 0
C172 vbp_syn m1_2436_960# 0.10756f
C173 aux m1_4902_6372# 0.00324f
C174 sub_b vdd 0.52125f
C175 stb spk 0.11085f
C176 sub vm 0.12759f
C177 m1_2260_4540# a_2510_1690# 0.25397f
C178 m1_3212_6232# m1_4902_6372# -0.0096f
C179 sub a_2510_1690# 0.27302f
C180 hold en 0.01347f
C181 a_1632_2940# a_480_5620# 0.59393f
C182 vbp_st a_288_2940# 0
C183 m1_196_2424# m1_3360_172# 0
C184 a_2080_2940# spk 0.2158f
C185 sub_b abus 0.08168f
C186 stb sta 0.00536f
C187 m1_3440_5086# el 0.08649f
C188 vreset rsel 0.04977f
C189 en vbn_ref 1.71636f
C190 el vsrc 0.03826f
C191 a_2804_3624# vsrc 0.12256f
C192 aux el 1.56834f
C193 vdd rsel 0.37435f
C194 vbp_syn m1_196_2424# 0.056f
C195 el m1_3212_6232# 0.02616f
C196 a_3184_3624# vdd 0.37527f
C197 a_2080_2940# a_2160_3542# 0.0104f
C198 m1_1540_4540# m1_2260_4540# 0.05897f
C199 m1_4822_412# vbn_ref 0.07762f
C200 el m1_4902_6372# 0.00192f
C201 a_1632_2940# spk 0.13524f
C202 vbp_st m1_2436_960# 0.03149f
C203 m1_1540_4540# sub 0.07287f
C204 abus rsel 0.0109f
C205 vbn_prb vreset 0.0515f
C206 mreset spk 0.09623f
C207 vbp_syn a_480_5620# 0
C208 hold m1_1692_4540# 0
C209 vbn_prb vdd 0.0936f
C210 vm m1_2272_972# 0.1543f
C211 mreset sta 0.03055f
C212 a_2160_3542# a_1632_2940# 0.18551f
C213 m1_2272_972# a_2510_1690# 0.15268f
C214 abus vbn_prb 0.38373f
C215 m1_3704_1572# m1_3360_172# 0.01359f
C216 vm stb 0.03495f
C217 m1_4802_1762# vsrc 0
C218 a_3844_4734# m1_196_2424# 0
C219 en m1_2436_960# 0.36559f
C220 sub_b vbn_leak 0.24019f
C221 vbp_syn spk 0.03525f
C222 vdd vreset 0.26257f
C223 m1_2972_1572# m1_2436_960# 0
C224 m1_3704_1572# vbp_syn 0.04071f
C225 a_2080_2940# vm 0.04252f
C226 sub_b m1_2260_4540# 0
C227 sub sub_b 0.13065f
C228 hold m1_3440_5086# 0
C229 a_2080_2940# a_2510_1690# 0.27516f
C230 m1_4822_412# m1_2436_960# 0
C231 vbp_syn sta 0.14423f
C232 abus vreset 1.81941f
C233 vbp_st a_480_5620# 0.56538f
C234 hold vsrc 0.02383f
C235 aux hold 0.02624f
C236 abus vdd 0.16569f
C237 a_2160_3542# vbp_syn 0
C238 rsel vbn_leak 0.15511f
C239 m1_3440_5086# vbn_ref 0.00173f
C240 en m1_196_2424# 0.00185f
C241 vsrc vbn_ref 0.03905f
C242 hold m1_3212_6232# 0.00196f
C243 en m1_4052_1572# 0
C244 aux vbn_ref 0
C245 vm a_1632_2940# 0.36912f
C246 a_3184_3624# vbn_leak 0.00376f
C247 hold m1_4902_6372# 0.03157f
C248 m1_2972_1572# m1_196_2424# 0
C249 rsel m1_2260_4540# 0.11683f
C250 vm mreset 0.00359f
C251 sub rsel 0.24744f
C252 a_1632_2940# a_2510_1690# 0.01643f
C253 vbp_st spk 0.07983f
C254 a_3844_4734# spk 0.2402f
C255 mreset a_2510_1690# 0.09702f
C256 m1_4902_6372# vbn_ref 0.10493f
C257 a_3184_3624# m1_2260_4540# 0.04958f
C258 a_2080_2940# m1_1540_4540# 0
C259 vbn_prb vbn_leak 0
C260 sub a_3184_3624# 0.01183f
C261 vm m1_3360_172# 0.17127f
C262 vbp_st sta 0.00136f
C263 vbn_prb m1_2260_4540# 0.00299f
C264 a_2510_1690# m1_3360_172# 0.01889f
C265 hold el 0.02558f
C266 sub vbn_prb 0
C267 a_2160_3542# a_3844_4734# 0
C268 vbp_st a_2160_3542# 0.00218f
C269 vm vbp_syn 0.10422f
C270 sub_b m1_2272_972# 0
C271 en spk 0
C272 vreset vbn_leak 0.03476f
C273 el vbn_ref 0
C274 m1_1540_4540# a_1632_2940# 0.04372f
C275 vbp_syn a_2510_1690# 0.19459f
C276 vsrc m1_2436_960# 0.03253f
C277 m1_3704_1572# en 0.00148f
C278 sub_b stb 0
C279 vdd vbn_leak 0.15513f
C280 aux m1_2436_960# 0.02747f
C281 a_480_5620# m1_1692_4540# 0.21542f
C282 vreset m1_2260_4540# 0.00143f
C283 en sta 0
C284 sub vreset 0.01819f
C285 vdd m1_2260_4540# 0.42314f
C286 a_2080_2940# sub_b 0.30333f
C287 sub vdd 0.31457f
C288 abus vbn_leak 0.07208f
C289 a_288_2940# el 0.06915f
C290 m1_2272_972# rsel 0.01748f
C291 stb rsel 0.08177f
C292 abus m1_2260_4540# 0.00117f
C293 vsrc m1_196_2424# 0.05077f
C294 vbp_st vm 0.21937f
C295 vm a_3844_4734# 0
C296 sub abus 0.0026f
C297 spk m1_1692_4540# 0.07173f
C298 aux m1_196_2424# 0.00207f
C299 a_3184_3624# stb 0
C300 vbp_st a_2510_1690# 0.12134f
C301 aux m1_4052_1572# 0.03429f
C302 a_3844_4734# a_2510_1690# 0.16375f
C303 sub_b a_1632_2940# 0.25029f
C304 a_2080_2940# rsel 0.00194f
C305 m1_4802_1762# vbn_ref 0.07709f
C306 el m1_2436_960# 0.04538f
C307 m1_3440_5086# a_480_5620# 0
C308 sub_b mreset 0.16825f
C309 a_480_5620# vsrc 0.03903f
C310 a_2160_3542# m1_1692_4540# 0.02653f
C311 vm en 0.06306f
C312 sub_b m1_3360_172# 0
C313 hold vbn_ref 0.05602f
C314 m1_2272_972# vreset 0.06668f
C315 a_1632_2940# rsel 0.02061f
C316 en a_2510_1690# 0.36472f
C317 vm m1_2972_1572# 0.02998f
C318 m1_1540_4540# a_3844_4734# 0
C319 mreset rsel 0
C320 m1_1540_4540# vbp_st -0.00914f
C321 m1_3440_5086# spk 0.11089f
C322 m1_2272_972# vdd 0
C323 sub_b vbp_syn 0.27913f
C324 el m1_196_2424# 0.07155f
C325 spk vsrc 0.10905f
C326 a_3184_3624# a_1632_2940# 0
C327 m1_2972_1572# a_2510_1690# 0.00129f
C328 a_2804_3624# m1_196_2424# 0
C329 el m1_4052_1572# 0.03948f
C330 vm m1_4822_412# 0
C331 aux spk 0
C332 stb vdd 0.12932f
C333 m1_2260_4540# vbn_leak 0.00971f
C334 m1_3212_6232# spk 0.08202f
C335 rsel m1_3360_172# 0.00368f
C336 hold a_288_2940# 0
C337 m1_3440_5086# sta 0.14912f
C338 sub vbn_leak 0.03504f
C339 abus m1_2272_972# 0.00161f
C340 a_2080_2940# vreset 0.00184f
C341 vsrc sta 0
C342 m1_4802_1762# m1_2436_960# 0.02119f
C343 el a_480_5620# 0.18471f
C344 aux sta 0
C345 a_2080_2940# vdd 0.00226f
C346 mreset vbn_prb 0
C347 a_2804_3624# a_480_5620# 0.00135f
C348 vm m1_1692_4540# 0.08921f
C349 a_2160_3542# vsrc 0.29512f
C350 vbp_syn rsel 0.10219f
C351 sub m1_2260_4540# 0.12683f
C352 m1_3212_6232# sta 0.04939f
C353 m1_1692_4540# a_2510_1690# 0
C354 m1_4902_6372# sta 0
C355 vbp_syn a_3184_3624# 0
C356 vbn_prb m1_3360_172# 0.03472f
C357 sub_b a_3844_4734# 0.00134f
C358 vbp_st sub_b 0.10907f
C359 mreset vreset 0
C360 el spk 0.07551f
C361 a_1632_2940# vdd 0.36666f
C362 a_2804_3624# spk 0.03387f
C363 m1_2436_960# vbn_ref 0.0384f
C364 vbp_syn vbn_prb 0.06062f
C365 mreset vdd 0.19947f
C366 vreset m1_3360_172# 0.0696f
C367 el sta 0
C368 m1_1540_4540# m1_1692_4540# 0.08141f
C369 vm m1_3440_5086# 0.12416f
C370 vm vsrc 0.11426f
C371 vdd m1_3360_172# 0.33794f
C372 abus mreset 0
C373 a_3844_4734# rsel 0.06548f
C374 vbp_st rsel 0.06466f
C375 hold m1_196_2424# 0
C376 a_2160_3542# el 0
C377 sub_b en 0.02585f
C378 m1_3440_5086# a_2510_1690# 0.16899f
C379 aux vm 0
C380 m1_2272_972# vbn_leak 0
C381 a_2160_3542# a_2804_3624# 0.09482f
C382 vsrc a_2510_1690# 0.22052f
C383 vbp_syn vreset 0.0337f
C384 vbp_st a_3184_3624# 0.00222f
C385 a_3844_4734# a_3184_3624# 0.00311f
C386 vm m1_3212_6232# 0.14131f
C387 aux a_2510_1690# 0.12145f
C388 sub_b m1_2972_1572# 0
C389 vbp_syn vdd 2.80321f
C390 abus m1_3360_172# 0.11527f
C391 sub m1_2272_972# 0
C392 hold a_480_5620# 0.09613f
C393 m1_4902_6372# a_2510_1690# 0.1234f
C394 vbp_st vbn_prb 1.63499f
C395 a_3844_4734# vbn_prb 0
C396 a_2080_2940# vbn_leak 0.00776f
C397 sub stb 0.00563f
C398 en rsel 0.06309f
C399 vbp_syn abus 0.03865f
C400 a_288_2940# m1_196_2424# 0.32959f
C401 a_2080_2940# m1_2260_4540# 0
C402 m1_2972_1572# rsel 0.00788f
C403 m1_1540_4540# vsrc 0.0031f
C404 a_2080_2940# sub 0.10021f
C405 sub_b m1_1692_4540# 0.24157f
C406 vm el 0.46399f
C407 hold spk 0.00281f
C408 vm a_2804_3624# 0.00288f
C409 vbp_st vreset 0.03391f
C410 a_3844_4734# vreset 0
C411 el a_2510_1690# 0.22258f
C412 a_1632_2940# vbn_leak 0
C413 en vbn_prb 0.10177f
C414 a_288_2940# a_480_5620# -0.02494f
C415 a_2804_3624# a_2510_1690# 0.16341f
C416 a_3844_4734# vdd 0.38651f
C417 vbp_st vdd 1.85091f
C418 mreset vbn_leak 0.02627f
C419 spk vbn_ref 0
C420 hold sta 0.00458f
C421 a_1632_2940# m1_2260_4540# 0.04152f
C422 sub a_1632_2940# 0.23548f
C423 m1_2436_960# m1_4052_1572# 0.03342f
C424 m1_1692_4540# rsel 0.02646f
C425 vbp_st abus 0.10796f
C426 a_3844_4734# abus 0
C427 vbn_leak m1_3360_172# 0.0323f
C428 m1_4822_412# vbn_prb 0.07062f
C429 sta vbn_ref 0
C430 en vreset 1.68661f
C431 a_3184_3624# m1_1692_4540# 0.00431f
C432 a_288_2940# spk 0.28676f
C433 sub_b m1_3440_5086# 0.00107f
C434 sub_b vsrc 0.14368f
C435 en vdd 0.37978f
C436 vbp_syn vbn_leak 0.18201f
C437 m1_2972_1572# vreset 0.0182f
C438 sub m1_3360_172# 0.00181f
C439 m1_1540_4540# a_2804_3624# 0.18218f
C440 aux sub_b 0.05328f
C441 m1_2972_1572# vdd 0
C442 sub_b m1_3212_6232# 0
C443 m1_4822_412# vreset 0.01268f
C444 vbp_syn m1_2260_4540# 0.23472f
C445 a_2080_2940# m1_2272_972# 0.00446f
C446 sub vbp_syn 0.00142f
C447 abus en 0.25773f
C448 sub_b m1_4902_6372# 0
C449 m1_4822_412# vdd 0.01221f
C450 m1_3440_5086# rsel 0
C451 abus m1_2972_1572# 0.00688f
C452 a_480_5620# m1_196_2424# 0.14403f
C453 vsrc rsel 0.04244f
C454 hold vm 0.16516f
C455 m1_3704_1572# m1_2436_960# 0.03383f
C456 aux rsel 0.00343f
C457 abus m1_4822_412# 0.0036f
C458 hold a_2510_1690# 0.41378f
C459 a_3184_3624# vsrc 0.02872f
C460 vdd m1_1692_4540# 0.4586f
C461 m1_3212_6232# rsel 0
C462 vm vbn_ref 0
C463 vbp_st vbn_leak 0.03981f
C464 a_3844_4734# vbn_leak 0.00378f
C465 sub_b el 0.10896f
C466 a_2510_1690# vbn_ref 0.19366f
C467 m1_3440_5086# vbn_prb 0.00334f
C468 sub_b a_2804_3624# 0.00299f
C469 a_3184_3624# m1_3212_6232# 0
C470 vbn_prb vsrc 0.01226f
C471 spk m1_196_2424# 0.1095f
C472 stb mreset 0.06105f
C473 a_3844_4734# m1_2260_4540# 0.06156f
C474 vbp_st m1_2260_4540# 0.056f
C475 aux vbn_prb 0
C476 sub vbp_st 0.05534f
C477 m1_2272_972# m1_3360_172# 0.00519f
C478 a_2080_2940# a_1632_2940# 0.06551f
C479 a_288_2940# vm 0.19087f
C480 m1_3212_6232# vbn_prb 0
C481 m1_3704_1572# m1_4052_1572# 0
C482 vbn_prb m1_4902_6372# 0.11648f
C483 el rsel 0.00721f
C484 en vbn_leak 0.07824f
C485 a_480_5620# spk 0.03128f
C486 m1_3440_5086# vreset 0
C487 vbp_syn m1_2272_972# 0
C488 vreset vsrc 0.03389f
C489 a_2804_3624# rsel 0.08665f
C490 a_2160_3542# m1_196_2424# 0.00113f
C491 m1_3440_5086# vdd 0.98597f
C492 aux vreset 0.03367f
C493 vdd vsrc 0.21191f
C494 vbp_syn stb 0
C495 m1_2972_1572# vbn_leak 0
C496 en m1_2260_4540# 0.00178f
C497 a_3184_3624# a_2804_3624# 0.25941f
C498 aux vdd 0.16836f
C499 sub en 0.01926f
C500 vm m1_2436_960# 0.15442f
C501 m1_4822_412# vbn_leak 0.00239f
C502 m1_3212_6232# vdd 0.53023f
C503 vreset m1_4902_6372# 0.00145f
C504 sub_b m1_4802_1762# 0
C505 a_2080_2940# vbp_syn 0
C506 a_2160_3542# a_480_5620# 0.04987f
C507 sub m1_2972_1572# 0.05921f
C508 el vbn_prb 0
C509 m1_2436_960# a_2510_1690# 0.1136f
C510 abus vsrc 0.09512f
C511 vdd m1_4902_6372# 0.10433f
C512 aux abus 0.03121f
C513 spk sta 0.0345f
C514 hold sub_b 0.57475f
C515 vm m1_196_2424# 0.08085f
C516 el vreset 0.03419f
C517 vbp_syn a_1632_2940# 0
C518 a_2160_3542# spk 0.08332f
C519 m1_1692_4540# m1_2260_4540# 0.00761f
C520 sub_b vbn_ref 0
C521 sub m1_1692_4540# 0.04506f
C522 vbp_st stb 0
C523 m1_196_2424# a_2510_1690# 0.16668f
C524 vbp_syn mreset 0.03752f
C525 el vdd 1.99798f
C526 a_2804_3624# vdd 0.33207f
C527 a_2510_1690# m1_4052_1572# 0
C528 vm a_480_5620# 0.51706f
C529 hold rsel 0.06439f
C530 vbp_syn m1_3360_172# 0.0669f
C531 el abus 0.03118f
C532 m1_2272_972# en 0.13486f
C533 m1_4802_1762# vbn_prb 0.10547f
C534 a_480_5620# a_2510_1690# 0.02484f
C535 a_288_2940# sub_b 0.22303f
C536 m1_3440_5086# vbn_leak 0.04776f
C537 rsel vbn_ref 0
C538 vsrc vbn_leak 1.64263f
C539 m1_2272_972# m1_2972_1572# 0.001f
C540 aux vbn_leak 1.59533f
C541 m1_1540_4540# m1_196_2424# 0
C542 a_3184_3624# vbn_ref 0
C543 m1_3440_5086# m1_2260_4540# 0.14218f
C544 vbp_st a_1632_2940# 0.16144f
C545 vsrc m1_2260_4540# 0.03124f
C546 vm spk 7.97179f
C547 m1_3212_6232# vbn_leak 0.00383f
C548 hold vbn_prb 0.05247f
C549 a_2080_2940# en 0.00186f
C550 m1_4802_1762# vreset 0.00985f
C551 sub vsrc 0.07897f
C552 vbp_st mreset 0
C553 aux m1_2260_4540# 0.01696f
C554 m1_3704_1572# vm 0
C555 spk a_2510_1690# 0.14207f
C556 vbn_leak m1_4902_6372# 0.00589f
C557 aux sub 0
C558 sub_b m1_2436_960# 0.01342f
C559 vbn_prb vbn_ref 1.66187f
C560 m1_3212_6232# m1_2260_4540# 0
C561 m1_3704_1572# a_2510_1690# 0
C562 m1_1540_4540# a_480_5620# 0.14419f
C563 vm sta 0.0293f
C564 vbp_st m1_3360_172# 0.02932f
C565 a_2510_1690# sta 0
C566 a_2160_3542# vm 0.06136f
C567 hold vreset 0.00201f
C568 m1_4802_1762# abus 0.1614f
C569 stb m1_1692_4540# 0
C570 a_2160_3542# a_2510_1690# 0.00808f
C571 hold vdd 0.57889f
C572 a_3844_4734# vbp_syn 0.13909f
C573 en mreset 0
C574 vbp_st vbp_syn 0.20991f
C575 el vbn_leak 0.03054f
C576 vreset vbn_ref 0.04625f
C577 rsel m1_2436_960# 0.0119f
C578 sub_b m1_196_2424# 0.66534f
C579 m1_1540_4540# spk 0.00434f
C580 vdd vbn_ref 0.3195f
C581 sub_b m1_4052_1572# 0.01364f
C582 el m1_2260_4540# 0.03523f
C583 hold abus 0
C584 en m1_3360_172# 0.15352f
C585 sub el 0.00343f
C586 a_2804_3624# m1_2260_4540# 0.1762f
C587 sub a_2804_3624# 0.10646f
C588 abus vbn_ref 0.10321f
C589 m1_2972_1572# m1_3360_172# 0.00239f
C590 sub_b a_480_5620# 0.59603f
C591 vbn_prb m1_2436_960# 0.11531f
C592 vbp_syn en 0.13513f
C593 a_288_2940# vdd 0.0017f
C594 m1_1540_4540# a_2160_3542# 0.07688f
C595 aux m1_2272_972# 0
C596 rsel m1_196_2424# 0.06579f
C597 a_1632_2940# m1_1692_4540# 0.18686f
C598 m1_4822_412# m1_3360_172# 0.05008f
C599 aux vss 0.35026f
C600 m1_3360_172# vss 0.89379f
C601 m1_196_2424# vss -0.03147f
C602 m1_2436_960# vss 0.45883f
C603 m1_2272_972# vss 0.1474f
C604 en vss 1.35839f
C605 abus vss 2.49653f
C606 sub vss 0.99622f
C607 mreset vss 1.02222f
C608 hold vss 2.90911f
C609 m1_4822_412# vss 0.29046f
C610 vbn_prb vss 0.72947f
C611 a_3184_3624# vss 0.34763f
C612 a_2804_3624# vss 0.12968f
C613 a_2160_3542# vss 0.26817f
C614 vsrc vss 0.89527f
C615 spk vss 1.07839f
C616 a_288_2940# vss -0.17315f
C617 m1_2972_1572# vss -0.05797f
C618 rsel vss 1.5435f
C619 m1_2260_4540# vss 0.33027f
C620 a_2080_2940# vss 0.06374f
C621 m1_3704_1572# vss -0.05941f
C622 m1_4052_1572# vss -0.05097f
C623 sub_b vss 3.14093f
C624 m1_1540_4540# vss 0.13853f
C625 vbp_st vss 0.35303f
C626 stb vss 0.7489f
C627 sta vss 0.18162f
C628 vdd vss 14.89011f
C629 a_2510_1690# vss 2.61662f
C630 vm vss 10.24131f
C631 vreset vss 0.49304f
C632 m1_1692_4540# vss -0.06835f
C633 vbn_ref vss 0.75784f
C634 m1_3212_6232# vss 0.09982f
C635 a_1632_2940# vss -0.0242f
C636 a_3844_4734# vss 0.07573f
C637 m1_4902_6372# vss -0.18906f
C638 m1_3440_5086# vss 0.04037f
C639 vbp_syn vss 0.34378f
C640 el vss 0.74106f
C641 m1_4802_1762# vss 0.01831f
C642 vbn_leak vss 1.10077f
C643 a_480_5620# vss -0.23821f
.ends
