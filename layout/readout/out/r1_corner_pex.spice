* NGSPICE file created from r1_corner.ext - technology: gf180mcuD

.subckt n_w2p5_l0p5_nf4 a_152_n250# a_52_n294# a_n152_n294# a_n256_n250# a_n52_n250#
+ a_356_n250# a_256_n294# a_n356_n294# a_n444_n250# VSUBS
X0 a_n256_n250# a_n356_n294# a_n444_n250# VSUBS nfet_03v3 ad=0.65p pd=3.02u as=1.1p ps=5.88u w=2.5u l=0.5u
X1 a_356_n250# a_256_n294# a_152_n250# VSUBS nfet_03v3 ad=1.1p pd=5.88u as=0.65p ps=3.02u w=2.5u l=0.5u
X2 a_152_n250# a_52_n294# a_n52_n250# VSUBS nfet_03v3 ad=0.65p pd=3.02u as=0.65p ps=3.02u w=2.5u l=0.5u
X3 a_n52_n250# a_n152_n294# a_n256_n250# VSUBS nfet_03v3 ad=0.65p pd=3.02u as=0.65p ps=3.02u w=2.5u l=0.5u
C0 a_52_n294# a_n52_n250# 0.03227f
C1 a_256_n294# a_356_n250# 0.03227f
C2 a_n152_n294# a_n356_n294# 0.00519f
C3 a_52_n294# a_n152_n294# 0.00519f
C4 a_n444_n250# a_n256_n250# 0.07806f
C5 a_n52_n250# a_n152_n294# 0.03227f
C6 a_n256_n250# a_n356_n294# 0.03227f
C7 a_n52_n250# a_n256_n250# 0.07806f
C8 a_256_n294# a_152_n250# 0.03227f
C9 a_52_n294# a_152_n250# 0.03227f
C10 a_n52_n250# a_152_n250# 0.07806f
C11 a_n256_n250# a_n152_n294# 0.03227f
C12 a_152_n250# a_356_n250# 0.07806f
C13 a_n444_n250# a_n356_n294# 0.03227f
C14 a_52_n294# a_256_n294# 0.00519f
C15 a_356_n250# VSUBS 0.16826f
C16 a_152_n250# VSUBS 0.12253f
C17 a_n52_n250# VSUBS 0.11745f
C18 a_n256_n250# VSUBS 0.12253f
C19 a_n444_n250# VSUBS 0.16826f
.ends

.subckt p_w0p22_l2_nf1 a_200_n22# a_n200_n66# a_n292_n36# w_n378_n159# VSUBS
X0 a_200_n22# a_n200_n66# a_n292_n36# w_n378_n159# pfet_03v3 ad=0.1516p pd=1.64u as=0.1516p ps=1.64u w=0.22u l=2u
C0 a_200_n22# w_n378_n159# 0.00771f
C1 a_n292_n36# a_n200_n66# 0.00705f
C2 w_n378_n159# a_n200_n66# 0.23197f
C3 a_200_n22# a_n200_n66# 0.00705f
C4 a_n292_n36# w_n378_n159# 0.00771f
C5 a_n292_n36# a_200_n22# 0.00245f
C6 a_200_n22# VSUBS 0.08442f
C7 a_n292_n36# VSUBS 0.08442f
C8 w_n378_n159# VSUBS 0.72122f
.ends

.subckt p_w1p6_l1_nf1 w_n274_n290# a_n100_n204# a_n188_n160# a_100_n160# VSUBS
X0 a_100_n160# a_n100_n204# a_n188_n160# w_n274_n290# pfet_03v3 ad=0.704p pd=4.08u as=0.704p ps=4.08u w=1.6u l=1u
C0 a_100_n160# w_n274_n290# 0.03917f
C1 a_n100_n204# a_n188_n160# 0.03376f
C2 w_n274_n290# a_n188_n160# 0.03917f
C3 a_100_n160# a_n188_n160# 0.03079f
C4 a_n100_n204# w_n274_n290# 0.12884f
C5 a_n100_n204# a_100_n160# 0.03376f
C6 a_100_n160# VSUBS 0.09794f
C7 a_n188_n160# VSUBS 0.09794f
C8 w_n274_n290# VSUBS 0.95352f
.ends

.subckt p_w0p4_l1_nf1 a_n188_n40# w_n274_n170# a_100_n40# a_n100_n84# VSUBS
X0 a_100_n40# a_n100_n84# a_n188_n40# w_n274_n170# pfet_03v3 ad=0.176p pd=1.68u as=0.176p ps=1.68u w=0.4u l=1u
C0 a_100_n40# w_n274_n170# 0.01117f
C1 a_n100_n84# a_n188_n40# 0.00812f
C2 w_n274_n170# a_n188_n40# 0.01117f
C3 a_100_n40# a_n188_n40# 0.0074f
C4 a_n100_n84# w_n274_n170# 0.12884f
C5 a_n100_n84# a_100_n40# 0.00812f
C6 a_100_n40# VSUBS 0.05913f
C7 a_n188_n40# VSUBS 0.05913f
C8 w_n274_n170# VSUBS 0.55896f
.ends

.subckt p_w1_l1_nf3 a_204_n144# a_404_n100# a_100_n100# a_n404_n144# a_n492_n100#
+ a_n100_n144# w_n578_n230# a_n204_n100# VSUBS
X0 a_404_n100# a_204_n144# a_100_n100# w_n578_n230# pfet_03v3 ad=0.44p pd=2.88u as=0.26p ps=1.52u w=1u l=1u
X1 a_100_n100# a_n100_n144# a_n204_n100# w_n578_n230# pfet_03v3 ad=0.26p pd=1.52u as=0.26p ps=1.52u w=1u l=1u
X2 a_n204_n100# a_n404_n144# a_n492_n100# w_n578_n230# pfet_03v3 ad=0.26p pd=1.52u as=0.44p ps=2.88u w=1u l=1u
C0 a_204_n144# w_n578_n230# 0.12548f
C1 a_204_n144# a_404_n100# 0.02094f
C2 a_n404_n144# a_n204_n100# 0.02094f
C3 a_n100_n144# a_100_n100# 0.02094f
C4 w_n578_n230# a_n204_n100# 0.03247f
C5 a_n404_n144# a_n100_n144# 0.00519f
C6 w_n578_n230# a_n100_n144# 0.12212f
C7 a_204_n144# a_n100_n144# 0.00519f
C8 a_n100_n144# a_n204_n100# 0.02094f
C9 a_n404_n144# a_n492_n100# 0.02094f
C10 w_n578_n230# a_n492_n100# 0.02517f
C11 w_n578_n230# a_100_n100# 0.03247f
C12 a_100_n100# a_404_n100# 0.0191f
C13 a_n492_n100# a_n204_n100# 0.0191f
C14 a_204_n144# a_100_n100# 0.02094f
C15 a_100_n100# a_n204_n100# 0.0191f
C16 a_n404_n144# w_n578_n230# 0.12548f
C17 w_n578_n230# a_404_n100# 0.02517f
C18 a_404_n100# VSUBS 0.07513f
C19 a_100_n100# VSUBS 0.0696f
C20 a_n204_n100# VSUBS 0.0696f
C21 a_n492_n100# VSUBS 0.07513f
C22 w_n578_n230# VSUBS 1.59528f
.ends

.subckt n_w2_l2_nf2 a_n52_n200# a_452_n200# a_n452_n244# a_n540_n200# a_52_n244# VSUBS
X0 a_452_n200# a_52_n244# a_n52_n200# VSUBS nfet_03v3 ad=0.88p pd=4.88u as=0.52p ps=2.52u w=2u l=2u
X1 a_n52_n200# a_n452_n244# a_n540_n200# VSUBS nfet_03v3 ad=0.52p pd=2.52u as=0.88p ps=4.88u w=2u l=2u
C0 a_52_n244# a_n52_n200# 0.0587f
C1 a_52_n244# a_n452_n244# 0.00519f
C2 a_n452_n244# a_n52_n200# 0.0587f
C3 a_n540_n200# a_n52_n200# 0.02133f
C4 a_52_n244# a_452_n200# 0.0587f
C5 a_452_n200# a_n52_n200# 0.02133f
C6 a_n540_n200# a_n452_n244# 0.0587f
C7 a_452_n200# VSUBS 0.26162f
C8 a_n52_n200# VSUBS 0.35281f
C9 a_n540_n200# VSUBS 0.26162f
.ends

.subckt p_w5_l0p5_nf4 a_n52_n500# a_356_n500# a_256_n544# a_n356_n544# a_n444_n500#
+ a_152_n500# a_52_n544# a_n152_n544# a_n256_n500# w_n530_n630# VSUBS
X0 a_n256_n500# a_n356_n544# a_n444_n500# w_n530_n630# pfet_03v3 ad=1.3p pd=5.52u as=2.2p ps=10.88u w=5u l=0.5u
X1 a_356_n500# a_256_n544# a_152_n500# w_n530_n630# pfet_03v3 ad=2.2p pd=10.88u as=1.3p ps=5.52u w=5u l=0.5u
X2 a_152_n500# a_52_n544# a_n52_n500# w_n530_n630# pfet_03v3 ad=1.3p pd=5.52u as=1.3p ps=5.52u w=5u l=0.5u
X3 a_n52_n500# a_n152_n544# a_n256_n500# w_n530_n630# pfet_03v3 ad=1.3p pd=5.52u as=1.3p ps=5.52u w=5u l=0.5u
C0 a_n356_n544# a_n256_n500# 0.06481f
C1 a_n52_n500# a_152_n500# 0.15674f
C2 a_n356_n544# a_n444_n500# 0.06481f
C3 w_n530_n630# a_256_n544# 0.07657f
C4 w_n530_n630# a_152_n500# 0.11021f
C5 a_256_n544# a_356_n500# 0.06481f
C6 a_356_n500# a_152_n500# 0.15674f
C7 a_n256_n500# a_n52_n500# 0.15674f
C8 a_n256_n500# w_n530_n630# 0.11021f
C9 w_n530_n630# a_n444_n500# 0.09239f
C10 a_256_n544# a_152_n500# 0.06481f
C11 a_n356_n544# w_n530_n630# 0.07657f
C12 a_n52_n500# a_52_n544# 0.06481f
C13 w_n530_n630# a_52_n544# 0.07322f
C14 a_n256_n500# a_n152_n544# 0.06481f
C15 a_n356_n544# a_n152_n544# 0.00519f
C16 w_n530_n630# a_n52_n500# 0.11021f
C17 a_n152_n544# a_52_n544# 0.00519f
C18 a_256_n544# a_52_n544# 0.00519f
C19 a_52_n544# a_152_n500# 0.06481f
C20 w_n530_n630# a_356_n500# 0.09239f
C21 a_n152_n544# a_n52_n500# 0.06481f
C22 a_n256_n500# a_n444_n500# 0.15674f
C23 a_n152_n544# w_n530_n630# 0.07322f
C24 a_356_n500# VSUBS 0.19143f
C25 a_152_n500# VSUBS 0.04344f
C26 a_n52_n500# VSUBS 0.04004f
C27 a_n256_n500# VSUBS 0.04344f
C28 a_n444_n500# VSUBS 0.19143f
C29 w_n530_n630# VSUBS 4.0068f
.ends

.subckt p_w5_l2_nf2 a_n52_n500# a_452_n500# a_n452_n544# a_n540_n500# a_52_n544# w_n626_n630#
+ VSUBS
X0 a_452_n500# a_52_n544# a_n52_n500# w_n626_n630# pfet_03v3 ad=2.2p pd=10.88u as=1.3p ps=5.52u w=5u l=2u
X1 a_n52_n500# a_n452_n544# a_n540_n500# w_n626_n630# pfet_03v3 ad=1.3p pd=5.52u as=2.2p ps=10.88u w=5u l=2u
C0 w_n626_n630# a_n540_n500# 0.15313f
C1 a_n540_n500# a_n52_n500# 0.05364f
C2 w_n626_n630# a_452_n500# 0.15313f
C3 a_452_n500# a_n52_n500# 0.05364f
C4 a_n540_n500# a_n452_n544# 0.14764f
C5 w_n626_n630# a_n52_n500# 0.23168f
C6 a_52_n544# a_452_n500# 0.14764f
C7 a_52_n544# w_n626_n630# 0.2233f
C8 a_52_n544# a_n52_n500# 0.14764f
C9 w_n626_n630# a_n452_n544# 0.2233f
C10 a_n452_n544# a_n52_n500# 0.14764f
C11 a_52_n544# a_n452_n544# 0.00519f
C12 a_452_n500# VSUBS 0.23067f
C13 a_n52_n500# VSUBS 0.12532f
C14 a_n540_n500# VSUBS 0.23067f
C15 w_n626_n630# VSUBS 4.73256f
.ends

.subckt p_w8_l7_nf1 w_n874_n930# a_n788_n800# a_700_n800# a_n700_n844# VSUBS
X0 a_700_n800# a_n700_n844# a_n788_n800# w_n874_n930# pfet_03v3 ad=3.52p pd=16.88u as=3.52p ps=16.88u w=8u l=7u
C0 w_n874_n930# a_700_n800# 0.32554f
C1 a_n788_n800# a_700_n800# 0.02424f
C2 a_700_n800# a_n700_n844# 0.30545f
C3 a_n788_n800# w_n874_n930# 0.32554f
C4 w_n874_n930# a_n700_n844# 0.71575f
C5 a_n788_n800# a_n700_n844# 0.30545f
C6 a_700_n800# VSUBS 0.46189f
C7 a_n788_n800# VSUBS 0.46189f
C8 w_n874_n930# VSUBS 9.75384f
.ends

.subckt n_w1_l4_nf1 a_n488_n100# a_400_n100# a_n400_n144# VSUBS
X0 a_400_n100# a_n400_n144# a_n488_n100# VSUBS nfet_03v3 ad=0.44p pd=2.88u as=0.44p ps=2.88u w=1u l=4u
C0 a_400_n100# a_n400_n144# 0.03474f
C1 a_n400_n144# a_n488_n100# 0.03474f
C2 a_400_n100# a_n488_n100# 0.00531f
C3 a_400_n100# VSUBS 0.37836f
C4 a_n488_n100# VSUBS 0.37836f
.ends

.subckt p_w4_l1_nf10 a_252_n400# a_n556_n444# a_660_n444# a_n1468_n444# a_1468_n400#
+ a_n1556_n400# a_n252_n444# a_n1164_n444# a_1164_n400# w_n1642_n530# a_n356_n400#
+ a_n1268_n400# a_860_n400# a_n52_n400# a_n860_n444# a_n964_n400# a_n660_n400# a_356_n444#
+ a_52_n444# a_1268_n444# a_556_n400# a_964_n444# VSUBS
X0 a_n356_n400# a_n556_n444# a_n660_n400# w_n1642_n530# pfet_03v3 ad=1.04p pd=4.52u as=1.04p ps=4.52u w=4u l=1u
X1 a_n1268_n400# a_n1468_n444# a_n1556_n400# w_n1642_n530# pfet_03v3 ad=1.04p pd=4.52u as=1.76p ps=8.88u w=4u l=1u
X2 a_1164_n400# a_964_n444# a_860_n400# w_n1642_n530# pfet_03v3 ad=1.04p pd=4.52u as=1.04p ps=4.52u w=4u l=1u
X3 a_n660_n400# a_n860_n444# a_n964_n400# w_n1642_n530# pfet_03v3 ad=1.04p pd=4.52u as=1.04p ps=4.52u w=4u l=1u
X4 a_1468_n400# a_1268_n444# a_1164_n400# w_n1642_n530# pfet_03v3 ad=1.76p pd=8.88u as=1.04p ps=4.52u w=4u l=1u
X5 a_556_n400# a_356_n444# a_252_n400# w_n1642_n530# pfet_03v3 ad=1.04p pd=4.52u as=1.04p ps=4.52u w=4u l=1u
X6 a_n52_n400# a_n252_n444# a_n356_n400# w_n1642_n530# pfet_03v3 ad=1.04p pd=4.52u as=1.04p ps=4.52u w=4u l=1u
X7 a_252_n400# a_52_n444# a_n52_n400# w_n1642_n530# pfet_03v3 ad=1.04p pd=4.52u as=1.04p ps=4.52u w=4u l=1u
X8 a_n964_n400# a_n1164_n444# a_n1268_n400# w_n1642_n530# pfet_03v3 ad=1.04p pd=4.52u as=1.04p ps=4.52u w=4u l=1u
X9 a_860_n400# a_660_n444# a_556_n400# w_n1642_n530# pfet_03v3 ad=1.04p pd=4.52u as=1.04p ps=4.52u w=4u l=1u
C0 a_n1268_n400# a_n1468_n444# 0.08505f
C1 w_n1642_n530# a_n860_n444# 0.12212f
C2 a_n860_n444# a_n556_n444# 0.00519f
C3 w_n1642_n530# a_964_n444# 0.12212f
C4 a_1164_n400# a_964_n444# 0.08505f
C5 a_356_n444# a_556_n400# 0.08505f
C6 w_n1642_n530# a_n660_n400# 0.12997f
C7 a_n660_n400# a_n556_n444# 0.08505f
C8 a_n1556_n400# a_n1468_n444# 0.08505f
C9 a_n1268_n400# a_n1556_n400# 0.07756f
C10 a_860_n400# w_n1642_n530# 0.12997f
C11 a_52_n444# a_n252_n444# 0.00519f
C12 a_n860_n444# a_n964_n400# 0.08505f
C13 a_860_n400# a_1164_n400# 0.07756f
C14 a_n660_n400# a_n964_n400# 0.07756f
C15 a_660_n444# a_556_n400# 0.08505f
C16 w_n1642_n530# a_n356_n400# 0.12997f
C17 w_n1642_n530# a_n252_n444# 0.12212f
C18 a_n356_n400# a_n556_n444# 0.08505f
C19 a_n252_n444# a_n556_n444# 0.00519f
C20 a_356_n444# a_252_n400# 0.08505f
C21 w_n1642_n530# a_1268_n444# 0.12548f
C22 a_1164_n400# a_1268_n444# 0.08505f
C23 a_n1164_n444# a_n860_n444# 0.00519f
C24 a_52_n444# w_n1642_n530# 0.12212f
C25 a_252_n400# a_556_n400# 0.07756f
C26 a_660_n444# a_964_n444# 0.00519f
C27 w_n1642_n530# a_n556_n444# 0.12212f
C28 a_1164_n400# w_n1642_n530# 0.12997f
C29 a_860_n400# a_660_n444# 0.08505f
C30 w_n1642_n530# a_n964_n400# 0.12997f
C31 a_252_n400# a_n52_n400# 0.07756f
C32 a_860_n400# a_556_n400# 0.07756f
C33 a_356_n444# a_52_n444# 0.00519f
C34 a_356_n444# w_n1642_n530# 0.12212f
C35 a_n660_n400# a_n860_n444# 0.08505f
C36 a_n1164_n444# w_n1642_n530# 0.12212f
C37 w_n1642_n530# a_n1468_n444# 0.12548f
C38 a_n1268_n400# w_n1642_n530# 0.12997f
C39 a_n356_n400# a_n52_n400# 0.07756f
C40 a_n252_n444# a_n52_n400# 0.08505f
C41 a_660_n444# w_n1642_n530# 0.12212f
C42 a_860_n400# a_964_n444# 0.08505f
C43 a_n1164_n444# a_n964_n400# 0.08505f
C44 w_n1642_n530# a_n1556_n400# 0.09518f
C45 a_n1268_n400# a_n964_n400# 0.07756f
C46 w_n1642_n530# a_556_n400# 0.12997f
C47 a_1468_n400# a_1268_n444# 0.08505f
C48 a_n660_n400# a_n356_n400# 0.07756f
C49 a_52_n444# a_n52_n400# 0.08505f
C50 a_52_n444# a_252_n400# 0.08505f
C51 a_964_n444# a_1268_n444# 0.00519f
C52 w_n1642_n530# a_n52_n400# 0.12997f
C53 w_n1642_n530# a_252_n400# 0.12997f
C54 a_n356_n400# a_n252_n444# 0.08505f
C55 a_1468_n400# w_n1642_n530# 0.09518f
C56 a_1468_n400# a_1164_n400# 0.07756f
C57 a_356_n444# a_660_n444# 0.00519f
C58 a_n1164_n444# a_n1468_n444# 0.00519f
C59 a_n1164_n444# a_n1268_n400# 0.08505f
C60 a_1468_n400# VSUBS 0.17216f
C61 a_1164_n400# VSUBS 0.0696f
C62 a_860_n400# VSUBS 0.06619f
C63 a_556_n400# VSUBS 0.06619f
C64 a_252_n400# VSUBS 0.06619f
C65 a_n52_n400# VSUBS 0.06619f
C66 a_n356_n400# VSUBS 0.06619f
C67 a_n660_n400# VSUBS 0.06619f
C68 a_n964_n400# VSUBS 0.06619f
C69 a_n1268_n400# VSUBS 0.0696f
C70 a_n1556_n400# VSUBS 0.17216f
C71 w_n1642_n530# VSUBS 10.4431f
.ends

.subckt n_w0p22_l20_nf1 a_2000_n22# a_n2000_n66# a_n2092_n36# VSUBS
X0 a_2000_n22# a_n2000_n66# a_n2092_n36# VSUBS nfet_03v3 ad=0.1516p pd=1.64u as=0.1516p ps=1.64u w=0.22u l=20u
C0 a_n2000_n66# a_2000_n22# 0.00918f
C1 a_n2000_n66# a_n2092_n36# 0.00918f
C2 a_2000_n22# VSUBS 1.56009f
C3 a_n2092_n36# VSUBS 1.56009f
.ends

.subckt p_w5_l0p28_nf2 a_n52_n500# w_n282_n630# a_52_n544# a_108_n500# a_n108_n544#
+ a_n196_n500# VSUBS
X0 a_108_n500# a_52_n544# a_n52_n500# w_n282_n630# pfet_03v3 ad=2.2p pd=10.88u as=1.3p ps=5.52u w=5u l=0.28u
X1 a_n52_n500# a_n108_n544# a_n196_n500# w_n282_n630# pfet_03v3 ad=1.3p pd=5.52u as=2.2p ps=10.88u w=5u l=0.28u
C0 a_n196_n500# a_n52_n500# 0.21627f
C1 a_52_n544# w_n282_n630# 0.05505f
C2 a_n108_n544# a_52_n544# 0.00519f
C3 a_108_n500# a_52_n544# 0.0391f
C4 a_n108_n544# w_n282_n630# 0.05505f
C5 a_108_n500# w_n282_n630# 0.0788f
C6 a_n196_n500# w_n282_n630# 0.0788f
C7 a_n196_n500# a_n108_n544# 0.0391f
C8 a_n52_n500# a_52_n544# 0.0391f
C9 a_n52_n500# w_n282_n630# 0.08302f
C10 a_n52_n500# a_n108_n544# 0.0391f
C11 a_108_n500# a_n52_n500# 0.21627f
C12 a_108_n500# VSUBS 0.18567f
C13 a_n52_n500# VSUBS 0.03533f
C14 a_n196_n500# VSUBS 0.18567f
C15 w_n282_n630# VSUBS 2.13192f
.ends

.subckt p_w5_l0p5_nf8 a_n52_n500# a_n852_n500# a_356_n500# a_256_n544# w_n938_n630#
+ a_560_n500# a_n356_n544# a_460_n544# a_n560_n544# a_152_n500# a_n664_n500# a_52_n544#
+ a_n152_n544# a_n256_n500# a_n460_n500# a_764_n500# a_664_n544# a_n764_n544# VSUBS
X0 a_560_n500# a_460_n544# a_356_n500# w_n938_n630# pfet_03v3 ad=1.3p pd=5.52u as=1.3p ps=5.52u w=5u l=0.5u
X1 a_n256_n500# a_n356_n544# a_n460_n500# w_n938_n630# pfet_03v3 ad=1.3p pd=5.52u as=1.3p ps=5.52u w=5u l=0.5u
X2 a_356_n500# a_256_n544# a_152_n500# w_n938_n630# pfet_03v3 ad=1.3p pd=5.52u as=1.3p ps=5.52u w=5u l=0.5u
X3 a_n664_n500# a_n764_n544# a_n852_n500# w_n938_n630# pfet_03v3 ad=1.3p pd=5.52u as=2.2p ps=10.88u w=5u l=0.5u
X4 a_152_n500# a_52_n544# a_n52_n500# w_n938_n630# pfet_03v3 ad=1.3p pd=5.52u as=1.3p ps=5.52u w=5u l=0.5u
X5 a_764_n500# a_664_n544# a_560_n500# w_n938_n630# pfet_03v3 ad=2.2p pd=10.88u as=1.3p ps=5.52u w=5u l=0.5u
X6 a_n460_n500# a_n560_n544# a_n664_n500# w_n938_n630# pfet_03v3 ad=1.3p pd=5.52u as=1.3p ps=5.52u w=5u l=0.5u
X7 a_n52_n500# a_n152_n544# a_n256_n500# w_n938_n630# pfet_03v3 ad=1.3p pd=5.52u as=1.3p ps=5.52u w=5u l=0.5u
C0 a_n356_n544# a_n256_n500# 0.06481f
C1 a_256_n544# a_460_n544# 0.00519f
C2 a_560_n500# w_n938_n630# 0.11021f
C3 a_n256_n500# a_n460_n500# 0.15674f
C4 a_664_n544# a_460_n544# 0.00519f
C5 a_n356_n544# a_n152_n544# 0.00519f
C6 a_356_n500# w_n938_n630# 0.11021f
C7 a_560_n500# a_764_n500# 0.15674f
C8 a_n52_n500# w_n938_n630# 0.11021f
C9 a_n460_n500# a_n664_n500# 0.15674f
C10 a_52_n544# a_n52_n500# 0.06481f
C11 a_n852_n500# w_n938_n630# 0.09239f
C12 a_n852_n500# a_n764_n544# 0.06481f
C13 a_460_n544# w_n938_n630# 0.07322f
C14 a_256_n544# w_n938_n630# 0.07322f
C15 a_52_n544# a_256_n544# 0.00519f
C16 a_n152_n544# a_n256_n500# 0.06481f
C17 a_n560_n544# w_n938_n630# 0.07322f
C18 a_664_n544# w_n938_n630# 0.07657f
C19 a_n764_n544# a_n560_n544# 0.00519f
C20 a_764_n500# a_664_n544# 0.06481f
C21 a_n764_n544# w_n938_n630# 0.07657f
C22 a_n356_n544# a_n560_n544# 0.00519f
C23 a_52_n544# w_n938_n630# 0.07322f
C24 a_764_n500# w_n938_n630# 0.09239f
C25 a_n52_n500# a_n256_n500# 0.15674f
C26 a_n560_n544# a_n460_n500# 0.06481f
C27 a_356_n500# a_152_n500# 0.15674f
C28 a_n52_n500# a_152_n500# 0.15674f
C29 a_n356_n544# w_n938_n630# 0.07322f
C30 a_n52_n500# a_n152_n544# 0.06481f
C31 a_n852_n500# a_n664_n500# 0.15674f
C32 a_n460_n500# w_n938_n630# 0.11021f
C33 a_256_n544# a_152_n500# 0.06481f
C34 a_560_n500# a_356_n500# 0.15674f
C35 a_n560_n544# a_n664_n500# 0.06481f
C36 a_560_n500# a_460_n544# 0.06481f
C37 a_n256_n500# w_n938_n630# 0.11021f
C38 a_n356_n544# a_n460_n500# 0.06481f
C39 a_356_n500# a_460_n544# 0.06481f
C40 a_152_n500# w_n938_n630# 0.11021f
C41 a_n664_n500# w_n938_n630# 0.11021f
C42 a_n152_n544# w_n938_n630# 0.07322f
C43 a_356_n500# a_256_n544# 0.06481f
C44 a_n764_n544# a_n664_n500# 0.06481f
C45 a_560_n500# a_664_n544# 0.06481f
C46 a_52_n544# a_152_n500# 0.06481f
C47 a_52_n544# a_n152_n544# 0.00519f
C48 a_764_n500# VSUBS 0.19143f
C49 a_560_n500# VSUBS 0.04344f
C50 a_356_n500# VSUBS 0.04004f
C51 a_152_n500# VSUBS 0.04004f
C52 a_n52_n500# VSUBS 0.04004f
C53 a_n256_n500# VSUBS 0.04004f
C54 a_n460_n500# VSUBS 0.04004f
C55 a_n664_n500# VSUBS 0.04344f
C56 a_n852_n500# VSUBS 0.19143f
C57 w_n938_n630# VSUBS 7.09128f
.ends

.subckt r1_corner pad vth_ref vsrc vrin ibias vreset abus en_b vdd vss
XXVS vsrc a_5884_6770# a_5884_6770# vsrc vss vss a_5884_6770# a_5884_6770# vss vss
+ n_w2p5_l0p5_nf4
XXVT m1_316_480# ibias vdd vdd vss p_w0p22_l2_nf1
XXVU vdd ibias vdd vsrc vss p_w1p6_l1_nf1
XXPR vdd vdd ibias ibias vss p_w0p4_l1_nf1
XXPT ibias w_172_4952# vdd ibias vdd ibias vdd w_172_4952# vss p_w1_l1_nf3
XXN1 m1_676_5560# vss m1_676_5560# vss m1_676_5560# vss n_w2_l2_nf2
XXN2 vreset vss m1_676_5560# vss m1_676_5560# vss n_w2_l2_nf2
XXM1 w_172_4952# w_172_4952# vrin vrin w_172_4952# m1_676_5560# vrin vrin m1_676_5560#
+ w_172_4952# vss p_w5_l0p5_nf4
XXM2 w_172_4952# w_172_4952# vreset vreset w_172_4952# vreset vreset vreset vreset
+ w_172_4952# vss p_w5_l0p5_nf4
XXVA a_3600_6620# m1_316_480# vsrc m1_316_480# vsrc vdd vss p_w5_l2_nf2
XXVB a_5884_6770# m1_316_480# vth_ref m1_316_480# vth_ref vdd vss p_w5_l2_nf2
XXVC vsrc vsrc vsrc a_5884_6770# vss p_w8_l7_nf1
XXVNB vss a_5884_6770# a_3600_6620# vss n_w1_l4_nf1
XXVNA vss a_3600_6620# a_3600_6620# vss n_w1_l4_nf1
XXPB m1_2284_3108# ibias ibias ibias m1_2284_3108# m1_2284_3108# ibias ibias pad vdd
+ m1_2284_3108# pad m1_2284_3108# pad ibias m1_2284_3108# pad ibias ibias ibias pad
+ ibias vss p_w4_l1_nf10
XXPD abus vdd vss vss n_w0p22_l20_nf1
XXPE m1_2284_3108# vdd en_b vdd en_b vdd vss p_w5_l0p28_nf2
XXPF pad pad pad abus pad vss abus abus abus vss vss abus abus vss pad pad abus abus
+ vss p_w5_l0p5_nf8
C0 pad vdd 0.49608f
C1 abus a_3600_6620# 0.34735f
C2 vreset ibias 0.20294f
C3 w_172_4952# vdd 0.57841f
C4 vsrc vdd 2.7617f
C5 pad a_3600_6620# 0.18178f
C6 vth_ref ibias 0.03697f
C7 abus a_5884_6770# 0.11596f
C8 w_172_4952# a_3600_6620# 0.15415f
C9 m1_676_5560# ibias 0.06251f
C10 vreset vth_ref 0.00743f
C11 a_3600_6620# vsrc 0.18368f
C12 pad a_5884_6770# 0.69556f
C13 en_b vdd 0.38533f
C14 abus m1_2284_3108# 0.13839f
C15 m1_316_480# ibias 0.01487f
C16 vreset m1_676_5560# 0.49538f
C17 vsrc a_5884_6770# 2.69161f
C18 m1_2284_3108# pad 1.25359f
C19 vth_ref m1_676_5560# 0.02712f
C20 en_b a_3600_6620# 0.02721f
C21 vth_ref m1_316_480# 0.20017f
C22 m1_2284_3108# w_172_4952# 0.00244f
C23 m1_2284_3108# vsrc 0.12445f
C24 ibias vrin 0.04612f
C25 en_b a_5884_6770# 0.24023f
C26 abus ibias 0.08415f
C27 vreset vrin 0.01705f
C28 pad ibias 0.50086f
C29 m1_2284_3108# en_b 0.07072f
C30 vreset abus 0.19001f
C31 vth_ref vrin 0.14516f
C32 a_3600_6620# vdd 0.25771f
C33 w_172_4952# ibias 0.33576f
C34 ibias vsrc 0.18287f
C35 m1_676_5560# vrin 0.08143f
C36 vdd a_5884_6770# 0.59882f
C37 abus m1_676_5560# 0.111f
C38 vreset w_172_4952# 0.92734f
C39 vreset vsrc 0
C40 abus m1_316_480# 0
C41 vth_ref w_172_4952# 0.24769f
C42 en_b ibias 0
C43 vth_ref vsrc 0.00674f
C44 a_3600_6620# a_5884_6770# 0.24503f
C45 m1_2284_3108# vdd 0.54549f
C46 m1_316_480# pad 0.05078f
C47 m1_676_5560# w_172_4952# 0.50407f
C48 m1_676_5560# vsrc 0
C49 vreset en_b 0.01343f
C50 m1_2284_3108# a_3600_6620# 0.11712f
C51 m1_316_480# w_172_4952# 0
C52 m1_316_480# vsrc 0.12468f
C53 en_b m1_676_5560# 0.06045f
C54 m1_2284_3108# a_5884_6770# 0.01565f
C55 ibias vdd 4.58321f
C56 abus pad 1.74303f
C57 w_172_4952# vrin 0.71777f
C58 vreset vdd 0.04638f
C59 abus w_172_4952# 0.00669f
C60 a_3600_6620# ibias 0.60162f
C61 abus vsrc 0.0604f
C62 vth_ref vdd 1.05017f
C63 pad w_172_4952# 0.00693f
C64 pad vsrc 0.37664f
C65 vreset a_3600_6620# 0.3373f
C66 m1_676_5560# vdd 0.03715f
C67 ibias a_5884_6770# 0.0344f
C68 vth_ref a_3600_6620# 0.0061f
C69 abus en_b 0.01579f
C70 m1_316_480# vdd 0.33678f
C71 vreset a_5884_6770# 0
C72 pad en_b 0.00658f
C73 m1_676_5560# a_3600_6620# 0.08812f
C74 m1_2284_3108# ibias 0.57246f
C75 vth_ref a_5884_6770# 0.09534f
C76 m1_316_480# a_3600_6620# 0.14498f
C77 en_b vsrc 0.05796f
C78 m1_676_5560# a_5884_6770# 0.01888f
C79 vdd vrin 0.01249f
C80 abus vdd 0.42471f
C81 m1_316_480# a_5884_6770# 0.23756f
C82 abus vss 1.27464f
C83 pad vss 7.24208f
C84 en_b vss 0.43946f
C85 m1_2284_3108# vss -0.2636f
C86 a_5884_6770# vss 2.0784f
C87 m1_316_480# vss -0.08123f
C88 vth_ref vss 0.29464f
C89 vdd vss 28.05444f
C90 a_3600_6620# vss 1.54192f
C91 vsrc vss 1.46983f
C92 vreset vss 0.79357f
C93 m1_676_5560# vss 1.57953f
C94 vrin vss 0.18048f
C95 w_172_4952# vss 6.82071f
C96 ibias vss -0.44961f
.ends
