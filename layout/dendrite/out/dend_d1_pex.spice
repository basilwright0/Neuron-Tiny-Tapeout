* NGSPICE file created from dend_d1.ext - technology: gf180mcuD

.subckt n_w2_l4 a_400_n200# a_n400_n244# a_n488_n200# VSUBS
X0 a_400_n200# a_n400_n244# a_n488_n200# VSUBS nfet_03v3 ad=0.88p pd=4.88u as=0.88p ps=4.88u w=2u l=4u
C0 a_400_n200# a_n488_n200# 0.01073f
C1 a_n488_n200# a_n400_n244# 0.07019f
C2 a_400_n200# a_n400_n244# 0.07019f
C3 a_400_n200# VSUBS 0.41684f
C4 a_n488_n200# VSUBS 0.41684f
.ends

.subckt n_w1_l0p28 a_28_n100# a_n28_n144# a_n116_n100# VSUBS
X0 a_28_n100# a_n28_n144# a_n116_n100# VSUBS nfet_03v3 ad=0.44p pd=2.88u as=0.44p ps=2.88u w=1u l=0.28u
C0 a_28_n100# a_n116_n100# 0.04256f
C1 a_n116_n100# a_n28_n144# 0.00769f
C2 a_28_n100# a_n28_n144# 0.00769f
C3 a_28_n100# VSUBS 0.09911f
C4 a_n116_n100# VSUBS 0.09911f
.ends

.subckt p_w1_l0p28 w_n202_n230# a_28_n100# a_n28_n144# a_n116_n100# VSUBS
X0 a_28_n100# a_n28_n144# a_n116_n100# w_n202_n230# pfet_03v3 ad=0.44p pd=2.88u as=0.44p ps=2.88u w=1u l=0.28u
C0 a_28_n100# a_n28_n144# 0.00769f
C1 a_n116_n100# a_n28_n144# 0.00769f
C2 a_n28_n144# w_n202_n230# 0.05841f
C3 a_28_n100# a_n116_n100# 0.04256f
C4 a_28_n100# w_n202_n230# 0.01808f
C5 a_n116_n100# w_n202_n230# 0.01808f
C6 a_28_n100# VSUBS 0.0597f
C7 a_n116_n100# VSUBS 0.0597f
C8 w_n202_n230# VSUBS 0.55752f
.ends

.subckt n_w2_l2 a_n288_n200# a_200_n200# a_n200_n244# VSUBS
X0 a_200_n200# a_n200_n244# a_n288_n200# VSUBS nfet_03v3 ad=0.88p pd=4.88u as=0.88p ps=4.88u w=2u l=2u
C0 a_200_n200# a_n288_n200# 0.02133f
C1 a_n288_n200# a_n200_n244# 0.0587f
C2 a_200_n200# a_n200_n244# 0.0587f
C3 a_200_n200# VSUBS 0.2667f
C4 a_n288_n200# VSUBS 0.2667f
.ends

.subckt p_w2_l4 a_400_n200# a_n400_n244# w_n574_n330# a_n488_n200# VSUBS
X0 a_400_n200# a_n400_n244# a_n488_n200# w_n574_n330# pfet_03v3 ad=0.88p pd=4.88u as=0.88p ps=4.88u w=2u l=4u
C0 a_400_n200# a_n400_n244# 0.07019f
C1 a_n488_n200# a_n400_n244# 0.07019f
C2 a_n400_n244# w_n574_n330# 0.42229f
C3 a_400_n200# a_n488_n200# 0.01073f
C4 a_400_n200# w_n574_n330# 0.07409f
C5 a_n488_n200# w_n574_n330# 0.07409f
C6 a_400_n200# VSUBS 0.18936f
C7 a_n488_n200# VSUBS 0.18936f
C8 w_n574_n330# VSUBS 2.27304f
.ends

.subckt p_w1_l0p5 a_n138_n100# a_50_n100# a_n50_n144# w_n224_n230# VSUBS
X0 a_50_n100# a_n50_n144# a_n138_n100# w_n224_n230# pfet_03v3 ad=0.44p pd=2.88u as=0.44p ps=2.88u w=1u l=0.5u
C0 a_50_n100# a_n50_n144# 0.01275f
C1 a_n138_n100# a_n50_n144# 0.01275f
C2 a_n50_n144# w_n224_n230# 0.07993f
C3 a_50_n100# a_n138_n100# 0.03085f
C4 a_50_n100# w_n224_n230# 0.0205f
C5 a_n138_n100# w_n224_n230# 0.0205f
C6 a_50_n100# VSUBS 0.06546f
C7 a_n138_n100# VSUBS 0.06546f
C8 w_n224_n230# VSUBS 0.61824f
.ends

.subckt p_w1_l2 w_n374_n230# a_n288_n100# a_200_n100# a_n200_n144# VSUBS
X0 a_200_n100# a_n200_n144# a_n288_n100# w_n374_n230# pfet_03v3 ad=0.44p pd=2.88u as=0.44p ps=2.88u w=1u l=2u
C0 a_200_n100# a_n200_n144# 0.02905f
C1 a_n288_n100# a_n200_n144# 0.02905f
C2 a_n200_n144# w_n374_n230# 0.22666f
C3 a_200_n100# a_n288_n100# 0.01056f
C4 a_200_n100# w_n374_n230# 0.03135f
C5 a_n288_n100# w_n374_n230# 0.03135f
C6 a_200_n100# VSUBS 0.1047f
C7 a_n288_n100# VSUBS 0.1047f
C8 w_n374_n230# VSUBS 1.03224f
.ends

.subckt n_w0p5_l0p28 a_n28_n94# a_n116_n50# a_28_n50# VSUBS
X0 a_28_n50# a_n28_n94# a_n116_n50# VSUBS nfet_03v3 ad=0.22p pd=1.88u as=0.22p ps=1.88u w=0.5u l=0.28u
C0 a_28_n50# a_n116_n50# 0.02085f
C1 a_n116_n50# a_n28_n94# 0.00377f
C2 a_28_n50# a_n28_n94# 0.00377f
C3 a_28_n50# VSUBS 0.07987f
C4 a_n116_n50# VSUBS 0.07987f
.ends

.subckt n_w0p5_l0p5 a_n138_n50# a_50_n50# a_n50_n94# VSUBS
X0 a_50_n50# a_n50_n94# a_n138_n50# VSUBS nfet_03v3 ad=0.22p pd=1.88u as=0.22p ps=1.88u w=0.5u l=0.5u
C0 a_50_n50# a_n138_n50# 0.01511f
C1 a_n138_n50# a_n50_n94# 0.00625f
C2 a_50_n50# a_n50_n94# 0.00625f
C3 a_50_n50# VSUBS 0.09639f
C4 a_n138_n50# VSUBS 0.09639f
.ends

.subckt n_w4_l2 a_n288_n400# a_200_n400# a_n200_n444# VSUBS
X0 a_200_n400# a_n200_n444# a_n288_n400# VSUBS nfet_03v3 ad=1.76p pd=8.88u as=1.76p ps=8.88u w=4u l=2u
C0 a_200_n400# a_n288_n400# 0.04287f
C1 a_n288_n400# a_n200_n444# 0.11799f
C2 a_200_n400# a_n200_n444# 0.11799f
C3 a_200_n400# VSUBS 0.34365f
C4 a_n288_n400# VSUBS 0.34365f
.ends

.subckt n_w3p54_l3p54 a_354_n354# a_n354_n398# a_n442_n354# VSUBS
X0 a_354_n354# a_n354_n398# a_n442_n354# VSUBS nfet_03v3 ad=1.5576p pd=7.96u as=1.5576p ps=7.96u w=3.54u l=3.54u
C0 a_354_n354# a_n442_n354# 0.02161f
C1 a_n442_n354# a_n354_n398# 0.12189f
C2 a_354_n354# a_n354_n398# 0.12189f
C3 a_354_n354# VSUBS 0.44156f
C4 a_n442_n354# VSUBS 0.44156f
.ends

.subckt n_w1_l0p5 a_n138_n100# a_50_n100# a_n50_n144# VSUBS
X0 a_50_n100# a_n50_n144# a_n138_n100# VSUBS nfet_03v3 ad=0.44p pd=2.88u as=0.44p ps=2.88u w=1u l=0.5u
C0 a_50_n100# a_n138_n100# 0.03085f
C1 a_n138_n100# a_n50_n144# 0.01275f
C2 a_50_n100# a_n50_n144# 0.01275f
C3 a_50_n100# VSUBS 0.11563f
C4 a_n138_n100# VSUBS 0.11563f
.ends

.subckt n_w1_l1 a_n188_n100# a_100_n100# a_n100_n144# VSUBS
X0 a_100_n100# a_n100_n144# a_n188_n100# VSUBS nfet_03v3 ad=0.44p pd=2.88u as=0.44p ps=2.88u w=1u l=1u
C0 a_100_n100# a_n188_n100# 0.0191f
C1 a_n188_n100# a_n100_n144# 0.02094f
C2 a_100_n100# a_n100_n144# 0.02094f
C3 a_100_n100# VSUBS 0.15316f
C4 a_n188_n100# VSUBS 0.15316f
.ends

.subckt n_w1_l4 a_n488_n100# a_400_n100# a_n400_n144# VSUBS
X0 a_400_n100# a_n400_n144# a_n488_n100# VSUBS nfet_03v3 ad=0.44p pd=2.88u as=0.44p ps=2.88u w=1u l=4u
C0 a_400_n100# a_n488_n100# 0.00531f
C1 a_n488_n100# a_n400_n144# 0.03474f
C2 a_400_n100# a_n400_n144# 0.03474f
C3 a_400_n100# VSUBS 0.37836f
C4 a_n488_n100# VSUBS 0.37836f
.ends

.subckt n_w0p22_l2 a_200_n22# a_n200_n66# a_n292_n36# VSUBS
X0 a_200_n22# a_n200_n66# a_n292_n36# VSUBS nfet_03v3 ad=0.1516p pd=1.64u as=0.1516p ps=1.64u w=0.22u l=2u
C0 a_200_n22# a_n200_n66# 0.00705f
C1 a_n200_n66# a_n292_n36# 0.00705f
C2 a_200_n22# a_n292_n36# 0.00245f
C3 a_200_n22# VSUBS 0.20767f
C4 a_n292_n36# VSUBS 0.20767f
.ends

.subckt n_w7p07_l7p07 a_707_n707# a_n795_n707# a_n707_n751# VSUBS
X0 a_707_n707# a_n707_n751# a_n795_n707# VSUBS nfet_03v3 ad=3.1108p pd=15.02u as=3.1108p ps=15.02u w=7.07u l=7.07u
C0 a_707_n707# a_n795_n707# 0.0212f
C1 a_n795_n707# a_n707_n751# 0.27012f
C2 a_707_n707# a_n707_n751# 0.27012f
C3 a_707_n707# VSUBS 0.84237f
C4 a_n795_n707# VSUBS 0.84237f
.ends

.subckt n_w4_l1 a_n188_n400# a_100_n400# a_n100_n444# VSUBS
X0 a_100_n400# a_n100_n444# a_n188_n400# VSUBS nfet_03v3 ad=1.76p pd=8.88u as=1.76p ps=8.88u w=4u l=1u
C0 a_100_n400# a_n188_n400# 0.07756f
C1 a_n188_n400# a_n100_n444# 0.08505f
C2 a_100_n400# a_n100_n444# 0.08505f
C3 a_100_n400# VSUBS 0.26859f
C4 a_n188_n400# VSUBS 0.26859f
.ends

.subckt dend_d1 vdd vss el vbn_leak vsrc vsrcp vbp_st vbn_ax vbn_ref vreset vbn_prb
+ abus sel0 sel2 mreset spk en pl_en chain sel1 d1_bsel sta stb hold ta0 ta1 ta2 ta3
+ tb0 tb1 tb2 tb3 vbp_syn la1 dl1 la2 dl2 d1 d2 vs
XXEP_XS a_8248_5320# vbn_leak vss vss n_w2_l4
XXS_XL_XMT m1_1704_2770# vbn_leak vss vss n_w2_l4
XXWS a_268_18120# a_1892_3934# vs vss n_w1_l0p28
XXS_XD_Xi4_XP vdd spk a_3272_6334# vdd vss p_w1_l0p28
XXL1_XM2 a_1780_10600# dl1 dl1 vss n_w2_l2
XXA2_XB_XD1 a_5204_18120# m1_5626_17750# a_5204_18120# vss n_w2_l2
XXA2_XA_XP2 a_2536_18120# a_488_19200# vdd vdd vss p_w2_l4
XXY2_XQB vdd vss vss m1_2678_13030# vss p_w1_l0p28
XXS_XL_XM1 a_488_5520# m1_690_2500# el vss n_w2_l2
XXA2_XB_XD2 m1_5626_17750# a_5960_18120# a_5960_18120# vss n_w2_l2
XXA2_XA_XHO vdd d2 hold a_2536_18120# vss p_w1_l0p28
XXA2_XA_XMT m1_1704_17750# vbn_ax vss vss n_w2_l4
XXT1_XME m1_7390_15740# en m1_8166_15130# vss n_w1_l0p28
XXS_XL_XM2 a_1780_2880# a_2536_2880# a_2536_2880# vss n_w2_l2
XXP2_XDT_XNE m1_7128_14156# a_5816_16974# vsrcp vss n_w1_l0p28
XXS_XD_XPI m1_910_6150# a_728_3738# vs vdd vss p_w1_l0p5
XXEP_XPD vdd vdd a_8248_5320# a_8248_5320# vss p_w1_l2
XXA2_XA_XM1 a_488_19200# m1_690_17890# a_268_18120# vss n_w2_l2
XXY2_XNA a_2180_13234# d2 m1_2220_12980# vss n_w0p5_l0p28
XXS_XR_XNR a_4374_1028# vbn_ref vss vss n_w2_l4
XXS_XR_XSW vreset vs a_4374_1028# vss n_w0p5_l0p5
XXT1_XMF m1_7390_15740# vdd d2 vss n_w4_l2
XXT2_XSW m1_7390_10270# sel2 abus vss n_w1_l0p28
XXP2_XTP vdd a_4588_13668# a_5816_16974# vdd vss p_w1_l0p28
XXP1_XCT_XC vss a_4588_8588# vss vss n_w3p54_l3p54
XXB_XP1 vdd a_2592_8154# d1_bsel stb vss p_w1_l0p28
XXA2_XA_XM2 a_1780_18120# a_2536_18120# a_2536_18120# vss n_w2_l2
XXY2_XNB vss d2 m1_2678_13030# vss n_w0p5_l0p28
XXP2_XDT_XPI m1_6726_16790# a_8436_16974# d2 vdd vss p_w1_l0p5
XXS_XD_XNI vsrc a_728_3738# vs vss n_w1_l0p5
XXY1_XWA m1_2868_9480# vbp_syn vdd m1_2122_9086# vss p_w2_l4
XXB_XP2 vdd a_2180_13234# a_672_19994# stb vss p_w1_l0p28
XXA1_XA_XD1 a_5204_2880# m1_5626_2500# a_5204_2880# vss n_w2_l2
XXP2_XDT_XNH m1_7128_14156# a_8436_16974# d2 vss n_w1_l1
XXB_XN1 a_672_19994# stb a_2592_8154# vss n_w0p5_l0p28
XXY1_XWB m1_2678_7950# vbp_syn vdd m1_2122_9086# vss p_w2_l4
XXP2_XDT_XNI vsrcp a_8436_16974# d2 vss n_w1_l1
XXA1_XA_XD2 m1_5626_2500# a_5960_2880# a_5960_2880# vss n_w2_l2
XXP2_XTS a_4588_13668# a_5816_16974# m1_6474_13030# vss n_w1_l0p28
XXB_XN2 d1_bsel stb a_2180_13234# vss n_w0p5_l0p28
XXY2_XPH vdd vdd m1_2064_14170# hold vss p_w1_l2
XXP1_XTI vss m1_6474_8020# vbn_leak vss n_w1_l4
XXL1_XD1 m1_690_10190# m1_1704_10270# m1_690_10190# vss n_w2_l2
XXMR mreset a_4374_1028# vdd vss n_w0p5_l0p28
XXL1_XD2 m1_1704_10270# a_1780_10600# a_1780_10600# vss n_w2_l2
XXP2_XS1 m1_7128_13020# m1_5122_15350# a_5816_16974# vss n_w1_l1
XXP2_XCT_XC vss a_4588_13668# vss vss n_w3p54_l3p54
XXT0_XMB vss m1_2702_380# vbn_prb vss n_w2_l2
XXS_XL_XD1 m1_690_2500# m1_1704_2770# m1_690_2500# vss n_w2_l2
XXP2_XS2 m1_7694_12850# m1_7128_13020# a_4588_13668# vss n_w1_l1
XXP2_XDT_XON a_6672_14314# vss a_5816_16974# vss n_w0p5_l0p28
XXY1_XQA vdd vss sta m1_2868_9480# vss p_w1_l0p28
XXP2_XOP1 a_2920_17120# a_2920_17120# vdd vdd vss p_w2_l4
XXS_XL_XD2 m1_1704_2770# a_1780_2880# a_1780_2880# vss n_w2_l2
XXEP_XPM vdd vdd a_2724_4480# a_8248_5320# vss p_w1_l2
XXA2_XA_XD1 m1_690_17890# m1_1704_17750# m1_690_17890# vss n_w2_l2
XXP2_XS3 m1_6390_15350# m1_7694_12850# pl_en vss n_w1_l1
XXY1_XQB vdd vss a_2592_8154# m1_2678_7950# vss p_w1_l0p28
XXP1_XDT_XNE m1_7138_8930# a_5816_11894# vsrcp vss n_w1_l0p28
XXP2_XOP2 a_5204_15680# a_2920_17120# vdd vdd vss p_w2_l4
XXP2_XDT_XOP vdd a_5816_16974# a_6672_14314# vdd vss p_w1_l0p28
XXS_XD_XPS vdd vdd m1_910_6150# vbp_st vss p_w1_l2
XXS_XD_XS2 vdd vdd m1_2122_6150# vbp_st vss p_w1_l2
XXA2_XA_XD2 m1_1704_17750# a_1780_18120# a_1780_18120# vss n_w2_l2
XXT0_XME m1_1946_330# en m1_2702_380# vss n_w1_l0p28
XXP1_XDT_XPI m1_6726_11710# a_5268_9138# d1 vdd vss p_w1_l0p5
XXY1_XNA sta d1 m1_2868_9480# vss n_w0p5_l0p28
XXP2_XOM1 a_2920_17120# m1_5122_15350# a_2724_4480# vss n_w2_l2
XXT1_XSW m1_7390_15740# sel1 abus vss n_w1_l0p28
XXT0_XMF m1_1946_330# vdd vs vss n_w4_l2
XXP2_XDT_XS2 vdd vdd m1_8050_16790# vbp_st vss p_w1_l2
XXP2_XDT_XPS vdd vdd m1_6726_16790# vbp_st vss p_w1_l2
XXY1_XNB a_2592_8154# d1 m1_2678_7950# vss n_w0p5_l0p28
XXP1_XDT_XNH m1_7138_8930# a_5268_9138# d1 vss n_w1_l1
XXP1_XTP vdd a_4588_8588# a_5816_11894# vdd vss p_w1_l0p28
XXP2_XOM2 m1_5122_15350# a_5204_15680# a_5204_15680# vss n_w2_l2
XXP2_XHP vdd d2 hold a_5204_15680# vss p_w1_l0p28
XXS_XD_XP2 vdd a_1480_3834# a_728_3738# m1_2122_6150# vss p_w1_l0p28
XXP1_XDT_XNI vsrcp a_5268_9138# d1 vss n_w1_l1
XXB_XD1 d1_bsel vss a_2592_8154# vss n_w0p5_l0p28
XXS_XD_XP3 vdd a_3272_6334# a_1480_3834# vdd vss p_w1_l0p28
XXB_XD2 a_672_19994# vss a_2180_13234# vss n_w0p5_l0p28
XXP2_XDT_XP2 vdd a_6140_14314# a_8436_16974# m1_8050_16790# vss p_w1_l0p28
XXS_XD_XN2 a_1480_3834# a_728_3738# vsrc vss n_w0p22_l2
XXP1_XTS a_4588_8588# a_5816_11894# m1_6474_8020# vss n_w1_l0p28
XXA1_XB_XP1 a_5524_5520# a_5524_5520# vdd vdd vss p_w2_l4
XXP2_XDT_XP3 vdd a_6672_14314# a_6140_14314# vdd vss p_w1_l0p28
XXS_XD_XN3 a_1480_3834# vsrc a_3272_6334# vss n_w0p5_l0p28
XXY1_XPH vdd vdd m1_2122_9086# hold vss p_w1_l2
XXA1_XB_XP2 a_5960_4080# a_5524_5520# vdd vdd vss p_w2_l4
XXY2_XHL vdd d2 hold dl2 vss p_w1_l0p28
XXP2_XDT_XN2 a_6140_14314# a_8436_16974# vsrcp vss n_w0p22_l2
XXP1_XDT_XON a_6672_9234# vss a_5816_11894# vss n_w0p5_l0p28
XXWC a_268_18120# chain d1 vss n_w1_l0p28
XXA1_XB_XMT m1_4870_3750# vbn_ax vss vss n_w2_l4
XXA1_XB_XHO vdd d1 hold a_5960_4080# vss p_w1_l0p28
XXP2_XDT_XN3 a_6140_14314# vsrcp a_6672_14314# vss n_w0p5_l0p28
XXY2_XMR vss vss vdd vss n_w0p5_l0p28
XXP1_XS1 m1_7138_8020# m1_5100_10180# a_5816_11894# vss n_w1_l1
XXL2_XP1 la2 la2 vdd vdd vss p_w2_l4
XXA1_XB_XM1 a_5524_5520# a_4448_4080# vs vss n_w2_l2
XXP1_XDT_XOP vdd a_5816_11894# a_6672_9234# vdd vss p_w1_l0p28
XXS_XR_XPC vdd a_4374_1028# a_4096_6334# vdd vss p_w1_l0p28
XXP1_XS2 m1_7684_8010# m1_7138_8020# a_4588_8588# vss n_w1_l1
XXL2_XP2 dl2 la2 vdd vdd vss p_w2_l4
XXP1_XOP1 a_2920_12040# a_2920_12040# vdd vdd vss p_w2_l4
XXS_XR_Xi_XN spk vss a_4096_6334# vss n_w0p5_l0p28
XXA1_XB_XM2 a_5204_4080# a_5960_4080# a_5960_4080# vss n_w2_l2
XXP1_XS3 m1_6390_10270# m1_7684_8010# pl_en vss n_w1_l1
XXP2_XOTA vss m1_6390_15350# vbn_leak vss n_w4_l2
XXL2_XMT m1_1704_15350# vbn_leak vss vss n_w2_l4
XXP1_XOP2 a_5204_10600# a_2920_12040# vdd vdd vss p_w2_l4
XXC1_XC vss vss d1 vss n_w7p07_l7p07
XXP1_XDT_XS2 vdd vdd m1_8050_11710# vbp_st vss p_w1_l2
XXP1_XDT_XPS vdd vdd m1_6726_11710# vbp_st vss p_w1_l2
XXP2_XOTB m1_6390_15350# vss vbn_leak vss n_w4_l2
XXL2_XM1 la2 m1_690_15350# el vss n_w2_l2
XXS_XR_Xi_XP vdd a_4096_6334# spk vdd vss p_w1_l0p28
XXT2_XMB vss m1_8166_10050# vbn_prb vss n_w2_l2
XXA2_XB_XP1 a_3212_19200# a_3212_19200# vdd vdd vss p_w2_l4
XXL2_XM2 a_1780_15680# dl2 dl2 vss n_w2_l2
XXT0_XSW m1_1946_330# sel0 abus vss n_w1_l0p28
XXP1_XOM1 a_2920_12040# m1_5100_10180# a_2724_4480# vss n_w2_l2
XXA2_XB_XP2 a_6716_18120# a_3212_19200# vdd vdd vss p_w2_l4
XXP1_XOM2 m1_5100_10180# a_5204_10600# a_5204_10600# vss n_w2_l2
XXA2_XB_XMT m1_5626_17750# vbn_ax vss vss n_w2_l4
XXA2_XB_XHO vdd a_268_18120# hold a_6716_18120# vss p_w1_l0p28
XXP1_XDT_XP2 vdd a_6140_9234# a_5268_9138# m1_8050_11710# vss p_w1_l0p28
XXP1_XHP vdd d1 hold a_5204_10600# vss p_w1_l0p28
XXT2_XME m1_7390_10270# en m1_8166_10050# vss n_w1_l0p28
XXA2_XB_XM1 a_3212_19200# a_5204_18120# d2 vss n_w2_l2
XXP1_XDT_XP3 vdd a_6672_9234# a_6140_9234# vdd vss p_w1_l0p28
XXT2_XMF m1_7390_10270# vdd d1 vss n_w4_l2
XXA2_XB_XM2 a_5960_18120# a_6716_18120# a_6716_18120# vss n_w2_l2
XXP1_XDT_XN2 a_6140_9234# a_5268_9138# vsrcp vss n_w0p22_l2
XXI_XN chain vss a_1892_3934# vss n_w0p5_l0p28
XXA1_XA_XP1 a_3956_5520# a_3956_5520# vdd vdd vss p_w2_l4
XXY2_XWA m1_2220_12980# vbp_syn vdd m1_2064_14170# vss p_w2_l4
XXP1_XDT_XN3 a_6140_9234# vsrcp a_6672_9234# vss n_w0p5_l0p28
XXA1_XB_XD1 a_4448_4080# m1_4870_3750# a_4448_4080# vss n_w2_l2
XXA1_XA_XP2 a_6716_2880# a_3956_5520# vdd vdd vss p_w2_l4
XXB_XI_XN d1_bsel vss a_672_19994# vss n_w0p5_l0p28
XXY2_XWB m1_2678_13030# vbp_syn vdd m1_2064_14170# vss p_w2_l4
XXY1_XHL vdd d1 hold dl1 vss p_w1_l0p28
XXEP_XN el a_2724_4480# a_2724_4480# vss n_w4_l1
XXA1_XB_XD2 m1_4870_3750# a_5204_4080# a_5204_4080# vss n_w2_l2
XXS_XHL vdd vs hold a_2536_2880# vss p_w1_l0p28
XXA1_XA_XMT m1_5626_2500# vbn_ax vss vss n_w2_l4
XXA1_XA_XHO vdd vs hold a_6716_2880# vss p_w1_l0p28
XXI_XP vdd a_1892_3934# chain vdd vss p_w1_l0p28
XXY1_XMR vss vss vdd vss n_w0p5_l0p28
XXA1_XA_XM1 a_3956_5520# a_5204_2880# d1 vss n_w2_l2
XXL1_XP1 la1 la1 vdd vdd vss p_w2_l4
XXB_XI_XP vdd a_672_19994# d1_bsel vdd vss p_w1_l0p28
XXS_XC_XC vss vss vs vss n_w7p07_l7p07
XXP2_XTI vss m1_6474_13030# vbn_leak vss n_w1_l4
XXL2_XD1 m1_690_15350# m1_1704_15350# m1_690_15350# vss n_w2_l2
XXL1_XP2 dl1 la1 vdd vdd vss p_w2_l4
XXA1_XA_XM2 a_5960_2880# a_6716_2880# a_6716_2880# vss n_w2_l2
XXL2_XD2 m1_1704_15350# a_1780_15680# a_1780_15680# vss n_w2_l2
XXS_XD_Xi4_XN a_3272_6334# vss spk vss n_w0p5_l0p28
XXS_XL_XP1 a_488_5520# a_488_5520# vdd vdd vss p_w2_l4
XXL1_XMT m1_1704_10270# vbn_leak vss vss n_w2_l4
XXP1_XOTA vss m1_6390_10270# vbn_leak vss n_w4_l2
XXL1_XM1 la1 m1_690_10190# el vss n_w2_l2
XXP1_XOTB m1_6390_10270# vss vbn_leak vss n_w4_l2
XXT1_XMB vss m1_8166_15130# vbn_prb vss n_w2_l2
XXS_XL_XP2 a_2536_2880# a_488_5520# vdd vdd vss p_w2_l4
XXY2_XQA vdd vss a_2180_13234# m1_2220_12980# vss p_w1_l0p28
XXC2_XC vss vss d2 vss n_w7p07_l7p07
XXS_XR_XCR_XC vss a_4374_1028# vss vss n_w3p54_l3p54
XXA2_XA_XP1 a_488_19200# a_488_19200# vdd vdd vss p_w2_l4
C0 sta a_5816_16974# 0.28356f
C1 mreset m1_1704_2770# 0
C2 a_3956_5520# d1 0.12475f
C3 sta m1_5100_10180# 0.23337f
C4 el m1_5122_15350# 0.20793f
C5 m1_910_6150# a_488_5520# 0.00603f
C6 abus a_2592_8154# 0.00121f
C7 a_672_19994# ta3 0
C8 a_2180_13234# d1_bsel 0.24168f
C9 vbn_ax a_6716_2880# 0.01166f
C10 m1_5122_15350# ta0 0.00626f
C11 a_6140_14314# m1_7390_15740# 0.26637f
C12 a_1780_18120# hold 0.09154f
C13 a_8248_5320# vbn_leak 0.12372f
C14 vbp_syn m1_2122_9086# 0.40271f
C15 hold m1_5122_15350# 0.01169f
C16 m1_690_2500# m1_1704_2770# 0
C17 a_4588_13668# m1_6474_13030# 0.18188f
C18 sel2 en 0
C19 a_1780_2880# vdd 0.18228f
C20 a_4096_6334# vbn_leak 0.07598f
C21 vbn_prb a_2592_8154# 0.01593f
C22 sel1 a_2180_13234# 0.03469f
C23 vbp_st a_2592_8154# 0.08236f
C24 vdd a_488_5520# 1.61602f
C25 a_3956_5520# a_4448_4080# 0.07348f
C26 m1_5100_10180# a_2920_12040# 0
C27 a_5816_11894# m1_7390_10270# 0.1147f
C28 a_4096_6334# a_4374_1028# 0.40545f
C29 la1 a_5816_11894# 0.05017f
C30 vdd a_4588_8588# 0.25335f
C31 vbp_syn a_2536_18120# 0.00108f
C32 a_1780_18120# a_488_19200# 0.00548f
C33 el vs 0.4067f
C34 m1_7390_15740# ta2 0.01268f
C35 a_1892_3934# a_4374_1028# 0.09669f
C36 hold vs 0.11282f
C37 m1_1704_15350# a_5204_15680# 0
C38 a_3272_6334# a_6716_2880# 0.15345f
C39 d2 pl_en 0.0291f
C40 stb a_2180_13234# 0.29186f
C41 vbn_ref vreset 4.00012f
C42 chain a_2592_8154# 0.01435f
C43 a_4588_13668# dl2 0.03944f
C44 m1_7128_14156# a_8436_16974# 0.12221f
C45 vbn_ax d1 0.02996f
C46 sta vbp_syn 0.21567f
C47 m1_6390_15350# pl_en 0.10244f
C48 m1_6726_11710# a_5816_16974# 0
C49 ta1 d2 0.15192f
C50 sel2 a_5816_11894# 0.006f
C51 a_268_18120# vbn_leak 0.57982f
C52 vbn_ax a_5204_18120# 0.00357f
C53 vbp_st a_5204_4080# 0
C54 a_6672_9234# m1_6390_10270# 0.0734f
C55 a_5816_16974# vreset 0
C56 m1_5626_2500# vsrc 0.84019f
C57 m1_6390_15350# ta1 0.04115f
C58 vdd vbn_ref 0.13492f
C59 la1 a_2180_13234# 0
C60 m1_2220_12980# vbp_syn 0.48488f
C61 hold a_2920_17120# 0.22417f
C62 mreset a_6716_2880# 0.20079f
C63 m1_2868_9480# m1_2122_9086# 0.3509f
C64 a_5204_18120# a_672_19994# 0
C65 a_268_18120# a_4374_1028# 0.07994f
C66 abus vsrc 0.41669f
C67 a_3212_19200# a_6716_18120# -0.02011f
C68 vbp_syn a_2920_12040# 0.15179f
C69 a_2724_4480# vbn_leak 0.45808f
C70 a_5204_18120# a_5204_15680# 0
C71 m1_8050_16790# a_6672_14314# 0
C72 m1_7128_13020# a_5816_16974# 0.03702f
C73 vdd a_5816_16974# 0.71647f
C74 chain a_5204_4080# 0.02971f
C75 d1 a_3272_6334# 0.01289f
C76 a_8436_16974# el 0.00155f
C77 a_268_18120# a_6672_14314# 0
C78 vdd m1_5100_10180# 0
C79 vbp_st vsrc 0.08443f
C80 spk vbn_ref 0.67575f
C81 vbn_prb vsrc 0.36636f
C82 a_2724_4480# a_4374_1028# 0.15841f
C83 a_8436_16974# ta0 0.02005f
C84 m1_2064_14170# m1_1704_15350# 0.00346f
C85 hold a_8436_16974# 0.1246f
C86 en a_2592_8154# 0.52919f
C87 la2 a_2592_8154# 0.31914f
C88 vbn_ax m1_1704_17750# 0.25729f
C89 sta m1_2868_9480# 0.22391f
C90 m1_7138_8930# ta0 0.00975f
C91 a_2724_4480# a_6672_14314# 0.00911f
C92 hold m1_7138_8930# 0.00221f
C93 mreset d1 0.38892f
C94 a_2536_2880# vs 0.02034f
C95 a_672_19994# m1_1704_17750# 0
C96 a_5960_4080# ta1 0
C97 chain vsrc 0.08648f
C98 ta2 a_4588_8588# 0.02888f
C99 a_728_3738# a_488_5520# 0.4853f
C100 sta pl_en 0.02598f
C101 sel0 vsrc 0.06619f
C102 chain tb0 0
C103 m1_2702_380# vs 0.01402f
C104 en a_5204_4080# 0.02499f
C105 a_5816_11894# a_2592_8154# 0.12163f
C106 sta ta1 0
C107 vbn_leak a_5268_9138# 0.22258f
C108 vbn_ax vsrcp 0.05471f
C109 a_5204_2880# m1_4870_3750# 0.0018f
C110 vbn_prb m1_5626_2500# 0.21951f
C111 ta3 m1_6390_10270# 0.01698f
C112 vdd vbp_syn 2.56852f
C113 mreset a_4448_4080# 0.0036f
C114 abus vbn_prb 2.40966f
C115 m1_1704_2770# vs 0.30614f
C116 a_6140_9234# a_4588_8588# 0.00218f
C117 abus vbp_st 0.09008f
C118 ta3 a_6716_18120# 0.00127f
C119 a_6140_14314# a_5816_16974# 0.19057f
C120 m1_690_17890# hold 0
C121 m1_5626_17750# dl2 0
C122 m1_2678_7950# d1 0.03851f
C123 a_5204_2880# el 0.36272f
C124 vsrcp a_5204_15680# 0
C125 a_3212_19200# a_2920_17120# 0.00154f
C126 en vsrc 0.53412f
C127 m1_7694_12850# el 0.10332f
C128 vbn_prb vbp_st 0.08028f
C129 chain m1_5626_2500# 0.01841f
C130 m1_2122_6150# a_3272_6334# 0
C131 sel1 vbn_leak 0.01537f
C132 abus chain 0
C133 m1_5122_15350# ta3 0.00402f
C134 a_2180_13234# a_2592_8154# 0.11152f
C135 sel0 m1_5626_2500# 0.03183f
C136 vsrcp a_3272_6334# 0
C137 m1_690_17890# a_488_19200# 0.05819f
C138 m1_8050_16790# m1_7390_15740# 0
C139 ta2 a_5816_16974# 0.01404f
C140 sel0 abus 4.02727f
C141 m1_5100_10180# ta2 0.01444f
C142 m1_7128_14156# d2 0.00423f
C143 m1_7390_15740# a_268_18120# 0.00193f
C144 chain vbn_prb 0.27507f
C145 a_5204_10600# d1 0.11694f
C146 m1_7128_14156# m1_6390_15350# 0.0021f
C147 m1_6726_11710# ta1 0
C148 chain vbp_st 0.4981f
C149 d1 m1_6390_10270# 0.01575f
C150 m1_1704_15350# m1_5122_15350# -0
C151 m1_2868_9480# vdd 0.20622f
C152 m1_7138_8930# a_6672_9234# 0.01981f
C153 sel1 a_6672_14314# 0.24804f
C154 sel0 vbp_st 0.02246f
C155 sel0 vbn_prb 0.77988f
C156 mreset vsrcp 0.02822f
C157 a_5816_11894# vsrc 0
C158 m1_7390_15740# a_2724_4480# 0.04945f
C159 a_5816_16974# a_6140_9234# 0
C160 a_6140_14314# vbp_syn 0
C161 a_5960_18120# a_5204_18120# 0.00278f
C162 en m1_5626_2500# 0.04269f
C163 m1_5100_10180# a_6140_9234# 0
C164 a_1480_3834# vsrc 0.1337f
C165 a_5204_18120# a_6716_18120# 0.00315f
C166 abus en 0.00802f
C167 vbn_leak m1_7390_10270# 0.23084f
C168 la1 vbn_leak 0.07472f
C169 m1_7128_13020# pl_en 0.04323f
C170 vdd pl_en 0.08409f
C171 vs a_6716_2880# 0.26432f
C172 d2 el 0.53688f
C173 a_1892_3934# a_1780_2880# 0.00186f
C174 m1_7128_13020# ta1 0.02933f
C175 vdd ta1 0.05455f
C176 a_268_18120# a_1780_15680# 0.00167f
C177 d2 ta0 0.07418f
C178 m1_5122_15350# d1 0
C179 sel0 chain 0.33821f
C180 a_1892_3934# a_488_5520# 0.02284f
C181 m1_2678_7950# dl1 0.00133f
C182 hold d2 0.3785f
C183 m1_6390_15350# el 0.04157f
C184 a_1892_3934# a_4588_8588# 0
C185 vbn_prb en 0.02739f
C186 m1_6390_15350# ta0 0.07803f
C187 en vbp_st 0.07262f
C188 m1_6390_15350# hold 0.07151f
C189 vbn_ax dl2 0.02956f
C190 vbn_prb la2 0.04468f
C191 sel2 vbn_leak 0.02559f
C192 la1 a_6672_14314# 0
C193 vbp_st la2 0.25998f
C194 m1_2702_380# m1_1946_330# 0.22418f
C195 chain m1_6474_8020# 0.00411f
C196 a_4588_13668# vbn_ax 0.00269f
C197 ta1 a_5524_5520# 0.00214f
C198 m1_1704_10270# vbn_leak 0.08674f
C199 m1_1704_15350# a_2920_17120# 0.07072f
C200 a_8248_5320# vbn_ref 0.08923f
C201 abus a_5816_11894# 0.01275f
C202 a_2180_13234# m1_2678_13030# 0.00554f
C203 m1_1704_2770# m1_1946_330# 0
C204 a_1780_2880# a_268_18120# 0.05875f
C205 a_8436_16974# ta3 0.28188f
C206 d1 vs 0.1728f
C207 chain en 0.76002f
C208 a_5204_15680# dl2 0.00178f
C209 a_268_18120# a_488_5520# 0
C210 a_5204_10600# dl1 0.3257f
C211 vbn_ref a_4096_6334# 0.15141f
C212 a_5960_4080# m1_4870_3750# 0.03906f
C213 chain la2 0.0273f
C214 a_5204_2880# m1_1704_2770# 0
C215 hold m1_2122_9086# 0.03846f
C216 dl1 m1_6390_10270# 0.1827f
C217 a_4588_13668# a_5204_15680# 0.11186f
C218 sel0 en 0.0038f
C219 pl_en m1_8050_11710# 0
C220 a_1892_3934# vbn_ref 0.20221f
C221 m1_7138_8930# ta3 0.0094f
C222 a_5204_10600# vsrcp 0
C223 vbn_prb a_5816_11894# 0.04599f
C224 vbp_st a_5816_11894# 0.01057f
C225 a_6140_14314# pl_en 0.18481f
C226 a_1780_18120# m1_1704_17750# 0.24334f
C227 vsrcp m1_6390_10270# 0.15476f
C228 a_1480_3834# vbp_st 0.00829f
C229 a_5960_4080# el 0.01649f
C230 a_4448_4080# vs 0
C231 a_2724_4480# a_4588_8588# 0.08099f
C232 a_6140_14314# ta1 0.00161f
C233 hold a_2536_18120# 0.3661f
C234 a_3272_6334# a_5960_2880# 0.53883f
C235 sel1 m1_7390_15740# 0.51079f
C236 a_5960_4080# ta0 0
C237 hold a_5960_4080# 0.08125f
C238 a_5204_18120# a_2920_17120# 0
C239 sta el 0.07644f
C240 chain a_5816_11894# 0.01969f
C241 ta2 pl_en 0.03112f
C242 sta ta0 0
C243 a_268_18120# vbn_ref 0.02387f
C244 sta hold 1.44147f
C245 a_1480_3834# chain 0.12948f
C246 en la2 0.01787f
C247 m1_2064_14170# dl2 0.00117f
C248 vbp_st a_2180_13234# 0
C249 vsrcp m1_5122_15350# 0.04192f
C250 ta1 ta2 2.79837f
C251 a_8436_16974# m1_8166_15130# 0
C252 a_2536_18120# a_488_19200# 0.05431f
C253 m1_2220_12980# el 0.11872f
C254 a_2592_8154# vbn_leak 0.41305f
C255 a_3212_19200# d2 0.11703f
C256 m1_2220_12980# hold 0.03497f
C257 a_268_18120# a_5816_16974# 0.4103f
C258 a_2724_4480# vbn_ref 0.02491f
C259 a_5816_11894# m1_6474_8020# 0
C260 a_2920_12040# el 0.43553f
C261 m1_7694_12850# ta3 0.00925f
C262 m1_7138_8930# d1 0.09033f
C263 pl_en a_6140_9234# 0.13127f
C264 hold a_2920_12040# 0.0247f
C265 a_2920_17120# m1_1704_17750# 0.00228f
C266 m1_8166_10050# ta1 0
C267 chain a_2180_13234# 0.04346f
C268 ta1 a_6140_9234# 0.00821f
C269 a_5268_9138# a_4588_8588# 0.25773f
C270 en a_5816_11894# 0.17377f
C271 a_2724_4480# a_5816_16974# 0.44669f
C272 a_6672_14314# a_2592_8154# 0.09252f
C273 vsrcp vs 0.00301f
C274 m1_5626_17750# vbn_ax 0.53705f
C275 m1_5100_10180# a_2724_4480# 0.26268f
C276 m1_6726_11710# ta0 0.00534f
C277 la2 m1_690_15350# -0.00486f
C278 m1_6726_11710# hold 0.05934f
C279 el vreset 0.028f
C280 m1_7684_8010# m1_6390_10270# 0.07233f
C281 vbp_syn a_268_18120# 0.07034f
C282 m1_6474_13030# m1_5122_15350# 0.08901f
C283 a_5204_2880# d1 0.14512f
C284 a_4588_13668# a_5204_10600# 0
C285 en a_2180_13234# 0.05466f
C286 vsrc vbn_leak 4.10014f
C287 la2 a_2180_13234# 0.50684f
C288 a_5524_5520# m1_4870_3750# 0.21523f
C289 m1_7128_13020# el 0.07487f
C290 vdd el 1.82816f
C291 d2 ta3 0.08103f
C292 spk m1_4870_3750# 0.00649f
C293 m1_7128_13020# ta0 0.01779f
C294 vsrc a_4374_1028# 0.13681f
C295 sta a_6672_9234# 0.00621f
C296 m1_7128_13020# hold 0
C297 vdd ta0 0.05348f
C298 a_5816_16974# a_5268_9138# 0
C299 a_8436_16974# vsrcp 0.14173f
C300 vbp_syn a_2724_4480# 0.31668f
C301 m1_6390_15350# ta3 0.01226f
C302 vdd hold 4.60776f
C303 sta a_3212_19200# 0
C304 vbn_leak m1_2678_13030# 0.00293f
C305 m1_5100_10180# a_5268_9138# 0.03742f
C306 m1_7138_8930# dl1 0.00117f
C307 el a_5524_5520# 0.00802f
C308 spk el 0.17815f
C309 a_6140_14314# m1_7128_14156# 0.08831f
C310 sel1 vbn_ref 0
C311 m1_1704_15350# d2 0.14984f
C312 m1_5122_15350# dl2 0.04218f
C313 a_6672_14314# vsrc 0
C314 a_5524_5520# ta0 0.00236f
C315 vsrcp m1_7138_8930# 0.17405f
C316 hold spk 0
C317 hold a_5524_5520# 0.22028f
C318 m1_690_17890# m1_1704_17750# 0.00182f
C319 a_3956_5520# a_3272_6334# 0.04785f
C320 ta2 m1_7138_8020# 0.04182f
C321 la1 a_4588_8588# 0.00555f
C322 a_4588_13668# m1_5122_15350# 0.71133f
C323 vdd a_488_19200# 1.47445f
C324 m1_5626_2500# vbn_leak 0.07716f
C325 a_2180_13234# m1_690_15350# 0
C326 sel1 a_5816_16974# 0.34078f
C327 abus vbn_leak 0.60356f
C328 m1_7390_15740# a_2592_8154# 0.15927f
C329 m1_7128_14156# ta2 0.02343f
C330 vbn_ax a_672_19994# 0.0083f
C331 mreset a_3956_5520# 0.02731f
C332 d2 d1 0.04685f
C333 abus a_4374_1028# 0.20525f
C334 d2 m1_8166_15130# 0
C335 a_268_18120# pl_en 0.02651f
C336 a_6140_14314# el 0
C337 vbp_syn a_5268_9138# 0
C338 a_5960_4080# ta3 0
C339 vbn_ax a_5204_15680# 0.04229f
C340 a_5204_18120# d2 -0.01946f
C341 m1_6390_15350# m1_8166_15130# 0
C342 vbn_ref m1_7390_10270# 0
C343 vbn_prb vbn_leak 0.57832f
C344 vbp_st vbn_leak 0.26281f
C345 a_6140_14314# ta0 0.00153f
C346 vs a_5960_2880# 0
C347 a_6140_14314# hold 0.00438f
C348 a_268_18120# ta1 0.02468f
C349 a_5960_4080# a_6716_2880# 0.28535f
C350 vbn_prb a_4374_1028# 0.33818f
C351 vbp_st a_4374_1028# 0
C352 vbp_syn d1_bsel 0.03632f
C353 sta ta3 0
C354 vbn_ax a_3272_6334# 0.10039f
C355 vdd a_2536_2880# 0.66717f
C356 a_2724_4480# pl_en 0.50085f
C357 a_2920_17120# dl2 0.01401f
C358 la1 a_5816_16974# 0
C359 a_2724_4480# ta1 0.0364f
C360 ta2 el 0.0305f
C361 vdd a_6672_9234# 0.34327f
C362 chain vbn_leak 0.16954f
C363 vbn_prb a_6672_14314# 0.07515f
C364 m1_2702_380# vdd 0.02699f
C365 el a_728_3738# 0.07846f
C366 m1_2122_9086# d1 0
C367 sel2 vbn_ref 0.02513f
C368 hold ta2 0.00256f
C369 vbp_st a_6672_14314# 0.03059f
C370 vdd a_3212_19200# 1.10934f
C371 a_2536_2880# a_5524_5520# 0
C372 spk a_2536_2880# 0.14984f
C373 a_5960_18120# m1_5626_17750# 0.09153f
C374 sel0 vbn_leak 0.05341f
C375 mreset vbn_ax 0.07656f
C376 chain a_4374_1028# 0
C377 a_8436_16974# dl2 0.45608f
C378 d2 m1_1704_17750# 0.28411f
C379 m1_1704_2770# vdd 0.11956f
C380 m1_6726_16790# vbn_ax 0.00343f
C381 m1_5626_17750# a_6716_18120# 0.09007f
C382 sel0 a_4374_1028# 0.40887f
C383 m1_8166_10050# el 0
C384 m1_8166_10050# ta0 0
C385 el a_6140_9234# 0.24464f
C386 a_4588_13668# a_8436_16974# 0.06832f
C387 m1_7390_15740# vsrc 0
C388 stb vbp_syn 0.06281f
C389 m1_8166_10050# hold 0
C390 ta0 a_6140_9234# 0.00591f
C391 a_5960_4080# d1 0.46708f
C392 m1_6474_8020# vbn_leak -0.02823f
C393 m1_2220_12980# m1_1704_15350# 0.00239f
C394 hold a_6140_9234# 0.1776f
C395 chain a_6672_14314# 0.00947f
C396 m1_1704_10270# m1_5100_10180# 0
C397 a_2592_8154# a_4588_8588# 0.04014f
C398 sta d1 0.28446f
C399 pl_en a_5268_9138# 0.08563f
C400 en vbn_leak 0.96286f
C401 la1 vbp_syn 0.05003f
C402 vsrcp d2 0.09224f
C403 mreset a_3272_6334# 0
C404 la2 vbn_leak 0.30793f
C405 ta1 a_5268_9138# 0.37427f
C406 en a_4374_1028# 0.12386f
C407 m1_6390_15350# vsrcp 0.26242f
C408 pl_en d1_bsel 0.0096f
C409 m1_690_2500# a_3272_6334# 0
C410 a_6716_2880# vreset 0
C411 a_2920_12040# d1 0.44358f
C412 en a_6672_14314# 0.1293f
C413 a_2536_18120# m1_1704_17750# 0.14978f
C414 sel1 pl_en 0.00118f
C415 m1_2122_9086# dl1 0
C416 m1_7128_13020# ta3 0.03422f
C417 abus m1_7390_15740# 0.11246f
C418 vdd ta3 0.16047f
C419 la2 a_6672_14314# 0.18205f
C420 a_2536_2880# a_728_3738# 0.00808f
C421 a_5816_11894# vbn_leak 0.28501f
C422 sel1 ta1 0.01208f
C423 vdd a_6716_2880# 0.09155f
C424 m1_1704_10270# vbp_syn 0.01423f
C425 a_1892_3934# m1_4870_3750# 0.07074f
C426 ta2 a_6672_9234# 0.00676f
C427 a_5960_18120# vbn_ax 0.00254f
C428 a_8248_5320# el 0.05218f
C429 a_4588_13668# m1_7694_12850# 0.05122f
C430 vbn_prb m1_7390_15740# 0.01375f
C431 a_2592_8154# a_5816_16974# 0.08151f
C432 vbp_st m1_7390_15740# 0.00609f
C433 stb pl_en 0.026f
C434 a_1780_2880# vsrc 0.0049f
C435 a_5204_2880# a_5960_2880# 0.00391f
C436 hold a_8248_5320# 0.00746f
C437 m1_6726_11710# d1 0.08378f
C438 vdd m1_1704_15350# 0.16319f
C439 vbn_ax a_6716_18120# 0.07645f
C440 m1_5100_10180# a_2592_8154# 0.07964f
C441 a_5960_18120# a_672_19994# 0
C442 a_4096_6334# el 0.13466f
C443 vsrc a_488_5520# 0.08198f
C444 a_1480_3834# a_4374_1028# 0
C445 a_2724_4480# m1_7138_8020# 0.07755f
C446 a_3956_5520# vs 0.41901f
C447 hold a_4096_6334# 0
C448 stb ta1 0.00594f
C449 a_1892_3934# el 0.2434f
C450 spk a_6716_2880# 0.14015f
C451 a_5524_5520# a_6716_2880# 0.07596f
C452 a_672_19994# a_6716_18120# 0.15357f
C453 d1 vreset 0.04436f
C454 m1_910_6150# d1 0
C455 tb1 tb2 0.16769f
C456 m1_8166_10050# a_6672_9234# 0.12398f
C457 a_6140_9234# a_6672_9234# 0.08273f
C458 a_1892_3934# hold 0.10087f
C459 sta dl1 0.05346f
C460 la1 pl_en 0.09622f
C461 a_268_18120# m1_4870_3750# 0.52434f
C462 a_2180_13234# vbn_leak 0.00648f
C463 m1_7128_14156# a_2724_4480# 0.01642f
C464 sta vsrcp 0.1633f
C465 ta1 m1_7390_10270# 0.00483f
C466 m1_7128_13020# d1 0
C467 vdd d1 2.85485f
C468 la1 ta1 0.05099f
C469 vdd m1_8166_15130# 0
C470 a_1780_18120# a_672_19994# 0
C471 ta3 m1_8050_11710# 0.00234f
C472 a_6140_14314# ta3 0.02798f
C473 vdd a_5204_18120# 0.048f
C474 a_2920_12040# dl1 0.0532f
C475 m1_1704_10270# m1_2868_9480# 0
C476 vbn_ref vsrc 0.10461f
C477 a_268_18120# el 0.80109f
C478 m1_5122_15350# a_5204_15680# 0.14024f
C479 d2 dl2 0.29883f
C480 a_268_18120# ta0 0.02838f
C481 vbp_syn a_2592_8154# 0.13021f
C482 hold a_268_18120# 0.60289f
C483 spk d1 0.14517f
C484 d1 a_5524_5520# 0.28512f
C485 m1_6390_15350# dl2 0.32667f
C486 vbn_ax vs 0.00184f
C487 a_4588_13668# d2 0.21802f
C488 vdd a_4448_4080# 0.00488f
C489 a_2724_4480# el 0.50497f
C490 a_4588_13668# m1_6390_15350# 0.00999f
C491 en m1_7390_15740# 0.06043f
C492 a_5816_16974# vsrc 0.00104f
C493 ta2 ta3 2.79837f
C494 a_2724_4480# ta0 0.04898f
C495 m1_6726_16790# a_6716_18120# 0
C496 hold a_2724_4480# 0.30605f
C497 m1_7390_15740# la2 0.01708f
C498 vbp_st a_488_5520# 0.06792f
C499 a_268_18120# a_488_19200# 0.25242f
C500 a_5524_5520# a_4448_4080# 0.42739f
C501 spk a_4448_4080# 0.06786f
C502 a_4096_6334# a_2536_2880# 0.00276f
C503 vbp_st a_4588_8588# 0.00155f
C504 vbn_ax a_2920_17120# 0.19651f
C505 vdd m1_1704_17750# 0.06822f
C506 a_1892_3934# a_2536_2880# 0.11299f
C507 m1_8166_10050# ta3 0.00115f
C508 d1 m1_8050_11710# 0
C509 ta3 a_6140_9234# 0.01604f
C510 m1_5626_2500# vbn_ref 0.05553f
C511 a_672_19994# a_2920_17120# 0
C512 vs a_3272_6334# 0.24558f
C513 m1_6474_13030# sta 0.01137f
C514 vsrcp vreset 0.02919f
C515 chain a_1780_2880# 0
C516 a_6140_14314# m1_8166_15130# 0.02841f
C517 abus vbn_ref 0.40093f
C518 chain a_488_5520# 0.02028f
C519 a_2920_17120# a_5204_15680# -0.0306f
C520 vdd m1_2122_6150# 0.05432f
C521 vdd dl1 0.43031f
C522 m1_2868_9480# a_2592_8154# 0.13345f
C523 chain a_4588_8588# 0.05184f
C524 a_2536_18120# dl2 0
C525 vbn_ax a_8436_16974# 0.00119f
C526 m1_1704_2770# a_4096_6334# 0.00443f
C527 m1_7128_14156# sel1 0.00483f
C528 la2 a_1780_15680# 0.00306f
C529 vdd vsrcp 0.1589f
C530 abus a_5816_16974# 0.07049f
C531 vbn_prb vbn_ref 0.37302f
C532 vbp_st vbn_ref 0.02742f
C533 el a_5268_9138# 0
C534 a_1892_3934# m1_1704_2770# 0.00128f
C535 mreset vs 0.06405f
C536 ta2 d1 0.13432f
C537 ta0 a_5268_9138# 0.22043f
C538 a_268_18120# a_2536_2880# 0.31434f
C539 hold a_5268_9138# 0.12294f
C540 a_2592_8154# pl_en 0.06871f
C541 a_5960_4080# a_5960_2880# 0.00358f
C542 a_728_3738# d1 0.00256f
C543 sta dl2 0.00899f
C544 a_5204_2880# a_3956_5520# 0.00382f
C545 a_5204_10600# m1_6390_10270# 0
C546 a_8436_16974# a_5204_15680# 0.03336f
C547 ta1 a_2592_8154# 0.05127f
C548 m1_6474_8020# a_4588_8588# 0.04553f
C549 vbp_syn m1_2678_13030# 0.56682f
C550 m1_690_2500# vs 0.17465f
C551 la1 m1_7138_8020# 0.00425f
C552 a_268_18120# a_6672_9234# 0
C553 a_4588_13668# sta 0.06936f
C554 vbn_prb a_5816_16974# 0.03271f
C555 vbp_st a_5816_16974# 0.05983f
C556 spk vsrcp 0.0515f
C557 hold d1_bsel 0.07351f
C558 a_2724_4480# a_2536_2880# 0.24242f
C559 a_268_18120# a_3212_19200# 0.01196f
C560 m1_8166_10050# d1 0.00273f
C561 m1_2220_12980# dl2 0.00434f
C562 a_5960_18120# a_6716_18120# 0.05832f
C563 chain vbn_ref 0.06326f
C564 d1 a_6140_9234# 0.1988f
C565 en a_4588_8588# 0.14033f
C566 sel1 el 0
C567 sel1 ta0 0.03057f
C568 sel0 vbn_ref 0.61191f
C569 m1_1704_2770# a_268_18120# 0.13083f
C570 a_2724_4480# a_6672_9234# 0.01375f
C571 m1_5626_17750# d2 0
C572 sel1 hold 0.02729f
C573 a_1780_15680# m1_690_15350# 0.00811f
C574 a_4588_13668# a_2920_12040# 0.00261f
C575 chain a_5816_16974# 0.04986f
C576 el a_1780_10600# 0.00203f
C577 chain m1_5100_10180# 0.03758f
C578 a_488_19200# d1_bsel 0.13847f
C579 m1_690_10190# el 0.1098f
C580 hold a_1780_10600# 0.01615f
C581 stb ta0 0.0131f
C582 vbn_leak a_4374_1028# 0.04033f
C583 a_6140_14314# vsrcp 0.69391f
C584 m1_6726_16790# a_8436_16974# 0
C585 stb hold 0.6377f
C586 a_4096_6334# a_6716_2880# 0
C587 a_2180_13234# a_1780_15680# 0.13909f
C588 en vbn_ref 0.00202f
C589 a_1892_3934# a_6716_2880# 0.23584f
C590 vbp_st vbp_syn 0
C591 a_5816_11894# a_4588_8588# 0.65024f
C592 m1_5100_10180# m1_6474_8020# 0.02082f
C593 a_6672_14314# vbn_leak 0.00356f
C594 a_1480_3834# a_488_5520# 0.37245f
C595 ta2 dl1 0.00602f
C596 el m1_7390_10270# 0.00106f
C597 la1 el 1.26385f
C598 m1_7390_10270# ta0 -0
C599 la1 ta0 0.06131f
C600 m1_2122_6150# a_728_3738# 0.02351f
C601 hold m1_7390_10270# -0
C602 pl_en tb0 0
C603 la1 hold 0.0429f
C604 vsrcp ta2 0.05543f
C605 en a_5816_16974# 0.09615f
C606 m1_8050_16790# ta3 0.00234f
C607 stb a_488_19200# 0.59632f
C608 en m1_5100_10180# 0.03068f
C609 a_6672_9234# a_5268_9138# 0.05208f
C610 a_268_18120# ta3 0.03133f
C611 la2 a_5816_16974# 0
C612 ta1 tb0 0
C613 a_5204_2880# a_3272_6334# 0.01416f
C614 a_8248_5320# d1 0.27794f
C615 chain vbp_syn 0
C616 vdd dl2 0.35081f
C617 dl1 a_6140_9234# 0.03575f
C618 m1_8166_10050# dl1 0.00381f
C619 a_268_18120# a_6716_2880# 0.08892f
C620 sel2 el 0.02667f
C621 a_4588_13668# m1_7128_13020# 0.17842f
C622 a_4588_13668# vdd 0.1735f
C623 a_4096_6334# d1 0.20227f
C624 a_5816_11894# vbn_ref 0
C625 m1_8166_10050# vsrcp 0
C626 a_2724_4480# ta3 0.04567f
C627 vsrcp a_6140_9234# 0.12566f
C628 a_3212_19200# d1_bsel 0.846f
C629 a_1892_3934# d1 0.20908f
C630 a_268_18120# m1_1704_15350# 0.00119f
C631 m1_1704_10270# el 0.08127f
C632 sta m1_5626_17750# 0.05343f
C633 m1_1704_10270# hold 0.00333f
C634 vbn_ax d2 0.58246f
C635 sel1 a_3212_19200# 0
C636 m1_5100_10180# a_5816_11894# 0.05198f
C637 spk a_5960_2880# 0.10025f
C638 a_672_19994# d2 0.10407f
C639 a_4096_6334# a_4448_4080# 0.08323f
C640 a_2724_4480# m1_1704_15350# 0
C641 en vbp_syn 0.26019f
C642 a_2920_17120# m1_5122_15350# 0
C643 a_1892_3934# a_4448_4080# 0.16578f
C644 m1_7128_14156# a_2592_8154# 0.00824f
C645 vbp_st pl_en 0.00125f
C646 d2 a_5204_15680# 0.3262f
C647 vbp_syn la2 0.04469f
C648 a_268_18120# d1 1.9769f
C649 m1_7138_8930# m1_6390_10270# 0.03195f
C650 a_268_18120# m1_8166_15130# 0
C651 stb a_3212_19200# 0.28517f
C652 vbn_prb ta1 0
C653 m1_6390_15350# a_5204_15680# 0
C654 vbp_st ta1 0.01398f
C655 a_268_18120# a_5204_18120# 0.24598f
C656 a_6140_14314# dl2 0.20356f
C657 a_8436_16974# m1_5122_15350# 0.18884f
C658 a_2180_13234# a_5816_16974# 0
C659 m1_7390_10270# a_6672_9234# 0.12512f
C660 a_2724_4480# d1 0.65828f
C661 ta3 a_5268_9138# 0.0721f
C662 a_4588_13668# a_6140_14314# 0.05376f
C663 m1_7390_15740# vbn_leak 0
C664 chain pl_en 2.41258f
C665 la1 a_6672_9234# 0.02493f
C666 a_2724_4480# m1_8166_15130# 0.00184f
C667 a_8248_5320# dl1 0
C668 a_268_18120# a_4448_4080# 0.00941f
C669 m1_7684_8010# ta2 0
C670 vbp_syn a_5816_11894# 0.00246f
C671 a_2592_8154# el 0.07379f
C672 a_2592_8154# ta0 0.09883f
C673 a_8248_5320# vsrcp 0
C674 vbn_ax a_2536_18120# 0.00523f
C675 hold a_2592_8154# 1.19351f
C676 ta2 dl2 0.00575f
C677 vbn_ax a_5960_4080# 0.03719f
C678 m1_6726_16790# d2 0.13702f
C679 a_2536_18120# a_672_19994# 0.03861f
C680 a_4588_13668# ta2 0.02772f
C681 m1_7390_15740# a_6672_14314# 0.18303f
C682 a_5204_4080# m1_4870_3750# 0.17193f
C683 sel2 a_6672_9234# 0
C684 m1_2064_14170# d2 0.00145f
C685 sel1 ta3 0.00917f
C686 a_268_18120# m1_1704_17750# 0.06099f
C687 sta vbn_ax 0.05063f
C688 vdd m1_5626_17750# 0.06374f
C689 en pl_en 2.3014f
C690 sta a_672_19994# 0.05041f
C691 a_488_19200# a_2592_8154# 0.45942f
C692 a_1780_18120# m1_690_17890# 0.01543f
C693 la2 pl_en 0.00391f
C694 a_5204_4080# el 0
C695 vbp_syn a_2180_13234# 0.17758f
C696 stb ta3 0.0018f
C697 a_268_18120# dl1 0.00247f
C698 d1 a_5268_9138# 0.49567f
C699 a_4588_13668# a_6140_9234# 0
C700 hold a_5204_4080# 0
C701 a_5960_4080# a_3272_6334# 0
C702 sta a_5204_15680# 0
C703 en ta1 0.01077f
C704 la2 ta1 0.0047f
C705 a_268_18120# vsrcp 0.06578f
C706 tb1 tb0 0.16769f
C707 m1_7694_12850# m1_5122_15350# 0.02882f
C708 a_2724_4480# dl1 0.13524f
C709 a_3956_5520# vdd 1.34155f
C710 la1 ta3 0.15573f
C711 ta3 m1_7390_10270# 0.0238f
C712 a_5204_18120# d1_bsel 0
C713 el vsrc 0.28979f
C714 mreset a_5960_4080# 0.14327f
C715 a_5816_11894# pl_en 0.26147f
C716 vbn_leak a_4588_8588# 0.84333f
C717 a_2724_4480# vsrcp 0.65495f
C718 a_1780_2880# a_4374_1028# 0
C719 m1_1946_330# vs 0.0928f
C720 sel1 m1_8166_15130# 0.16443f
C721 a_2592_8154# a_2536_2880# 0
C722 a_3956_5520# a_5524_5520# 0.04624f
C723 a_3956_5520# spk 0.50072f
C724 m1_2678_7950# m1_2122_9086# 0.14869f
C725 a_5816_11894# ta1 0.01182f
C726 el m1_2678_13030# 0.30062f
C727 tb0 ta0 0
C728 a_5960_18120# d2 0
C729 hold tb0 0
C730 hold m1_2678_13030# 0.03415f
C731 vbn_ax vreset 0.03336f
C732 a_1780_10600# d1 0.00114f
C733 a_2592_8154# a_6672_9234# 0.61099f
C734 m1_6726_16790# sta 0.00538f
C735 m1_5626_2500# m1_4870_3750# 0.00113f
C736 m1_690_10190# d1 0.25735f
C737 d2 a_6716_18120# 0.00122f
C738 a_3212_19200# a_2592_8154# 0.22668f
C739 chain m1_7138_8020# 0
C740 stb a_5204_18120# 0.09202f
C741 vbn_ref vbn_leak 0.30064f
C742 vdd vbn_ax 0.91789f
C743 a_2180_13234# pl_en 0.05712f
C744 m1_5626_2500# el 0.18483f
C745 dl1 a_5268_9138# 0.03472f
C746 m1_2220_12980# m1_2064_14170# 0.36718f
C747 a_1780_18120# d2 -0
C748 m1_5626_17750# ta2 0.005f
C749 m1_7390_10270# d1 0.51014f
C750 abus el 0.0972f
C751 d2 m1_5122_15350# 0.13407f
C752 ta1 a_2180_13234# 0
C753 vbn_ref a_4374_1028# 0.08831f
C754 la1 d1 0.86528f
C755 vdd a_672_19994# 1.59137f
C756 sta m1_2678_7950# 0.15645f
C757 a_3272_6334# vreset 0.00134f
C758 vsrcp a_5268_9138# 0.65418f
C759 m1_6390_15350# m1_5122_15350# 0
C760 a_5816_16974# vbn_leak 0.15716f
C761 vbn_ax spk 0.05232f
C762 vbn_ax a_5524_5520# 0.00493f
C763 m1_6474_8020# m1_7138_8020# 0.0015f
C764 m1_5100_10180# vbn_leak 0.31603f
C765 vdd a_5204_15680# 0.18834f
C766 m1_6474_13030# a_2724_4480# 0.00798f
C767 vbn_prb el 0.08163f
C768 vbp_st el 0.25577f
C769 a_6672_14314# vbn_ref 0
C770 a_268_18120# m1_7684_8010# 0
C771 vbn_prb ta0 0
C772 chain m1_4870_3750# 0.14154f
C773 vbp_st ta0 0.01158f
C774 a_2536_2880# vsrc 0
C775 vdd a_3272_6334# 1.02428f
C776 sel2 d1 0.02668f
C777 vbp_st hold 0.62033f
C778 en m1_7138_8020# 0
C779 stb m1_1704_17750# 0.10788f
C780 a_268_18120# dl2 0.196f
C781 mreset vreset 0.03098f
C782 sel0 m1_4870_3750# 0.00404f
C783 a_6672_14314# a_5816_16974# 0.09674f
C784 a_5204_10600# sta 0.04372f
C785 m1_1704_10270# d1 0.09188f
C786 vsrc a_6672_9234# 0
C787 sel1 vsrcp 0.0241f
C788 m1_2702_380# vsrc 0.00612f
C789 m1_7684_8010# a_2724_4480# 0.10235f
C790 dl1 a_1780_10600# -0.02294f
C791 chain el 0.41101f
C792 sta m1_6390_10270# 0.05159f
C793 sta a_5960_18120# 0.00708f
C794 a_2592_8154# ta3 0.46662f
C795 chain ta0 0
C796 spk a_3272_6334# 0.39228f
C797 a_2724_4480# dl2 0.1738f
C798 a_6140_14314# vbn_ax 0.0014f
C799 mreset vdd 1.44366f
C800 chain hold 0.41691f
C801 sta a_6716_18120# 0.02525f
C802 m1_1704_2770# vsrc 0.12218f
C803 sel0 el 0.02682f
C804 d2 a_2920_17120# 0.18874f
C805 a_1780_18120# a_2536_18120# -0.02834f
C806 m1_6726_16790# vdd 0.08679f
C807 a_4588_13668# a_2724_4480# 0.21343f
C808 vbp_syn vbn_leak 0.23125f
C809 a_5204_10600# a_2920_12040# 0.01281f
C810 vdd m1_2064_14170# 0.3136f
C811 en m1_4870_3750# 0.04113f
C812 a_5816_11894# m1_7138_8020# 0.13631f
C813 dl1 m1_7390_10270# 0.10962f
C814 la1 dl1 0.60269f
C815 mreset a_5524_5520# 0.06223f
C816 mreset spk 4.00455f
C817 hold m1_6474_8020# 0.00383f
C818 sta m1_5122_15350# 0.00608f
C819 a_8436_16974# d2 0.59777f
C820 vbn_ax ta2 0.0334f
C821 vsrcp m1_7390_10270# 0.01645f
C822 la1 vsrcp 0.01709f
C823 en el 0.12751f
C824 vdd m1_2678_7950# 0.51966f
C825 abus a_6672_9234# 0.00232f
C826 m1_6390_15350# a_8436_16974# 0.04408f
C827 en ta0 0.00841f
C828 a_672_19994# ta2 0.00113f
C829 abus m1_2702_380# 0.04069f
C830 la2 el 0.15105f
C831 en hold 0.1995f
C832 a_5204_4080# a_6716_2880# 0.11838f
C833 la2 ta0 0.00516f
C834 vbp_st a_2536_2880# 0.16395f
C835 m1_6726_11710# m1_6390_10270# 0
C836 a_2592_8154# d1 0.25232f
C837 hold la2 0.55897f
C838 a_2592_8154# m1_8166_15130# 0.01139f
C839 a_5204_18120# a_2592_8154# 0
C840 vbn_prb a_6672_9234# 0.09436f
C841 sel2 vsrcp 0.02514f
C842 m1_1704_10270# dl1 0.27549f
C843 vbp_st a_6672_9234# 0.04164f
C844 m1_7390_15740# vbn_ref 0
C845 a_2536_18120# a_2920_17120# 0
C846 m1_2702_380# vbn_prb 0.09221f
C847 a_4588_13668# a_5268_9138# 0
C848 m1_2868_9480# vbn_leak 0
C849 a_6140_14314# m1_6726_16790# 0
C850 a_728_3738# a_3272_6334# 0
C851 vsrc a_6716_2880# 0.0024f
C852 chain a_2536_2880# 0.83319f
C853 ta3 tb0 0.14922f
C854 m1_1704_2770# vbn_prb 0
C855 a_5204_10600# vdd 0.2298f
C856 a_5816_11894# el 0.00389f
C857 m1_7390_15740# a_5816_16974# 0.01712f
C858 a_488_19200# la2 0.01373f
C859 a_5816_11894# ta0 0.01154f
C860 vdd m1_6390_10270# 0.0028f
C861 vdd a_5960_18120# 0.06759f
C862 a_3956_5520# a_4096_6334# 0.49691f
C863 hold a_5816_11894# 0.14815f
C864 pl_en vbn_leak 0.35903f
C865 a_1480_3834# el 0.16432f
C866 chain a_6672_9234# 0.01073f
C867 a_5204_4080# d1 0.13663f
C868 el m1_690_15350# 0.07569f
C869 sel1 dl2 0.30776f
C870 vdd a_6716_18120# 0.43555f
C871 a_3956_5520# a_1892_3934# 0.61859f
C872 m1_5626_17750# a_268_18120# 0.32662f
C873 hold m1_690_15350# 0.00116f
C874 ta1 vbn_leak 0.10715f
C875 a_4588_13668# sel1 0.0021f
C876 sel0 m1_2702_380# 0.00976f
C877 a_2592_8154# m1_1704_17750# 0
C878 m1_1704_15350# m1_2678_13030# 0.00103f
C879 m1_7694_12850# m1_6390_15350# 0.07111f
C880 a_6672_14314# pl_en 0.04272f
C881 sta a_8436_16974# 0.04506f
C882 m1_690_2500# a_728_3738# 0.00216f
C883 m1_6474_8020# a_6672_9234# 0
C884 a_1780_18120# vdd 0.03959f
C885 en a_2536_2880# 0.00271f
C886 m1_7128_13020# m1_5122_15350# 0.10033f
C887 a_2180_13234# el 0.10539f
C888 vdd m1_5122_15350# 0.0054f
C889 a_5204_4080# a_4448_4080# 0.00285f
C890 vsrc d1 0.05291f
C891 a_2180_13234# ta0 0
C892 m1_5626_2500# a_6716_2880# 0.01477f
C893 vsrc m1_8166_15130# 0
C894 hold a_2180_13234# 0.96764f
C895 la1 m1_7684_8010# 0.04302f
C896 a_6672_14314# ta1 0.03401f
C897 vs vreset 0.14564f
C898 a_3956_5520# a_268_18120# 0.02616f
C899 vbn_ax a_8248_5320# 0.14586f
C900 m1_910_6150# vs 0.04955f
C901 a_2592_8154# dl1 1.09317f
C902 abus a_6716_2880# 0
C903 en a_6672_9234# 0.09271f
C904 d1 m1_2678_13030# 0
C905 m1_2702_380# en 0.02937f
C906 vbn_prb ta3 0
C907 vsrcp a_2592_8154# 0.0795f
C908 vbp_st ta3 0.0519f
C909 en a_3212_19200# 0.00899f
C910 a_1892_3934# vbn_ax 0.44944f
C911 a_4588_13668# la1 0.00747f
C912 la2 a_3212_19200# 0.00319f
C913 m1_690_17890# a_2536_18120# 0
C914 m1_1704_2770# en 0.02119f
C915 vbn_prb a_6716_2880# 0.0052f
C916 vbp_st a_6716_2880# 0.0042f
C917 a_3956_5520# a_2724_4480# 0.09307f
C918 vdd vs 1.50578f
C919 a_488_19200# a_2180_13234# 0.22521f
C920 a_8248_5320# a_3272_6334# 0.04253f
C921 a_5524_5520# vs 0.17313f
C922 a_1480_3834# a_2536_2880# 0.10753f
C923 m1_5100_10180# a_4588_8588# 0.52614f
C924 spk vs 8.10898f
C925 a_5816_11894# a_6672_9234# 0.49357f
C926 vdd a_2920_17120# 1.05949f
C927 m1_8050_16790# vbn_ax 0
C928 abus d1 0.03594f
C929 a_4096_6334# a_3272_6334# 0.03396f
C930 ta2 m1_6390_10270# 0.00361f
C931 m1_6390_15350# d2 0.16879f
C932 chain a_6716_2880# 0.38039f
C933 vbn_ax a_268_18120# 1.59057f
C934 a_6140_14314# m1_5122_15350# 0.00401f
C935 a_1892_3934# a_3272_6334# 0.26017f
C936 ta2 a_6716_18120# 0.00319f
C937 m1_5626_17750# d1_bsel 0
C938 sel0 a_6716_2880# 0.15111f
C939 a_268_18120# a_672_19994# 0.01233f
C940 mreset a_8248_5320# 0.49613f
C941 vbn_prb d1 0.0495f
C942 a_5204_10600# a_6140_9234# 0
C943 vbp_st d1 0.74995f
C944 vbn_ax a_2724_4480# 0.0552f
C945 vbn_prb m1_8166_15130# 0.11649f
C946 a_1480_3834# m1_1704_2770# 0
C947 m1_8166_10050# m1_6390_10270# 0
C948 a_6140_9234# m1_6390_10270# 0.10646f
C949 vbp_st m1_8166_15130# 0
C950 mreset a_4096_6334# 0.03558f
C951 sel1 m1_5626_17750# 0.03282f
C952 vdd a_8436_16974# 0.60151f
C953 vbn_leak m1_7138_8020# 0.00274f
C954 vbn_ref a_5816_16974# 0
C955 vsrcp vsrc 3.98155f
C956 mreset a_1892_3934# 0.63998f
C957 ta2 m1_5122_15350# 0.00947f
C958 en ta3 0.02002f
C959 la2 ta3 0.06355f
C960 a_268_18120# a_3272_6334# 0.02686f
C961 a_3212_19200# a_2180_13234# 0
C962 en a_6716_2880# 0.0843f
C963 vbp_syn a_4588_8588# 0.00362f
C964 a_2724_4480# a_5204_15680# 0.00441f
C965 m1_7390_15740# ta1 0.00459f
C966 chain d1 0.40506f
C967 vsrcp m1_2678_13030# 0.02754f
C968 stb m1_5626_17750# 0
C969 a_2536_18120# d2 0.18978f
C970 sel0 d1 0.02487f
C971 a_2724_4480# a_3272_6334# 0.09556f
C972 la2 m1_1704_15350# 0.00443f
C973 a_2592_8154# dl2 0.07404f
C974 mreset a_268_18120# 0.06678f
C975 a_728_3738# vs 0.46693f
C976 sta d2 0.11851f
C977 chain a_4448_4080# 0.02019f
C978 a_5816_11894# ta3 0.01405f
C979 a_4588_13668# a_2592_8154# 0.00864f
C980 m1_7128_14156# a_6672_14314# 0.16068f
C981 sta m1_6390_15350# 0.03147f
C982 m1_690_17890# vdd 0.17461f
C983 m1_1946_330# vdd 0.02044f
C984 mreset a_2724_4480# 0.16528f
C985 m1_2220_12980# d2 0.12173f
C986 abus vsrcp 0.12074f
C987 en d1 0.1234f
C988 el vbn_leak 4.31555f
C989 a_6140_14314# a_8436_16974# 0.24255f
C990 en m1_8166_15130# 0.11668f
C991 vbn_leak ta0 0.1819f
C992 vbp_st m1_2122_6150# 0
C993 vbp_st dl1 0.00153f
C994 hold vbn_leak 0.47915f
C995 vbn_ax d1_bsel 0.00388f
C996 en a_5204_18120# 0.01372f
C997 el a_4374_1028# 0.17119f
C998 a_2920_12040# d2 0.01998f
C999 m1_7128_13020# m1_7694_12850# 0.07391f
C1000 la2 m1_8166_15130# 0.0428f
C1001 vbp_syn a_5816_16974# 0
C1002 vbp_st vsrcp 4.00574f
C1003 vbp_syn m1_5100_10180# 0.01184f
C1004 vbn_prb vsrcp 0.07963f
C1005 la2 a_5204_18120# 0.11886f
C1006 a_672_19994# d1_bsel 1.07808f
C1007 m1_1704_15350# m1_690_15350# 0.00155f
C1008 sta m1_2122_9086# 0.41637f
C1009 sel1 vbn_ax 0.03591f
C1010 a_2180_13234# ta3 0
C1011 en a_4448_4080# 0.00372f
C1012 pl_en a_4588_8588# 0.01374f
C1013 a_8436_16974# ta2 0.07115f
C1014 a_6672_14314# el 0
C1015 sel1 a_672_19994# 0.03308f
C1016 a_5204_2880# spk 0.14377f
C1017 chain m1_2122_6150# 0.02239f
C1018 chain dl1 0.01075f
C1019 a_6672_14314# ta0 0.03946f
C1020 hold a_6672_14314# 0.0049f
C1021 m1_2678_7950# a_2724_4480# 0.01897f
C1022 a_5816_11894# d1 0.30393f
C1023 ta1 a_4588_8588# 0.03531f
C1024 vsrc dl2 0
C1025 chain vsrcp 0.10348f
C1026 sel1 a_5204_15680# 0
C1027 stb vbn_ax 0.30547f
C1028 m1_7138_8930# ta2 0.00345f
C1029 m1_1704_15350# a_2180_13234# 0.29412f
C1030 a_1480_3834# d1 0
C1031 sel0 vsrcp 0.02236f
C1032 stb a_672_19994# 0.52664f
C1033 vsrc a_5960_2880# 0.00101f
C1034 la2 m1_1704_17750# 0.31056f
C1035 a_5960_18120# a_268_18120# 0.12918f
C1036 dl2 m1_2678_13030# 0.01717f
C1037 vbn_ax m1_7390_10270# 0
C1038 a_268_18120# a_6716_18120# 0.25658f
C1039 a_4588_13668# m1_2678_13030# 0
C1040 m1_6474_8020# vsrcp 0.0035f
C1041 a_5204_10600# a_2724_4480# 0.00827f
C1042 m1_7128_13020# d2 0
C1043 a_8248_5320# vs 0.22476f
C1044 en dl1 0.43388f
C1045 vdd d2 1.47672f
C1046 a_2724_4480# m1_6390_10270# 0.00122f
C1047 a_2536_2880# vbn_leak 0.00374f
C1048 a_2180_13234# d1 0
C1049 m1_7128_13020# m1_6390_15350# 0.03185f
C1050 a_4096_6334# vs 0.37802f
C1051 m1_6474_13030# vbp_st 0
C1052 a_5816_16974# pl_en 0.25736f
C1053 en vsrcp 0.08528f
C1054 a_5204_18120# a_2180_13234# 0.30955f
C1055 m1_5626_17750# a_2592_8154# 0.02247f
C1056 m1_5100_10180# pl_en 0
C1057 a_1892_3934# vs 0.41499f
C1058 a_1780_18120# a_268_18120# 0
C1059 la2 vsrcp 0
C1060 a_2536_2880# a_4374_1028# 0.01924f
C1061 m1_2678_7950# a_5268_9138# 0
C1062 vbn_leak a_6672_9234# 0.0389f
C1063 m1_6726_16790# sel1 0
C1064 sel2 vbn_ax 0.02519f
C1065 abus dl2 0.00467f
C1066 ta1 a_5816_16974# 0.01664f
C1067 m1_5100_10180# ta1 0.02659f
C1068 m1_7694_12850# ta2 0
C1069 m1_5626_2500# a_5960_2880# 0.04794f
C1070 m1_2702_380# a_4374_1028# 0
C1071 m1_1704_2770# vbn_leak 0.25285f
C1072 abus a_5960_2880# 0
C1073 chain m1_6474_13030# 0.00385f
C1074 a_2724_4480# m1_5122_15350# 0.17784f
C1075 vdd m1_2122_9086# 0.16399f
C1076 a_5816_11894# dl1 0.20613f
C1077 vbn_prb dl2 0.03128f
C1078 vbp_st dl2 0.01397f
C1079 m1_1704_2770# a_4374_1028# 0.05345f
C1080 m1_6726_11710# sta 0.00552f
C1081 m1_7390_15740# el 0
C1082 a_268_18120# vs 0.05222f
C1083 m1_7390_15740# ta0 0
C1084 a_1480_3834# m1_2122_6150# 0.03077f
C1085 m1_2868_9480# vbp_syn 0.27247f
C1086 a_5204_10600# a_5268_9138# 0.00242f
C1087 a_5816_11894# vsrcp 0.49373f
C1088 a_4588_13668# vbp_st 0.00221f
C1089 m1_7390_15740# hold 0
C1090 vbn_prb a_5960_2880# 0
C1091 a_5268_9138# m1_6390_10270# 0.23649f
C1092 a_2180_13234# m1_1704_17750# 0.04557f
C1093 vdd a_2536_18120# 0.33682f
C1094 a_6140_14314# d2 0.00357f
C1095 vdd a_5960_4080# 0.46108f
C1096 a_6140_14314# m1_6390_15350# 0.12374f
C1097 a_2724_4480# vs 0
C1098 chain dl2 0.00614f
C1099 m1_7138_8020# a_4588_8588# 0.17452f
C1100 a_268_18120# a_2920_17120# 0.42142f
C1101 a_5960_18120# d1_bsel 0.00116f
C1102 a_4588_13668# chain 0.02004f
C1103 m1_6474_13030# en 0
C1104 sta vdd 0.94702f
C1105 chain a_5960_2880# 0.03449f
C1106 a_6716_18120# d1_bsel 0.10745f
C1107 mreset sel2 3.94804f
C1108 a_5960_4080# a_5524_5520# 0.16274f
C1109 ta2 d2 0.1948f
C1110 el a_1780_15680# 0.00429f
C1111 sel0 a_5960_2880# 0.00462f
C1112 vdd m1_2220_12980# 0.19351f
C1113 a_2724_4480# a_2920_17120# 0.01298f
C1114 sel1 a_5960_18120# 0.01992f
C1115 hold a_1780_15680# 0.15054f
C1116 ta3 vbn_leak 0.11892f
C1117 m1_8050_16790# a_8436_16974# 0.03688f
C1118 m1_6390_15350# ta2 0.00592f
C1119 vbn_ax a_2592_8154# 0.14323f
C1120 sta spk 0
C1121 sel1 a_6716_18120# 0.05364f
C1122 a_8436_16974# a_268_18120# 0
C1123 vbn_leak a_6716_2880# 0
C1124 vdd a_2920_12040# 1.24699f
C1125 a_672_19994# a_2592_8154# 0.57642f
C1126 en dl2 0.35522f
C1127 a_3956_5520# vsrc 0
C1128 stb a_5960_18120# 0
C1129 m1_1704_15350# vbn_leak 0.23399f
C1130 la2 dl2 1.03729f
C1131 a_4588_13668# en 0.16589f
C1132 a_8436_16974# a_2724_4480# 0.15077f
C1133 a_6672_14314# ta3 0.05502f
C1134 stb a_6716_18120# 0.01976f
C1135 sel1 m1_5122_15350# 0
C1136 a_1780_2880# el 0
C1137 en a_5960_2880# 0.05368f
C1138 el a_488_5520# 0.12739f
C1139 a_5204_2880# a_4096_6334# 0.01425f
C1140 m1_5100_10180# m1_7138_8020# 0.14267f
C1141 la1 a_5204_10600# 0
C1142 m1_7390_10270# m1_6390_10270# 0
C1143 m1_6726_11710# vdd 0.07489f
C1144 ta0 a_4588_8588# 0.03905f
C1145 la1 m1_6390_10270# 0.02056f
C1146 hold a_4588_8588# 0.08289f
C1147 a_6140_14314# sta 0.01299f
C1148 m1_7684_8010# a_5816_11894# 0.03516f
C1149 stb a_1780_18120# 0.3058f
C1150 vdd vreset 0.13205f
C1151 m1_910_6150# vdd 0.05632f
C1152 ta1 pl_en 0.03498f
C1153 vbn_leak d1 0.42139f
C1154 m1_7128_14156# a_5816_16974# 0.04937f
C1155 a_5960_4080# ta2 0
C1156 m1_8166_15130# vbn_leak 0
C1157 vbp_st m1_5626_17750# 0.02624f
C1158 m1_690_17890# a_268_18120# 0.13997f
C1159 a_5204_18120# vbn_leak 0
C1160 d1 a_4374_1028# 0.04234f
C1161 m1_690_15350# dl2 0
C1162 vbn_ax vsrc 0.08147f
C1163 sta ta2 0
C1164 spk vreset 0.21976f
C1165 la1 m1_5122_15350# 0.00131f
C1166 vbn_ref el 0.22705f
C1167 a_5204_2880# a_268_18120# 0.00274f
C1168 a_5204_10600# m1_1704_10270# 0
C1169 sta a_728_3738# 0
C1170 m1_7694_12850# a_268_18120# 0
C1171 vbn_leak a_4448_4080# 0
C1172 chain m1_5626_17750# 0.04387f
C1173 sel1 a_2920_17120# 0
C1174 a_6672_14314# m1_8166_15130# 0.05067f
C1175 vdd a_5524_5520# 1.1332f
C1176 a_3956_5520# vbp_st 0.00142f
C1177 vdd spk 4.56736f
C1178 el a_5816_16974# 0.2902f
C1179 sta m1_8166_10050# 0
C1180 a_2180_13234# dl2 0.24891f
C1181 a_5816_16974# ta0 0.0117f
C1182 sta a_6140_9234# 0.14705f
C1183 m1_7138_8930# a_5268_9138# 0.0922f
C1184 m1_7694_12850# a_2724_4480# 0.0072f
C1185 hold a_5816_16974# 0.12379f
C1186 m1_5100_10180# ta0 0.02366f
C1187 mreset a_5204_4080# 0.01613f
C1188 m1_2678_7950# a_2592_8154# 0.04879f
C1189 m1_5100_10180# hold 0.16294f
C1190 vsrc a_3272_6334# 0.36632f
C1191 a_1780_2880# a_2536_2880# 0.00815f
C1192 stb a_2920_17120# 0.00174f
C1193 a_2536_2880# a_488_5520# -0.0501f
C1194 spk a_5524_5520# 0.05491f
C1195 m1_5626_2500# vbn_ax 0.10137f
C1196 sel1 a_8436_16974# 0.14778f
C1197 a_2536_2880# a_4588_8588# 0
C1198 a_3956_5520# chain 0.02007f
C1199 m1_7390_15740# ta3 0.03194f
C1200 abus vbn_ax 0.09132f
C1201 a_2920_12040# a_6140_9234# 0
C1202 dl1 vbn_leak 0.5234f
C1203 en m1_5626_17750# 0.04364f
C1204 a_6672_9234# a_4588_8588# 0
C1205 vdd m1_8050_11710# 0.07794f
C1206 mreset vsrc 0.02828f
C1207 m1_5626_17750# la2 0.52306f
C1208 a_6140_14314# vdd 0.39942f
C1209 m1_1704_2770# a_1780_2880# 0.2425f
C1210 a_5204_10600# a_2592_8154# 0.00345f
C1211 vbn_prb vbn_ax 0.32795f
C1212 vsrcp vbn_leak 0.45668f
C1213 a_268_18120# d2 0.08204f
C1214 a_2592_8154# m1_6390_10270# 0.04504f
C1215 vbp_st vbn_ax 4.51948f
C1216 a_5960_18120# a_2592_8154# 0
C1217 m1_690_2500# vsrc 0.0381f
C1218 m1_910_6150# a_728_3738# 0.02324f
C1219 m1_6390_15350# a_268_18120# 0
C1220 vbp_syn el 0.16317f
C1221 m1_5626_2500# a_3272_6334# 0.29781f
C1222 a_8248_5320# a_5960_4080# 0
C1223 m1_7694_12850# a_5268_9138# 0
C1224 vbp_syn hold 0.51386f
C1225 a_2592_8154# a_6716_18120# 0.06221f
C1226 m1_6726_11710# a_6140_9234# 0.00126f
C1227 abus a_3272_6334# 0
C1228 pl_en m1_7138_8020# 0.00168f
C1229 la1 a_8436_16974# 0
C1230 a_2724_4480# d2 0.26048f
C1231 a_3956_5520# en 0.00669f
C1232 m1_7128_13020# ta2 0.02593f
C1233 m1_2064_14170# m1_2678_13030# 0.01242f
C1234 vdd ta2 0.06862f
C1235 vbp_st a_5204_15680# 0
C1236 vdd a_728_3738# 0.69112f
C1237 chain vbn_ax 0.43912f
C1238 vbn_ref a_6672_9234# 0
C1239 m1_6390_15350# a_2724_4480# 0.21851f
C1240 a_6672_14314# vsrcp 0.0864f
C1241 a_1892_3934# a_5960_4080# 0.28854f
C1242 ta1 m1_7138_8020# 0.01946f
C1243 la1 m1_7138_8930# 0.00509f
C1244 a_1780_18120# a_2592_8154# 0
C1245 sta a_4096_6334# 0
C1246 vbn_prb a_3272_6334# 0.11497f
C1247 sel0 vbn_ax 0.24895f
C1248 vbp_st a_3272_6334# 0.00411f
C1249 m1_7390_15740# m1_8166_15130# 0.23873f
C1250 chain a_672_19994# 0.02869f
C1251 ta2 a_5524_5520# 0.00182f
C1252 m1_8166_10050# vdd 0.02192f
C1253 mreset abus 0.03616f
C1254 vdd a_6140_9234# 0.59327f
C1255 m1_1704_15350# a_1780_15680# 0.25164f
C1256 chain a_5204_15680# 0
C1257 spk a_728_3738# 0.00331f
C1258 m1_5100_10180# a_6672_9234# 0
C1259 stb m1_690_17890# 0.01931f
C1260 m1_7128_14156# ta1 0.02699f
C1261 a_2536_18120# a_268_18120# 0.00513f
C1262 mreset vbn_prb 0.0357f
C1263 a_268_18120# a_5960_4080# 0.07146f
C1264 mreset vbp_st 0.24575f
C1265 chain a_3272_6334# 0.21271f
C1266 ta3 a_4588_8588# 0.04011f
C1267 m1_6474_13030# vbn_leak -0.02257f
C1268 m1_5626_17750# a_2180_13234# 0.18056f
C1269 en vbn_ax 0.04661f
C1270 m1_2868_9480# hold 0
C1271 m1_6726_16790# vbp_st 0.00667f
C1272 a_3956_5520# a_1480_3834# 0.00142f
C1273 sel0 a_3272_6334# 0.11505f
C1274 vbn_ax la2 0.25671f
C1275 el pl_en 0.05856f
C1276 sta a_268_18120# 0.05049f
C1277 en a_672_19994# 0.11739f
C1278 pl_en ta0 0.04339f
C1279 a_6140_14314# ta2 0.00299f
C1280 hold pl_en 0.06648f
C1281 ta1 el 0.03067f
C1282 d2 d1_bsel 0.00388f
C1283 ta1 ta0 2.79837f
C1284 mreset chain 0.03948f
C1285 m1_6474_13030# a_6672_14314# 0
C1286 en a_5204_15680# 0.0249f
C1287 m1_6726_16790# chain 0
C1288 hold ta1 0.0034f
C1289 a_8248_5320# vreset 0.09687f
C1290 sta a_2724_4480# 0.2227f
C1291 vbn_leak dl2 0.39794f
C1292 mreset sel0 0.03199f
C1293 vbp_st m1_2678_7950# 0
C1294 vbp_syn a_3212_19200# 0.18724f
C1295 a_4096_6334# vreset 0.08186f
C1296 a_6140_9234# m1_8050_11710# 0.01101f
C1297 a_4588_13668# vbn_leak 0.84366f
C1298 sel1 d2 0.09748f
C1299 en a_3272_6334# 0.22919f
C1300 a_5204_4080# vs 0
C1301 a_1780_2880# d1 0.01101f
C1302 vbn_ax a_5816_11894# 0
C1303 vbn_leak a_5960_2880# 0
C1304 vbn_ref a_6716_2880# 0.00149f
C1305 d1 a_488_5520# 0
C1306 vdd a_8248_5320# 0.98026f
C1307 m1_6390_15350# sel1 0.29618f
C1308 d1 a_4588_8588# 0.01559f
C1309 m1_7390_15740# vsrcp 0.00583f
C1310 ta3 a_5816_16974# 0.01874f
C1311 a_8436_16974# a_2592_8154# 0.05283f
C1312 m1_5100_10180# ta3 0.00303f
C1313 a_2724_4480# a_2920_12040# 0.05155f
C1314 vdd a_4096_6334# 0.78768f
C1315 a_6672_14314# dl2 0.2004f
C1316 stb d2 0.61421f
C1317 chain m1_2678_7950# 0.00637f
C1318 mreset en 0.01702f
C1319 a_1892_3934# vdd 2.13672f
C1320 m1_8166_10050# ta2 0
C1321 a_4588_13668# a_6672_14314# 0
C1322 ta2 a_6140_9234# 0.0089f
C1323 vsrc vs 1.3352f
C1324 a_8248_5320# a_5524_5520# 0.00105f
C1325 a_8248_5320# spk 0.47952f
C1326 m1_7138_8930# a_2592_8154# 0.00446f
C1327 vbp_st m1_6390_10270# 0.00101f
C1328 vbp_st a_5960_18120# 0.00136f
C1329 a_268_18120# vreset 0
C1330 a_4096_6334# a_5524_5520# 0.0282f
C1331 vbn_ax a_2180_13234# 0.10691f
C1332 a_2536_18120# d1_bsel 0
C1333 spk a_4096_6334# 0.19582f
C1334 sta a_5268_9138# 0.09766f
C1335 la1 d2 0.05238f
C1336 vbp_st a_6716_18120# 0.00128f
C1337 a_1892_3934# a_5524_5520# 0.8537f
C1338 a_1892_3934# spk 0.14891f
C1339 vbn_ref d1 0.02406f
C1340 a_1480_3834# a_3272_6334# 0.31965f
C1341 a_672_19994# a_2180_13234# 0.19894f
C1342 m1_2122_9086# a_1780_10600# 0
C1343 m1_8050_16790# vdd 0.10214f
C1344 a_5204_10600# chain 0
C1345 a_2724_4480# vreset 0
C1346 sta d1_bsel 0.44633f
C1347 vdd a_268_18120# 1.78738f
C1348 pl_en a_6672_9234# 0.07488f
C1349 chain m1_6390_10270# 0.01794f
C1350 a_2180_13234# a_5204_15680# 0.09155f
C1351 chain a_5960_18120# 0.02374f
C1352 a_3212_19200# pl_en 0
C1353 m1_690_17890# a_2592_8154# 0
C1354 a_5816_16974# d1 0
C1355 vbp_st m1_5122_15350# 0
C1356 a_5816_16974# m1_8166_15130# 0.00161f
C1357 chain a_6716_18120# 0.05285f
C1358 m1_5100_10180# d1 0.04683f
C1359 ta1 a_6672_9234# 0.00556f
C1360 sta sel1 0.41343f
C1361 vdd a_2724_4480# 0.94657f
C1362 abus vs 0.27542f
C1363 a_268_18120# spk 0.06806f
C1364 a_268_18120# a_5524_5520# 0.28067f
C1365 stb a_2536_18120# 0.5826f
C1366 m1_2122_6150# a_488_5520# 0.0041f
C1367 dl1 a_4588_8588# 0.06689f
C1368 m1_7694_12850# a_2592_8154# 0.01668f
C1369 vbp_syn m1_1704_15350# 0.01195f
C1370 a_1480_3834# m1_690_2500# 0.00168f
C1371 ta0 m1_7138_8020# 0.00656f
C1372 hold m1_7138_8020# 0.00181f
C1373 sta a_1780_10600# 0.00246f
C1374 vsrcp a_4588_8588# 0.14388f
C1375 chain m1_5122_15350# 0.00484f
C1376 a_8436_16974# m1_2678_13030# 0
C1377 a_2724_4480# a_5524_5520# 0.00211f
C1378 a_5204_10600# en 0.02992f
C1379 vbn_prb vs 0.19959f
C1380 a_2724_4480# spk 0.06257f
C1381 vbp_st vs 0.10454f
C1382 m1_6726_11710# a_5268_9138# 0.01687f
C1383 m1_5626_17750# vbn_leak 0.0275f
C1384 stb sta 0.50946f
C1385 m1_2678_7950# a_5816_11894# 0
C1386 en m1_6390_10270# 0.0326f
C1387 en a_5960_18120# 0.01383f
C1388 m1_7128_14156# ta0 0.01663f
C1389 m1_7390_15740# dl2 0.08704f
C1390 a_5960_18120# la2 0.05861f
C1391 en a_6716_18120# 0.05342f
C1392 a_1480_3834# m1_2678_7950# 0
C1393 m1_7128_14156# hold 0.00242f
C1394 m1_2064_14170# a_2180_13234# 0.12838f
C1395 a_6140_14314# m1_8050_16790# 0.01407f
C1396 la2 a_6716_18120# 0.01067f
C1397 a_6140_14314# a_268_18120# 0
C1398 a_5204_2880# a_5204_4080# 0.00358f
C1399 a_1892_3934# a_728_3738# 0.00219f
C1400 vbp_syn d1 0.27274f
C1401 la1 sta 0.00468f
C1402 vbp_st a_2920_17120# 0
C1403 tb2 tb3 0.16769f
C1404 el m1_4870_3750# 0.15285f
C1405 chain vs 0.11483f
C1406 vbp_syn a_5204_18120# 0.01471f
C1407 hold m1_4870_3750# 0
C1408 vdd a_5268_9138# 0.4712f
C1409 vsrcp vbn_ref 0.02517f
C1410 sel0 vs 0.38955f
C1411 en m1_5122_15350# 0.03631f
C1412 m1_1946_330# vsrc 0.01364f
C1413 ta3 pl_en 0.05484f
C1414 la1 m1_2220_12980# 0
C1415 a_5204_10600# a_5816_11894# 0.0287f
C1416 a_6140_14314# a_2724_4480# 0.24503f
C1417 a_1780_18120# la2 0.0366f
C1418 a_5816_11894# m1_6390_10270# 0.17252f
C1419 m1_5100_10180# dl1 0.02336f
C1420 a_2592_8154# d2 0.03962f
C1421 a_3956_5520# a_4374_1028# 0.32651f
C1422 vdd d1_bsel 1.10803f
C1423 el ta0 0.02949f
C1424 a_5204_2880# vsrc 0
C1425 la1 a_2920_12040# 0.59385f
C1426 a_268_18120# ta2 0.02479f
C1427 vbn_prb a_8436_16974# 0
C1428 chain a_2920_17120# 0
C1429 hold el 0.09784f
C1430 vbp_st a_8436_16974# 0.15408f
C1431 vsrcp a_5816_16974# 0.28535f
C1432 a_268_18120# a_728_3738# 0
C1433 m1_6390_15350# a_2592_8154# 0.13971f
C1434 a_1780_15680# dl2 -0.00402f
C1435 m1_5100_10180# vsrcp 0.04707f
C1436 hold ta0 2.7945f
C1437 m1_1704_10270# sta 0
C1438 vdd sel1 0.05385f
C1439 a_2724_4480# ta2 0.03768f
C1440 en vs 0.1739f
C1441 a_2724_4480# a_728_3738# 0
C1442 m1_8166_10050# a_268_18120# 0
C1443 vbp_syn m1_1704_17750# 0.00515f
C1444 a_268_18120# a_6140_9234# 0
C1445 a_5816_11894# m1_5122_15350# 0
C1446 m1_2868_9480# d1 0.092f
C1447 la1 m1_6726_11710# 0.00137f
C1448 chain a_8436_16974# 0.00355f
C1449 vdd a_1780_10600# 0.06505f
C1450 m1_2122_9086# a_2592_8154# 0.02121f
C1451 vdd m1_690_10190# 0.02286f
C1452 vbn_ax vbn_leak 0.36571f
C1453 a_5960_18120# a_2180_13234# 0.1514f
C1454 m1_7684_8010# a_4588_8588# 0.05496f
C1455 hold a_488_19200# 0.02797f
C1456 m1_7390_10270# vreset 0
C1457 m1_1704_10270# a_2920_12040# 0.16068f
C1458 stb vdd 1.11166f
C1459 abus m1_1946_330# 0.03895f
C1460 m1_8166_10050# a_2724_4480# 0.00115f
C1461 a_5268_9138# m1_8050_11710# 0.10034f
C1462 a_2180_13234# a_6716_18120# 0.20632f
C1463 a_2724_4480# a_6140_9234# 0
C1464 vbp_syn dl1 0.0455f
C1465 pl_en d1 0.19746f
C1466 en a_2920_17120# 0.00562f
C1467 a_5204_2880# m1_5626_2500# -0.06299f
C1468 a_5204_2880# abus 0
C1469 la2 a_2920_17120# 0.43299f
C1470 ta1 d1 0.02413f
C1471 a_2536_18120# a_2592_8154# 0.0714f
C1472 vbp_syn vsrcp 0.09932f
C1473 vbn_leak a_5204_15680# 0.2732f
C1474 vbn_prb m1_1946_330# 0.02478f
C1475 vdd m1_7390_10270# 0.2103f
C1476 a_1892_3934# a_8248_5320# 0.06305f
C1477 la1 vdd 1.86931f
C1478 vbn_ax a_6672_14314# 0.0038f
C1479 a_1780_18120# a_2180_13234# 0.17956f
C1480 m1_6474_13030# a_5816_16974# 0.00193f
C1481 sel2 vreset 0.02516f
C1482 a_1480_3834# vs 0.12656f
C1483 a_1892_3934# a_4096_6334# 0.21161f
C1484 m1_6390_15350# vsrc 0
C1485 a_5204_2880# vbn_prb 0
C1486 vbn_leak a_3272_6334# 0.32345f
C1487 ta2 a_5268_9138# 0.23362f
C1488 en a_8436_16974# 0.41899f
C1489 a_2536_2880# el 0.17374f
C1490 m1_7694_12850# vbp_st 0
C1491 sta a_2592_8154# 0.60009f
C1492 a_6140_14314# sel1 0.02384f
C1493 a_8436_16974# la2 0.13089f
C1494 d2 m1_2678_13030# 0.21207f
C1495 a_3272_6334# a_4374_1028# 0.03552f
C1496 hold a_2536_2880# 0.09075f
C1497 sel2 vdd 0.15165f
C1498 el a_6672_9234# 0.01822f
C1499 ta0 a_6672_9234# 0.0085f
C1500 a_8248_5320# a_268_18120# 0.08214f
C1501 m1_5100_10180# m1_7684_8010# 0.02412f
C1502 hold a_6672_9234# 0.01961f
C1503 m1_8166_10050# a_5268_9138# 0
C1504 a_5204_2880# chain 0.00164f
C1505 sel0 m1_1946_330# 0.0573f
C1506 vbn_ref a_5960_2880# 0.00119f
C1507 a_5960_4080# a_5204_4080# -0.06074f
C1508 mreset vbn_leak 0.02895f
C1509 a_6140_9234# a_5268_9138# 0.1259f
C1510 m1_1704_10270# vdd 0.68003f
C1511 a_2920_12040# a_2592_8154# 0.01358f
C1512 a_5816_16974# dl2 0.10842f
C1513 hold a_3212_19200# 0.01016f
C1514 a_268_18120# a_4096_6334# 0.02713f
C1515 m1_2868_9480# dl1 0.00448f
C1516 m1_6726_16790# vbn_leak 0.02849f
C1517 sel1 ta2 0.00693f
C1518 m1_1704_2770# el 0.06356f
C1519 ta3 m1_7138_8020# 0.04657f
C1520 a_5204_2880# sel0 0
C1521 mreset a_4374_1028# 0.07705f
C1522 sel2 spk 0.06185f
C1523 a_1892_3934# a_268_18120# 0.20481f
C1524 m1_2064_14170# vbn_leak 0
C1525 a_4588_13668# a_5816_16974# 0.51361f
C1526 a_8248_5320# a_2724_4480# 0.13228f
C1527 dl1 pl_en 0.01314f
C1528 m1_7390_10270# m1_8050_11710# 0
C1529 la1 m1_8050_11710# 0.06071f
C1530 a_2180_13234# a_2920_17120# 0.70799f
C1531 a_2724_4480# a_4096_6334# 0.00152f
C1532 a_488_19200# a_3212_19200# 0
C1533 m1_7128_14156# ta3 0.03415f
C1534 stb ta2 0.00304f
C1535 en m1_1946_330# 0.015f
C1536 a_1892_3934# a_2724_4480# 0.0314f
C1537 a_5816_11894# m1_7138_8930# 0.03827f
C1538 ta1 dl1 0.00773f
C1539 vsrcp pl_en 0.7853f
C1540 m1_690_17890# la2 0.01944f
C1541 vbn_prb d2 0
C1542 m1_2678_7950# vbn_leak 0.14664f
C1543 vbp_st d2 0.22289f
C1544 vsrcp ta1 0.03144f
C1545 a_5204_2880# en 0.01656f
C1546 vbn_prb m1_6390_15350# 0
C1547 m1_6390_15350# vbp_st 0.00101f
C1548 ta2 m1_7390_10270# 0.02502f
C1549 la1 ta2 0.03406f
C1550 m1_4870_3750# a_6716_2880# 0.03806f
C1551 vbp_syn dl2 0.09188f
C1552 m1_7390_15740# vbn_ax 0
C1553 sta tb0 0
C1554 d1 m1_7138_8020# 0
C1555 m1_7128_13020# a_2592_8154# 0.01067f
C1556 a_4588_13668# vbp_syn 0.06681f
C1557 chain d2 0.03095f
C1558 vdd a_2592_8154# 1.66932f
C1559 el ta3 0.03866f
C1560 a_268_18120# a_2724_4480# 2.62495f
C1561 a_5204_10600# vbn_leak 0.00179f
C1562 chain m1_6390_15350# 0.00541f
C1563 hold ta3 0.00194f
C1564 m1_8166_10050# m1_7390_10270# 0.09938f
C1565 m1_2220_12980# m1_2678_13030# 0.00912f
C1566 el a_6716_2880# 0.15413f
C1567 vbn_leak m1_6390_10270# 0.21844f
C1568 la1 m1_8166_10050# 0.04176f
C1569 m1_7390_10270# a_6140_9234# 0.00167f
C1570 la1 a_6140_9234# 0.26864f
C1571 a_5960_18120# vbn_leak 0.00128f
C1572 hold a_6716_2880# 0.0813f
C1573 a_6716_18120# vbn_leak 0.00209f
C1574 m1_1704_2770# a_2536_2880# 0.0233f
C1575 a_3956_5520# a_488_5520# 0.00245f
C1576 a_2920_12040# m1_2678_13030# 0
C1577 m1_1704_15350# el 0.00495f
C1578 m1_6474_13030# pl_en 0
C1579 hold m1_1704_15350# 0.39261f
C1580 d1 m1_4870_3750# 0.03223f
C1581 m1_2702_380# m1_1704_2770# 0.0028f
C1582 vdd a_5204_4080# 0.00693f
C1583 vbp_st a_5960_4080# 0.11532f
C1584 sel2 m1_8166_10050# 0.00732f
C1585 m1_690_17890# a_2180_13234# 0.00278f
C1586 en d2 0.17067f
C1587 m1_5122_15350# vbn_leak 0.14589f
C1588 vsrc vreset 0.39161f
C1589 en m1_6390_15350# 0.24383f
C1590 la2 d2 0.1853f
C1591 m1_5626_17750# a_5816_16974# 0
C1592 sta vbp_st 0.03875f
C1593 m1_6390_15350# la2 0
C1594 a_268_18120# a_5268_9138# 0
C1595 m1_7684_8010# pl_en 0.04044f
C1596 el d1 2.584f
C1597 a_5204_4080# a_5524_5520# 0.09227f
C1598 a_2592_8154# m1_8050_11710# 0.01095f
C1599 el m1_8166_15130# 0
C1600 spk a_5204_4080# 0.00195f
C1601 d1 ta0 0.01437f
C1602 a_6140_14314# a_2592_8154# 0.09718f
C1603 a_4448_4080# m1_4870_3750# -0.06551f
C1604 chain a_5960_4080# 0.03512f
C1605 hold d1 0.74003f
C1606 pl_en dl2 0.02296f
C1607 m1_7684_8010# ta1 0
C1608 vdd vsrc 0.24106f
C1609 dl1 m1_7138_8020# 0
C1610 a_4588_13668# pl_en 0.11051f
C1611 hold a_5204_18120# 0.08704f
C1612 a_268_18120# d1_bsel 0.00734f
C1613 a_2724_4480# a_5268_9138# 0.00352f
C1614 a_6672_14314# m1_5122_15350# 0
C1615 ta1 dl2 0.00457f
C1616 chain sta 0.42301f
C1617 vbn_leak vs 0.957f
C1618 vdd m1_2678_13030# 0.29687f
C1619 la1 a_8248_5320# 0
C1620 el a_4448_4080# 0
C1621 a_4588_13668# ta1 0.02868f
C1622 ta2 a_2592_8154# 0.04456f
C1623 spk vsrc 0.15691f
C1624 vs a_4374_1028# 0.91788f
C1625 sel1 a_268_18120# 0.03468f
C1626 m1_5626_2500# vreset 0.00235f
C1627 ta3 a_6672_9234# 0.01692f
C1628 d2 m1_690_15350# 0.00796f
C1629 abus vreset 0.5903f
C1630 m1_7128_14156# vsrcp 0.33635f
C1631 a_2920_17120# vbn_leak 0.05381f
C1632 m1_5626_17750# vbp_syn 0.00231f
C1633 chain a_2920_12040# 0
C1634 a_1780_2880# a_3272_6334# 0.15772f
C1635 en a_5960_4080# 0.01321f
C1636 sta m1_6474_8020# 0
C1637 m1_6726_11710# vbp_st -0.00277f
C1638 sel1 a_2724_4480# 0.01624f
C1639 a_2536_18120# la2 0.01952f
C1640 a_488_5520# a_3272_6334# 0.2446f
C1641 m1_2064_14170# a_1780_15680# 0
C1642 stb a_268_18120# 0.08702f
C1643 m1_8166_10050# a_2592_8154# 0.02564f
C1644 hold m1_1704_17750# 0.03481f
C1645 vbn_ax vbn_ref 4.15008f
C1646 a_2592_8154# a_6140_9234# 0.18007f
C1647 vbn_prb vreset 4.0041f
C1648 a_2180_13234# d2 0.12626f
C1649 vbp_st vreset 0.03026f
C1650 abus vdd 0.16433f
C1651 m1_910_6150# vbp_st 0.01024f
C1652 sta en 0.40253f
C1653 sta la2 0.02036f
C1654 dl1 el 0.05318f
C1655 a_268_18120# m1_7390_10270# 0.0035f
C1656 a_8436_16974# vbn_leak 0.12849f
C1657 vbn_ax a_5816_16974# 0.09193f
C1658 la1 a_268_18120# 0
C1659 dl1 ta0 0.00384f
C1660 m1_6726_11710# chain 0
C1661 a_2536_2880# d1 0.07664f
C1662 m1_5626_2500# spk 0.29241f
C1663 hold dl1 0.3012f
C1664 m1_7128_13020# vbp_st 0
C1665 vbn_prb vdd 0.2858f
C1666 abus spk 0.12113f
C1667 vsrcp el 0.09025f
C1668 vdd vbp_st 4.12126f
C1669 a_488_19200# m1_1704_17750# 0
C1670 m1_690_2500# a_1780_2880# 0.00696f
C1671 vsrcp ta0 0.031f
C1672 chain vreset 0
C1673 en a_2920_12040# 0.00637f
C1674 hold vsrcp 0.05639f
C1675 m1_690_2500# a_488_5520# 0.00255f
C1676 d1 a_6672_9234# 0.13053f
C1677 la1 a_2724_4480# 0.06018f
C1678 vbn_ref a_3272_6334# 0.32282f
C1679 a_2724_4480# m1_7390_10270# 0.0644f
C1680 a_5816_16974# a_5204_15680# 0.00141f
C1681 sel0 vreset 0.13243f
C1682 sta a_5816_11894# 0.04151f
C1683 a_8436_16974# a_6672_14314# 0.3581f
C1684 vbn_prb spk 0.49139f
C1685 a_728_3738# vsrc 0.10187f
C1686 vbp_st a_5524_5520# 0.76713f
C1687 vbp_st spk 0.06585f
C1688 sel2 a_268_18120# 0.02518f
C1689 a_5204_18120# a_3212_19200# -0.01934f
C1690 m1_1704_2770# d1 0.00128f
C1691 chain vdd 0.63609f
C1692 ta2 tb0 0.00137f
C1693 m1_7684_8010# m1_7138_8020# 0.12093f
C1694 sel0 vdd 0.13546f
C1695 m1_5626_17750# pl_en 0.06096f
C1696 mreset vbn_ref 0.03095f
C1697 a_2536_18120# a_2180_13234# 0.02373f
C1698 sel1 d1_bsel 0.52089f
C1699 m1_2678_7950# a_4588_8588# 0
C1700 m1_8166_10050# vsrc 0
C1701 sel2 a_2724_4480# 0.03317f
C1702 vbp_syn vbn_ax 0.03807f
C1703 m1_5626_17750# ta1 0.00656f
C1704 chain a_5524_5520# 0.18924f
C1705 chain spk 0.60409f
C1706 m1_1704_10270# a_2724_4480# 0.0028f
C1707 vbp_syn a_672_19994# 0.04544f
C1708 sel0 spk 0.31928f
C1709 vbp_st m1_8050_11710# -0.01305f
C1710 sta a_2180_13234# 0.09151f
C1711 m1_7128_14156# dl2 0
C1712 m1_1946_330# a_4374_1028# 0.00672f
C1713 a_5204_2880# vbn_leak 0.01766f
C1714 m1_6726_16790# a_5816_16974# 0
C1715 a_6140_14314# vbn_prb 0
C1716 stb d1_bsel 0.44804f
C1717 a_6140_14314# vbp_st 0.07516f
C1718 m1_7390_10270# a_5268_9138# 0.02417f
C1719 la1 a_5268_9138# 0.17552f
C1720 m1_6474_13030# el 0.02199f
C1721 a_3212_19200# m1_1704_17750# 0.04693f
C1722 a_4588_13668# m1_7128_14156# 0
C1723 vbp_syn a_5204_15680# 0.01829f
C1724 en vdd 0.66461f
C1725 a_5204_2880# a_4374_1028# 0
C1726 a_5204_10600# a_4588_8588# 0.19791f
C1727 m1_6474_13030# hold 0.00179f
C1728 m1_2220_12980# a_2180_13234# 0.27215f
C1729 vdd la2 2.0966f
C1730 m1_6390_10270# a_4588_8588# 0.03825f
C1731 stb sel1 0.03948f
C1732 dl1 a_6672_9234# 0.281f
C1733 ta3 d1 0.26087f
C1734 ta3 m1_8166_15130# 0
C1735 en a_5524_5520# 0.07917f
C1736 m1_690_10190# a_1780_10600# 0.0035f
C1737 vbn_prb ta2 0
C1738 a_6140_14314# chain 0.01033f
C1739 vbp_st ta2 0.01845f
C1740 m1_8050_16790# a_2592_8154# 0.01536f
C1741 en spk 0.05604f
C1742 m1_7684_8010# el 0
C1743 d1 a_6716_2880# 0.18896f
C1744 m1_7684_8010# ta0 0
C1745 vbp_st a_728_3738# 0.20369f
C1746 abus m1_8166_10050# 0.02772f
C1747 vsrcp a_6672_9234# 0.04493f
C1748 a_268_18120# a_2592_8154# 0.09721f
C1749 m1_2678_7950# m1_5100_10180# 0
C1750 a_1892_3934# a_5204_4080# 0.04203f
C1751 a_1480_3834# m1_910_6150# 0
C1752 el dl2 0.0143f
C1753 ta0 dl2 0.00606f
C1754 vdd a_5816_11894# 0.41846f
C1755 hold dl2 0.32646f
C1756 a_4588_13668# el 0.39185f
C1757 m1_7390_15740# a_8436_16974# 0.13867f
C1758 a_8248_5320# vsrc 0.10637f
C1759 m1_8166_10050# vbp_st 0
C1760 m1_8166_10050# vbn_prb 0.17687f
C1761 a_4588_13668# ta0 0.03809f
C1762 el a_5960_2880# 0.04164f
C1763 a_2724_4480# a_2592_8154# 0.11339f
C1764 la1 a_1780_10600# 0.00298f
C1765 vbn_prb a_6140_9234# 0
C1766 vbp_st a_6140_9234# 0.3786f
C1767 a_4588_13668# hold 0.05808f
C1768 vbn_ax pl_en 0.02946f
C1769 a_1480_3834# vdd 0.94541f
C1770 chain a_728_3738# 0.06143f
C1771 la1 m1_690_10190# 0.08269f
C1772 vbp_syn m1_2064_14170# 0.26109f
C1773 vdd m1_690_15350# 0.08767f
C1774 a_4096_6334# vsrc 0.15372f
C1775 a_4448_4080# a_6716_2880# 0
C1776 d2 vbn_leak 0.58389f
C1777 en m1_8050_11710# 0
C1778 a_672_19994# pl_en 0.10109f
C1779 a_1892_3934# vsrc 0.03659f
C1780 a_6140_14314# en 0.01836f
C1781 m1_6390_15350# vbn_leak 0.15604f
C1782 vbn_ax ta1 0.04348f
C1783 a_1780_2880# vs 0.00895f
C1784 a_268_18120# a_5204_4080# 0.11775f
C1785 a_5204_10600# m1_5100_10180# 0.01385f
C1786 a_5960_18120# a_5816_16974# 0
C1787 a_488_5520# vs 0.53707f
C1788 a_6140_14314# la2 0.42732f
C1789 pl_en a_5204_15680# 0
C1790 chain a_6140_9234# 0.29067f
C1791 a_672_19994# ta1 0.00146f
C1792 vs a_4588_8588# 0
C1793 la1 m1_7390_10270# 0.20009f
C1794 vdd a_2180_13234# 1.40389f
C1795 m1_2678_7950# vbp_syn 0.47145f
C1796 a_6672_14314# d2 0.11841f
C1797 m1_1704_10270# a_1780_10600# 0.23276f
C1798 dl1 ta3 0.0245f
C1799 m1_5626_2500# a_8248_5320# 0.11654f
C1800 m1_1704_10270# m1_690_10190# -0.01389f
C1801 m1_6390_15350# a_6672_14314# 0.08291f
C1802 en ta2 0.01115f
C1803 m1_2122_9086# vbn_leak 0
C1804 a_268_18120# vsrc 0.00456f
C1805 la2 ta2 0.0059f
C1806 abus a_8248_5320# 0.05422f
C1807 d1 a_4448_4080# 0.04876f
C1808 m1_5122_15350# a_5816_16974# 0.11308f
C1809 m1_5626_2500# a_4096_6334# 0
C1810 a_2592_8154# a_5268_9138# 0.06559f
C1811 vsrcp ta3 0.15342f
C1812 sel2 m1_7390_10270# 0.02866f
C1813 la1 sel2 0
C1814 abus a_4096_6334# 0.12959f
C1815 a_1892_3934# m1_5626_2500# 0.00768f
C1816 vbn_ref vs 0.37414f
C1817 a_2724_4480# vsrc 0.00315f
C1818 m1_8166_10050# en 0.12154f
C1819 a_5204_10600# vbp_syn 0.02407f
C1820 vbp_st a_8248_5320# 0.08025f
C1821 vbn_prb a_8248_5320# 0.11628f
C1822 en a_6140_9234# 0.05129f
C1823 la1 m1_1704_10270# 0.00469f
C1824 a_2592_8154# d1_bsel 1.0143f
C1825 a_5960_18120# vbp_syn 0
C1826 vbp_st a_4096_6334# 0.01121f
C1827 vbn_prb a_4096_6334# 0.079f
C1828 vbp_syn a_6716_18120# 0.00499f
C1829 a_5816_11894# ta2 0.01095f
C1830 m1_6726_16790# ta1 0
C1831 a_1892_3934# vbn_prb 0.04664f
C1832 a_5204_18120# m1_1704_17750# 0
C1833 a_1892_3934# vbp_st 0.08568f
C1834 sta vbn_leak 0.28582f
C1835 sel1 a_2592_8154# 0.02686f
C1836 m1_2868_9480# m1_2678_7950# 0.0451f
C1837 chain a_8248_5320# 0.19152f
C1838 a_1480_3834# a_728_3738# 0.07006f
C1839 m1_7138_8930# a_4588_8588# 0
C1840 dl1 d1 0.29782f
C1841 m1_5626_17750# ta0 0.00352f
C1842 a_2592_8154# a_1780_10600# 0.25836f
C1843 abus a_268_18120# 0.05829f
C1844 m1_5626_17750# hold 0.15807f
C1845 sel0 a_8248_5320# 0.10681f
C1846 chain a_4096_6334# 0.0099f
C1847 m1_690_10190# a_2592_8154# 0.00114f
C1848 m1_8166_10050# a_5816_11894# 0.05784f
C1849 vbp_syn m1_5122_15350# 0.01531f
C1850 vsrcp d1 0.33327f
C1851 a_5816_11894# a_6140_9234# 0.0561f
C1852 vsrcp m1_8166_15130# 0
C1853 stb a_2592_8154# 0.75673f
C1854 a_1892_3934# chain 0.65209f
C1855 a_2920_12040# vbn_leak 0.00558f
C1856 sel0 a_4096_6334# 0.08654f
C1857 sta a_6672_14314# 0.01873f
C1858 m1_8050_16790# vbp_st 0.02435f
C1859 vbn_prb a_268_18120# 0.07534f
C1860 abus a_2724_4480# 0.06778f
C1861 ta2 a_2180_13234# 0
C1862 vbp_st a_268_18120# 0.0928f
C1863 a_1892_3934# sel0 0.03286f
C1864 a_1780_2880# m1_1946_330# 0
C1865 m1_7390_15740# d2 0.35369f
C1866 a_3956_5520# el 0.05464f
C1867 a_2592_8154# m1_7390_10270# 0.07186f
C1868 la1 a_2592_8154# 0.31928f
C1869 a_3956_5520# hold 0.00241f
C1870 m1_6390_15350# m1_7390_15740# 0.00236f
C1871 a_8436_16974# a_5816_16974# 0.20126f
C1872 a_5204_10600# pl_en 0
C1873 vbp_st a_2724_4480# 0.18951f
C1874 vbn_prb a_2724_4480# 0.09623f
C1875 m1_7684_8010# ta3 0.01556f
C1876 pl_en m1_6390_10270# 0.32291f
C1877 m1_6726_11710# vbn_leak 0
C1878 a_5960_18120# pl_en 0.02047f
C1879 chain a_268_18120# 0.24897f
C1880 en a_4096_6334# 0.12981f
C1881 ta3 dl2 0.01049f
C1882 tb0 d1_bsel 0
C1883 a_6716_18120# pl_en 0.03359f
C1884 vbn_leak vreset 0.30126f
C1885 a_1892_3934# en 0.06606f
C1886 sel1 vsrc 0
C1887 sel0 a_268_18120# 0.02498f
C1888 vbn_ax m1_4870_3750# 0.42899f
C1889 ta1 m1_6390_10270# 0.03365f
C1890 sel2 a_2592_8154# 0.00142f
C1891 a_4588_13668# ta3 0.0397f
C1892 vbp_syn a_2920_17120# 0.17066f
C1893 chain a_2724_4480# 0.28322f
C1894 ta1 a_6716_18120# 0.0118f
C1895 a_4374_1028# vreset 0.10687f
C1896 sel1 tb0 0
C1897 m1_1704_10270# a_2592_8154# 0.06937f
C1898 sel0 a_2724_4480# 0.03695f
C1899 m1_1704_15350# dl2 0.45978f
C1900 vdd vbn_leak 1.31437f
C1901 m1_1946_330# vbn_ref 0
C1902 a_6716_2880# a_5960_2880# 0.30562f
C1903 m1_5122_15350# pl_en 0.00583f
C1904 vbn_ax el 0.63788f
C1905 m1_8050_16790# en 0
C1906 vsrcp dl1 0.01937f
C1907 vbn_ax ta0 0.07641f
C1908 vdd a_4374_1028# 0.65443f
C1909 hold vbn_ax 0.36904f
C1910 a_5204_2880# vbn_ref 0
C1911 en a_268_18120# 0.09937f
C1912 stb tb0 0
C1913 ta1 m1_5122_15350# 0.00867f
C1914 vbp_syn a_8436_16974# 0.01584f
C1915 m1_8050_16790# la2 0.01411f
C1916 vbn_prb a_5268_9138# 0
C1917 vbp_st a_5268_9138# 0.331f
C1918 a_672_19994# ta0 0.00188f
C1919 vbn_leak a_5524_5520# 0.00178f
C1920 m1_4870_3750# a_3272_6334# 0.00339f
C1921 a_268_18120# la2 1.0413f
C1922 hold a_672_19994# 0.25939f
C1923 spk vbn_leak 0.40097f
C1924 m1_7684_8010# d1 0.05237f
C1925 vsrc m1_7390_10270# 0
C1926 ta0 a_5204_15680# 0
C1927 vdd a_6672_14314# 0.53872f
C1928 a_1480_3834# a_1892_3934# 0.0054f
C1929 abus sel1 0.14531f
C1930 hold a_5204_15680# 0.17461f
C1931 vbp_st d1_bsel 0
C1932 a_5524_5520# a_4374_1028# 0
C1933 a_3956_5520# a_2536_2880# 0.00251f
C1934 spk a_4374_1028# 0.01902f
C1935 m1_7694_12850# a_5816_16974# 0.02301f
C1936 en a_2724_4480# 0.08232f
C1937 m1_8166_15130# dl2 0.01964f
C1938 a_2724_4480# la2 0
C1939 el a_3272_6334# 0.6809f
C1940 a_4588_13668# d1 0
C1941 la1 m1_2678_13030# 0
C1942 chain a_5268_9138# 0.01324f
C1943 d1 a_5960_2880# 0.00105f
C1944 mreset m1_4870_3750# 0
C1945 hold a_3272_6334# 0
C1946 a_488_19200# a_672_19994# 0.12046f
C1947 sel2 vsrc 0.02508f
C1948 vbn_prb sel1 0.04972f
C1949 vbp_st sel1 0.02043f
C1950 a_268_18120# a_5816_11894# 0.00151f
C1951 a_2920_17120# pl_en 0
C1952 vbn_leak m1_8050_11710# 0.00167f
C1953 a_6140_14314# vbn_leak 0.09284f
C1954 chain d1_bsel 0.01292f
C1955 a_1480_3834# a_268_18120# 0
C1956 a_3956_5520# m1_1704_2770# 0.04421f
C1957 a_268_18120# m1_690_15350# 0.00256f
C1958 mreset el 0.03652f
C1959 mreset hold 0.00469f
C1960 a_2724_4480# a_5816_11894# 0.13108f
C1961 abus m1_7390_10270# 0.11775f
C1962 m1_6726_16790# ta0 0.0053f
C1963 chain sel1 1.15859f
C1964 la1 abus 0.00127f
C1965 m1_6726_16790# hold 0.01148f
C1966 m1_2064_14170# el 0.04591f
C1967 m1_690_2500# el 0.03452f
C1968 a_1480_3834# a_2724_4480# 0.00875f
C1969 m1_7138_8020# m1_6390_10270# 0.04113f
C1970 hold m1_2064_14170# 0.19889f
C1971 en a_5268_9138# 0.05348f
C1972 a_8436_16974# pl_en 0.00569f
C1973 m1_5626_17750# ta3 0.01502f
C1974 ta2 vbn_leak 0.08795f
C1975 a_6140_14314# a_6672_14314# 0.16133f
C1976 a_268_18120# a_2180_13234# 0.38578f
C1977 d2 a_5816_16974# 0.12671f
C1978 m1_7684_8010# dl1 0.0275f
C1979 vbn_prb m1_7390_10270# 0.02723f
C1980 la1 vbn_prb 0.00435f
C1981 vbp_st m1_7390_10270# 0
C1982 vbn_ax a_6672_9234# 0
C1983 la1 vbp_st 0.18127f
C1984 a_8436_16974# ta1 0.02313f
C1985 m1_7390_15740# vreset 0
C1986 vbn_ax a_3212_19200# 0.02816f
C1987 stb chain 0.08153f
C1988 m1_7138_8930# pl_en 0.25786f
C1989 m1_6390_15350# a_5816_16974# 0.73898f
C1990 en d1_bsel 0.01693f
C1991 sel2 abus 0.1458f
C1992 m1_7684_8010# vsrcp 0
C1993 m1_2678_7950# hold 0.00305f
C1994 a_3212_19200# a_672_19994# 0.46346f
C1995 la2 d1_bsel 0
C1996 m1_8166_10050# vbn_leak 0.00709f
C1997 m1_7138_8930# ta1 0.01124f
C1998 sta a_4588_8588# 0.26817f
C1999 vbn_leak a_6140_9234# 0.33464f
C2000 vsrcp dl2 0.0084f
C2001 a_6672_14314# ta2 0.02766f
C2002 a_2536_2880# a_3272_6334# 0.30579f
C2003 en sel1 0.02293f
C2004 vdd m1_7390_15740# 0.2421f
C2005 la1 chain 0.00249f
C2006 sel2 vbp_st 0.02523f
C2007 sel2 vbn_prb 0.33821f
C2008 a_5816_11894# a_5268_9138# 0.26354f
C2009 a_4588_13668# vsrcp 0.16852f
C2010 sel1 la2 0.04378f
C2011 a_3956_5520# a_6716_2880# -0.05493f
C2012 m1_2702_380# a_3272_6334# 0
C2013 a_5204_10600# el 0
C2014 stb en 0.01947f
C2015 a_5204_10600# ta0 0
C2016 a_2920_12040# a_4588_8588# 0
C2017 mreset a_2536_2880# 0
C2018 a_5204_10600# hold 0.36072f
C2019 vbp_syn d2 0.42202f
C2020 m1_1704_2770# a_3272_6334# 0.54422f
C2021 ta0 m1_6390_10270# 0.18112f
C2022 a_5960_18120# ta0 0
C2023 m1_5626_17750# a_5204_18120# -0.06004f
C2024 stb la2 0.18387f
C2025 hold m1_6390_10270# 0.31642f
C2026 a_5960_18120# hold 0.16299f
C2027 m1_7694_12850# pl_en 0.07252f
C2028 a_6716_18120# ta0 0.03665f
C2029 sel2 sel0 3.94813f
C2030 m1_690_2500# a_2536_2880# 0
C2031 hold a_6716_18120# 0.42152f
C2032 vdd a_1780_15680# 0.05075f
C2033 en m1_7390_10270# 0.06985f
C2034 la1 en 0.11567f
C2035 vbn_ax ta3 0.08175f
C2036 ta3 vss 0.81431f
C2037 ta2 vss 0.46576f
C2038 ta1 vss 0.54734f
C2039 ta0 vss 0.42179f
C2040 tb3 vss 0.20729f
C2041 tb2 vss 0.08133f
C2042 tb1 vss 0.08133f
C2043 tb0 vss 0.09704f
C2044 a_2724_4480# vss 2.62743f
C2045 a_4374_1028# vss 1.23408f
C2046 la1 vss 1.50636f
C2047 a_3272_6334# vss 1.56919f
C2048 a_1780_15680# vss 0.08576f
C2049 a_5960_2880# vss 0.02838f
C2050 a_6716_2880# vss 0.55376f
C2051 m1_1704_15350# vss 0.35913f
C2052 vs vss 5.17458f
C2053 a_672_19994# vss 1.37624f
C2054 d1_bsel vss 0.96159f
C2055 d1 vss 5.84777f
C2056 hold vss 2.43379f
C2057 vbn_ax vss 3.26284f
C2058 a_5204_4080# vss 0.06029f
C2059 dl1 vss 1.08661f
C2060 m1_4870_3750# vss 0.20726f
C2061 a_6672_9234# vss 0.94985f
C2062 m1_2064_14170# vss -0.12087f
C2063 a_3956_5520# vss -0.36703f
C2064 a_1892_3934# vss 0.96836f
C2065 chain vss 1.72737f
C2066 a_6140_9234# vss 1.47096f
C2067 a_6716_18120# vss 0.12256f
C2068 m1_7390_10270# vss 0.76899f
C2069 a_3212_19200# vss -0.21006f
C2070 m1_8166_10050# vss 0.13813f
C2071 a_5204_10600# vss 0.02285f
C2072 m1_5100_10180# vss 0.84762f
C2073 a_2920_12040# vss -0.26121f
C2074 abus vss 3.70031f
C2075 sel0 vss 2.65426f
C2076 dl2 vss 1.21217f
C2077 m1_690_15350# vss 0.15801f
C2078 la2 vss 0.94149f
C2079 m1_6726_11710# vss -0.04812f
C2080 m1_8050_11710# vss -0.09048f
C2081 m1_6390_10270# vss 0.21885f
C2082 pl_en vss 1.56788f
C2083 a_5960_4080# vss 0.21213f
C2084 a_4096_6334# vss 1.02713f
C2085 spk vss 5.7863f
C2086 m1_7684_8010# vss 0.03046f
C2087 a_4448_4080# vss 0.01016f
C2088 a_5524_5520# vss -0.15457f
C2089 m1_7138_8020# vss 0.06962f
C2090 a_6672_14314# vss 1.09016f
C2091 a_6140_14314# vss 0.95276f
C2092 m1_2122_9086# vss -0.19176f
C2093 m1_6474_8020# vss 0.12079f
C2094 a_5816_11894# vss 2.07816f
C2095 a_1480_3834# vss 0.15674f
C2096 a_5268_9138# vss 1.03823f
C2097 vsrcp vss 3.2328f
C2098 a_5204_15680# vss 0.00462f
C2099 m1_7138_8930# vss 0.12605f
C2100 m1_2678_7950# vss 0.34717f
C2101 a_2592_8154# vss 3.12777f
C2102 m1_6726_16790# vss -0.0909f
C2103 m1_8050_16790# vss -0.09115f
C2104 vdd vss 80.99175f
C2105 m1_1946_330# vss 0.62558f
C2106 sel1 vss 0.94994f
C2107 m1_5122_15350# vss 1.18298f
C2108 a_2920_17120# vss -0.24359f
C2109 sta vss 1.66538f
C2110 m1_2702_380# vss 0.09106f
C2111 en vss 2.67072f
C2112 a_1780_18120# vss -0.01158f
C2113 m1_2122_6150# vss -0.09115f
C2114 m1_910_6150# vss -0.08335f
C2115 vbp_st vss 2.11249f
C2116 m1_6390_15350# vss 0.6574f
C2117 m1_1704_17750# vss 0.23972f
C2118 m1_690_17890# vss 0.04984f
C2119 a_1780_2880# vss 0.09143f
C2120 m1_2868_9480# vss -0.00986f
C2121 a_5816_16974# vss 2.02087f
C2122 m1_7694_12850# vss 0.47046f
C2123 m1_1704_2770# vss 0.51188f
C2124 m1_690_2500# vss 0.12436f
C2125 vbn_prb vss 4.08521f
C2126 a_4588_13668# vss 1.19251f
C2127 m1_7128_13020# vss -0.04212f
C2128 a_1780_10600# vss 0.05647f
C2129 mreset vss 2.27451f
C2130 m1_1704_10270# vss 0.53306f
C2131 m1_690_10190# vss 0.10548f
C2132 m1_6474_13030# vss -0.06665f
C2133 a_8436_16974# vss 1.08663f
C2134 m1_7128_14156# vss 0.01523f
C2135 m1_5626_2500# vss 0.28278f
C2136 a_5204_2880# vss 0.01903f
C2137 vbp_syn vss 1.07485f
C2138 a_728_3738# vss 0.44488f
C2139 vsrc vss 1.85205f
C2140 m1_2678_13030# vss 0.74194f
C2141 a_2536_18120# vss 0.05005f
C2142 stb vss 1.33376f
C2143 a_4588_8588# vss 1.54883f
C2144 sel2 vss 1.87469f
C2145 vreset vss -2.21299f
C2146 vbn_ref vss 1.22203f
C2147 m1_2220_12980# vss -0.02722f
C2148 d2 vss 4.20387f
C2149 a_2180_13234# vss 1.27062f
C2150 a_488_19200# vss 0.06476f
C2151 a_2536_2880# vss 0.7397f
C2152 m1_7390_15740# vss 0.51714f
C2153 m1_8166_15130# vss 0.20306f
C2154 a_5960_18120# vss 0.02673f
C2155 a_488_5520# vss 0.07008f
C2156 el vss 4.20776f
C2157 m1_5626_17750# vss 0.45828f
C2158 a_5204_18120# vss 0.01636f
C2159 a_268_18120# vss 1.69034f
C2160 vbn_leak vss 7.05229f
C2161 a_8248_5320# vss 0.57266f
.ends
