* NGSPICE file created from dend_d1.ext - technology: gf180mcuD

.subckt n_w4_l1 a_n188_n400# a_100_n400# a_n100_n444# VSUBS
X0 a_100_n400# a_n100_n444# a_n188_n400# VSUBS nfet_03v3 ad=1.76p pd=8.88u as=1.76p ps=8.88u w=4u l=1u
C0 a_n100_n444# a_100_n400# 0.08505f
C1 a_n100_n444# a_n188_n400# 0.08505f
C2 a_n188_n400# a_100_n400# 0.07756f
C3 a_100_n400# VSUBS 0.26859f
C4 a_n188_n400# VSUBS 0.26859f
.ends

.subckt n_w2_l4 a_400_n200# a_n400_n244# a_n488_n200# VSUBS
X0 a_400_n200# a_n400_n244# a_n488_n200# VSUBS nfet_03v3 ad=0.88p pd=4.88u as=0.88p ps=4.88u w=2u l=4u
C0 a_n400_n244# a_400_n200# 0.07019f
C1 a_n400_n244# a_n488_n200# 0.07019f
C2 a_n488_n200# a_400_n200# 0.01073f
C3 a_400_n200# VSUBS 0.41684f
C4 a_n488_n200# VSUBS 0.41684f
.ends

.subckt n_w1_l0p28 a_28_n100# a_n28_n144# a_n116_n100# VSUBS
X0 a_28_n100# a_n28_n144# a_n116_n100# VSUBS nfet_03v3 ad=0.44p pd=2.88u as=0.44p ps=2.88u w=1u l=0.28u
C0 a_n28_n144# a_28_n100# 0.00769f
C1 a_n28_n144# a_n116_n100# 0.00769f
C2 a_n116_n100# a_28_n100# 0.04256f
C3 a_28_n100# VSUBS 0.09911f
C4 a_n116_n100# VSUBS 0.09911f
.ends

.subckt p_w1_l0p28 w_n202_n230# a_28_n100# a_n28_n144# a_n116_n100# VSUBS
X0 a_28_n100# a_n28_n144# a_n116_n100# w_n202_n230# pfet_03v3 ad=0.44p pd=2.88u as=0.44p ps=2.88u w=1u l=0.28u
C0 w_n202_n230# a_28_n100# 0.01808f
C1 w_n202_n230# a_n116_n100# 0.01808f
C2 a_n116_n100# a_28_n100# 0.04256f
C3 w_n202_n230# a_n28_n144# 0.05841f
C4 a_n28_n144# a_28_n100# 0.00769f
C5 a_n28_n144# a_n116_n100# 0.00769f
C6 a_28_n100# VSUBS 0.0597f
C7 a_n116_n100# VSUBS 0.0597f
C8 w_n202_n230# VSUBS 0.55752f
.ends

.subckt p_w0p22_l1 a_100_n22# a_n100_n66# w_n278_n159# a_n192_n36# VSUBS
X0 a_100_n22# a_n100_n66# a_n192_n36# w_n278_n159# pfet_03v3 ad=0.1516p pd=1.64u as=0.1516p ps=1.64u w=0.22u l=1u
C0 w_n278_n159# a_100_n22# 0.00771f
C1 w_n278_n159# a_n100_n66# 0.13163f
C2 a_n100_n66# a_100_n22# 0.00509f
C3 w_n278_n159# a_n192_n36# 0.00771f
C4 a_n192_n36# a_100_n22# 0.00453f
C5 a_n192_n36# a_n100_n66# 0.00509f
C6 a_100_n22# VSUBS 0.05952f
C7 a_n192_n36# VSUBS 0.05952f
C8 w_n278_n159# VSUBS 0.53042f
.ends

.subckt n_w0p5_l1p5 a_150_n50# a_n238_n50# a_n150_n94# VSUBS
X0 a_150_n50# a_n150_n94# a_n238_n50# VSUBS nfet_03v3 ad=0.22p pd=1.88u as=0.22p ps=1.88u w=0.5u l=1.5u
C0 a_n150_n94# a_150_n50# 0.01269f
C1 a_n150_n94# a_n238_n50# 0.01269f
C2 a_n238_n50# a_150_n50# 0.00671f
C3 a_150_n50# VSUBS 0.17146f
C4 a_n238_n50# VSUBS 0.17146f
.ends

.subckt p_w2_l4 a_400_n200# a_n400_n244# w_n574_n330# a_n488_n200# VSUBS
X0 a_400_n200# a_n400_n244# a_n488_n200# w_n574_n330# pfet_03v3 ad=0.88p pd=4.88u as=0.88p ps=4.88u w=2u l=4u
C0 w_n574_n330# a_400_n200# 0.07409f
C1 w_n574_n330# a_n488_n200# 0.07409f
C2 a_n488_n200# a_400_n200# 0.01073f
C3 w_n574_n330# a_n400_n244# 0.42229f
C4 a_n400_n244# a_400_n200# 0.07019f
C5 a_n400_n244# a_n488_n200# 0.07019f
C6 a_400_n200# VSUBS 0.18936f
C7 a_n488_n200# VSUBS 0.18936f
C8 w_n574_n330# VSUBS 2.27304f
.ends

.subckt p_w1_l0p5 a_n138_n100# a_50_n100# a_n50_n144# w_n224_n230# VSUBS
X0 a_50_n100# a_n50_n144# a_n138_n100# w_n224_n230# pfet_03v3 ad=0.44p pd=2.88u as=0.44p ps=2.88u w=1u l=0.5u
C0 w_n224_n230# a_50_n100# 0.0205f
C1 w_n224_n230# a_n138_n100# 0.0205f
C2 a_n138_n100# a_50_n100# 0.03085f
C3 w_n224_n230# a_n50_n144# 0.07993f
C4 a_n50_n144# a_50_n100# 0.01275f
C5 a_n50_n144# a_n138_n100# 0.01275f
C6 a_50_n100# VSUBS 0.06546f
C7 a_n138_n100# VSUBS 0.06546f
C8 w_n224_n230# VSUBS 0.61824f
.ends

.subckt p_w1_l2 w_n374_n230# a_n288_n100# a_200_n100# a_n200_n144# VSUBS
X0 a_200_n100# a_n200_n144# a_n288_n100# w_n374_n230# pfet_03v3 ad=0.44p pd=2.88u as=0.44p ps=2.88u w=1u l=2u
C0 w_n374_n230# a_200_n100# 0.03135f
C1 w_n374_n230# a_n288_n100# 0.03135f
C2 a_n288_n100# a_200_n100# 0.01056f
C3 w_n374_n230# a_n200_n144# 0.22666f
C4 a_n200_n144# a_200_n100# 0.02905f
C5 a_n200_n144# a_n288_n100# 0.02905f
C6 a_200_n100# VSUBS 0.1047f
C7 a_n288_n100# VSUBS 0.1047f
C8 w_n374_n230# VSUBS 1.03224f
.ends

.subckt n_w0p5_l0p28 a_n28_n94# a_n116_n50# a_28_n50# VSUBS
X0 a_28_n50# a_n28_n94# a_n116_n50# VSUBS nfet_03v3 ad=0.22p pd=1.88u as=0.22p ps=1.88u w=0.5u l=0.28u
C0 a_n28_n94# a_28_n50# 0.00377f
C1 a_n28_n94# a_n116_n50# 0.00377f
C2 a_n116_n50# a_28_n50# 0.02085f
C3 a_28_n50# VSUBS 0.07987f
C4 a_n116_n50# VSUBS 0.07987f
.ends

.subckt n_w0p5_l0p5 a_n138_n50# a_50_n50# a_n50_n94# VSUBS
X0 a_50_n50# a_n50_n94# a_n138_n50# VSUBS nfet_03v3 ad=0.22p pd=1.88u as=0.22p ps=1.88u w=0.5u l=0.5u
C0 a_n50_n94# a_50_n50# 0.00625f
C1 a_n50_n94# a_n138_n50# 0.00625f
C2 a_n138_n50# a_50_n50# 0.01511f
C3 a_50_n50# VSUBS 0.09639f
C4 a_n138_n50# VSUBS 0.09639f
.ends

.subckt n_w4_l2 a_n288_n400# a_200_n400# a_n200_n444# VSUBS
X0 a_200_n400# a_n200_n444# a_n288_n400# VSUBS nfet_03v3 ad=1.76p pd=8.88u as=1.76p ps=8.88u w=4u l=2u
C0 a_n200_n444# a_200_n400# 0.11799f
C1 a_n200_n444# a_n288_n400# 0.11799f
C2 a_n288_n400# a_200_n400# 0.04287f
C3 a_200_n400# VSUBS 0.34365f
C4 a_n288_n400# VSUBS 0.34365f
.ends

.subckt n_w3p54_l3p54 a_354_n354# a_n354_n398# a_n442_n354# VSUBS
X0 a_354_n354# a_n354_n398# a_n442_n354# VSUBS nfet_03v3 ad=1.5576p pd=7.96u as=1.5576p ps=7.96u w=3.54u l=3.54u
C0 a_n354_n398# a_354_n354# 0.12189f
C1 a_n354_n398# a_n442_n354# 0.12189f
C2 a_n442_n354# a_354_n354# 0.02161f
C3 a_354_n354# VSUBS 0.44156f
C4 a_n442_n354# VSUBS 0.44156f
.ends

.subckt n_w0p5_l0p6 a_n148_n50# a_60_n50# a_n60_n94# VSUBS
X0 a_60_n50# a_n60_n94# a_n148_n50# VSUBS nfet_03v3 ad=0.22p pd=1.88u as=0.22p ps=1.88u w=0.5u l=0.6u
C0 a_n60_n94# a_60_n50# 0.00722f
C1 a_n60_n94# a_n148_n50# 0.00722f
C2 a_n148_n50# a_60_n50# 0.01345f
C3 a_60_n50# VSUBS 0.1039f
C4 a_n148_n50# VSUBS 0.1039f
.ends

.subckt n_w1_l0p5 a_n138_n100# a_50_n100# a_n50_n144# VSUBS
X0 a_50_n100# a_n50_n144# a_n138_n100# VSUBS nfet_03v3 ad=0.44p pd=2.88u as=0.44p ps=2.88u w=1u l=0.5u
C0 a_n50_n144# a_50_n100# 0.01275f
C1 a_n50_n144# a_n138_n100# 0.01275f
C2 a_n138_n100# a_50_n100# 0.03085f
C3 a_50_n100# VSUBS 0.11563f
C4 a_n138_n100# VSUBS 0.11563f
.ends

.subckt n_w0p5_l3 a_n388_n50# a_300_n50# a_n300_n94# VSUBS
X0 a_300_n50# a_n300_n94# a_n388_n50# VSUBS nfet_03v3 ad=0.22p pd=1.88u as=0.22p ps=1.88u w=0.5u l=3u
C0 a_n300_n94# a_300_n50# 0.01602f
C1 a_n300_n94# a_n388_n50# 0.01602f
C2 a_n388_n50# a_300_n50# 0.00348f
C3 a_300_n50# VSUBS 0.28406f
C4 a_n388_n50# VSUBS 0.28406f
.ends

.subckt n_w1_l1 a_n188_n100# a_100_n100# a_n100_n144# VSUBS
X0 a_100_n100# a_n100_n144# a_n188_n100# VSUBS nfet_03v3 ad=0.44p pd=2.88u as=0.44p ps=2.88u w=1u l=1u
C0 a_n100_n144# a_100_n100# 0.02094f
C1 a_n100_n144# a_n188_n100# 0.02094f
C2 a_n188_n100# a_100_n100# 0.0191f
C3 a_100_n100# VSUBS 0.15316f
C4 a_n188_n100# VSUBS 0.15316f
.ends

.subckt p_w0p22_l4 a_n400_n66# a_n492_n36# w_n578_n159# a_400_n22# VSUBS
X0 a_400_n22# a_n400_n66# a_n492_n36# w_n578_n159# pfet_03v3 ad=0.1516p pd=1.64u as=0.1516p ps=1.64u w=0.22u l=4u
C0 w_n578_n159# a_400_n22# 0.0077f
C1 w_n578_n159# a_n400_n66# 0.43266f
C2 a_n400_n66# a_400_n22# 0.00842f
C3 w_n578_n159# a_n492_n36# 0.0077f
C4 a_n492_n36# a_400_n22# 0.00123f
C5 a_n492_n36# a_n400_n66# 0.00842f
C6 a_400_n22# VSUBS 0.13421f
C7 a_n492_n36# VSUBS 0.13421f
C8 w_n578_n159# VSUBS 1.10282f
.ends

.subckt n_w1_l4 a_n488_n100# a_400_n100# a_n400_n144# VSUBS
X0 a_400_n100# a_n400_n144# a_n488_n100# VSUBS nfet_03v3 ad=0.44p pd=2.88u as=0.44p ps=2.88u w=1u l=4u
C0 a_n400_n144# a_400_n100# 0.03474f
C1 a_n400_n144# a_n488_n100# 0.03474f
C2 a_n488_n100# a_400_n100# 0.00531f
C3 a_400_n100# VSUBS 0.37836f
C4 a_n488_n100# VSUBS 0.37836f
.ends

.subckt n_w2_l2 a_n288_n200# a_200_n200# a_n200_n244# VSUBS
X0 a_200_n200# a_n200_n244# a_n288_n200# VSUBS nfet_03v3 ad=0.88p pd=4.88u as=0.88p ps=4.88u w=2u l=2u
C0 a_n200_n244# a_200_n200# 0.0587f
C1 a_n200_n244# a_n288_n200# 0.0587f
C2 a_n288_n200# a_200_n200# 0.02133f
C3 a_200_n200# VSUBS 0.2667f
C4 a_n288_n200# VSUBS 0.2667f
.ends

.subckt n_w0p22_l2 a_200_n22# a_n200_n66# a_n292_n36# VSUBS
X0 a_200_n22# a_n200_n66# a_n292_n36# VSUBS nfet_03v3 ad=0.1516p pd=1.64u as=0.1516p ps=1.64u w=0.22u l=2u
C0 a_n292_n36# a_200_n22# 0.00245f
C1 a_n292_n36# a_n200_n66# 0.00705f
C2 a_n200_n66# a_200_n22# 0.00705f
C3 a_200_n22# VSUBS 0.20767f
C4 a_n292_n36# VSUBS 0.20767f
.ends

.subckt n_w7p07_l7p07 a_707_n707# a_n795_n707# a_n707_n751# VSUBS
X0 a_707_n707# a_n707_n751# a_n795_n707# VSUBS nfet_03v3 ad=3.1108p pd=15.02u as=3.1108p ps=15.02u w=7.07u l=7.07u
C0 a_n707_n751# a_707_n707# 0.27012f
C1 a_n707_n751# a_n795_n707# 0.27012f
C2 a_n795_n707# a_707_n707# 0.0212f
C3 a_707_n707# VSUBS 0.84237f
C4 a_n795_n707# VSUBS 0.84237f
.ends

.subckt dend_d1 vdd vss el vbn_leak vsrc vsrcp vbp_st vbn_ax vbn_ref vreset vbn_prb
+ abus sel0 sel2 mreset spk en pl_en chain sel1 d1_bsel sta stb hold ta0 ta1 ta2 ta3
+ tb0 tb1 tb2 tb3 vbp_syn d1 d2 vs
XXL1_XM2 a_2492_11000# a_3048_11000# a_3048_11000# vss n_w4_l1
XXEP_XS a_8248_5320# vbn_leak vss vss n_w2_l4
XXS_XL_XMT m1_2722_2630# vbn_leak vss vss n_w2_l4
XXWS a_268_18520# a_1892_3934# vs vss n_w1_l0p28
XXS_XD_Xi4_XP vdd spk a_3272_6334# vdd vss p_w1_l0p28
XXP1_XDT_XK a_6672_9234# a_5524_11840# vdd vdd vss p_w0p22_l1
XXR1_XP0 vdd a_3048_11000# ta0 m1_6494_5850# vss p_w1_l0p28
XXR1_XR2 m1_4282_6970# m1_2712_6970# vbn_leak vss n_w0p5_l1p5
XXA2_XA_XP2 a_3048_18520# a_488_19360# vdd vdd vss p_w2_l4
XXY2_XQB vdd vss vss m1_2678_13100# vss p_w1_l0p28
XXS_XL_XM1 a_488_5520# a_824_3120# el vss n_w4_l1
XXA2_XA_XMT m1_1046_17880# vbn_ax vss vss n_w2_l4
XXA2_XA_XHO vdd d2 hold a_3048_18520# vss p_w1_l0p28
XXR1_XP1 vdd a_3048_11000# ta1 m1_5286_6830# vss p_w1_l0p28
XXR1_XR3 m1_5942_6980# m1_4282_6970# vbn_leak vss n_w0p5_l1p5
XXT1_XME m1_7702_15650# en m1_8466_15350# vss n_w1_l0p28
XXS_XL_XM2 a_2492_3120# a_3048_3120# a_3048_3120# vss n_w4_l1
XXP2_XDT_XNE m1_6940_14170# a_5524_16920# vsrcp vss n_w1_l0p28
XXS_XD_XPI m1_910_6150# a_728_3738# vs vdd vss p_w1_l0p5
XXR1_XP2 vdd a_3048_11000# ta2 m1_3676_6970# vss p_w1_l0p28
XXEP_XPD vdd vdd a_8248_5320# a_8248_5320# vss p_w1_l2
XXR1_XN0 ta0 m1_6494_5850# a_488_12040# vss n_w0p5_l0p28
XXA2_XA_XM1 a_488_19360# a_824_18520# a_268_18520# vss n_w4_l1
XXY2_XNA a_2180_13234# d2 m1_2862_14560# vss n_w0p5_l0p28
XXS_XR_XNR a_6594_420# vbn_ref vss vss n_w2_l4
XXS_XR_XSW vreset vs a_6594_420# vss n_w0p5_l0p5
XXT1_XMF m1_7702_15650# vdd d2 vss n_w4_l2
XXT2_XSW m1_7702_10190# sel2 abus vss n_w1_l0p28
XXP2_XTP vdd vdd a_4588_13668# a_5524_16920# vss p_w1_l2
XXS_XL_XD2_a m1_2722_2630# a_2492_3120# a_2492_3120# vss n_w4_l1
XXR1_XP3 vdd a_3048_11000# ta3 m1_2062_6980# vss p_w1_l0p28
XXP1_XCT_XC vss a_4588_8588# vss vss n_w3p54_l3p54
XXR1_XN1 ta1 m1_5286_6830# a_488_12040# vss n_w0p5_l0p28
XXB_XP1 vdd a_2592_8154# d1_bsel stb vss p_w1_l0p28
XXA2_XA_XM2 a_2492_18520# a_3048_18520# a_3048_18520# vss n_w4_l1
XXY2_XNB vss d2 m1_2678_13100# vss n_w0p5_l0p28
XXR2_XRA vss m1_2470_19900# vbn_leak vss n_w0p5_l0p6
XXP2_XDT_XPI m1_6716_16790# a_5268_14218# d2 vdd vss p_w1_l0p5
XXS_XL_XD2_b a_2492_3120# m1_2722_2630# a_2492_3120# vss n_w4_l1
XXS_XD_XNI vsrc a_728_3738# vs vss n_w1_l0p5
XXR1_XL0 m1_5942_6980# m1_6494_5850# vbn_leak vss n_w0p5_l3
XXR1_XLT m1_5942_6980# vdd vbn_leak vss n_w0p5_l3
XXR1_XN2 ta2 m1_3676_6970# a_488_12040# vss n_w0p5_l0p28
XXY1_XWA m1_2236_8010# vbp_syn vdd m1_2112_9090# vss p_w2_l4
XXB_XP2 vdd a_2180_13234# a_672_20034# stb vss p_w1_l0p28
XXR2_XRB m1_2470_19900# m1_2956_19890# vbn_leak vss n_w0p5_l0p6
XXP2_XDT_XNH m1_6940_14170# a_5268_14218# d2 vss n_w1_l1
XXR1_XL1 m1_4282_6970# m1_5286_6830# vbn_leak vss n_w0p5_l3
XXR1_XN3 ta3 m1_2062_6980# a_488_12040# vss n_w0p5_l0p28
XXB_XN1 a_672_20034# stb a_2592_8154# vss n_w0p5_l0p28
XXY1_XWB m1_2668_7940# vbp_syn vdd m1_2112_9090# vss p_w2_l4
XXP2_XDT_XNI vsrcp a_5268_14218# d2 vss n_w1_l0p5
XXP1_XDT_XQ a_6140_9234# vdd vdd a_6672_9234# vss p_w0p22_l4
XXP2_XTS a_4588_13668# a_5524_16920# m1_6494_13030# vss n_w1_l0p28
XXR1_XL2 m1_2712_6970# m1_3676_6970# vbn_leak vss n_w0p5_l3
XXB_XN2 d1_bsel stb a_2180_13234# vss n_w0p5_l0p28
XXP2_XDT_XK a_6672_14314# a_5524_16920# vdd vdd vss p_w0p22_l1
XXA1_XB_XD2_a m1_4882_3700# a_6328_4480# a_6328_4480# vss n_w4_l1
XXR1_XL3 m1_1080_6970# m1_2062_6980# vbn_leak vss n_w0p5_l3
XXY2_XPH vdd vdd m1_2112_14220# hold vss p_w1_l2
XXP1_XTI vss m1_6494_7910# vbn_leak vss n_w1_l4
XXA1_XB_XD2_b a_6328_4480# m1_4882_3700# a_6328_4480# vss n_w4_l1
XXA1_XA_XD2_a m1_7206_2340# a_6984_3120# a_6984_3120# vss n_w4_l1
XXMR mreset a_6594_420# vdd vss n_w0p5_l0p28
XXP2_XS1 m1_7158_13030# m1_5190_15350# a_5524_16920# vss n_w1_l1
XXA1_XA_XD2_b a_6984_3120# m1_7206_2340# a_6984_3120# vss n_w4_l1
XXP2_XCT_XC vss a_4588_13668# vss vss n_w3p54_l3p54
XXT0_XMB vss m1_2708_380# vbn_prb vss n_w2_l2
XXP2_XS2 m1_7702_12990# m1_7158_13030# a_4588_13668# vss n_w1_l1
XXP2_XDT_XON a_6672_14314# vss a_5524_16920# vss n_w0p5_l0p28
XXY1_XQA vdd vss sta m1_2236_8010# vss p_w1_l0p28
XXP2_XOP1 a_2800_17120# a_2800_17120# vdd vdd vss p_w2_l4
XXEP_XPM vdd vdd a_3136_4480# a_8248_5320# vss p_w1_l2
XXP2_XS3 m1_6968_15350# m1_7702_12990# pl_en vss n_w1_l1
XXP1_XDT_XNE m1_7150_9086# a_5524_11840# vsrcp vss n_w1_l0p28
XXY1_XQB vdd vss a_2592_8154# m1_2668_7940# vss p_w1_l0p28
XXP2_XOP2 a_5516_15680# a_2800_17120# vdd vdd vss p_w2_l4
XXP2_XDT_XOP vdd a_5524_16920# a_6672_14314# vdd vss p_w1_l0p28
XXS_XD_XPS vdd vdd m1_910_6150# vbp_st vss p_w1_l2
XXS_XD_XS2 vdd vdd m1_2122_6150# vbp_st vss p_w1_l2
XXP2_XDT_XQ a_6140_14314# vdd vdd a_6672_14314# vss p_w0p22_l4
XXT0_XME m1_1968_380# en m1_2708_380# vss n_w1_l0p28
XXP1_XDT_XPI m1_6716_11710# a_5268_9138# d1 vdd vss p_w1_l0p5
XXS_XD_XS3 vdd vdd m1_2792_6140# vbp_st vss p_w1_l2
XXY1_XNA sta d1 m1_2236_8010# vss n_w0p5_l0p28
XXP2_XOM1 a_2800_17120# m1_5190_15350# a_3136_4480# vss n_w2_l2
XXT1_XSW m1_7702_15650# sel1 abus vss n_w1_l0p28
XXT0_XMF m1_1968_380# vdd vs vss n_w4_l2
XXP2_XDT_XS2 vdd vdd m1_7930_16790# vbp_st vss p_w1_l2
XXP2_XDT_XPS vdd vdd m1_6716_16790# vbp_st vss p_w1_l2
XXP1_XTP vdd vdd a_4588_8588# a_5524_11840# vss p_w1_l2
XXP1_XDT_XNH m1_7150_9086# a_5268_9138# d1 vss n_w1_l1
XXY1_XNB a_2592_8154# d1 m1_2668_7940# vss n_w0p5_l0p28
XXP2_XOM2 m1_5190_15350# a_5516_15680# a_5516_15680# vss n_w2_l2
XXP2_XDT_XS3 vdd vdd m1_9090_16790# vbp_st vss p_w1_l2
XXP2_XHP vdd d2 hold a_5516_15680# vss p_w1_l0p28
XXL2_XD1_a a_824_16080# m1_2712_15340# a_824_16080# vss n_w4_l1
XXP1_XDT_XNI vsrcp a_5268_9138# d1 vss n_w1_l0p5
XXS_XD_XP2 vdd a_1480_3834# a_728_3738# m1_2122_6150# vss p_w1_l0p28
XXR1_XRA vss m1_642_6980# vbn_leak vss n_w0p5_l0p6
XXB_XD1 d1_bsel vss a_2592_8154# vss n_w0p5_l0p28
XXA2_XB_XD1_a a_5316_18520# m1_7206_18030# a_5316_18520# vss n_w4_l1
XXL2_XD1_b m1_2712_15340# a_824_16080# a_824_16080# vss n_w4_l1
XXS_XD_XP3 vdd a_3272_6334# a_1480_3834# m1_2792_6140# vss p_w1_l0p28
XXR1_XRB m1_642_6980# m1_1080_6970# vbn_leak vss n_w0p5_l0p6
XXB_XD2 a_672_20034# vss a_2180_13234# vss n_w0p5_l0p28
XXL1_XD1_a a_824_11000# m1_1046_10270# a_824_11000# vss n_w4_l1
XXS_XD_XK a_3272_6334# spk vdd vdd vss p_w0p22_l1
XXA2_XB_XD1_b m1_7206_18030# a_5316_18520# a_5316_18520# vss n_w4_l1
XXA2_XA_XD1_a a_824_18520# m1_1046_17880# a_824_18520# vss n_w4_l1
XXP2_XDT_XP2 vdd a_6140_14314# a_5268_14218# m1_7930_16790# vss p_w1_l0p28
XXS_XD_XN2 a_1480_3834# a_728_3738# vsrc vss n_w0p22_l2
XXP1_XTS a_4588_8588# a_5524_11840# m1_6494_7910# vss n_w1_l0p28
XXL1_XD1_b m1_1046_10270# a_824_11000# a_824_11000# vss n_w4_l1
XXA1_XB_XP1 a_6680_5520# a_6680_5520# vdd vdd vss p_w2_l4
XXP2_XDT_XP3 vdd a_6672_14314# a_6140_14314# m1_9090_16790# vss p_w1_l0p28
XXS_XD_XN3 a_1480_3834# vsrc a_3272_6334# vss n_w0p5_l0p28
XXA2_XA_XD1_b m1_1046_17880# a_824_18520# a_824_18520# vss n_w4_l1
XXY1_XPH vdd vdd m1_2112_9090# hold vss p_w1_l2
XXA1_XB_XP2 a_6884_4480# a_6680_5520# vdd vdd vss p_w2_l4
XXY2_XHL vdd d2 hold a_3048_16080# vss p_w1_l0p28
XXP2_XDT_XN2 a_6140_14314# a_5268_14218# vsrcp vss n_w0p22_l2
XXP1_XDT_XON a_6672_9234# vss a_5524_11840# vss n_w0p5_l0p28
XXWC a_268_18520# chain d1 vss n_w1_l0p28
XXA1_XB_XMT m1_4882_3700# vbn_ax vss vss n_w2_l4
XXA1_XB_XHO vdd d1 hold a_6884_4480# vss p_w1_l0p28
XXP2_XDT_XN3 a_6140_14314# vsrcp a_6672_14314# vss n_w0p5_l0p28
XXY2_XMR vss vss vdd vss n_w0p5_l0p28
XXP1_XS1 m1_7158_7910# m1_5432_10260# a_5524_11840# vss n_w1_l1
XXL2_XP1 a_488_17120# a_488_17120# vdd vdd vss p_w2_l4
XXA1_XB_XM1 a_6680_5520# a_4660_4480# vs vss n_w4_l1
XXP1_XDT_XOP vdd a_5524_11840# a_6672_9234# vdd vss p_w1_l0p28
XXS_XR_XPC vdd a_6594_420# a_4096_6334# vdd vss p_w1_l0p28
XXP1_XS2 m1_7684_7940# m1_7158_7910# a_4588_8588# vss n_w1_l1
XXL2_XP2 a_3048_16080# a_488_17120# vdd vdd vss p_w2_l4
XXP1_XOP1 a_2800_12040# a_2800_12040# vdd vdd vss p_w2_l4
XXS_XR_Xi_XN spk vss a_4096_6334# vss n_w0p5_l0p28
XXA1_XB_XM2 a_6328_4480# a_6884_4480# a_6884_4480# vss n_w4_l1
XXP1_XS3 m1_6968_10190# m1_7684_7940# pl_en vss n_w1_l1
XXP2_XOTA vss m1_6968_15350# vbn_leak vss n_w4_l2
XXL2_XMT m1_2712_15340# vbn_leak vss vss n_w2_l4
XXS_XL_XD1_a a_824_3120# m1_2722_2630# a_824_3120# vss n_w4_l1
XXP1_XOP2 a_5516_10600# a_2800_12040# vdd vdd vss p_w2_l4
XXC1_XC vss vss d1 vss n_w7p07_l7p07
XXP1_XDT_XS2 vdd vdd m1_7930_11710# vbp_st vss p_w1_l2
XXP1_XDT_XPS vdd vdd m1_6716_11710# vbp_st vss p_w1_l2
XXP2_XOTB m1_6968_15350# vss vbn_leak vss n_w4_l2
XXL2_XM1 a_488_17120# a_824_16080# el vss n_w4_l1
XXS_XL_XD1_b m1_2722_2630# a_824_3120# a_824_3120# vss n_w4_l1
XXT2_XMB vss m1_8466_10270# vbn_prb vss n_w2_l2
XXS_XR_Xi_XP vdd a_4096_6334# spk vdd vss p_w1_l0p28
XXR2_XR1 m1_4568_19890# m1_2956_19890# vbn_leak vss n_w0p5_l1p5
XXA2_XB_XP1 a_3212_19360# a_3212_19360# vdd vdd vss p_w2_l4
XXP1_XDT_XS3 vdd vdd m1_9090_11710# vbp_st vss p_w1_l2
XXL2_XM2 a_2492_16080# a_3048_16080# a_3048_16080# vss n_w4_l1
XXP1_XOM1 a_2800_12040# m1_5432_10260# a_3136_4480# vss n_w2_l2
XXT0_XSW m1_1968_380# sel0 abus vss n_w1_l0p28
XXR2_XR2 m1_6190_19900# m1_4568_19890# vbn_leak vss n_w0p5_l1p5
XXR2_XP0 vdd a_3048_16080# tb0 m1_8326_19030# vss p_w1_l0p28
XXA2_XB_XP2 a_7540_18520# a_3212_19360# vdd vdd vss p_w2_l4
XXP1_XOM2 m1_5432_10260# a_5516_10600# a_5516_10600# vss n_w2_l2
XXR2_XR3 m1_7790_19900# m1_6190_19900# vbn_leak vss n_w0p5_l1p5
XXR2_XP1 vdd a_3048_16080# tb1 m1_7130_19630# vss p_w1_l0p28
XXA2_XB_XMT m1_7206_18030# vbn_ax vss vss n_w2_l4
XXA2_XB_XHO vdd a_268_18520# hold a_7540_18520# vss p_w1_l0p28
XXP1_XDT_XP2 vdd a_6140_9234# a_5268_9138# m1_7930_11710# vss p_w1_l0p28
XXP1_XHP vdd d1 hold a_5516_10600# vss p_w1_l0p28
XXT2_XME m1_7702_10190# en m1_8466_10270# vss n_w1_l0p28
XXA1_XB_XD1_a a_4660_4480# m1_4882_3700# a_4660_4480# vss n_w4_l1
XXR2_XN0 tb0 m1_8326_19030# a_488_17120# vss n_w0p5_l0p28
XXR2_XP2 vdd a_3048_16080# tb2 m1_5504_19890# vss p_w1_l0p28
XXA2_XB_XM1 a_3212_19360# a_5316_18520# d2 vss n_w4_l1
XXP1_XDT_XP3 vdd a_6672_9234# a_6140_9234# m1_9090_11710# vss p_w1_l0p28
XXA1_XB_XD1_b m1_4882_3700# a_4660_4480# a_4660_4480# vss n_w4_l1
XXT2_XMF m1_7702_10190# vdd d1 vss n_w4_l2
XXA1_XA_XD1_a a_5316_3120# m1_7206_2340# a_5316_3120# vss n_w4_l1
XXR2_XN1 tb1 m1_7130_19630# a_488_17120# vss n_w0p5_l0p28
XXR2_XP3 vdd a_3048_16080# tb3 m1_3902_19900# vss p_w1_l0p28
XXA2_XB_XM2 a_6984_18520# a_7540_18520# a_7540_18520# vss n_w4_l1
XXP1_XDT_XN2 a_6140_9234# a_5268_9138# vsrcp vss n_w0p22_l2
XXI_XN chain vss a_1892_3934# vss n_w0p5_l0p28
XXR2_XLT m1_7790_19900# vdd vbn_leak vss n_w0p5_l3
XXR2_XL0 m1_7790_19900# m1_8326_19030# vbn_leak vss n_w0p5_l3
XXR2_XN2 tb2 m1_5504_19890# a_488_17120# vss n_w0p5_l0p28
XXA1_XA_XD1_b m1_7206_2340# a_5316_3120# a_5316_3120# vss n_w4_l1
XXA1_XA_XP1 a_2800_5520# a_2800_5520# vdd vdd vss p_w2_l4
XXY2_XWA m1_2862_14560# vbp_syn vdd m1_2112_14220# vss p_w2_l4
XXP1_XDT_XN3 a_6140_9234# vsrcp a_6672_9234# vss n_w0p5_l0p28
XXA1_XA_XP2 a_7540_3120# a_2800_5520# vdd vdd vss p_w2_l4
XXR2_XL1 m1_6190_19900# m1_7130_19630# vbn_leak vss n_w0p5_l3
XXB_XI_XN d1_bsel vss a_672_20034# vss n_w0p5_l0p28
XXR2_XN3 tb3 m1_3902_19900# a_488_17120# vss n_w0p5_l0p28
XXY2_XWB m1_2678_13100# vbp_syn vdd m1_2112_14220# vss p_w2_l4
XXY1_XHL vdd d1 hold a_3048_11000# vss p_w1_l0p28
XXEP_XN el a_3136_4480# a_3136_4480# vss n_w4_l1
XXS_XHL vdd vs hold a_3048_3120# vss p_w1_l0p28
XXR2_XL2 m1_4568_19890# m1_5504_19890# vbn_leak vss n_w0p5_l3
XXA1_XA_XMT m1_7206_2340# vbn_ax vss vss n_w2_l4
XXA1_XA_XHO vdd vs hold a_7540_3120# vss p_w1_l0p28
XXI_XP vdd a_1892_3934# chain vdd vss p_w1_l0p28
XXY1_XMR vss vss vdd vss n_w0p5_l0p28
XXL2_XD2_a m1_2712_15340# a_2492_16080# a_2492_16080# vss n_w4_l1
XXL1_XP1 a_488_12040# a_488_12040# vdd vdd vss p_w2_l4
XXA1_XA_XM1 a_2800_5520# a_5316_3120# d1 vss n_w4_l1
XXR2_XL3 m1_2956_19890# m1_3902_19900# vbn_leak vss n_w0p5_l3
XXB_XI_XP vdd a_672_20034# d1_bsel vdd vss p_w1_l0p28
XXS_XC_XC vss vss vs vss n_w7p07_l7p07
XXA2_XB_XD2_a m1_7206_18030# a_6984_18520# a_6984_18520# vss n_w4_l1
XXP2_XTI vss m1_6494_13030# vbn_leak vss n_w1_l4
XXL2_XD2_b a_2492_16080# m1_2712_15340# a_2492_16080# vss n_w4_l1
XXL1_XP2 a_3048_11000# a_488_12040# vdd vdd vss p_w2_l4
XXL1_XD2_a m1_1046_10270# a_2492_11000# a_2492_11000# vss n_w4_l1
XXA1_XA_XM2 a_6984_3120# a_7540_3120# a_7540_3120# vss n_w4_l1
XXA2_XB_XD2_b a_6984_18520# m1_7206_18030# a_6984_18520# vss n_w4_l1
XXA2_XA_XD2_a m1_1046_17880# a_2492_18520# a_2492_18520# vss n_w4_l1
XXP1_XOTA vss m1_6968_10190# vbn_leak vss n_w4_l2
XXL1_XMT m1_1046_10270# vbn_leak vss vss n_w2_l4
XXL1_XD2_b a_2492_11000# m1_1046_10270# a_2492_11000# vss n_w4_l1
XXS_XD_Xi4_XN a_3272_6334# vss spk vss n_w0p5_l0p28
XXS_XL_XP1 a_488_5520# a_488_5520# vdd vdd vss p_w2_l4
XXA2_XA_XD2_b a_2492_18520# m1_1046_17880# a_2492_18520# vss n_w4_l1
XXP1_XOTB m1_6968_10190# vss vbn_leak vss n_w4_l2
XXL1_XM1 a_488_12040# a_824_11000# el vss n_w4_l1
XXT1_XMB vss m1_8466_15350# vbn_prb vss n_w2_l2
XXS_XL_XP2 a_3048_3120# a_488_5520# vdd vdd vss p_w2_l4
XXY2_XQA vdd vss a_2180_13234# m1_2862_14560# vss p_w1_l0p28
XXC2_XC vss vss d2 vss n_w7p07_l7p07
XXS_XR_XCR_XC vss a_6594_420# vss vss n_w3p54_l3p54
XXR1_XR1 m1_2712_6970# m1_1080_6970# vbn_leak vss n_w0p5_l1p5
XXA2_XA_XP1 a_488_19360# a_488_19360# vdd vdd vss p_w2_l4
C0 m1_9090_11710# a_6672_9234# 0.02583f
C1 m1_2470_19900# d1_bsel 0.01201f
C2 a_4588_8588# m1_7150_9086# 0
C3 a_488_12040# el 1.77828f
C4 abus vbn_prb 2.30398f
C5 m1_2862_14560# el 0.07504f
C6 m1_4568_19890# a_3212_19360# 0.01197f
C7 a_6680_5520# m1_2792_6140# 0.21984f
C8 vs a_7540_3120# 0.31376f
C9 a_3136_4480# a_5524_11840# 0.02893f
C10 m1_2112_9090# sta 0.27888f
C11 a_3136_4480# ta2 0.15188f
C12 a_4588_8588# m1_5942_6980# 0
C13 m1_5190_15350# d1 0
C14 a_3048_18520# a_672_20034# 0.00211f
C15 a_3272_6334# mreset 0.44828f
C16 vbn_leak a_4660_4480# 0
C17 vbp_st a_6328_4480# 0.02605f
C18 d2 a_268_18520# 0.58022f
C19 spk vreset 0.43172f
C20 m1_4882_3700# mreset 0
C21 m1_6494_5850# a_8248_5320# 0.0983f
C22 sta m1_6494_13030# 0.00958f
C23 a_7540_18520# a_2180_13234# 0.00452f
C24 tb2 ta1 0
C25 spk a_2800_5520# 0.34673f
C26 m1_2112_9090# hold 0.0122f
C27 a_488_17120# vsrc 0
C28 vdd m1_6494_5850# 1.07669f
C29 ta0 a_5524_11840# 0.04367f
C30 a_5268_14218# chain 0.00715f
C31 ta0 ta2 0.04392f
C32 m1_2112_9090# m1_1046_10270# 0.00126f
C33 a_2800_12040# d1 0.06075f
C34 sta a_6140_14314# 0.04575f
C35 sel1 m1_6968_15350# 0.15492f
C36 m1_5504_19890# stb 0.01469f
C37 a_3048_16080# m1_6190_19900# 0.00329f
C38 a_4660_4480# el 0.16288f
C39 a_6680_5520# vbp_st 0.27221f
C40 vdd d1_bsel 0.61589f
C41 a_4096_6334# vbn_leak 0.10837f
C42 ta3 m1_7702_12990# 0.00665f
C43 m1_6494_13030# a_6672_14314# 0
C44 vsrc tb0 0
C45 vbn_ax d1_bsel 0.09866f
C46 vbn_ref a_5316_3120# 0.0012f
C47 hold m1_6494_13030# 0.00122f
C48 ta1 m1_7206_18030# 0.04016f
C49 a_3048_11000# chain 0.08597f
C50 ta2 a_5524_11840# 0.03673f
C51 hold a_6140_14314# 0.02623f
C52 a_4096_6334# el 0.0745f
C53 sel1 a_5524_16920# 0.0115f
C54 a_6140_14314# a_6672_14314# 0.45916f
C55 a_2800_5520# en 0.01822f
C56 d1 m1_2062_6980# 0.01756f
C57 m1_7930_16790# d2 0.0033f
C58 a_3048_18520# m1_1046_17880# 0.07727f
C59 a_7540_18520# pl_en 0.00945f
C60 spk a_6328_4480# 0
C61 ta3 m1_6940_14170# 0.01551f
C62 sel0 vbn_prb 0.32478f
C63 a_3136_4480# a_8248_5320# 0.27617f
C64 m1_7158_7910# en 0
C65 a_3048_3120# hold 0.00542f
C66 vbp_st d2 0.22999f
C67 m1_4568_19890# vbn_leak 0.2722f
C68 a_4588_8588# a_488_12040# 0.00482f
C69 vdd a_3136_4480# 1.2828f
C70 abus a_268_18520# 0.07878f
C71 a_6680_5520# spk 0.09173f
C72 m1_9090_16790# a_488_17120# 0
C73 a_7540_18520# m1_8326_19030# 0
C74 vbn_ax a_3136_4480# 0.09586f
C75 a_5268_14218# m1_6968_15350# 0.0764f
C76 en a_6328_4480# 0.04505f
C77 vsrcp a_5268_9138# 0.44928f
C78 ta0 a_8248_5320# 0
C79 vdd ta0 0.72756f
C80 vbn_ax ta0 0.00354f
C81 a_6594_420# m1_2722_2630# 0.10127f
C82 a_6680_5520# en 0.04663f
C83 a_5268_14218# a_5524_16920# 0.09837f
C84 a_824_18520# a_268_18520# 0.39262f
C85 m1_7206_2340# vbn_prb 0.16693f
C86 ta2 a_8248_5320# 0
C87 ta3 m1_7684_7940# 0.02408f
C88 vs m1_4282_6970# 0.00159f
C89 vdd a_5524_11840# 1.01995f
C90 a_824_16080# a_2180_13234# 0.11888f
C91 vdd ta2 0.22322f
C92 d1_bsel a_672_20034# 0.54864f
C93 m1_5504_19890# m1_6190_19900# 0.1572f
C94 chain a_6984_18520# 0
C95 stb m1_7206_18030# 0
C96 vbn_ax ta2 0.00737f
C97 sta vbp_syn 0.39828f
C98 a_6140_9234# sel2 0.00573f
C99 a_3048_11000# a_5524_16920# 0
C100 m1_7790_19900# m1_6190_19900# -0.00611f
C101 abus m1_2708_380# 0.04074f
C102 a_2492_3120# m1_2722_2630# 0.38763f
C103 vbp_st abus 0.1774f
C104 vs a_1480_3834# 0.01485f
C105 a_3048_11000# a_6140_9234# 0.05047f
C106 a_4588_13668# m1_7930_11710# 0
C107 a_2592_8154# m1_7702_12990# 0.0169f
C108 a_4660_4480# a_7540_3120# 0.1888f
C109 m1_2062_6980# m1_2236_8010# 0
C110 a_7540_18520# a_268_18520# 0.50127f
C111 en d2 0.26141f
C112 a_3272_6334# vreset 0.15737f
C113 m1_6968_10190# chain 0.00295f
C114 hold vbp_syn 0.53846f
C115 vs m1_5286_6830# 0
C116 a_2800_5520# a_3272_6334# 0.06002f
C117 m1_4282_6970# m1_5942_6980# 0
C118 m1_1046_10270# vbp_syn 0.00934f
C119 vdd m1_2470_19900# 0.02516f
C120 sel0 a_268_18520# 0.0069f
C121 vs vbn_prb 0.20635f
C122 m1_4882_3700# a_2800_5520# 0.00871f
C123 m1_2678_13100# vbp_syn 0.46332f
C124 a_2592_8154# a_488_19360# 0.38526f
C125 chain mreset 0
C126 a_4096_6334# a_7540_3120# 0.05315f
C127 vdd m1_1080_6970# 0.05163f
C128 m1_5190_15350# ta3 0.00849f
C129 a_2592_8154# m1_6940_14170# 0.00195f
C130 a_3048_16080# ta3 0.06769f
C131 vsrcp ta1 0.01251f
C132 vbn_leak a_6984_3120# 0
C133 a_6140_9234# m1_7702_10190# 0.06132f
C134 a_728_3738# m1_2722_2630# 0.00191f
C135 vsrcp m1_2668_7940# 0.01895f
C136 chain m1_3676_6970# 0.10527f
C137 abus spk 0.58876f
C138 chain a_6672_9234# 0.03735f
C139 m1_3902_19900# a_7540_18520# 0.12144f
C140 a_6984_3120# el 0
C141 m1_642_6980# a_488_5520# 0.00143f
C142 pl_en m1_7150_9086# 0.0045f
C143 vbp_st m1_6716_11710# 0.01312f
C144 ta3 m1_7158_13030# 0.03572f
C145 vdd a_8248_5320# 0.91686f
C146 a_6984_18520# m1_6968_15350# 0
C147 m1_5942_6980# m1_5286_6830# 0.00111f
C148 m1_5942_6980# pl_en 0
C149 ta0 a_672_20034# 0.00187f
C150 m1_4882_3700# a_6328_4480# 0.08996f
C151 vbn_ax a_8248_5320# 0.14976f
C152 a_5268_9138# a_3136_4480# 0.04662f
C153 vbn_leak m1_6494_13030# -0.02073f
C154 m1_5432_10260# vbp_syn 0
C155 m1_7206_2340# a_268_18520# 0.28646f
C156 vbp_st a_7540_18520# 0.00478f
C157 vbn_ax vdd 0.74527f
C158 hold a_6884_4480# 0.06677f
C159 ta3 m1_2062_6980# 0.39476f
C160 m1_2712_15340# a_3136_4480# 0
C161 vbn_leak a_6140_14314# 0.07248f
C162 vbp_st sel0 0.03177f
C163 abus en 0.00398f
C164 sel0 m1_2708_380# 0.01504f
C165 m1_6494_5850# ta1 0.07689f
C166 a_2800_12040# a_2492_11000# 0.00977f
C167 m1_6494_13030# el 0.10079f
C168 a_6680_5520# m1_4882_3700# 0.00742f
C169 ta1 d1_bsel 0
C170 vsrcp vsrc 4.0019f
C171 m1_8466_10270# vbn_prb 0.1764f
C172 a_5268_9138# ta0 0.27585f
C173 sta hold 0.82381f
C174 a_488_12040# a_2180_13234# 0
C175 sta a_6672_14314# 0.01745f
C176 a_6140_14314# el 0
C177 m1_2792_6140# m1_7206_2340# 0
C178 m1_2862_14560# a_2180_13234# 0.1087f
C179 a_2492_16080# m1_2112_14220# 0
C180 vbn_leak a_488_5520# 0.0032f
C181 a_3048_3120# vbn_leak 0.19849f
C182 m1_1046_10270# sta 0.00501f
C183 a_5268_9138# a_5524_11840# 0.31373f
C184 a_3212_19360# vbp_syn 0.12843f
C185 a_5268_9138# ta2 0.04596f
C186 a_488_5520# a_824_3120# 0.00667f
C187 vs a_268_18520# 0.21924f
C188 a_3048_3120# el 0.07292f
C189 m1_6968_10190# a_6140_9234# 0.05322f
C190 hold a_6672_14314# 0.0079f
C191 sel1 m1_6940_14170# 0
C192 d2 a_5516_15680# 0.23904f
C193 m1_2470_19900# a_672_20034# 0.00196f
C194 el a_488_5520# 0.11127f
C195 m1_1046_10270# hold 0.45974f
C196 d2 a_5316_18520# 0.06259f
C197 hold m1_2678_13100# 0.01851f
C198 m1_2712_6970# m1_1080_6970# 0.00114f
C199 m1_5504_19890# ta3 0.1659f
C200 tb3 a_7540_18520# 0.0012f
C201 sel0 spk 0.78178f
C202 a_488_12040# m1_5286_6830# 0.1293f
C203 a_488_12040# vbn_prb 0.00862f
C204 a_488_12040# pl_en 0.11651f
C205 a_3048_16080# a_2592_8154# 0.20435f
C206 m1_5190_15350# a_2592_8154# 0
C207 m1_2792_6140# vs 0.12068f
C208 a_3136_4480# ta1 0.06821f
C209 sta m1_5432_10260# 0.05193f
C210 vbp_st m1_7930_11710# 0.00193f
C211 a_488_12040# a_4588_13668# 0.01204f
C212 m1_2862_14560# a_4588_13668# 0
C213 m1_1968_380# vdd 0.11022f
C214 m1_2668_7940# a_3136_4480# 0.00447f
C215 a_6140_9234# a_6672_9234# 0.72906f
C216 ta3 a_488_17120# 0.03778f
C217 a_7540_18520# en 0.07647f
C218 a_4096_6334# m1_4282_6970# 0.00173f
C219 m1_4568_19890# m1_7130_19630# 0
C220 a_2800_12040# a_2592_8154# 0.07449f
C221 a_2592_8154# m1_7158_13030# 0.01048f
C222 a_1892_3934# m1_2722_2630# 0
C223 vdd a_672_20034# 0.43412f
C224 ta3 tb0 0.23705f
C225 sel0 en 0.07525f
C226 m1_2062_6980# a_728_3738# 0.01428f
C227 vdd m1_2712_6970# 0.02665f
C228 ta0 ta1 2.96638f
C229 hold m1_5432_10260# 0.07858f
C230 a_5516_10600# vbp_syn 0.01959f
C231 a_6984_3120# a_7540_3120# 0.12951f
C232 vbn_ax a_672_20034# 0.2937f
C233 vs m1_2708_380# 0.01205f
C234 a_4096_6334# a_1480_3834# 0
C235 spk m1_7206_2340# 0.16066f
C236 chain a_2800_5520# 0.20675f
C237 vbp_st vs 0.07853f
C238 a_5268_14218# m1_6940_14170# 0.12261f
C239 m1_7702_15650# d2 0.3706f
C240 stb d1_bsel 0.69475f
C241 sta a_3212_19360# 0
C242 abus a_3272_6334# 0
C243 a_5316_3120# mreset 0.03796f
C244 a_2592_8154# m1_2062_6980# 0
C245 ta1 a_5524_11840# 0.04265f
C246 vbn_leak vbp_syn 0.57454f
C247 ta2 ta1 3.25261f
C248 a_5268_9138# vdd 0.52903f
C249 a_4096_6334# vbn_prb 0.05538f
C250 chain m1_7158_7910# 0
C251 vsrcp d1 0.15008f
C252 vsrc a_3136_4480# 0.09725f
C253 el vbp_syn 0.32243f
C254 a_3048_3120# a_4588_8588# 0
C255 a_3212_19360# hold 0.28977f
C256 m1_2712_15340# vdd 0.16192f
C257 en m1_7206_2340# 0.07242f
C258 vbp_st m1_5942_6980# 0
C259 m1_1046_17880# vdd 0.09395f
C260 tb2 ta3 0.00845f
C261 chain a_6328_4480# 0.0946f
C262 ta3 tb1 0.00669f
C263 vbn_ax m1_1046_17880# 0.03766f
C264 vs spk 8.10456f
C265 a_3048_16080# sel1 0.13926f
C266 ta3 m1_7206_18030# 0.05601f
C267 a_3048_3120# a_7540_3120# 0.00555f
C268 a_6680_5520# chain 0.15606f
C269 m1_5504_19890# a_2592_8154# 0.00782f
C270 m1_4568_19890# pl_en 0
C271 vbn_leak a_6884_4480# 0
C272 a_2592_8154# m1_7790_19900# 0.00261f
C273 a_5516_10600# sta 0.00535f
C274 vbp_st m1_8466_10270# 0.00145f
C275 m1_7702_15650# abus 0.09877f
C276 d1 m1_6494_5850# 0.16294f
C277 a_7540_18520# a_5516_15680# 0.00152f
C278 ta0 stb 0.00297f
C279 m1_2122_6150# vdd 0.072f
C280 a_3048_11000# m1_7684_7940# 0.04186f
C281 a_824_11000# hold 0.00215f
C282 vs en 0.53766f
C283 a_6884_4480# el 0.0536f
C284 ta1 a_8248_5320# 0
C285 a_824_11000# m1_1046_10270# 0.23239f
C286 a_2592_8154# a_488_17120# 0.31514f
C287 a_7540_18520# a_5316_18520# 0.27311f
C288 sta vbn_leak 0.23614f
C289 a_5516_10600# hold 0.12075f
C290 vdd ta1 0.29402f
C291 sel0 a_3272_6334# 0.44095f
C292 a_4660_4480# a_268_18520# 0
C293 vbn_ax ta1 0.00678f
C294 m1_2668_7940# vdd 0.42647f
C295 a_2592_8154# tb0 0.08715f
C296 sta el 0.13145f
C297 chain d2 0.02618f
C298 m1_6190_19900# d1_bsel 0.07038f
C299 vbn_leak a_6672_14314# 0.00203f
C300 hold vbn_leak 1.02519f
C301 a_4588_8588# vbp_syn 0.01924f
C302 vbp_st a_488_12040# 0.06882f
C303 a_3048_16080# a_5268_14218# 0.21204f
C304 m1_5190_15350# a_5268_14218# 0.04278f
C305 a_4096_6334# a_268_18520# 0.04927f
C306 m1_2062_6980# a_1892_3934# 0
C307 m1_1046_10270# vbn_leak 0.18571f
C308 vbn_leak m1_2678_13100# 0.05187f
C309 m1_2792_6140# a_4660_4480# 0.01831f
C310 en m1_5942_6980# 0.00706f
C311 a_6140_9234# m1_7158_7910# 0.00631f
C312 hold el 0.0952f
C313 el a_6672_14314# 0
C314 a_6140_14314# m1_7130_19630# 0.00419f
C315 m1_1046_10270# el 0.01428f
C316 d1 a_3136_4480# 0.87364f
C317 m1_2678_13100# el 0.10427f
C318 stb m1_2470_19900# 0.00249f
C319 m1_2792_6140# a_4096_6334# 0.14642f
C320 a_5516_10600# m1_5432_10260# 0.14667f
C321 a_3272_6334# m1_7206_2340# 0.02134f
C322 vsrc a_8248_5320# 0.08141f
C323 tb2 a_2592_8154# 0.0583f
C324 m1_5504_19890# sel1 0.00519f
C325 m1_4882_3700# m1_7206_2340# 0.01374f
C326 en m1_8466_10270# 0.14207f
C327 a_2592_8154# tb1 0.14295f
C328 vdd vsrc 0.84136f
C329 a_2800_12040# a_3048_11000# 0.56829f
C330 vbn_ax vsrc 0.26721f
C331 vbn_leak m1_5432_10260# 0.25859f
C332 d1 ta0 0.11149f
C333 a_2800_5520# a_5316_3120# 0
C334 a_6984_3120# vbn_prb 0.00601f
C335 a_2592_8154# m1_7206_18030# 0.31829f
C336 d2 m1_6968_15350# 0.12832f
C337 sel1 a_488_17120# 0.06743f
C338 vbp_st a_4096_6334# 0
C339 d1 a_5524_11840# 0.3923f
C340 a_3048_16080# a_2492_16080# 0.05027f
C341 mreset m1_2722_2630# 0.07338f
C342 a_3048_11000# m1_2062_6980# 0.00447f
C343 d1 ta2 0.12966f
C344 vdd stb 0.49119f
C345 ta0 m1_6190_19900# 0.02851f
C346 vs a_3272_6334# 0.3418f
C347 a_3048_3120# m1_4282_6970# 0.11683f
C348 ta3 vsrcp 0.0314f
C349 vbn_ax stb 0.11836f
C350 m1_3902_19900# m1_4568_19890# 0.01603f
C351 ta1 a_672_20034# 0
C352 sta a_4588_8588# 0.20927f
C353 d2 a_5524_16920# 0.18537f
C354 vs m1_4882_3700# 0.24519f
C355 m1_6968_10190# m1_7684_7940# 0.11259f
C356 a_488_12040# en 0.0605f
C357 a_3212_19360# vbn_leak 0.23245f
C358 a_5316_3120# a_6328_4480# 0.00826f
C359 a_6884_4480# a_7540_3120# 0.03244f
C360 m1_2668_7940# m1_2712_6970# 0.00447f
C361 spk a_4660_4480# 0.01846f
C362 m1_6494_13030# a_4588_13668# 0.00807f
C363 a_6140_14314# vbn_prb 0.01964f
C364 m1_6190_19900# ta2 0.0745f
C365 a_3048_3120# a_1480_3834# 0.08603f
C366 a_6140_14314# pl_en 0.56769f
C367 a_488_5520# a_1480_3834# 0.11813f
C368 hold a_4588_8588# 0.1482f
C369 a_5268_9138# ta1 0.14236f
C370 a_6140_14314# a_4588_13668# 0.00759f
C371 m1_9090_16790# vdd 0.0909f
C372 d1 m1_1080_6970# 0.01931f
C373 m1_7684_7940# m1_3676_6970# 0
C374 a_4096_6334# spk 0.3365f
C375 vbn_leak m1_642_6980# 0.08297f
C376 a_5268_9138# m1_2668_7940# 0
C377 m1_6716_11710# chain 0
C378 a_3048_3120# m1_5286_6830# 0.00471f
C379 a_6140_14314# m1_8326_19030# 0.00388f
C380 a_3048_3120# vbn_prb 0
C381 a_4660_4480# en 0.01741f
C382 a_2592_8154# m1_8466_15350# 0.00224f
C383 a_5268_14218# a_488_17120# 0.01493f
C384 a_3048_18520# a_2592_8154# 0.0481f
C385 m1_1968_380# vsrc 0.02404f
C386 ta3 m1_6494_5850# 0.14137f
C387 chain a_7540_18520# 0.00555f
C388 hold a_7540_3120# 0.02695f
C389 sta m1_6716_16790# 0.00704f
C390 d1 a_8248_5320# 0.56008f
C391 sel1 m1_7206_18030# 0.04513f
C392 d2 m1_2112_14220# 0.00617f
C393 a_4096_6334# en 0.15329f
C394 a_6984_3120# a_268_18520# 0.20629f
C395 vdd d1 2.51152f
C396 a_4588_8588# m1_5432_10260# 0.23134f
C397 a_5516_10600# vbn_leak 0.16988f
C398 abus a_5524_16920# 0.05583f
C399 vbn_ax d1 0.08216f
C400 a_824_11000# el 0.05007f
C401 hold m1_6716_16790# 0.01041f
C402 abus a_6140_9234# 0.01802f
C403 a_2180_13234# vbp_syn 0.25638f
C404 a_5516_10600# el 0
C405 m1_2792_6140# a_6984_3120# 0
C406 stb a_672_20034# 0.8583f
C407 vdd m1_6190_19900# 0.02192f
C408 vbn_ax m1_6190_19900# 0.12153f
C409 a_2592_8154# vsrcp 0.08919f
C410 ta3 a_3136_4480# 0.08007f
C411 vbn_leak el 4.95145f
C412 m1_4568_19890# en 0.02294f
C413 a_488_17120# a_2492_16080# 0.00466f
C414 a_6140_14314# a_268_18520# 0.1021f
C415 vsrcp vbn_ref 0.0325f
C416 chain m1_7206_2340# 0.00953f
C417 hold a_2492_18520# 0.00744f
C418 el a_824_3120# 0.08989f
C419 a_3136_4480# a_6594_420# 0.33121f
C420 m1_2236_8010# m1_1080_6970# 0
C421 m1_6716_11710# a_5524_16920# 0
C422 a_5268_14218# m1_7206_18030# 0
C423 sta m1_7130_19630# 0
C424 a_3048_3120# a_268_18520# 0.52865f
C425 m1_2062_6980# m1_3676_6970# 0.40027f
C426 ta3 ta0 0.07402f
C427 a_4588_13668# vbp_syn 0.0694f
C428 sel1 m1_8466_15350# 0.25395f
C429 a_2800_17120# vbp_syn 0.20291f
C430 a_488_5520# a_268_18520# 0
C431 m1_2062_6980# a_6672_9234# 0
C432 a_2800_5520# m1_2722_2630# 0.04678f
C433 vbp_st m1_2112_9090# 0
C434 a_7540_18520# a_5524_16920# 0
C435 m1_7130_19630# a_6672_14314# 0
C436 hold m1_7130_19630# 0.00339f
C437 a_3136_4480# a_2492_3120# 0
C438 ta3 a_5524_11840# 0.04737f
C439 a_6140_14314# m1_7930_16790# 0.0141f
C440 a_488_17120# a_6984_18520# 0.07209f
C441 m1_4882_3700# a_4660_4480# 0.14315f
C442 a_3048_3120# m1_2792_6140# 0.36507f
C443 chain vs 0.06767f
C444 ta3 ta2 2.97202f
C445 vbp_st m1_6494_13030# 0
C446 sta a_2180_13234# 0.51503f
C447 vdd m1_2236_8010# 0.1653f
C448 d1 m1_2712_6970# 0.00115f
C449 vbp_st a_6140_14314# 0.15075f
C450 a_2592_8154# d1_bsel 0.25572f
C451 a_4096_6334# a_3272_6334# 0.07936f
C452 spk a_6984_3120# 0.03945f
C453 a_5516_10600# a_4588_8588# 0.05726f
C454 a_4096_6334# m1_4882_3700# 0.12722f
C455 a_6884_4480# m1_5286_6830# 0.02793f
C456 hold m1_4282_6970# 0.00751f
C457 hold a_2180_13234# 0.9457f
C458 m1_7684_7940# m1_7158_7910# 0.09133f
C459 vbn_leak a_4588_8588# 0.44169f
C460 m1_2678_13100# a_2180_13234# 0.00512f
C461 m1_6190_19900# a_672_20034# 0.10851f
C462 vbp_st a_488_5520# 0.06213f
C463 vbp_st a_3048_3120# 0.06071f
C464 chain m1_5942_6980# 0.05335f
C465 a_5268_9138# d1 0.68315f
C466 sel1 vsrcp 0
C467 sta pl_en 0.05893f
C468 d2 a_488_19360# 0.00821f
C469 d2 m1_6940_14170# 0.0061f
C470 en a_6984_3120# 0.01395f
C471 sta a_4588_13668# 0.00909f
C472 a_2592_8154# a_3136_4480# 0.1267f
C473 a_268_18520# vbp_syn 0.09057f
C474 vbn_ref a_3136_4480# 0
C475 sel0 a_5316_3120# 0
C476 vbn_leak a_7540_3120# 0.00438f
C477 hold m1_5286_6830# 0.31175f
C478 vbn_prb a_6672_14314# 0.06342f
C479 hold pl_en 0.08907f
C480 a_6140_9234# m1_7930_11710# 0.00239f
C481 pl_en a_6672_14314# 0.24448f
C482 tb3 a_6140_14314# 0
C483 a_4588_13668# a_6672_14314# 0.06275f
C484 hold a_4588_13668# 0.07335f
C485 a_2800_17120# hold 0.48662f
C486 a_6984_18520# m1_7206_18030# 0.75899f
C487 ta3 vdd 0.93426f
C488 el a_7540_3120# 0.23137f
C489 a_3048_3120# spk 0.05531f
C490 m1_2678_13100# a_4588_13668# 0
C491 vbn_ax ta3 0.00379f
C492 a_2592_8154# ta0 0.02764f
C493 vbn_leak m1_6716_16790# 0.00287f
C494 m1_8326_19030# a_6672_14314# 0
C495 vdd a_6594_420# 0.50846f
C496 a_6140_14314# en 0.21938f
C497 sel1 d1_bsel 0.3069f
C498 m1_3902_19900# vbp_syn 0.02566f
C499 a_5268_14218# vsrcp 0.3256f
C500 a_2592_8154# a_5524_11840# 0.01841f
C501 a_2592_8154# ta2 0.0525f
C502 m1_2062_6980# a_2800_5520# 0
C503 chain a_488_12040# 0.02468f
C504 m1_7206_2340# a_5316_3120# 0.32213f
C505 vsrcp sel2 0.02684f
C506 vdd a_2492_11000# 0.3381f
C507 d1 ta1 0.16987f
C508 a_3212_19360# a_2180_13234# 0.00128f
C509 a_3048_11000# vsrcp 0.06412f
C510 a_3048_3120# en 0.00293f
C511 a_6884_4480# a_268_18520# 0.00171f
C512 vbp_st vbp_syn 0.00655f
C513 pl_en m1_5432_10260# 0.21769f
C514 vdd a_2492_3120# 0.00314f
C515 m1_2668_7940# d1 0.2881f
C516 a_728_3738# m1_1080_6970# 0.00963f
C517 a_6140_9234# m1_7150_9086# 0.28918f
C518 vbn_leak a_2492_18520# 0.00176f
C519 m1_2062_6980# m1_7158_7910# 0
C520 sta a_268_18520# 0.01944f
C521 m1_6190_19900# ta1 0.0912f
C522 m1_2792_6140# a_6884_4480# 0.17915f
C523 a_2592_8154# m1_2470_19900# 0
C524 sel1 a_3136_4480# 0
C525 a_2592_8154# m1_1080_6970# 0
C526 a_824_18520# a_488_19360# 0.08577f
C527 chain a_4660_4480# 0.00113f
C528 vs a_5316_3120# 0.11342f
C529 a_3272_6334# a_6984_3120# 0.00409f
C530 a_3048_16080# d2 0.12983f
C531 a_268_18520# a_6672_14314# 0.05219f
C532 a_3212_19360# pl_en 0
C533 vbn_leak m1_7130_19630# 0.04506f
C534 a_3136_4480# a_1892_3934# 0.0883f
C535 m1_5190_15350# d2 0.07416f
C536 hold a_268_18520# 0.38048f
C537 m1_4882_3700# a_6984_3120# 0.01092f
C538 a_2800_17120# a_3212_19360# 0
C539 vdd a_728_3738# 0.74886f
C540 a_6680_5520# m1_2062_6980# 0
C541 a_6140_9234# m1_8466_10270# 0.05745f
C542 chain a_4096_6334# 0.16771f
C543 a_3048_11000# m1_6494_5850# 0.29361f
C544 sel1 ta0 0.05312f
C545 d1 vsrc 0.048f
C546 vbp_st a_6884_4480# 0.06903f
C547 a_488_12040# m1_6968_15350# 0.00261f
C548 m1_3902_19900# sta 0.00832f
C549 m1_1968_380# a_6594_420# 0.00191f
C550 a_2800_12040# d2 0.01063f
C551 m1_7158_13030# d2 0
C552 vbn_ref a_8248_5320# 0.00766f
C553 m1_2792_6140# hold 0.13253f
C554 a_2592_8154# vdd 1.82802f
C555 vbn_ax a_2592_8154# 0.14634f
C556 vbn_leak a_2180_13234# 0.10719f
C557 vdd vbn_ref 0.17709f
C558 vbn_leak m1_4282_6970# 0.2419f
C559 a_6140_14314# a_5516_15680# 0.00254f
C560 sel1 ta2 0.03962f
C561 m1_3902_19900# a_6672_14314# 0.00179f
C562 m1_3902_19900# hold 0.07525f
C563 vbn_ax vbn_ref 3.9836f
C564 vbp_st sta 0.11138f
C565 en vbp_syn 0.05533f
C566 m1_1968_380# a_2492_3120# 0
C567 ta3 a_5268_9138# 0.07877f
C568 a_488_12040# a_5524_16920# 0.00144f
C569 a_5268_14218# a_3136_4480# 0.01882f
C570 a_6140_9234# a_488_12040# 0.078f
C571 a_2180_13234# el 0.15858f
C572 vbn_leak a_1480_3834# 0.00946f
C573 m1_2668_7940# m1_2236_8010# 0.03107f
C574 sel2 a_3136_4480# 0.02953f
C575 a_5516_10600# pl_en 0.00704f
C576 vbp_st hold 0.14421f
C577 vbp_st a_6672_14314# 0.15811f
C578 a_3048_3120# a_3272_6334# 0.28189f
C579 a_3048_11000# a_3136_4480# 0.0682f
C580 a_824_3120# a_1480_3834# 0.01276f
C581 a_3272_6334# a_488_5520# 0.22361f
C582 a_5516_10600# a_4588_13668# 0.00191f
C583 a_3048_16080# abus 0.00433f
C584 m1_6190_19900# stb 0.08746f
C585 el a_1480_3834# 0.00367f
C586 vbn_leak m1_5286_6830# 0.1445f
C587 m1_6968_10190# vsrcp 0.16685f
C588 vbn_leak vbn_prb 0.65617f
C589 a_5268_14218# ta0 0.18521f
C590 vbn_leak pl_en 0.16303f
C591 a_2800_17120# vbn_leak 0.1952f
C592 vsrcp mreset 0.02676f
C593 vbn_leak a_4588_13668# 0.2096f
C594 el m1_5286_6830# 0
C595 a_3212_19360# a_268_18520# 0.0031f
C596 el vbn_prb 0.12003f
C597 a_3048_11000# ta0 0.22035f
C598 pl_en el 0.08198f
C599 a_6884_4480# en 0
C600 tb3 sta 0
C601 a_5268_14218# ta2 0.06547f
C602 m1_7702_15650# a_6140_14314# 0.01414f
C603 vsrcp m1_3676_6970# 0
C604 vsrcp a_6672_9234# 0.08968f
C605 a_3136_4480# m1_7702_10190# 0
C606 a_4588_13668# el 0.50602f
C607 vbn_leak m1_8326_19030# 0.02176f
C608 sel2 a_5524_11840# 0.03348f
C609 m1_2862_14560# m1_2112_14220# 0.26305f
C610 a_6984_18520# d1_bsel 0
C611 hold spk 0
C612 a_3048_11000# a_5524_11840# 0.14952f
C613 sel1 vdd 0.18153f
C614 a_3048_11000# ta2 0.10226f
C615 vbn_ax sel1 0.03547f
C616 ta3 ta1 0.21453f
C617 sta en 0.23906f
C618 tb3 a_6672_14314# 0.00153f
C619 m1_8326_19030# el 0
C620 a_488_17120# d2 0.17831f
C621 tb3 hold 0
C622 a_2592_8154# a_672_20034# 0.01084f
C623 m1_3902_19900# a_3212_19360# 0.01793f
C624 vdd a_1892_3934# 0.80604f
C625 a_3048_16080# a_7540_18520# 0.02229f
C626 a_4588_8588# m1_4282_6970# 0.01448f
C627 en a_6672_14314# 0.00236f
C628 m1_6968_10190# m1_6494_7910# 0
C629 a_5516_15680# vbp_syn 0.00665f
C630 hold en 0.33177f
C631 m1_7702_10190# a_5524_11840# 0.03217f
C632 a_4660_4480# a_5316_3120# 0.00355f
C633 m1_910_6150# m1_1080_6970# 0.00149f
C634 m1_7702_10190# ta2 0
C635 a_2592_8154# a_5268_9138# 0.17639f
C636 a_5316_18520# vbp_syn 0.02177f
C637 m1_3676_6970# m1_6494_5850# 0.1485f
C638 vbn_leak a_268_18520# 0.27096f
C639 vs m1_2722_2630# 0.25314f
C640 a_4096_6334# a_5316_3120# 0.17771f
C641 vbp_st m1_642_6980# 0.02048f
C642 a_6672_9234# m1_6494_7910# 0
C643 a_5268_14218# vdd 0.45332f
C644 a_2592_8154# m1_1046_17880# 0.00789f
C645 a_3048_18520# m1_2956_19890# 0.00554f
C646 a_4588_8588# m1_5286_6830# 0.00123f
C647 m1_6968_10190# a_3136_4480# 0.03234f
C648 a_4588_8588# pl_en 0.03827f
C649 vbn_ax a_5268_14218# 0.0014f
C650 ta0 a_6984_18520# 0.06678f
C651 a_3048_11000# a_8248_5320# 0.00912f
C652 vdd sel2 0.19715f
C653 chain m1_6494_13030# 0.00258f
C654 el a_268_18520# 0.99076f
C655 vbn_ax sel2 0.02704f
C656 m1_910_6150# vdd 0.0564f
C657 en m1_5432_10260# 0.14416f
C658 a_3136_4480# mreset 0.25707f
C659 m1_2792_6140# vbn_leak 0.15187f
C660 a_3048_11000# vdd 1.88403f
C661 a_2180_13234# m1_6716_16790# 0.03501f
C662 vsrc a_6594_420# 0.15906f
C663 m1_2122_6150# a_728_3738# 0.02262f
C664 chain a_6140_14314# 0.0452f
C665 vbn_ax a_3048_11000# 0
C666 d2 m1_7206_18030# 0.00179f
C667 ta2 a_6984_18520# 0.03948f
C668 m1_3902_19900# vbn_leak 0.46884f
C669 vbn_prb a_7540_3120# 0.01885f
C670 m1_4882_3700# a_6884_4480# 0.03871f
C671 m1_2792_6140# el 0.02012f
C672 m1_3676_6970# a_3136_4480# 0.00381f
C673 m1_6968_10190# ta0 0.0174f
C674 vbp_st a_5516_10600# 0
C675 a_6672_9234# a_3136_4480# 0.07854f
C676 sel1 a_672_20034# 0.03541f
C677 d1 m1_2236_8010# 0.33342f
C678 a_3048_3120# chain 0.23668f
C679 m1_7702_12990# a_488_12040# 0.00368f
C680 vsrc a_2492_3120# 0.00372f
C681 vbn_leak m1_2708_380# 0
C682 chain a_488_5520# 0.00131f
C683 sta a_5516_15680# 0
C684 a_488_17120# a_824_18520# 0.0439f
C685 vsrcp vreset 0.03653f
C686 a_2592_8154# ta1 0.0429f
C687 m1_6968_10190# a_5524_11840# 0.08057f
C688 vdd m1_7702_10190# 0.06904f
C689 vbp_st vbn_leak 0.81393f
C690 a_3212_19360# en 0.00212f
C691 a_2180_13234# a_2492_18520# 0.22316f
C692 m1_6968_10190# ta2 0.04282f
C693 m1_3676_6970# ta0 0.1631f
C694 a_2592_8154# m1_2668_7940# 0.07065f
C695 m1_5504_19890# a_7540_18520# 0
C696 a_6672_9234# ta0 0.00771f
C697 vdd a_2492_16080# 0.34163f
C698 hold a_5516_15680# 0.16039f
C699 a_488_12040# m1_6940_14170# 0
C700 vbp_st el 0.18944f
C701 hold a_5316_18520# 0.17002f
C702 hold m1_4882_3700# 0
C703 vsrcp m1_7158_7910# 0.08081f
C704 a_6672_9234# a_5524_11840# 0.59391f
C705 m1_3676_6970# ta2 0.26868f
C706 a_6672_9234# ta2 0.0316f
C707 a_488_17120# a_7540_18520# 0.26627f
C708 m1_7130_19630# a_2180_13234# 0
C709 a_6140_14314# m1_6968_15350# 0.15403f
C710 vsrc a_728_3738# 0.20398f
C711 a_3048_18520# d2 0.15816f
C712 vbn_leak spk 1.1233f
C713 m1_6494_13030# a_5524_16920# 0.00147f
C714 d2 m1_8466_15350# 0
C715 a_7540_18520# tb0 0
C716 a_2800_17120# a_2492_18520# 0.00237f
C717 vdd a_6984_18520# 0.17979f
C718 ta3 d1 0.18893f
C719 m1_7702_15650# sta 0
C720 a_6140_14314# a_5524_16920# 0.18956f
C721 vbn_ax a_6984_18520# 0
C722 tb3 vbn_leak 0.57499f
C723 spk el 0.16949f
C724 vs m1_2062_6980# 0.05765f
C725 a_5516_10600# en 0.03786f
C726 vsrc vbn_ref 0.04012f
C727 m1_3676_6970# m1_1080_6970# 0
C728 m1_2792_6140# a_4588_8588# 0
C729 d1_bsel m1_2956_19890# 0.14663f
C730 m1_7130_19630# pl_en 0
C731 d1 a_6594_420# 0.1248f
C732 a_268_18520# a_7540_3120# 0.23564f
C733 m1_7684_7940# a_488_12040# 0.06178f
C734 m1_7702_15650# hold 0
C735 m1_7702_15650# a_6672_14314# 0.09415f
C736 a_5268_9138# sel2 0
C737 m1_6968_10190# vdd 0.00107f
C738 vbn_leak en 0.83179f
C739 ta3 m1_6190_19900# 0
C740 a_8248_5320# mreset 0.04797f
C741 a_6984_3120# a_5316_3120# 0.00335f
C742 sel1 ta1 0.05086f
C743 a_2592_8154# stb 0.17431f
C744 a_4660_4480# m1_2722_2630# 0.00284f
C745 vdd mreset 0.29423f
C746 a_3048_11000# a_5268_9138# 0.17514f
C747 tb2 a_7540_18520# 0.00152f
C748 m1_6494_5850# a_6328_4480# 0
C749 m1_7158_7910# m1_6494_7910# 0
C750 a_7540_18520# tb1 0.00173f
C751 d1 a_2492_3120# 0.11554f
C752 vbn_ax mreset 0.14506f
C753 m1_3676_6970# a_8248_5320# 0
C754 m1_2792_6140# a_7540_3120# 0.17773f
C755 en el 0.10477f
C756 m1_7130_19630# m1_8326_19030# 0.04548f
C757 m1_2062_6980# m1_5942_6980# 0.08538f
C758 vbp_st a_4588_8588# 0.03181f
C759 vsrcp d2 0.092f
C760 a_3136_4480# vreset 0
C761 m1_4282_6970# m1_5286_6830# 0.04372f
C762 vdd m1_3676_6970# 0.42883f
C763 a_3212_19360# a_5316_18520# 0.00107f
C764 a_4096_6334# m1_2722_2630# 0
C765 vdd a_6672_9234# 0.82058f
C766 abus m1_8466_15350# 0
C767 a_2180_13234# pl_en 0.01055f
C768 a_7540_18520# m1_7206_18030# 0.42379f
C769 a_2800_5520# a_3136_4480# 0.01667f
C770 a_2180_13234# a_4588_13668# 0
C771 a_6680_5520# m1_6494_5850# 0.01437f
C772 a_2800_17120# a_2180_13234# 0.43267f
C773 a_5268_9138# m1_7702_10190# 0.2121f
C774 a_3048_16080# m1_2862_14560# 0.00146f
C775 vbp_st a_7540_3120# 0
C776 chain a_6884_4480# 0.0086f
C777 m1_7158_7910# a_3136_4480# 0.00607f
C778 a_2492_18520# a_268_18520# 0.07935f
C779 m1_9090_11710# vbn_leak 0
C780 a_488_17120# a_824_16080# 0.04866f
C781 d1 a_728_3738# 0
C782 a_2800_12040# a_488_12040# 0.05185f
C783 m1_7158_13030# a_488_12040# 0.00196f
C784 a_5268_14218# ta1 0.13142f
C785 a_2800_12040# m1_2862_14560# 0
C786 a_3136_4480# a_6328_4480# 0.17146f
C787 m1_2712_15340# a_2492_16080# 0.34996f
C788 a_6984_18520# a_672_20034# 0
C789 chain sta 0.11616f
C790 vbp_st m1_6716_16790# 0.03147f
C791 m1_7158_7910# ta0 0.01154f
C792 m1_9090_11710# el 0
C793 a_2800_17120# pl_en 0
C794 a_4588_13668# pl_en 0.03225f
C795 d2 d1_bsel 0.00261f
C796 a_2592_8154# d1 0.74367f
C797 m1_7130_19630# a_268_18520# 0.02344f
C798 a_3048_11000# ta1 0.13619f
C799 a_5524_16920# vbp_syn 0
C800 a_2800_17120# a_4588_13668# 0.00355f
C801 d1 vbn_ref 0.00383f
C802 a_6680_5520# a_3136_4480# 0.01924f
C803 vsrcp abus 0.14376f
C804 chain hold 0.24112f
C805 m1_2062_6980# a_488_12040# 0.07223f
C806 a_3048_11000# m1_2668_7940# 0.01533f
C807 chain a_6672_14314# 0.01357f
C808 sel1 stb 0.02825f
C809 ta0 a_6328_4480# 0
C810 m1_7158_7910# a_5524_11840# 0.12257f
C811 spk a_7540_3120# 0
C812 m1_7158_7910# ta2 0.08302f
C813 a_4588_8588# en 0.17172f
C814 vbn_leak a_5516_15680# 0.12818f
C815 a_2592_8154# m1_6190_19900# 0
C816 vbn_leak a_3272_6334# 0.28483f
C817 vbn_leak a_5316_18520# 0.00171f
C818 a_3272_6334# a_824_3120# 0.03862f
C819 a_6680_5520# ta0 0.00211f
C820 m1_2470_19900# m1_2956_19890# 0.00741f
C821 a_3272_6334# el 0.31272f
C822 m1_7702_10190# ta1 0
C823 a_2180_13234# a_268_18520# 0.32097f
C824 m1_3902_19900# m1_7130_19630# 0.15414f
C825 m1_3676_6970# m1_2712_6970# 0.06435f
C826 m1_6968_10190# a_5268_9138# 0.38485f
C827 sel1 m1_9090_16790# 0
C828 m1_4882_3700# el 0.66763f
C829 a_3136_4480# d2 0.21736f
C830 en a_7540_3120# 0.04918f
C831 vsrc sel2 0.02673f
C832 m1_2062_6980# a_4660_4480# 0
C833 a_1480_3834# a_268_18520# 0.01547f
C834 a_6680_5520# ta2 0.00179f
C835 sta m1_6968_15350# 0.0261f
C836 vreset a_8248_5320# 0.13217f
C837 m1_2792_6140# m1_4282_6970# 0.02646f
C838 chain m1_5432_10260# 0.00555f
C839 m1_2112_14220# vbp_syn 0.30043f
C840 vbp_st m1_7130_19630# 0
C841 a_5268_9138# m1_3676_6970# 0
C842 a_5268_9138# a_6672_9234# 0.16422f
C843 vdd vreset 0.17731f
C844 a_4096_6334# m1_2062_6980# 0
C845 m1_3902_19900# a_2180_13234# 0.05099f
C846 a_728_3738# m1_2236_8010# 0
C847 vbn_prb a_268_18520# 0.11913f
C848 vbn_ax vreset 0.06641f
C849 vdd a_2800_5520# 1.63478f
C850 m1_6968_15350# a_6672_14314# 0.04948f
C851 hold m1_6968_15350# 0.03063f
C852 ta0 d2 0.01874f
C853 pl_en a_268_18520# 0.01101f
C854 m1_2792_6140# a_1480_3834# 0.12825f
C855 sta a_5524_16920# 0.23481f
C856 m1_7702_15650# vbn_leak 0.00106f
C857 vdd m1_2956_19890# 0.0412f
C858 vbn_ax m1_2956_19890# 0
C859 a_4588_13668# a_268_18520# 0
C860 a_2800_17120# a_268_18520# 0.05516f
C861 vsrcp sel0 0.03161f
C862 sta a_6140_9234# 0.17744f
C863 a_6984_18520# ta1 0.04078f
C864 vbp_st m1_4282_6970# 0.04045f
C865 a_2592_8154# m1_2236_8010# 0.11023f
C866 vbp_st a_2180_13234# 0.22373f
C867 d2 ta2 0.12651f
C868 m1_2792_6140# m1_5286_6830# 0.00744f
C869 chain a_3212_19360# 0
C870 a_6140_14314# m1_6940_14170# 0
C871 a_5524_16920# a_6672_14314# 0.6037f
C872 d1 a_1892_3934# 0.04357f
C873 hold a_5524_16920# 0.19528f
C874 m1_8326_19030# a_268_18520# 0.00728f
C875 a_824_18520# d1_bsel 0
C876 m1_2678_13100# a_5524_16920# 0
C877 a_6140_9234# hold 0.08304f
C878 sel1 m1_6190_19900# 0.03427f
C879 m1_3902_19900# pl_en 0.00378f
C880 abus a_3136_4480# 0.08779f
C881 vdd a_6328_4480# 0.10945f
C882 vbp_st a_1480_3834# 0.02174f
C883 a_6594_420# a_2492_3120# 0.01162f
C884 vbn_ax a_6328_4480# 0
C885 m1_6968_10190# ta1 0.04882f
C886 tb3 m1_7130_19630# 0.24812f
C887 a_6680_5520# a_8248_5320# 0
C888 m1_2708_380# vbn_prb 0.05453f
C889 a_6680_5520# vdd 1.55656f
C890 vbp_st m1_5286_6830# 0.13293f
C891 vbp_st pl_en 0.00185f
C892 vbp_st vbn_prb 0.11043f
C893 a_7540_18520# d1_bsel 0
C894 a_6680_5520# vbn_ax 0
C895 m1_3902_19900# m1_8326_19030# 0.0045f
C896 en m1_7130_19630# 0
C897 a_6672_9234# ta1 0.02629f
C898 m1_3676_6970# ta1 0.12322f
C899 vbp_st a_4588_13668# 0.00123f
C900 a_3048_3120# m1_2722_2630# 0.07453f
C901 a_3272_6334# a_7540_3120# 0
C902 tb3 a_2180_13234# 0
C903 m1_4882_3700# a_7540_3120# 0.18186f
C904 a_6140_9234# m1_5432_10260# 0.13241f
C905 d1 sel2 0.02383f
C906 abus a_5524_11840# 0.04725f
C907 a_5516_10600# chain 0.00217f
C908 hold m1_2112_14220# 0.03514f
C909 m1_5504_19890# m1_4568_19890# 0.09724f
C910 spk a_1480_3834# 0
C911 m1_910_6150# d1 0
C912 vbp_st m1_8326_19030# 0.01376f
C913 ta3 a_2592_8154# 0.3083f
C914 a_3048_11000# d1 0.66781f
C915 m1_2678_13100# m1_2112_14220# 0.15231f
C916 a_2800_5520# m1_2712_6970# 0
C917 en a_2180_13234# 0.0071f
C918 vdd d2 1.56809f
C919 stb a_6984_18520# 0
C920 m1_4282_6970# en 0.00648f
C921 vbn_ax d2 0.42333f
C922 chain vbn_leak 0.29205f
C923 a_672_20034# m1_2956_19890# 0.0166f
C924 spk vbn_prb 0.1561f
C925 vsrc mreset 0.1997f
C926 vbn_ref a_6594_420# 0.41409f
C927 m1_2792_6140# a_268_18520# 0.02108f
C928 m1_6716_11710# ta0 0.00172f
C929 chain el 0.20675f
C930 sel0 a_3136_4480# 0
C931 a_2592_8154# a_2492_11000# 0.01216f
C932 d1 m1_7702_10190# 0.28672f
C933 a_6672_9234# vsrc 0
C934 m1_5190_15350# a_6140_14314# 0.00311f
C935 m1_3902_19900# a_268_18520# 0.01052f
C936 a_3048_16080# a_6140_14314# 0.25796f
C937 vsrcp m1_7150_9086# 0.13847f
C938 m1_6716_11710# a_5524_11840# 0.00126f
C939 a_7540_18520# ta0 0.00741f
C940 a_5268_9138# m1_7158_7910# 0.00234f
C941 en m1_5286_6830# 0.14781f
C942 en vbn_prb 0.26154f
C943 en pl_en 2.57937f
C944 tb3 m1_8326_19030# 0.30812f
C945 a_2800_17120# en 0
C946 en a_4588_13668# 0.10186f
C947 vbp_st a_268_18520# 0.42043f
C948 abus a_8248_5320# 0.00851f
C949 a_7540_18520# ta2 0.00879f
C950 abus vdd 0.24465f
C951 vbn_leak m1_6968_15350# 0.19298f
C952 vbn_ax abus 0.09496f
C953 a_3136_4480# m1_7206_2340# 0.16464f
C954 vbp_st m1_2792_6140# 0.23881f
C955 ta3 sel1 0.06231f
C956 m1_6968_15350# el 0.01806f
C957 a_3048_11000# m1_2236_8010# 0.00201f
C958 a_5516_10600# a_6140_9234# 0
C959 vbn_leak a_5524_16920# 0.35073f
C960 vbp_st m1_3902_19900# 0.02602f
C961 d2 a_672_20034# 0.00133f
C962 m1_5942_6980# m1_6494_5850# 0.05843f
C963 m1_7702_12990# a_6672_14314# 0.00914f
C964 vbp_st m1_7930_16790# 0.04584f
C965 spk a_268_18520# 0.15386f
C966 a_3048_3120# m1_2062_6980# 0.03455f
C967 m1_9090_11710# vbn_prb 0
C968 a_6140_9234# vbn_leak 0.26806f
C969 a_2180_13234# a_5516_15680# 0.16874f
C970 vdd a_824_18520# 0.37016f
C971 m1_6190_19900# a_6984_18520# 0
C972 a_6594_420# a_1892_3934# 0.1026f
C973 m1_2062_6980# a_488_5520# 0
C974 chain a_4588_8588# 0.05952f
C975 m1_6968_10190# d1 0.28566f
C976 sta m1_6940_14170# 0.00297f
C977 a_2180_13234# a_5316_18520# 0.02745f
C978 a_5524_16920# el 0.08116f
C979 vs a_3136_4480# 0.05746f
C980 tb3 a_268_18520# 0
C981 d1 mreset 0.2113f
C982 vsrcp a_488_12040# 0.07878f
C983 m1_7158_7910# ta1 0.04727f
C984 m1_6716_11710# vdd 0.0873f
C985 a_6140_9234# el 0.05543f
C986 vsrcp m1_2862_14560# 0
C987 hold a_488_19360# 0.01706f
C988 m1_2792_6140# spk 0.07027f
C989 a_3272_6334# a_1480_3834# 0.27707f
C990 m1_6940_14170# a_6672_14314# 0.3436f
C991 hold m1_6940_14170# 0.06608f
C992 m1_5504_19890# a_6140_14314# 0.00571f
C993 d1 m1_3676_6970# 0
C994 a_1892_3934# a_2492_3120# 0.00947f
C995 chain a_7540_3120# 0.15745f
C996 d1 a_6672_9234# 0.34144f
C997 a_5268_14218# ta3 0.04263f
C998 a_3048_16080# vbp_syn 0.1762f
C999 m1_5190_15350# vbp_syn 0.00164f
C1000 en a_268_18520# 0.19718f
C1001 vdd a_7540_18520# 0.33043f
C1002 sel0 a_8248_5320# 0.0175f
C1003 a_3136_4480# m1_7150_9086# 0
C1004 m1_2712_15340# d2 0.01867f
C1005 vbn_ax a_7540_18520# 0.01608f
C1006 pl_en a_5516_15680# 0.00865f
C1007 m1_1046_17880# d2 0.26431f
C1008 sel0 vdd 0.18092f
C1009 abus m1_1968_380# 0.05817f
C1010 a_3272_6334# vbn_prb 0.27189f
C1011 tb3 m1_3902_19900# 0.1113f
C1012 m1_5942_6980# a_3136_4480# 0
C1013 m1_4882_3700# vbn_prb 0
C1014 vbn_leak m1_2112_14220# 0.00104f
C1015 a_2800_17120# a_5516_15680# -0.03978f
C1016 a_488_17120# a_6140_14314# 0.27144f
C1017 pl_en a_5316_18520# 0.02818f
C1018 vsrc vreset 0.03644f
C1019 vbn_ax sel0 0.04083f
C1020 vbn_leak a_5316_3120# 0
C1021 ta3 a_3048_11000# 0.25516f
C1022 a_4588_13668# a_5516_15680# 0.14834f
C1023 m1_2792_6140# en 0.04185f
C1024 a_6680_5520# ta1 0.00305f
C1025 vbp_st spk 0.17464f
C1026 a_2800_12040# vbp_syn 0.09634f
C1027 a_4588_13668# a_5316_18520# 0
C1028 chain m1_6716_16790# 0
C1029 ta0 m1_7150_9086# 0.00336f
C1030 tb0 a_6140_14314# 0.00465f
C1031 m1_3902_19900# en 0.00539f
C1032 a_488_12040# m1_6494_5850# 0.14142f
C1033 m1_2112_14220# el 0.03797f
C1034 vbp_st tb3 0
C1035 el a_5316_3120# 0.01487f
C1036 en m1_7930_16790# 0
C1037 a_728_3738# a_1892_3934# 0
C1038 m1_5942_6980# ta0 0.02437f
C1039 a_2592_8154# sel1 0.21926f
C1040 m1_2062_6980# vbp_syn 0
C1041 a_5524_11840# m1_7150_9086# 0.18314f
C1042 a_3048_11000# a_2492_11000# 0.07739f
C1043 en m1_2708_380# 0.02156f
C1044 m1_7206_2340# a_8248_5320# 0.00888f
C1045 ta2 m1_7150_9086# 0.00928f
C1046 ta3 m1_7702_10190# 0.01151f
C1047 vbp_st en 0.37777f
C1048 stb m1_2956_19890# 0.01986f
C1049 vsrc a_6328_4480# 0
C1050 d2 ta1 0.08774f
C1051 a_824_18520# a_672_20034# 0
C1052 vbn_ax m1_7206_2340# 0.41469f
C1053 vs m1_1080_6970# 0.00791f
C1054 m1_5942_6980# ta2 0.15405f
C1055 a_6140_9234# a_4588_8588# 0.00233f
C1056 m1_7702_15650# vbn_prb 0.03583f
C1057 vdd m1_7930_11710# 0.07932f
C1058 m1_7702_15650# pl_en 0
C1059 tb2 a_6140_14314# 0.00611f
C1060 a_3212_19360# a_488_19360# 0.0013f
C1061 a_3048_16080# sta 0.00934f
C1062 tb1 a_6140_14314# 0.00192f
C1063 m1_5190_15350# sta 0.00845f
C1064 a_6680_5520# vsrc 0
C1065 a_488_12040# a_3136_4480# 0.06867f
C1066 a_5524_11840# m1_8466_10270# 0
C1067 sel0 m1_1968_380# 0.05533f
C1068 vs a_8248_5320# 0.03666f
C1069 a_3048_16080# a_6672_14314# 0.02976f
C1070 a_2800_12040# sta 0
C1071 m1_7684_7940# m1_5432_10260# 0.02268f
C1072 m1_5190_15350# a_6672_14314# 0.17374f
C1073 a_3048_16080# hold 0.33106f
C1074 m1_5190_15350# hold 0.00832f
C1075 a_268_18520# a_5516_15680# 0.01095f
C1076 a_7540_18520# a_672_20034# 0.00117f
C1077 m1_5504_19890# vbp_syn 0
C1078 spk en 0.02403f
C1079 a_3272_6334# a_268_18520# 0.28996f
C1080 m1_910_6150# a_728_3738# 0.01414f
C1081 a_5316_18520# a_268_18520# 0.08766f
C1082 vs vdd 1.56939f
C1083 m1_6716_11710# a_5268_9138# 0.00571f
C1084 m1_5190_15350# m1_2678_13100# 0
C1085 a_3048_16080# m1_2678_13100# 0.01156f
C1086 a_5268_14218# a_2592_8154# 0.01655f
C1087 ta3 a_6984_18520# 0.01684f
C1088 vbn_ax vs 0.00127f
C1089 m1_4882_3700# a_268_18520# 0.05091f
C1090 a_824_16080# vdd 0.14723f
C1091 m1_1046_17880# a_824_18520# 0.2282f
C1092 a_488_12040# ta0 0.16428f
C1093 m1_9090_11710# vbp_st 0.03545f
C1094 m1_7158_13030# a_6672_14314# 0.00531f
C1095 a_488_17120# vbp_syn 0.03363f
C1096 a_2800_12040# hold 0.33616f
C1097 m1_7158_13030# hold 0.00151f
C1098 vbn_ref sel2 0.02681f
C1099 d1 vreset 0.03426f
C1100 sta m1_2062_6980# 0
C1101 m1_2792_6140# a_3272_6334# 0.06436f
C1102 chain m1_4282_6970# 0.00145f
C1103 a_3048_11000# a_2592_8154# 0.25576f
C1104 a_2800_12040# m1_1046_10270# 0.18291f
C1105 chain a_2180_13234# 0.03981f
C1106 d1 a_2800_5520# 0.09578f
C1107 a_4660_4480# a_3136_4480# 0
C1108 a_2800_12040# m1_2678_13100# 0.00238f
C1109 m1_2792_6140# m1_4882_3700# 0.04861f
C1110 m1_6968_10190# ta3 0.17922f
C1111 a_488_12040# a_5524_11840# 0.01764f
C1112 a_488_12040# ta2 0.06126f
C1113 m1_4568_19890# d1_bsel 0.09598f
C1114 vdd m1_5942_6980# 0.00601f
C1115 chain a_1480_3834# 0.01008f
C1116 m1_1046_17880# a_7540_18520# 0
C1117 a_4096_6334# a_3136_4480# 0.05186f
C1118 m1_2062_6980# hold 0.38855f
C1119 d1 m1_7158_7910# 0
C1120 m1_7702_12990# el 0.11177f
C1121 vbn_leak a_488_19360# 0.0059f
C1122 a_5316_3120# a_7540_3120# 0.00247f
C1123 vbn_leak m1_6940_14170# 0
C1124 m1_2708_380# a_3272_6334# 0.00148f
C1125 ta3 m1_3676_6970# 0.22215f
C1126 a_2592_8154# m1_7702_10190# 0.06824f
C1127 m1_7702_15650# a_268_18520# 0
C1128 vbp_st a_5516_15680# 0
C1129 ta3 a_6672_9234# 0.02112f
C1130 a_6594_420# mreset 0.01994f
C1131 chain m1_5286_6830# 0.09332f
C1132 vbp_st a_3272_6334# 0.04204f
C1133 a_6140_14314# m1_8466_15350# 0.04098f
C1134 chain pl_en 2.45993f
C1135 vbp_st m1_4882_3700# 0
C1136 d1 a_6328_4480# 0.52586f
C1137 a_2800_12040# m1_5432_10260# -0.01766f
C1138 vdd m1_8466_10270# 0.00308f
C1139 el m1_6940_14170# 0.00122f
C1140 m1_5504_19890# sta 0.00521f
C1141 chain a_4588_13668# 0.02774f
C1142 chain a_2800_17120# 0
C1143 m1_7130_19630# a_5524_16920# 0
C1144 vs m1_1968_380# 0.06706f
C1145 a_6680_5520# d1 0.00214f
C1146 a_2180_13234# m1_6968_15350# 0
C1147 abus vsrc 0.12132f
C1148 vbn_leak m1_2722_2630# 0.1071f
C1149 m1_2112_9090# vsrcp 0
C1150 a_5268_14218# sel1 0.07674f
C1151 sta a_488_17120# 0.0372f
C1152 m1_2062_6980# m1_5432_10260# 0
C1153 a_5268_9138# m1_7930_11710# 0.04489f
C1154 m1_7206_18030# vbp_syn 0.00465f
C1155 a_7540_18520# ta1 0.00745f
C1156 m1_5504_19890# hold 0.00526f
C1157 a_824_3120# m1_2722_2630# 0.1955f
C1158 a_488_12040# a_8248_5320# 0
C1159 hold m1_7790_19900# 0
C1160 el m1_2722_2630# 0.18958f
C1161 spk a_3272_6334# 0.16536f
C1162 m1_4882_3700# spk 0
C1163 vdd a_488_12040# 1.59885f
C1164 a_2180_13234# a_5524_16920# 0.10318f
C1165 a_2592_8154# a_6984_18520# 0.25325f
C1166 m1_7684_7940# vbn_leak 0
C1167 vdd m1_2862_14560# 0.21616f
C1168 a_488_17120# a_6672_14314# 0.00495f
C1169 vbp_st m1_7702_15650# 0
C1170 a_488_17120# hold 0.16169f
C1171 vsrcp a_6140_14314# 0.27092f
C1172 a_3048_11000# a_1892_3934# 0
C1173 m1_6968_15350# pl_en 0.17895f
C1174 tb0 a_6672_14314# 0
C1175 m1_6968_10190# a_2592_8154# 0.11806f
C1176 a_4588_13668# m1_6968_15350# 0.06724f
C1177 en a_5516_15680# 0.08257f
C1178 en a_3272_6334# 0.25072f
C1179 en a_5316_18520# 0.05658f
C1180 m1_4882_3700# en 0.0451f
C1181 m1_2712_15340# a_824_16080# 0.25466f
C1182 a_5268_9138# m1_7150_9086# 0.16011f
C1183 stb a_824_18520# 0
C1184 vdd a_4660_4480# 0.12445f
C1185 a_5524_16920# vbn_prb 0.04795f
C1186 vbn_ref mreset 0.05091f
C1187 chain a_268_18520# 0.14078f
C1188 pl_en a_5524_16920# 0.18638f
C1189 m1_2062_6980# m1_642_6980# 0
C1190 a_2800_17120# a_5524_16920# 0
C1191 a_3048_16080# vbn_leak 0.24351f
C1192 a_4096_6334# a_8248_5320# 0
C1193 a_6140_9234# vbn_prb 0.09215f
C1194 a_6140_9234# pl_en 0.25459f
C1195 m1_5190_15350# vbn_leak 0.10871f
C1196 a_4588_13668# a_5524_16920# 0.92146f
C1197 sel0 vsrc 0.29532f
C1198 a_2800_12040# a_5516_10600# -0.00222f
C1199 a_2592_8154# a_6672_9234# 0.26097f
C1200 a_3048_18520# vbp_syn 0
C1201 vdd a_4096_6334# 0.58198f
C1202 a_2180_13234# m1_2112_14220# 0.19927f
C1203 tb2 hold 0
C1204 sta m1_7206_18030# 0.04121f
C1205 tb1 a_6672_14314# 0
C1206 m1_8326_19030# a_5524_16920# 0.02685f
C1207 chain m1_2792_6140# 0.4824f
C1208 m1_5190_15350# el 0.04146f
C1209 a_3048_16080# el 0
C1210 a_7540_18520# stb 0.01328f
C1211 a_3136_4480# a_6984_3120# 0.08446f
C1212 a_2800_12040# vbn_leak 0.34004f
C1213 m1_3902_19900# chain 0.00542f
C1214 m1_2122_6150# vs 0.00148f
C1215 abus d1 0.15595f
C1216 a_5268_9138# m1_8466_10270# 0.07723f
C1217 hold m1_7206_18030# 0.0704f
C1218 m1_2112_9090# a_3136_4480# 0
C1219 m1_7702_15650# en 0.09677f
C1220 sel1 a_6984_18520# 0.03011f
C1221 vreset a_6594_420# 0.0371f
C1222 a_2800_12040# el 0.07909f
C1223 m1_7158_13030# el 0.11099f
C1224 a_2800_5520# a_6594_420# 0.13437f
C1225 a_488_17120# a_3212_19360# 0.03394f
C1226 ta3 m1_7158_7910# 0.04316f
C1227 vdd m1_4568_19890# 0.02006f
C1228 m1_2062_6980# vbn_leak 0.44715f
C1229 vsrc m1_7206_2340# 0.19277f
C1230 m1_7684_7940# a_4588_8588# 0.04865f
C1231 sel2 m1_7702_10190# 0.03119f
C1232 m1_6494_13030# a_3136_4480# 0.12386f
C1233 vbp_st chain 0.3909f
C1234 vbn_ax m1_4568_19890# 0.04087f
C1235 a_3048_11000# m1_7702_10190# 0.10777f
C1236 ta3 a_6328_4480# 0
C1237 ta1 m1_7150_9086# 0.00773f
C1238 vsrcp vbp_syn 0.02346f
C1239 a_6140_14314# a_3136_4480# 0.00131f
C1240 a_5268_9138# a_488_12040# 0.50236f
C1241 m1_5942_6980# ta1 0.05495f
C1242 m1_6716_11710# d1 0.08137f
C1243 a_5316_18520# a_5516_15680# 0.00385f
C1244 a_2492_18520# a_488_19360# 0.01249f
C1245 a_6680_5520# ta3 0.52844f
C1246 a_5524_16920# a_268_18520# 0.16557f
C1247 a_1892_3934# mreset 0
C1248 a_3048_3120# a_3136_4480# 0.14706f
C1249 a_6140_14314# ta0 0.00846f
C1250 a_6140_9234# a_268_18520# 0
C1251 m1_2712_15340# m1_2862_14560# 0
C1252 a_5268_14218# a_6984_18520# 0
C1253 m1_5504_19890# vbn_leak 0.27024f
C1254 vs vsrc 0.99123f
C1255 chain spk 0.2186f
C1256 m1_6494_13030# a_5524_11840# 0
C1257 a_6680_5520# a_6594_420# 0.00626f
C1258 m1_3676_6970# a_1892_3934# 0
C1259 m1_8466_15350# a_6672_14314# 0.02691f
C1260 a_3048_18520# hold 0.065f
C1261 vbn_leak m1_7790_19900# 0.32779f
C1262 sel0 d1 0
C1263 a_6140_14314# ta2 0.01508f
C1264 vbp_st m1_6968_15350# 0
C1265 m1_3902_19900# a_5524_16920# 0.02063f
C1266 a_488_17120# vbn_leak 0.03949f
C1267 d1_bsel vbp_syn 0.0566f
C1268 a_2800_12040# a_4588_8588# 0
C1269 ta3 d2 0.15782f
C1270 chain en 0.72529f
C1271 vbn_leak tb0 0.16543f
C1272 a_3048_3120# ta2 0
C1273 vbn_ref vreset 4.48812f
C1274 a_488_17120# el 0.10733f
C1275 a_2592_8154# m1_2956_19890# 0.00195f
C1276 a_6984_3120# a_8248_5320# 0.00122f
C1277 m1_6968_10190# a_3048_11000# 0.05039f
C1278 vsrcp sta 0.10222f
C1279 vbp_st a_5524_16920# 0.23413f
C1280 sel2 mreset 3.95824f
C1281 a_2180_13234# a_488_19360# 0.18646f
C1282 m1_4568_19890# a_672_20034# 0.13384f
C1283 vdd a_6984_3120# 0
C1284 a_5316_3120# a_268_18520# 0.15515f
C1285 a_488_12040# ta1 0.11546f
C1286 m1_2062_6980# a_4588_8588# 0.09307f
C1287 vbp_st a_6140_9234# 0.13381f
C1288 tb0 el 0
C1289 vbn_ax a_6984_3120# 0
C1290 d1 m1_7206_2340# 0.05202f
C1291 a_6672_9234# sel2 0.03838f
C1292 vsrcp a_6672_14314# 0.57039f
C1293 m1_2112_9090# vdd 0.26471f
C1294 vsrcp hold 0.01071f
C1295 a_3048_11000# a_6672_9234# 0.1318f
C1296 a_3048_11000# m1_3676_6970# 0.34802f
C1297 m1_7702_12990# pl_en 0.04781f
C1298 a_6884_4480# m1_6494_5850# 0
C1299 m1_2792_6140# a_5316_3120# 0
C1300 d1 m1_7930_11710# 0
C1301 vsrcp m1_2678_13100# 0.02091f
C1302 a_3136_4480# vbp_syn 0.23181f
C1303 m1_6968_10190# m1_7702_10190# 0.0118f
C1304 m1_7702_12990# a_4588_13668# 0.06567f
C1305 a_488_5520# m1_1080_6970# 0.0065f
C1306 tb2 vbn_leak 0.01842f
C1307 tb1 vbn_leak 0.01121f
C1308 vdd a_6140_14314# 0.97016f
C1309 a_3048_16080# a_2492_18520# 0.00757f
C1310 a_3048_18520# a_3212_19360# 0.00797f
C1311 pl_en m1_6940_14170# 0.05613f
C1312 en m1_6968_15350# 0.15586f
C1313 vbn_ax a_6140_14314# 0.0012f
C1314 sta d1_bsel 0.25185f
C1315 vbn_leak m1_7206_18030# 0
C1316 tb1 el 0
C1317 a_1480_3834# m1_2722_2630# 0.00401f
C1318 vs d1 0.11624f
C1319 a_4588_13668# m1_6940_14170# 0.00961f
C1320 tb3 a_5524_16920# 0.00473f
C1321 a_6672_9234# m1_7702_10190# 0.30523f
C1322 abus a_6594_420# 0.32983f
C1323 vsrcp m1_5432_10260# 0.37236f
C1324 vdd a_488_5520# 1.74768f
C1325 a_3048_3120# vdd 0.69362f
C1326 hold m1_6494_5850# 0.06767f
C1327 a_5524_11840# vbp_syn 0
C1328 en a_5524_16920# 0.22734f
C1329 hold d1_bsel 0.12861f
C1330 a_3048_16080# m1_7130_19630# 0.43611f
C1331 vbn_prb m1_2722_2630# 0
C1332 a_6884_4480# a_3136_4480# 0.06845f
C1333 d1 m1_7150_9086# 0.03685f
C1334 a_2800_5520# a_1892_3934# 0.49932f
C1335 hold m1_6494_7910# 0.00176f
C1336 a_6140_9234# en 0.19204f
C1337 a_2592_8154# d2 0.12578f
C1338 chain a_3272_6334# 0.09364f
C1339 chain a_5516_15680# 0
C1340 chain a_5316_18520# 0.0051f
C1341 chain m1_4882_3700# 0.06137f
C1342 sta a_3136_4480# 0.08487f
C1343 m1_7684_7940# pl_en 0.1173f
C1344 spk a_5316_3120# 0.26747f
C1345 a_3048_16080# a_2180_13234# 0.18403f
C1346 ta3 a_7540_18520# 0.03692f
C1347 d1 m1_8466_10270# 0.03178f
C1348 a_4096_6334# vsrc 0.06398f
C1349 hold a_3136_4480# 0.24202f
C1350 a_3136_4480# a_6672_14314# 0.08131f
C1351 a_3048_18520# vbn_leak 0.00889f
C1352 m1_1046_10270# a_3136_4480# 0
C1353 m1_2678_13100# a_3136_4480# 0
C1354 a_268_18520# a_488_19360# 0.12284f
C1355 m1_6968_10190# m1_3676_6970# 0
C1356 m1_6494_7910# m1_5432_10260# 0
C1357 m1_6968_10190# a_6672_9234# 0.02525f
C1358 sel2 vreset 0.02697f
C1359 m1_2112_9090# a_5268_9138# 0
C1360 en a_5316_3120# 0.06711f
C1361 sel0 a_6594_420# 0.39478f
C1362 a_6680_5520# a_1892_3934# 0.0816f
C1363 sta a_5524_11840# 0.5487f
C1364 m1_9090_11710# a_6140_9234# 0.03128f
C1365 sta ta2 0
C1366 hold ta0 2.8375f
C1367 ta0 a_6672_14314# 0.00416f
C1368 a_3048_16080# vbn_prb 0.00598f
C1369 vdd vbp_syn 2.37967f
C1370 a_3048_16080# pl_en 0.0374f
C1371 m1_5190_15350# pl_en 0.02953f
C1372 m1_6968_15350# a_5516_15680# 0
C1373 abus vbn_ref 0.25853f
C1374 vbn_ax vbp_syn 0.19483f
C1375 m1_2062_6980# m1_4282_6970# 0.18881f
C1376 a_3048_16080# a_4588_13668# 0.01356f
C1377 m1_5190_15350# a_2800_17120# -0
C1378 m1_5190_15350# a_4588_13668# 0.93999f
C1379 a_3048_16080# a_2800_17120# 0.05833f
C1380 a_3212_19360# d1_bsel 0.13439f
C1381 a_5516_10600# vsrcp 0
C1382 d1 a_488_12040# 0.2178f
C1383 a_488_17120# a_2492_18520# 0.03875f
C1384 a_268_18520# m1_2722_2630# 0.11146f
C1385 a_3048_3120# m1_2712_6970# 0.04721f
C1386 hold a_5524_11840# 0.32016f
C1387 vbp_st m1_7702_12990# 0
C1388 ta2 a_6672_14314# 0.00232f
C1389 sel1 d2 0.16835f
C1390 hold ta2 0.04053f
C1391 a_3136_4480# m1_5432_10260# 0.03195f
C1392 m1_5504_19890# m1_7130_19630# 0.12352f
C1393 a_2800_12040# pl_en 0
C1394 m1_7158_13030# pl_en 0.00148f
C1395 a_5524_16920# a_5516_15680# 0.24409f
C1396 a_3048_16080# m1_8326_19030# 0.40241f
C1397 m1_2062_6980# a_1480_3834# 0.00159f
C1398 vsrcp vbn_leak 0.18926f
C1399 a_5524_16920# a_5316_18520# 0.00113f
C1400 a_2800_12040# a_4588_13668# 0.00126f
C1401 m1_7158_13030# a_4588_13668# 0.07628f
C1402 m1_7790_19900# m1_7130_19630# 0
C1403 ta3 m1_7930_11710# 0.00504f
C1404 a_2592_8154# a_824_18520# 0.01569f
C1405 m1_4568_19890# stb 0.12869f
C1406 a_3048_11000# a_6328_4480# 0
C1407 sta m1_1080_6970# 0
C1408 a_488_17120# m1_7130_19630# 0.08991f
C1409 a_6884_4480# a_8248_5320# 0.00134f
C1410 m1_2062_6980# m1_5286_6830# 0.10037f
C1411 ta0 m1_5432_10260# 0.03029f
C1412 vsrcp el 0.30532f
C1413 m1_2062_6980# pl_en 0
C1414 hold m1_2470_19900# 0
C1415 d1 a_4660_4480# 0.02152f
C1416 vdd a_6884_4480# 0.30001f
C1417 vbn_ax a_6884_4480# 0.01466f
C1418 a_6680_5520# a_3048_11000# 0.36739f
C1419 tb0 m1_7130_19630# 0.04084f
C1420 m1_7702_15650# m1_6968_15350# 0
C1421 ta3 vs 0.05457f
C1422 a_5524_11840# m1_5432_10260# 0.27129f
C1423 ta2 m1_5432_10260# 0.01148f
C1424 m1_2112_9090# m1_2668_7940# 0.04315f
C1425 a_2592_8154# a_7540_18520# 0.23692f
C1426 d1 a_4096_6334# 0.15707f
C1427 a_488_17120# a_2180_13234# 0.56476f
C1428 a_5268_14218# d2 0.38369f
C1429 sta vdd 0.59526f
C1430 vbn_leak m1_6494_5850# 0.31837f
C1431 vbn_ax sta 0.00828f
C1432 vs a_6594_420# 0.71123f
C1433 sel1 abus 0.12574f
C1434 m1_7702_15650# a_5524_16920# 0.05892f
C1435 sel0 vbn_ref 0.45754f
C1436 hold a_8248_5320# 0.0114f
C1437 vbn_leak d1_bsel 0.16533f
C1438 a_6140_14314# ta1 0.00665f
C1439 a_3272_6334# a_5316_3120# 0.00512f
C1440 ta3 m1_7150_9086# 0.00769f
C1441 a_3048_16080# a_268_18520# 0.00827f
C1442 a_672_20034# vbp_syn 0.02558f
C1443 a_3048_11000# d2 0.02726f
C1444 vdd a_6672_14314# 0.76117f
C1445 vdd hold 4.23638f
C1446 vbn_ax a_6672_14314# 0
C1447 m1_5504_19890# pl_en 0.00164f
C1448 m1_4882_3700# a_5316_3120# 0.01013f
C1449 vbn_leak m1_6494_7910# -0.01166f
C1450 ta3 m1_5942_6980# 0
C1451 m1_1046_10270# vdd 0.10521f
C1452 vdd m1_2678_13100# 0.42332f
C1453 vbn_ax hold 0.1567f
C1454 tb2 m1_7130_19630# 0.18527f
C1455 vs a_2492_3120# 0.01308f
C1456 m1_2122_6150# a_488_5520# 0.01019f
C1457 tb1 m1_7130_19630# 0.61127f
C1458 vsrc a_6984_3120# 0.14702f
C1459 a_3048_3120# ta1 0
C1460 vreset mreset 0.16554f
C1461 a_5268_9138# vbp_syn 0
C1462 a_5516_10600# a_3136_4480# 0.06677f
C1463 a_488_17120# vbn_prb 0
C1464 a_488_17120# pl_en 0.03001f
C1465 a_3048_3120# m1_2668_7940# 0.00412f
C1466 spk m1_2722_2630# 0.018f
C1467 a_2800_5520# mreset 0.09093f
C1468 m1_7130_19630# m1_7206_18030# 0.00515f
C1469 m1_5504_19890# m1_8326_19030# 0.24875f
C1470 a_3048_16080# m1_3902_19900# 0.19354f
C1471 a_488_17120# a_4588_13668# 0.00565f
C1472 vsrcp a_4588_8588# 0.21934f
C1473 a_2800_17120# a_488_17120# 0.39821f
C1474 m1_7790_19900# m1_8326_19030# 0.07795f
C1475 m1_6968_10190# m1_7158_7910# 0.13643f
C1476 m1_4568_19890# m1_6190_19900# 0
C1477 vbn_ref m1_7206_2340# 0
C1478 vbn_leak a_3136_4480# 1.60723f
C1479 m1_2712_15340# vbp_syn 0.0465f
C1480 a_2592_8154# m1_7930_11710# 0.01078f
C1481 vdd m1_5432_10260# 0
C1482 a_5516_10600# ta0 0
C1483 m1_1046_17880# vbp_syn 0.02461f
C1484 a_488_17120# m1_8326_19030# 0.19378f
C1485 a_3048_16080# vbp_st 0.06906f
C1486 vsrc a_6140_14314# 0
C1487 vs a_728_3738# 0.14497f
C1488 m1_5190_15350# vbp_st 0
C1489 a_3136_4480# el 1.06676f
C1490 sel1 a_7540_18520# 0.00356f
C1491 en m1_2722_2630# 0.00345f
C1492 abus sel2 0.08267f
C1493 a_2180_13234# m1_7206_18030# 0.06273f
C1494 chain m1_6968_15350# 0.00307f
C1495 a_3048_18520# a_2492_18520# 0.07682f
C1496 tb0 m1_8326_19030# 0.31287f
C1497 m1_2792_6140# m1_2062_6980# 0.02979f
C1498 a_5516_10600# a_5524_11840# 0.00581f
C1499 vbn_leak ta0 0.34387f
C1500 a_5516_10600# ta2 0
C1501 m1_642_6980# m1_1080_6970# 0.00279f
C1502 vbp_st m1_7158_13030# 0
C1503 sta a_672_20034# 0.01756f
C1504 a_3048_3120# vsrc 0
C1505 vsrc a_488_5520# 0.11173f
C1506 ta3 a_488_12040# 0.11469f
C1507 ta0 el 0.06004f
C1508 vs vbn_ref 0.46838f
C1509 vbn_leak a_5524_11840# 0.1985f
C1510 a_6680_5520# mreset 0.0859f
C1511 chain a_5524_16920# 0.07493f
C1512 vdd a_3212_19360# 1.27387f
C1513 d2 a_6984_18520# 0.00221f
C1514 vbn_leak ta2 0.38737f
C1515 m1_5504_19890# a_268_18520# 0.00152f
C1516 vbn_ax a_3212_19360# 0.31153f
C1517 chain a_6140_9234# 0.02683f
C1518 hold a_672_20034# 0.05592f
C1519 a_6680_5520# m1_3676_6970# 0.00513f
C1520 vbp_st m1_2062_6980# 0.49165f
C1521 a_2592_8154# m1_7150_9086# 0.00146f
C1522 abus m1_7702_10190# 0.0245f
C1523 a_5268_9138# sta 0.22835f
C1524 a_5524_11840# el 0.09344f
C1525 ta2 el 0.03528f
C1526 a_4588_8588# m1_6494_7910# 0.06759f
C1527 pl_en m1_7206_18030# 0.04288f
C1528 m1_2668_7940# vbp_syn 0.44096f
C1529 a_2492_11000# a_488_12040# 0.01645f
C1530 tb2 m1_8326_19030# 0.1236f
C1531 vdd m1_642_6980# 0.01007f
C1532 m1_9090_16790# a_6140_14314# 0.05449f
C1533 a_3048_16080# tb3 0.10983f
C1534 tb1 m1_8326_19030# 0.1073f
C1535 d1 a_6984_3120# 0.0017f
C1536 a_5268_14218# a_7540_18520# 0
C1537 a_488_17120# a_268_18520# 1.26807f
C1538 ta3 a_4660_4480# 0
C1539 a_3048_11000# m1_6716_11710# 0.00833f
C1540 a_5268_9138# hold 0.25437f
C1541 vbn_leak m1_2470_19900# 0.09964f
C1542 vbn_leak m1_1080_6970# 0.12512f
C1543 m1_2112_9090# d1 0.10264f
C1544 m1_8326_19030# m1_7206_18030# 0.00118f
C1545 m1_5504_19890# m1_3902_19900# 0.56713f
C1546 a_3048_16080# en 0.47464f
C1547 tb0 a_268_18520# 0.01179f
C1548 a_3048_18520# a_2180_13234# 0.0344f
C1549 a_4660_4480# a_6594_420# 0
C1550 a_824_11000# vdd 0.16228f
C1551 m1_5190_15350# en 0.05447f
C1552 m1_3902_19900# m1_7790_19900# 0
C1553 ta3 a_4096_6334# 0
C1554 m1_2712_15340# hold 0.03884f
C1555 sel0 sel2 3.94927f
C1556 a_4588_8588# a_3136_4480# 0.82936f
C1557 m1_2712_15340# m1_2678_13100# 0
C1558 m1_1046_17880# hold 0.05646f
C1559 m1_2062_6980# spk 0
C1560 m1_5504_19890# vbp_st 0
C1561 chain a_5316_3120# 0.00441f
C1562 a_5516_10600# vdd 0.2387f
C1563 m1_6968_15350# a_5524_16920# 0.16727f
C1564 m1_3902_19900# a_488_17120# 0.17198f
C1565 a_4096_6334# a_6594_420# 0.27534f
C1566 vbn_leak a_8248_5320# 0.28014f
C1567 a_2800_12040# en 0
C1568 a_488_17120# m1_7930_16790# 0
C1569 m1_3902_19900# tb0 0
C1570 a_3272_6334# m1_2722_2630# 0.18528f
C1571 vdd vbn_leak 3.696f
C1572 a_5268_9138# m1_5432_10260# 0.16385f
C1573 a_4588_8588# ta0 0.04628f
C1574 vbn_ax vbn_leak 1.28455f
C1575 a_3136_4480# a_7540_3120# 0.06764f
C1576 el a_8248_5320# 0.16414f
C1577 pl_en m1_8466_15350# 0.00174f
C1578 vbn_prb m1_8466_15350# 0.19936f
C1579 tb2 a_268_18520# 0.00135f
C1580 vbp_st a_488_17120# 0.15358f
C1581 sta ta1 0
C1582 vdd a_824_3120# 0.20694f
C1583 vs a_1892_3934# 0.01641f
C1584 tb1 a_268_18520# 0.00959f
C1585 a_3048_3120# d1 0.08125f
C1586 a_3048_18520# a_2800_17120# 0.01296f
C1587 m1_2062_6980# en 0.06625f
C1588 d1_bsel a_2492_18520# 0
C1589 sta m1_2668_7940# 0.10139f
C1590 a_2592_8154# a_488_12040# 0.58857f
C1591 a_4588_8588# a_5524_11840# 0.30351f
C1592 vdd el 1.45099f
C1593 a_3212_19360# a_672_20034# 0.00857f
C1594 stb vbp_syn 0.06888f
C1595 vbn_ax el 0.52553f
C1596 a_4588_8588# ta2 0.04621f
C1597 vbp_st tb0 0.00177f
C1598 abus mreset 0.04665f
C1599 m1_7206_18030# a_268_18520# 0.19566f
C1600 ta1 a_6672_14314# 0.00373f
C1601 hold ta1 0.03464f
C1602 m1_2668_7940# hold 0
C1603 a_2800_5520# a_6328_4480# 0.00335f
C1604 m1_1046_10270# m1_2668_7940# 0
C1605 a_3048_11000# m1_7930_11710# 0.02137f
C1606 abus a_6672_9234# 0.04944f
C1607 tb2 m1_3902_19900# 0.00203f
C1608 m1_5504_19890# tb3 0.67413f
C1609 vsrc a_6884_4480# 0.00412f
C1610 m1_3902_19900# tb1 0.03968f
C1611 m1_7130_19630# d1_bsel 0
C1612 tb3 m1_7790_19900# 0.22282f
C1613 m1_2112_9090# m1_2236_8010# 0.31298f
C1614 ta0 m1_6716_16790# 0.00135f
C1615 a_7540_18520# a_6984_18520# 0.22243f
C1616 vsrcp m1_5286_6830# 0
C1617 vsrcp vbn_prb 0.08844f
C1618 m1_3902_19900# m1_7206_18030# 0.20944f
C1619 m1_5504_19890# en 0.00663f
C1620 a_6680_5520# a_2800_5520# 0.13691f
C1621 vsrcp pl_en 0.49915f
C1622 a_3048_16080# a_5516_15680# 0.08954f
C1623 m1_1046_17880# a_3212_19360# 0.05932f
C1624 tb3 a_488_17120# 0.03011f
C1625 m1_7930_16790# m1_7206_18030# 0
C1626 vbp_st tb1 0.00201f
C1627 m1_910_6150# vs 0.01863f
C1628 m1_5190_15350# a_5516_15680# 0.01237f
C1629 a_3048_11000# vs 0.01106f
C1630 vsrcp a_4588_13668# 0.19477f
C1631 m1_4282_6970# m1_6494_5850# 0
C1632 m1_7702_10190# m1_7930_11710# 0
C1633 ta1 m1_5432_10260# 0.01257f
C1634 a_2180_13234# d1_bsel 0.07372f
C1635 tb3 tb0 0.21553f
C1636 a_4096_6334# vbn_ref 0.3296f
C1637 a_488_17120# en 0.08175f
C1638 vbp_st m1_7206_18030# 0.00866f
C1639 m1_2668_7940# m1_5432_10260# 0
C1640 vsrc a_6672_14314# 0
C1641 vsrcp m1_8326_19030# 0
C1642 vbn_leak m1_2712_6970# 0.12682f
C1643 d1 vbp_syn 0.71603f
C1644 a_3048_18520# a_268_18520# 0.03302f
C1645 sta stb 0.33157f
C1646 vbn_leak a_672_20034# 0.21735f
C1647 a_3048_11000# m1_7150_9086# 0
C1648 vdd a_4588_8588# 0.31132f
C1649 a_6680_5520# a_6328_4480# 0.00794f
C1650 a_5516_10600# a_5268_9138# 0.21177f
C1651 sel0 mreset 0.29701f
C1652 d2 m1_2956_19890# 0
C1653 a_3048_11000# m1_5942_6980# 0.00142f
C1654 m1_6494_5850# m1_5286_6830# 0.19112f
C1655 a_2592_8154# m1_4568_19890# 0.00463f
C1656 a_5268_9138# vbn_leak 0.72355f
C1657 hold stb 0.30673f
C1658 a_8248_5320# a_7540_3120# 0.00897f
C1659 a_824_16080# a_2492_16080# 0.00977f
C1660 pl_en d1_bsel 0.00544f
C1661 tb2 tb3 0.40221f
C1662 m1_7130_19630# ta0 0.00383f
C1663 a_3048_16080# m1_7702_15650# 0.33733f
C1664 tb3 tb1 0.1238f
C1665 m1_4282_6970# a_3136_4480# 0
C1666 a_3136_4480# a_2180_13234# 0
C1667 a_6594_420# a_6984_3120# 0
C1668 vdd a_7540_3120# 0.35463f
C1669 sel2 m1_8466_10270# 0.00909f
C1670 vbn_ax a_7540_3120# 0.02114f
C1671 a_5268_9138# el 0.1199f
C1672 a_3048_11000# m1_8466_10270# 0.00268f
C1673 m1_2712_15340# vbn_leak 0.1325f
C1674 tb3 m1_7206_18030# 0.02649f
C1675 m1_7130_19630# ta2 0.00465f
C1676 m1_1046_17880# vbn_leak 0.04635f
C1677 m1_2470_19900# a_2492_18520# 0
C1678 a_3136_4480# a_1480_3834# 0
C1679 m1_9090_16790# a_6672_14314# 0.01482f
C1680 m1_7206_2340# mreset 0.0674f
C1681 chain m1_2722_2630# 0
C1682 d1 a_6884_4480# 0.21204f
C1683 m1_2712_15340# el 0.01955f
C1684 ta3 a_6140_14314# 0.0435f
C1685 vdd m1_6716_16790# 0.08085f
C1686 vbp_st m1_8466_15350# 0.00153f
C1687 vsrcp a_268_18520# 0.08058f
C1688 m1_2112_9090# a_2492_11000# 0.00385f
C1689 m1_7702_12990# m1_6968_15350# 0.04012f
C1690 ta0 a_2180_13234# 0
C1691 en m1_7206_18030# 0.0506f
C1692 a_3136_4480# vbn_prb 0.07336f
C1693 m1_5504_19890# a_5316_18520# 0
C1694 abus vreset 0.15561f
C1695 a_3136_4480# m1_5286_6830# 0.01216f
C1696 m1_7702_10190# m1_8466_10270# 0.2351f
C1697 sta d1 0.3215f
C1698 a_3136_4480# pl_en 0.12661f
C1699 a_488_12040# sel2 0
C1700 a_2180_13234# ta2 0
C1701 m1_7702_12990# a_5524_16920# 0
C1702 a_4096_6334# a_1892_3934# 0.18497f
C1703 m1_4282_6970# ta2 0
C1704 a_5516_10600# ta1 0
C1705 a_3136_4480# a_4588_13668# 0.53926f
C1706 a_2800_17120# a_3136_4480# 0.03038f
C1707 a_3048_11000# a_488_12040# 1.26056f
C1708 a_6672_9234# m1_7930_11710# 0
C1709 m1_6968_15350# m1_6940_14170# 0.01238f
C1710 a_488_17120# a_5516_15680# 0
C1711 m1_2122_6150# vbn_leak 0
C1712 m1_2236_8010# vbp_syn 0.18718f
C1713 vdd a_2492_18520# 0.25498f
C1714 a_488_17120# a_5316_18520# 0.03814f
C1715 a_3048_3120# a_6594_420# 0.07568f
C1716 ta0 m1_5286_6830# 0.10767f
C1717 d1 hold 0.41342f
C1718 vbn_ax a_2492_18520# 0
C1719 sta m1_6190_19900# 0.04884f
C1720 vbn_leak ta1 0.38789f
C1721 ta0 pl_en 0.05632f
C1722 vs mreset 0.06463f
C1723 m1_1046_10270# d1 0.03073f
C1724 m1_2668_7940# vbn_leak 0.00811f
C1725 ta0 a_4588_13668# 0.01405f
C1726 a_5524_16920# m1_6940_14170# 0.22761f
C1727 a_3212_19360# stb 0.01639f
C1728 a_2180_13234# m1_2470_19900# 0
C1729 vbp_st vsrcp 4.03846f
C1730 vs m1_3676_6970# 0
C1731 ta1 el 0.07376f
C1732 m1_6968_10190# m1_7150_9086# 0.02228f
C1733 a_5524_11840# vbn_prb 0.03753f
C1734 d1_bsel a_268_18520# 0.00428f
C1735 ta2 vbn_prb 0
C1736 a_3048_3120# a_2492_3120# -0.09331f
C1737 ta2 m1_5286_6830# 0.05735f
C1738 a_488_12040# m1_7702_10190# 0.106f
C1739 pl_en a_5524_11840# 0.04245f
C1740 hold m1_6190_19900# 0.05235f
C1741 ta2 pl_en 0.02607f
C1742 a_5268_9138# a_4588_8588# 0.22547f
C1743 vdd m1_7130_19630# 0.37159f
C1744 a_3048_16080# chain 0.00399f
C1745 vbn_ref a_6984_3120# 0
C1746 vbn_ax m1_7130_19630# 0.25924f
C1747 ta2 a_4588_13668# 0.04222f
C1748 m1_5190_15350# chain 0.03294f
C1749 a_2592_8154# m1_2112_9090# 0.04425f
C1750 m1_2862_14560# a_2492_16080# 0
C1751 m1_1080_6970# a_1480_3834# 0
C1752 en m1_8466_15350# 0.09315f
C1753 a_6672_9234# m1_7150_9086# 0.02745f
C1754 a_3048_11000# a_4096_6334# 0
C1755 d1 m1_5432_10260# 0.01382f
C1756 a_2800_12040# chain 0
C1757 sel0 vreset 0.24797f
C1758 m1_7702_15650# a_488_17120# 0.05161f
C1759 m1_3902_19900# d1_bsel 0.01427f
C1760 m1_3676_6970# m1_5942_6980# 0.15019f
C1761 vbn_leak vsrc 3.96761f
C1762 vdd m1_4282_6970# 0.01926f
C1763 vdd a_2180_13234# 2.03921f
C1764 a_2592_8154# a_6140_14314# 0.41153f
C1765 vbn_ax a_2180_13234# 0.00332f
C1766 a_3136_4480# a_268_18520# 3.12653f
C1767 vsrcp spk 0.06757f
C1768 a_3048_3120# a_728_3738# 0.0039f
C1769 vsrc a_824_3120# 0.20074f
C1770 a_728_3738# a_488_5520# 0.50228f
C1771 vbp_st m1_6494_5850# 0.00856f
C1772 sta m1_2236_8010# 0.21412f
C1773 m1_7206_18030# a_5316_18520# 0.29944f
C1774 chain m1_2062_6980# 0.1084f
C1775 vsrc el 0.31522f
C1776 a_6140_9234# m1_7684_7940# 0.00197f
C1777 vdd a_1480_3834# 0.51634f
C1778 a_6672_9234# m1_8466_10270# 0.00548f
C1779 a_8248_5320# vbn_prb 0.24885f
C1780 m1_2792_6140# a_3136_4480# 0.26831f
C1781 a_8248_5320# m1_5286_6830# 0.01761f
C1782 hold m1_2236_8010# 0.00302f
C1783 vbn_leak stb 0.29548f
C1784 ta0 a_268_18520# 0.02278f
C1785 a_2492_11000# vbp_syn 0.00147f
C1786 a_3048_16080# m1_6968_15350# 0.05476f
C1787 m1_5190_15350# m1_6968_15350# 0
C1788 vsrcp en 0.06075f
C1789 vdd m1_5286_6830# 0.77048f
C1790 a_4588_8588# ta1 0.03798f
C1791 m1_6968_10190# a_488_12040# 0.02848f
C1792 vdd vbn_prb 0.46876f
C1793 vdd pl_en 0.13333f
C1794 vbn_ax m1_5286_6830# 0
C1795 a_2800_5520# m1_7206_2340# 0
C1796 vbn_ax vbn_prb 0.39061f
C1797 a_5316_3120# m1_2722_2630# 0
C1798 m1_2668_7940# a_4588_8588# 0.00351f
C1799 a_2800_17120# vdd 1.16301f
C1800 d2 a_824_18520# 0.00405f
C1801 vbn_ax pl_en 0.05473f
C1802 d1 m1_642_6980# 0
C1803 a_5524_11840# a_268_18520# 0
C1804 vdd a_4588_13668# 0.16177f
C1805 vbn_ax a_2800_17120# 0.00837f
C1806 spk m1_6494_5850# 0
C1807 ta2 a_268_18520# 0.0224f
C1808 m1_2792_6140# ta0 0
C1809 m1_7158_13030# m1_6968_15350# 0.02564f
C1810 a_3048_16080# a_5524_16920# 0.05059f
C1811 ta3 a_6884_4480# 0.00392f
C1812 m1_5190_15350# a_5524_16920# 0.44328f
C1813 m1_7130_19630# a_672_20034# 0.02047f
C1814 vbp_st a_3136_4480# 0.77677f
C1815 m1_5504_19890# chain 0.00469f
C1816 m1_3676_6970# a_488_12040# 0.15331f
C1817 vdd m1_8326_19030# 0.31182f
C1818 a_6672_9234# a_488_12040# 0.01306f
C1819 m1_3902_19900# ta0 0.20562f
C1820 vbn_ax m1_8326_19030# 0.27207f
C1821 tb3 d1_bsel 0
C1822 a_824_11000# d1 0.02537f
C1823 m1_2792_6140# ta2 0
C1824 m1_7158_13030# a_5524_16920# 0.10224f
C1825 m1_1046_17880# a_2492_18520# 0.21725f
C1826 m1_7206_2340# a_6328_4480# 0.00277f
C1827 a_7540_18520# d2 0.0334f
C1828 vs vreset 0.38978f
C1829 a_5516_10600# d1 0.15869f
C1830 chain a_488_17120# 0.03117f
C1831 vs a_2800_5520# 0.1457f
C1832 en m1_6494_5850# 0
C1833 sel1 a_6140_14314# 0.16904f
C1834 m1_3902_19900# ta2 0.0352f
C1835 a_4660_4480# mreset 0.00317f
C1836 vbp_st ta0 0.03639f
C1837 m1_4282_6970# m1_2712_6970# 0.00211f
C1838 en d1_bsel 0.08328f
C1839 a_2180_13234# a_672_20034# 0.0498f
C1840 ta3 hold 0.2298f
C1841 ta3 a_6672_14314# 0.00619f
C1842 d1 vbn_leak 0.99239f
C1843 en m1_6494_7910# 0
C1844 a_2592_8154# vbp_syn 0.40175f
C1845 vbp_st a_5524_11840# 0.20359f
C1846 a_4096_6334# mreset 0.25106f
C1847 spk a_3136_4480# 0.46262f
C1848 sta a_2492_11000# 0.00784f
C1849 vbp_st ta2 0.10813f
C1850 m1_2712_6970# a_1480_3834# 0.00387f
C1851 a_3048_16080# m1_2112_14220# 0
C1852 hold a_6594_420# 0
C1853 d1 el 1.61621f
C1854 m1_1968_380# vbn_prb 0.03679f
C1855 a_8248_5320# a_268_18520# 0.03261f
C1856 vbn_leak m1_6190_19900# 0.22363f
C1857 vs a_6328_4480# 0.00599f
C1858 a_3048_3120# a_1892_3934# 0.29977f
C1859 vsrc a_7540_3120# 0.09011f
C1860 a_1892_3934# a_488_5520# 0.00428f
C1861 a_2492_11000# hold 0.17434f
C1862 vdd a_268_18520# 1.27878f
C1863 m1_7158_7910# m1_7150_9086# 0
C1864 m1_2712_6970# m1_5286_6830# 0
C1865 m1_1046_10270# a_2492_11000# 0.24617f
C1866 a_3048_11000# m1_2112_9090# 0.00527f
C1867 m1_2712_15340# a_2180_13234# 0.22184f
C1868 vsrcp a_5516_15680# 0.00436f
C1869 vbn_ax a_268_18520# 0.43888f
C1870 pl_en a_672_20034# 0.16941f
C1871 vsrcp a_3272_6334# 0
C1872 m1_7702_15650# m1_8466_15350# 0.08616f
C1873 en a_3136_4480# 0.11914f
C1874 a_6680_5520# vs 0.21879f
C1875 m1_2792_6140# a_8248_5320# 0.06277f
C1876 m1_1046_17880# a_2180_13234# 0.08347f
C1877 ta3 m1_5432_10260# 0.00834f
C1878 a_5268_14218# a_6140_14314# 0.12929f
C1879 tb3 ta0 0.00276f
C1880 vbp_st m1_1080_6970# 0.28405f
C1881 m1_5504_19890# a_5524_16920# 0.007f
C1882 m1_2792_6140# vdd 0.99014f
C1883 sel0 abus 4.14952f
C1884 vbn_ax m1_2792_6140# 0.01013f
C1885 a_5268_9138# vbn_prb 0.02765f
C1886 m1_7130_19630# ta1 0.01495f
C1887 a_5268_9138# pl_en 0.11759f
C1888 chain m1_7206_18030# 0.05483f
C1889 m1_3902_19900# vdd 0.23237f
C1890 en ta0 0.01877f
C1891 a_5268_9138# a_4588_13668# 0
C1892 vbn_ax m1_3902_19900# 0.74376f
C1893 tb3 ta2 0.066f
C1894 vdd m1_7930_16790# 0.07861f
C1895 a_488_17120# a_5524_16920# 0.09721f
C1896 vbp_st a_8248_5320# 0.1502f
C1897 vbn_ax m1_7930_16790# 0
C1898 a_6680_5520# m1_5942_6980# 0
C1899 vdd m1_2708_380# 0.02691f
C1900 en a_5524_11840# 0.03361f
C1901 m1_2712_15340# a_2800_17120# 0.06797f
C1902 m1_2712_15340# a_4588_13668# 0
C1903 a_2592_8154# sta 0.45882f
C1904 tb0 a_5524_16920# 0.00159f
C1905 m1_910_6150# a_488_5520# 0.02758f
C1906 a_824_16080# d2 0.02194f
C1907 vbp_st vdd 6.09809f
C1908 vbn_leak m1_2236_8010# 0.00188f
C1909 en ta2 0.18456f
C1910 a_2800_17120# m1_1046_17880# 0.02524f
C1911 vbn_ax vbp_st 4.12235f
C1912 a_2180_13234# ta1 0
C1913 m1_7702_15650# vsrcp 0
C1914 d1_bsel a_5316_18520# 0.00151f
C1915 m1_2122_6150# a_1480_3834# 0.03781f
C1916 d1 a_4588_8588# 0.16725f
C1917 a_2592_8154# a_6672_14314# 0.09427f
C1918 a_2592_8154# hold 0.6754f
C1919 a_2592_8154# m1_1046_10270# 0.20692f
C1920 a_488_12040# m1_7158_7910# 0.00264f
C1921 m1_2668_7940# a_1480_3834# 0
C1922 spk a_8248_5320# 0.35684f
C1923 a_672_20034# a_268_18520# 0
C1924 a_4660_4480# a_2800_5520# 0.0865f
C1925 d1 a_7540_3120# 0.10908f
C1926 vdd spk 4.83829f
C1927 ta1 m1_5286_6830# 0.03007f
C1928 tb2 a_5524_16920# 0.00332f
C1929 vbn_ax spk 0.08504f
C1930 pl_en ta1 0.03708f
C1931 tb1 a_5524_16920# 0
C1932 a_3136_4480# a_5516_15680# 0.00945f
C1933 a_3272_6334# a_3136_4480# 0.29021f
C1934 ta3 a_5516_10600# 0
C1935 m1_9090_11710# a_5524_11840# 0.01111f
C1936 a_4588_13668# ta1 0.03054f
C1937 m1_7130_19630# stb 0.00251f
C1938 tb3 vdd 0.47109f
C1939 a_4096_6334# vreset 0.09484f
C1940 abus vs 0.04038f
C1941 a_6984_3120# mreset 0.07776f
C1942 m1_2792_6140# m1_2712_6970# 0.03366f
C1943 m1_7158_13030# m1_7702_12990# 0.09347f
C1944 m1_4882_3700# a_3136_4480# 0.34703f
C1945 a_2592_8154# m1_5432_10260# 0.09702f
C1946 a_5268_14218# vbp_syn 0.00519f
C1947 m1_7206_18030# a_5524_16920# 0.00107f
C1948 vbn_ax tb3 0.13777f
C1949 m1_5190_15350# m1_6940_14170# 0.00269f
C1950 a_4096_6334# a_2800_5520# 0.34516f
C1951 m1_3902_19900# a_672_20034# 0.15274f
C1952 a_824_11000# a_2492_11000# 0.01713f
C1953 ta3 vbn_leak 0.27013f
C1954 m1_1968_380# m1_2708_380# 0.19165f
C1955 sel1 sta 0.44541f
C1956 vdd en 0.44334f
C1957 a_3048_11000# vbp_syn 0.15713f
C1958 ta0 a_5516_15680# 0
C1959 vbn_ax en 0.05438f
C1960 vsrc a_1480_3834# 0.0532f
C1961 a_4660_4480# a_6328_4480# 0.02059f
C1962 m1_1046_17880# a_268_18520# 0.45361f
C1963 ta3 el 0.09314f
C1964 m1_4882_3700# ta0 0
C1965 vbn_leak a_6594_420# 0.48957f
C1966 stb a_2180_13234# 0.04572f
C1967 sel0 m1_7206_2340# 0.01655f
C1968 vbp_st m1_2712_6970# 0.10109f
C1969 sel1 a_6672_14314# 0.15791f
C1970 a_488_12040# d2 0.08798f
C1971 ta2 a_5516_15680# 0
C1972 sel1 hold 0.07124f
C1973 a_824_16080# a_824_18520# 0
C1974 a_2592_8154# a_3212_19360# 0.60773f
C1975 vsrc vbn_prb 0.1796f
C1976 a_6680_5520# a_4660_4480# 0.04993f
C1977 a_4096_6334# a_6328_4480# 0.00287f
C1978 a_2492_11000# vbn_leak 0.00173f
C1979 d2 m1_2862_14560# 0.08667f
C1980 chain vsrcp 0.15942f
C1981 a_6594_420# el 0.06213f
C1982 m1_4568_19890# m1_2956_19890# 0.00533f
C1983 vbn_leak a_2492_3120# 0
C1984 hold a_1892_3934# 0
C1985 m1_7702_15650# a_3136_4480# 0.00397f
C1986 a_2492_11000# el 0.01825f
C1987 vbp_st a_5268_9138# 0.38946f
C1988 a_3048_3120# mreset 0.00153f
C1989 a_6680_5520# a_4096_6334# 0.15527f
C1990 a_824_3120# a_2492_3120# 0.00575f
C1991 abus m1_8466_10270# 0.03053f
C1992 a_2492_16080# vbp_syn 0.00259f
C1993 el a_2492_3120# 0.22313f
C1994 vsrc m1_8326_19030# 0
C1995 a_5524_16920# m1_8466_15350# 0
C1996 stb pl_en 0.0147f
C1997 ta1 a_268_18520# 0.02221f
C1998 a_3048_11000# a_6884_4480# 0.09514f
C1999 a_3048_3120# m1_3676_6970# 0.019f
C2000 m1_9090_11710# vdd 0.08576f
C2001 a_5268_14218# sta 0.33845f
C2002 sel0 vs 0.39221f
C2003 spk m1_2712_6970# 0.00264f
C2004 m1_7702_15650# ta0 0
C2005 m1_2122_6150# m1_2792_6140# 0.001f
C2006 tb3 a_672_20034# 0.00798f
C2007 m1_7130_19630# m1_6190_19900# 0.01807f
C2008 chain m1_6494_5850# 0.00995f
C2009 a_3048_11000# sta 0.01347f
C2010 m1_2792_6140# ta1 0
C2011 m1_1968_380# en 0.01856f
C2012 vbn_leak a_728_3738# 0.0272f
C2013 a_2592_8154# a_5516_10600# 0.11353f
C2014 a_5268_14218# a_6672_14314# 0.02127f
C2015 m1_7702_15650# ta2 0
C2016 a_5268_14218# hold 0.40553f
C2017 chain d1_bsel 0.00882f
C2018 m1_9090_16790# vbn_prb 0
C2019 m1_2792_6140# m1_2668_7940# 0
C2020 abus a_488_12040# 0
C2021 a_5268_14218# m1_2678_13100# 0
C2022 vsrcp m1_6968_15350# 0.03522f
C2023 a_3272_6334# a_8248_5320# 0.05577f
C2024 a_728_3738# a_824_3120# 0.00436f
C2025 chain m1_6494_7910# 0.00198f
C2026 a_3048_16080# m1_5190_15350# 0.09323f
C2027 m1_3902_19900# ta1 0.11204f
C2028 a_728_3738# el 0.01571f
C2029 ta3 a_4588_8588# 0.06326f
C2030 en a_672_20034# 0.13572f
C2031 m1_4882_3700# a_8248_5320# 0.00456f
C2032 a_3048_11000# hold 0.91666f
C2033 vdd a_5516_15680# 0.28121f
C2034 a_488_17120# a_488_19360# 0.00353f
C2035 a_2592_8154# vbn_leak 0.40671f
C2036 m1_2122_6150# vbp_st 0.01984f
C2037 vdd a_3272_6334# 0.91634f
C2038 a_3048_11000# m1_1046_10270# 0.07801f
C2039 vdd a_5316_18520# 0.28824f
C2040 a_3048_11000# m1_2678_13100# 0
C2041 sel1 a_3212_19360# 0
C2042 vbn_leak vbn_ref 0.1224f
C2043 vbn_ax a_3272_6334# 0.14659f
C2044 vdd m1_4882_3700# 0.01085f
C2045 vbn_ax a_5316_18520# 0.00349f
C2046 vs m1_7206_2340# 0.13674f
C2047 vbn_ax m1_4882_3700# 0.23791f
C2048 vsrcp a_5524_16920# 0.29761f
C2049 m1_9090_16790# m1_8326_19030# 0
C2050 m1_6190_19900# a_2180_13234# 0
C2051 vsrc a_268_18520# 0.78638f
C2052 m1_5190_15350# m1_7158_13030# 0.04229f
C2053 vbp_st ta1 0.06294f
C2054 a_2592_8154# el 0.12066f
C2055 a_5268_9138# en 0.34501f
C2056 vbn_ref el 0.04756f
C2057 vreset a_6984_3120# 0
C2058 vbp_st m1_2668_7940# 0.01231f
C2059 vsrcp a_6140_9234# 0.48518f
C2060 ta3 a_7540_3120# 0.00175f
C2061 d1 m1_5286_6830# 0.09801f
C2062 d1 vbn_prb 0.07591f
C2063 chain a_3136_4480# 0.17482f
C2064 d1 pl_en 0.04345f
C2065 d1 a_4588_13668# 0
C2066 m1_2792_6140# vsrc 0.05966f
C2067 a_6594_420# a_7540_3120# 0
C2068 m1_3676_6970# vbp_syn 0
C2069 hold a_2492_16080# 0.05698f
C2070 stb a_268_18520# 0.00759f
C2071 a_3048_11000# m1_5432_10260# 0
C2072 abus a_4096_6334# 0.03346f
C2073 m1_6190_19900# pl_en 0.00308f
C2074 chain ta0 0.00353f
C2075 m1_7702_15650# vdd 0.24692f
C2076 a_6984_3120# a_6328_4480# 0.00519f
C2077 sta a_6984_18520# 0.04427f
C2078 vsrc m1_2708_380# 0.06455f
C2079 vbp_st vsrc 0.11131f
C2080 chain a_5524_11840# 0.24317f
C2081 m1_9090_16790# a_268_18520# 0.00458f
C2082 tb3 ta1 0.02484f
C2083 chain ta2 0.05914f
C2084 m1_3902_19900# stb 0.17077f
C2085 m1_1968_380# a_3272_6334# 0
C2086 a_6884_4480# mreset 0
C2087 sel1 vbn_leak 0.29904f
C2088 hold a_6984_18520# 0.05928f
C2089 a_2800_5520# a_488_5520# 0.00598f
C2090 a_3048_3120# a_2800_5520# 0.29522f
C2091 m1_6968_10190# sta 0.02725f
C2092 a_3048_16080# m1_5504_19890# 0.20407f
C2093 en ta1 0.0546f
C2094 a_3136_4480# m1_6968_15350# 0.06745f
C2095 m1_3676_6970# a_6884_4480# 0
C2096 a_3272_6334# m1_2712_6970# 0.00957f
C2097 vbn_leak a_1892_3934# 0.08786f
C2098 a_3048_16080# m1_7790_19900# 0
C2099 a_2592_8154# a_4588_8588# 0.03843f
C2100 a_672_20034# a_5316_18520# 0
C2101 m1_3902_19900# m1_9090_16790# 0
C2102 m1_910_6150# m1_642_6980# 0.00105f
C2103 a_3048_16080# a_488_17120# 0.8436f
C2104 m1_6968_10190# hold 0.06074f
C2105 el a_1892_3934# 0.05822f
C2106 ta3 m1_7130_19630# 0.05541f
C2107 d1 a_268_18520# 1.8616f
C2108 vsrc spk 0.13482f
C2109 sta a_6672_9234# 0.00677f
C2110 a_3136_4480# a_5524_16920# 0.19205f
C2111 ta0 m1_6968_15350# 0.02472f
C2112 a_3048_16080# tb0 0.02756f
C2113 a_6140_9234# a_3136_4480# 0.01297f
C2114 sel0 a_4096_6334# 0.09006f
C2115 a_488_12040# m1_7930_11710# 0.00715f
C2116 a_3048_11000# a_824_11000# 0
C2117 vbp_st m1_9090_16790# 0.00366f
C2118 vbn_ref a_7540_3120# 0
C2119 m1_3676_6970# hold 0.29946f
C2120 a_6672_9234# hold 0.00964f
C2121 m1_2792_6140# d1 0.19746f
C2122 ta2 m1_6968_15350# 0.09622f
C2123 a_6680_5520# a_3048_3120# 0
C2124 a_3048_11000# a_5516_10600# 0.05006f
C2125 ta0 a_5524_16920# 0.07227f
C2126 a_5268_14218# vbn_leak 0.21595f
C2127 a_3048_18520# a_488_19360# 0.01063f
C2128 ta3 m1_4282_6970# 0.00262f
C2129 vsrc en 0.30092f
C2130 vbn_leak sel2 0.39868f
C2131 a_6140_9234# ta0 0.02633f
C2132 chain vdd 0.95781f
C2133 tb3 stb 0
C2134 a_5524_11840# a_5524_16920# 0.00142f
C2135 vbn_ax chain 0.04902f
C2136 m1_910_6150# vbn_leak 0.00144f
C2137 m1_6968_10190# m1_5432_10260# 0.00259f
C2138 a_5268_14218# el 0.00373f
C2139 a_6140_14314# d2 0.07917f
C2140 a_3048_11000# vbn_leak 0.2145f
C2141 ta2 a_5524_16920# 0.03854f
C2142 a_3048_16080# tb2 0.08272f
C2143 sel2 el 0.02317f
C2144 a_6140_9234# a_5524_11840# 0.68871f
C2145 a_3048_16080# tb1 0.31969f
C2146 m1_2956_19890# vbp_syn 0.00947f
C2147 a_4096_6334# m1_7206_2340# 0.01333f
C2148 a_6140_9234# ta2 0.02791f
C2149 vbp_st d1 0.43874f
C2150 m1_3902_19900# m1_6190_19900# 0.20439f
C2151 a_3048_11000# el 0.36665f
C2152 en stb 0.00794f
C2153 a_3136_4480# a_5316_3120# 0.06449f
C2154 vsrcp m1_7702_12990# 0.001f
C2155 m1_2122_6150# a_3272_6334# 0.00355f
C2156 ta3 m1_5286_6830# 0.17913f
C2157 a_6672_9234# m1_5432_10260# 0.05627f
C2158 a_488_12040# m1_7150_9086# 0
C2159 a_3048_16080# m1_7206_18030# 0.01567f
C2160 ta3 vbn_prb 0
C2161 ta3 pl_en 0.08003f
C2162 tb3 m1_9090_16790# 0
C2163 a_2592_8154# a_2492_18520# 0.02146f
C2164 ta1 a_5516_15680# 0
C2165 m1_5504_19890# m1_7790_19900# 0.02813f
C2166 a_4588_8588# a_1892_3934# 0
C2167 vbn_leak m1_7702_10190# 0.07702f
C2168 ta3 a_4588_13668# 0.08996f
C2169 vs a_4660_4480# 0.51584f
C2170 a_6594_420# vbn_prb 0.46801f
C2171 m1_5504_19890# a_488_17120# 0.15061f
C2172 a_2492_3120# a_1480_3834# 0
C2173 vbn_leak a_2492_16080# 0
C2174 vsrcp m1_6940_14170# 0.3853f
C2175 a_488_17120# m1_7790_19900# 0
C2176 vs a_4096_6334# 0.66673f
C2177 vdd m1_6968_15350# 0.01748f
C2178 a_2592_8154# m1_7130_19630# 0.10149f
C2179 m1_5504_19890# tb0 0.11066f
C2180 d1 spk 0.2733f
C2181 a_488_12040# m1_8466_10270# 0.05409f
C2182 a_2492_16080# el 0.0015f
C2183 a_1892_3934# a_7540_3120# 0.03152f
C2184 tb0 m1_7790_19900# 0.17658f
C2185 sel1 m1_6716_16790# 0
C2186 vdd a_5524_16920# 1.10852f
C2187 a_488_17120# tb0 0.03001f
C2188 vbn_ax a_5524_16920# 0.00524f
C2189 chain m1_2712_6970# 0.02472f
C2190 chain a_672_20034# 0.07421f
C2191 vbn_leak a_6984_18520# 0.00171f
C2192 a_728_3738# a_1480_3834# 0.2052f
C2193 vdd a_6140_9234# 1.17796f
C2194 m1_7702_15650# ta1 0
C2195 a_2592_8154# a_2180_13234# 0.11432f
C2196 vsrc a_3272_6334# 0.53485f
C2197 m1_6968_10190# a_5516_10600# 0.00293f
C2198 d1 en 0.20157f
C2199 a_3048_16080# a_3048_18520# 0
C2200 a_3048_16080# m1_8466_15350# 0.04161f
C2201 tb3 m1_6190_19900# 0.04661f
C2202 vsrc m1_4882_3700# 0.20993f
C2203 a_6884_4480# a_6328_4480# 0.03426f
C2204 d1_bsel a_488_19360# 0.03863f
C2205 a_3048_11000# a_4588_8588# 0.0075f
C2206 d2 vbp_syn 0.50036f
C2207 tb2 m1_5504_19890# 0.32468f
C2208 vbp_st m1_2236_8010# 0.0011f
C2209 sel0 a_6984_3120# 0.0231f
C2210 hold a_2800_5520# 0.0022f
C2211 vsrcp m1_7684_7940# 0.00771f
C2212 m1_5504_19890# tb1 0.08151f
C2213 hold m1_2956_19890# 0.01332f
C2214 a_488_12040# m1_2862_14560# 0.00276f
C2215 m1_6968_10190# vbn_leak 0.16235f
C2216 chain a_5268_9138# 0.05288f
C2217 tb2 m1_7790_19900# 0.00854f
C2218 ta3 a_268_18520# 0.02964f
C2219 en m1_6190_19900# 0
C2220 tb1 m1_7790_19900# 0.0092f
C2221 vbn_leak mreset 0.27295f
C2222 a_6680_5520# a_6884_4480# 0.04621f
C2223 m1_5504_19890# m1_7206_18030# 0.00193f
C2224 stb a_5316_18520# 0
C2225 hold m1_7158_7910# 0.00424f
C2226 tb2 a_488_17120# 0.03115f
C2227 m1_7702_12990# a_3136_4480# 0.10968f
C2228 a_488_17120# tb1 0.14452f
C2229 a_2592_8154# vbn_prb 0
C2230 a_2592_8154# pl_en 0.12622f
C2231 a_6594_420# a_268_18520# 0.06961f
C2232 a_5268_14218# m1_6716_16790# 0.0231f
C2233 vbn_ref vbn_prb 0.48952f
C2234 el mreset 0.10317f
C2235 ta3 m1_2792_6140# 0.01084f
C2236 m1_3676_6970# vbn_leak 0.55125f
C2237 a_6672_9234# vbn_leak 0.07323f
C2238 vdd m1_2112_14220# 0.23047f
C2239 tb2 tb0 0.28975f
C2240 sel1 m1_7130_19630# 0
C2241 hold a_6328_4480# 0
C2242 vdd a_5316_3120# 0.00349f
C2243 a_2592_8154# a_4588_13668# 0.02005f
C2244 a_488_17120# m1_7206_18030# 0.41324f
C2245 tb1 tb0 0.39724f
C2246 ta3 m1_3902_19900# 0.05242f
C2247 a_3136_4480# m1_6940_14170# 0.00415f
C2248 m1_7206_2340# a_6984_3120# 0.61493f
C2249 a_3048_16080# vsrcp 0.00183f
C2250 m1_5190_15350# vsrcp 0.06274f
C2251 m1_2792_6140# a_6594_420# 0
C2252 a_2492_3120# a_268_18520# 0.29741f
C2253 a_6672_9234# el 0.01573f
C2254 ta3 m1_7930_16790# 0.00177f
C2255 a_2592_8154# m1_8326_19030# 0.10021f
C2256 a_6680_5520# hold 0.07774f
C2257 m1_7158_7910# m1_5432_10260# 0.09255f
C2258 vbp_st ta3 0.1706f
C2259 sel1 a_2180_13234# 0.06942f
C2260 a_2800_12040# vsrcp 0
C2261 a_5268_9138# m1_6968_15350# 0
C2262 ta0 m1_6940_14170# 0.05847f
C2263 sta d2 0.00799f
C2264 a_3136_4480# m1_2722_2630# 0.08762f
C2265 m1_2708_380# a_6594_420# 0
C2266 chain ta1 0.01948f
C2267 tb2 tb1 0.45124f
C2268 m1_4282_6970# a_1892_3934# 0.00264f
C2269 a_3212_19360# m1_2956_19890# 0.00517f
C2270 vs a_6984_3120# 0
C2271 d1 a_3272_6334# 0.04275f
C2272 d2 a_6672_14314# 0.00307f
C2273 hold d2 0.47588f
C2274 vsrcp m1_2062_6980# 0.0058f
C2275 a_728_3738# a_268_18520# 0
C2276 d1 m1_4882_3700# 0.36798f
C2277 ta2 m1_6940_14170# 0.03511f
C2278 tb2 m1_7206_18030# 0
C2279 a_4096_6334# a_4660_4480# 0.12049f
C2280 m1_2678_13100# d2 0.13831f
C2281 tb1 m1_7206_18030# 0.0054f
C2282 a_1892_3934# a_1480_3834# 0.05177f
C2283 m1_7684_7940# a_3136_4480# 0.10946f
C2284 a_5268_9138# a_6140_9234# 0.26755f
C2285 m1_6968_10190# a_4588_8588# 0.01666f
C2286 sel1 vbn_prb 0.14483f
C2287 a_488_17120# m1_8466_15350# 0.05739f
C2288 a_3048_18520# a_488_17120# 0.00794f
C2289 sel1 pl_en 0.00203f
C2290 a_2592_8154# a_268_18520# 0.13191f
C2291 m1_2792_6140# a_728_3738# 0.0106f
C2292 vbn_ref a_268_18520# 0
C2293 a_2492_16080# a_2492_18520# 0.00101f
C2294 ta3 tb3 0.00387f
C2295 spk a_6594_420# 0.0927f
C2296 a_5268_14218# a_2180_13234# 0.02343f
C2297 a_7540_18520# vbp_syn 0.00838f
C2298 m1_3676_6970# a_4588_8588# 0.00461f
C2299 a_6672_9234# a_4588_8588# 0
C2300 a_6984_18520# m1_6716_16790# 0
C2301 chain vsrc 0
C2302 m1_6968_15350# ta1 0.08837f
C2303 a_7540_3120# mreset 0.07759f
C2304 a_3048_11000# m1_4282_6970# 0
C2305 m1_2062_6980# m1_6494_5850# 0.08641f
C2306 m1_7684_7940# a_5524_11840# 0
C2307 ta3 en 0.13589f
C2308 vbp_st a_728_3738# 0.08389f
C2309 a_3048_3120# vs 0.00207f
C2310 m1_7684_7940# ta2 0.00309f
C2311 m1_5190_15350# a_3136_4480# 0.14973f
C2312 a_3048_16080# a_3136_4480# 0.08968f
C2313 a_2592_8154# m1_3902_19900# 0.25832f
C2314 vbn_leak vreset 0.3202f
C2315 vs a_488_5520# 0.55493f
C2316 vbn_leak a_2800_5520# 0.09842f
C2317 a_2592_8154# m1_7930_16790# 0.01156f
C2318 abus a_6672_14314# 0.03501f
C2319 en a_6594_420# 0.14986f
C2320 m1_910_6150# a_1480_3834# 0
C2321 m1_2062_6980# m1_6494_7910# 0.00166f
C2322 vsrcp a_488_17120# 0
C2323 vbn_leak m1_2956_19890# 0.30159f
C2324 ta1 a_5524_16920# 0.06138f
C2325 vdd a_488_19360# 1.55804f
C2326 chain stb 0.07042f
C2327 a_5268_14218# pl_en 0.11336f
C2328 m1_2712_15340# m1_2112_14220# 0
C2329 vreset el 0.03898f
C2330 a_2800_12040# a_3136_4480# -0.01941f
C2331 m1_7158_13030# a_3136_4480# 0.11839f
C2332 vbp_st a_2592_8154# 0.102f
C2333 a_2800_5520# el 0.10114f
C2334 vbn_leak m1_7158_7910# 0.00249f
C2335 a_6140_9234# ta1 0.03802f
C2336 sel2 vbn_prb 0.52519f
C2337 a_5268_14218# a_4588_13668# 0.04687f
C2338 vsrcp tb0 0
C2339 a_3212_19360# d2 0.13578f
C2340 a_3048_16080# ta0 0.00668f
C2341 vbp_st vbn_ref 0.03502f
C2342 m1_5190_15350# ta0 0.00334f
C2343 a_3048_11000# vbn_prb 0
C2344 a_3048_11000# m1_5286_6830# 0.67583f
C2345 en a_2492_3120# 0.00141f
C2346 a_3048_11000# pl_en 0.02714f
C2347 m1_6716_11710# sta 0.00566f
C2348 a_2180_13234# a_2492_16080# 0.09019f
C2349 m1_5190_15350# a_5524_11840# 0
C2350 a_3048_11000# a_4588_13668# 0
C2351 m1_7130_19630# a_6984_18520# 0
C2352 m1_2062_6980# a_3136_4480# 0.13094f
C2353 m1_5190_15350# ta2 0.01814f
C2354 m1_7158_13030# ta0 0.00719f
C2355 sel1 a_268_18520# 0.00967f
C2356 a_3048_16080# ta2 0.04682f
C2357 m1_5504_19890# d1_bsel 0.00917f
C2358 vdd m1_2722_2630# 0.02282f
C2359 sta a_7540_18520# 0.00219f
C2360 m1_6716_11710# hold 0.00711f
C2361 a_1892_3934# a_268_18520# 0.10279f
C2362 el a_6328_4480# 0.13147f
C2363 a_6680_5520# vbn_leak 0.02511f
C2364 m1_7702_10190# vbn_prb 0.03436f
C2365 a_2800_12040# a_5524_11840# 0
C2366 m1_7158_13030# ta2 0.02821f
C2367 a_488_17120# d1_bsel 0
C2368 vbn_ref spk 0.15658f
C2369 m1_2062_6980# ta0 0.13711f
C2370 a_7540_18520# hold 0.15403f
C2371 a_2592_8154# tb3 0.05197f
C2372 a_6680_5520# el 0.11403f
C2373 m1_3902_19900# sel1 0.00567f
C2374 a_2180_13234# a_6984_18520# 0.02504f
C2375 m1_2792_6140# a_1892_3934# 0.06133f
C2376 a_6140_9234# vsrc 0
C2377 chain d1 0.16107f
C2378 sel1 m1_7930_16790# 0.00165f
C2379 a_2800_17120# a_2492_16080# 0.00412f
C2380 a_6884_4480# m1_7206_2340# 0.00141f
C2381 m1_2062_6980# a_5524_11840# 0
C2382 m1_2062_6980# ta2 0.12252f
C2383 ta3 a_5516_15680# 0
C2384 a_2592_8154# en 0.49585f
C2385 a_4096_6334# a_6984_3120# 0
C2386 vbp_st sel1 0.0244f
C2387 vbn_leak d2 0.33729f
C2388 a_5268_14218# a_268_18520# 0.04641f
C2389 vbn_ref en 0.0022f
C2390 a_672_20034# a_488_19360# 0.01864f
C2391 a_5268_9138# m1_7702_12990# 0.00125f
C2392 chain m1_6190_19900# 0.00763f
C2393 a_3272_6334# a_6594_420# 0.23924f
C2394 a_488_17120# a_3136_4480# 0
C2395 vbp_st a_1892_3934# 0
C2396 sel2 a_268_18520# 0.02159f
C2397 m1_5504_19890# ta0 0.00123f
C2398 d2 el 0.56107f
C2399 a_6984_18520# pl_en 0
C2400 a_3048_16080# vdd 1.24792f
C2401 a_4588_8588# m1_7158_7910# 0.27075f
C2402 m1_5190_15350# vdd 0.00898f
C2403 a_3048_16080# vbn_ax 0.04441f
C2404 m1_1968_380# m1_2722_2630# 0.00113f
C2405 m1_7790_19900# ta0 0
C2406 vreset a_7540_3120# 0
C2407 m1_2062_6980# m1_1080_6970# 0.1034f
C2408 m1_3676_6970# m1_4282_6970# 0.03845f
C2409 m1_9090_16790# a_5524_16920# 0.01091f
C2410 a_3272_6334# a_2492_3120# 0.25374f
C2411 vs a_6884_4480# 0
C2412 vsrc a_5316_3120# 0.00652f
C2413 a_2800_5520# a_7540_3120# -0.01518f
C2414 a_488_17120# ta0 0.03005f
C2415 m1_910_6150# m1_2792_6140# 0
C2416 a_2800_12040# vdd 1.22682f
C2417 m1_5504_19890# ta2 0.058f
C2418 a_3048_3120# a_4660_4480# 0
C2419 a_3048_11000# m1_2792_6140# 0.0088f
C2420 m1_6968_10190# pl_en 0.09687f
C2421 a_5268_14218# m1_7930_16790# 0.0148f
C2422 m1_7206_18030# d1_bsel 0
C2423 m1_7790_19900# ta2 0
C2424 vbn_prb mreset 0.56798f
C2425 ta3 m1_7702_15650# 0.01251f
C2426 m1_1046_17880# a_488_19360# 0.03569f
C2427 vsrcp m1_8466_15350# 0
C2428 m1_7702_10190# a_268_18520# 0
C2429 a_7540_18520# a_3212_19360# 0.00681f
C2430 vbp_st a_5268_14218# 0.37098f
C2431 a_488_17120# ta2 0.02755f
C2432 a_3048_3120# a_4096_6334# 0.01303f
C2433 spk a_1892_3934# 0.05398f
C2434 m1_3676_6970# m1_5286_6830# 0.13559f
C2435 vdd m1_2062_6980# 0.2281f
C2436 abus vbn_leak 0.24495f
C2437 m1_3676_6970# pl_en 0
C2438 a_6672_9234# pl_en 0.0151f
C2439 vbp_st sel2 0.03412f
C2440 a_6672_9234# vbn_prb 0.04464f
C2441 a_6328_4480# a_7540_3120# 0.14756f
C2442 vbp_st m1_910_6150# 0.01206f
C2443 vs hold 0.24888f
C2444 d1 a_5524_16920# 0
C2445 a_728_3738# a_3272_6334# 0.09442f
C2446 vbp_st a_3048_11000# 0.52882f
C2447 sel1 en 0.2153f
C2448 abus el 0.09812f
C2449 a_6140_9234# d1 0.07441f
C2450 a_488_12040# vbp_syn 0.04451f
C2451 m1_2862_14560# vbp_syn 0.10925f
C2452 a_6680_5520# a_7540_3120# 0.0706f
C2453 tb2 ta0 0
C2454 a_2592_8154# a_5316_18520# 0.2206f
C2455 vbn_ref a_3272_6334# 0.16746f
C2456 a_6984_18520# a_268_18520# 0.01386f
C2457 hold m1_5942_6980# 0.01198f
C2458 vbp_st m1_7702_10190# 0.00102f
C2459 ta1 m1_6940_14170# 0.03814f
C2460 a_3048_18520# d1_bsel 0.00263f
C2461 m1_5504_19890# vdd 0.28836f
C2462 sel2 spk 0.0766f
C2463 tb2 ta2 0
C2464 ta0 m1_7206_18030# 0.03407f
C2465 vbn_ax m1_5504_19890# 0.50327f
C2466 vdd m1_7790_19900# 0
C2467 a_7540_18520# vbn_leak 0.00767f
C2468 d1 a_5316_3120# 0.19599f
C2469 ta2 m1_7206_18030# 0.03107f
C2470 a_488_17120# vdd 1.83573f
C2471 a_5268_14218# en 0.19293f
C2472 m1_3902_19900# a_6984_18520# 0.05479f
C2473 vbn_ax a_488_17120# 0.18867f
C2474 sel0 vbn_leak 0.04495f
C2475 a_268_18520# mreset 0.0877f
C2476 ta3 chain 0.06295f
C2477 sel2 en 0
C2478 d2 m1_6716_16790# 0.01771f
C2479 vdd tb0 0.88189f
C2480 a_3048_16080# m1_2712_15340# 0.28275f
C2481 m1_5190_15350# m1_2712_15340# -0
C2482 m1_7702_15650# a_2592_8154# 0.01927f
C2483 vbn_ax tb0 0.12622f
C2484 sta a_488_12040# 0.00805f
C2485 m1_4282_6970# a_2800_5520# 0
C2486 a_3048_11000# en 0.1679f
C2487 a_6672_9234# a_268_18520# 0
C2488 a_2180_13234# m1_2956_19890# 0
C2489 vsrcp m1_6494_5850# 0
C2490 sel0 el 0.04803f
C2491 chain a_6594_420# 0.04733f
C2492 m1_2062_6980# m1_2712_6970# 0.23642f
C2493 a_3048_16080# m1_1046_17880# 0.00371f
C2494 vbp_st a_6984_18520# 0.00216f
C2495 a_2800_5520# a_1480_3834# 0.00884f
C2496 sel1 a_5516_15680# 0
C2497 m1_2792_6140# m1_3676_6970# 0.00824f
C2498 vsrcp m1_6494_7910# 0.00243f
C2499 hold a_488_12040# 0.11117f
C2500 sel1 a_5316_18520# 0
C2501 m1_4568_19890# vbp_syn 0.0339f
C2502 chain a_2492_3120# 0.00329f
C2503 vs m1_642_6980# 0
C2504 m1_1046_10270# a_488_12040# 0.09249f
C2505 hold m1_2862_14560# 0.01207f
C2506 a_5268_9138# m1_2062_6980# 0
C2507 m1_2678_13100# a_488_12040# 0.00505f
C2508 m1_6968_10190# vbp_st 0
C2509 d2 a_2492_18520# 0.09537f
C2510 stb a_488_19360# 0.01987f
C2511 vreset vbn_prb 4.09469f
C2512 vbn_leak m1_7206_2340# 0.17744f
C2513 en m1_7702_10190# 0.2062f
C2514 m1_2678_13100# m1_2862_14560# 0.1433f
C2515 a_3272_6334# a_1892_3934# 0.06828f
C2516 tb2 vdd 0.97839f
C2517 vbp_st mreset 0.02683f
C2518 vbn_ax tb2 0.04076f
C2519 vsrc m1_2722_2630# 0.02134f
C2520 vdd tb1 0.33652f
C2521 vbn_ax tb1 0.1015f
C2522 vbn_leak m1_7930_11710# 0.05133f
C2523 ta3 m1_6968_15350# 0.06753f
C2524 m1_7206_2340# el 0.00247f
C2525 m1_5504_19890# a_672_20034# 0.05147f
C2526 a_6680_5520# m1_4282_6970# 0
C2527 vbp_st m1_3676_6970# 0.25995f
C2528 m1_5190_15350# ta1 0.00723f
C2529 a_3048_16080# ta1 0.053f
C2530 vdd m1_7206_18030# 0.03139f
C2531 m1_7158_7910# pl_en 0.13088f
C2532 vbp_st a_6672_9234# 0.08278f
C2533 vsrcp a_3136_4480# 0.64362f
C2534 vbn_ax m1_7206_18030# 0.29044f
C2535 hold a_4660_4480# 0
C2536 m1_7930_11710# el 0
C2537 tb3 a_6984_18520# 0
C2538 chain a_728_3738# 0
C2539 a_488_12040# m1_5432_10260# 0
C2540 a_6328_4480# m1_5286_6830# 0
C2541 m1_7158_13030# ta1 0.01823f
C2542 ta3 a_5524_16920# 0.10624f
C2543 vs vbn_leak 0.0841f
C2544 a_5268_14218# a_5516_15680# 0.00364f
C2545 m1_7702_15650# sel1 0.12518f
C2546 a_3048_18520# m1_2470_19900# 0.00942f
C2547 a_4096_6334# hold 0
C2548 a_2800_12040# m1_2668_7940# 0
C2549 ta3 a_6140_9234# 0.02919f
C2550 vsrcp ta0 0.00844f
C2551 en a_6984_18520# 0
C2552 spk mreset 4.3613f
C2553 vs a_824_3120# 0.30508f
C2554 a_2592_8154# chain 0.03262f
C2555 vs el 0.43202f
C2556 m1_2122_6150# m1_2062_6980# 0.00283f
C2557 a_6680_5520# m1_5286_6830# 0.39973f
C2558 d2 a_2180_13234# 0.27777f
C2559 vbn_leak m1_7150_9086# 0
C2560 a_824_16080# el 0.11394f
C2561 m1_3676_6970# spk 0
C2562 m1_2062_6980# ta1 0.10533f
C2563 vsrcp a_5524_11840# 0.17102f
C2564 a_3048_3120# a_488_5520# 0.01209f
C2565 vsrcp ta2 0.00969f
C2566 m1_2668_7940# m1_2062_6980# 0.0029f
C2567 m1_6494_5850# a_3136_4480# 0.06773f
C2568 m1_6968_10190# en 0.10565f
C2569 vbn_leak m1_5942_6980# 0.5572f
C2570 m1_2712_15340# a_488_17120# 0.01278f
C2571 en mreset 0.05745f
C2572 sel0 a_7540_3120# 0.00117f
C2573 m1_4568_19890# hold 0
C2574 vreset a_268_18520# 0
C2575 a_488_17120# m1_1046_17880# 0.12617f
C2576 a_3048_18520# vdd 0.37489f
C2577 a_3136_4480# m1_6494_7910# 0.09605f
C2578 vdd m1_8466_15350# 0.03014f
C2579 a_2800_5520# a_268_18520# 0.00457f
C2580 a_824_18520# a_2492_18520# 0.01033f
C2581 vbn_ax a_3048_18520# 0.01601f
C2582 tb2 a_672_20034# 0.00237f
C2583 m1_2112_9090# vbp_syn 0.27359f
C2584 d2 vbn_prb 0.00158f
C2585 d2 pl_en 0.1431f
C2586 m1_3676_6970# en 0.03294f
C2587 tb1 a_672_20034# 0
C2588 ta0 m1_6494_5850# 0.52283f
C2589 a_6672_9234# en 0.09984f
C2590 d1 m1_2722_2630# 0.2657f
C2591 vbn_leak m1_8466_10270# 0.03433f
C2592 a_2800_17120# d2 0.01448f
C2593 a_5268_14218# m1_7702_15650# 0.00111f
C2594 d2 a_4588_13668# 0.18819f
C2595 m1_5504_19890# ta1 0.00591f
C2596 m1_2792_6140# a_2800_5520# 0.03211f
C2597 m1_7206_18030# a_672_20034# 0
C2598 a_6594_420# a_5316_3120# 0
C2599 a_824_11000# a_488_12040# 0.22524f
C2600 a_2592_8154# m1_6968_15350# 0.2849f
C2601 m1_6494_5850# ta2 0.00644f
C2602 m1_7790_19900# ta1 0
C2603 m1_7206_2340# a_7540_3120# 0.13039f
C2604 a_6140_14314# vbp_syn 0
C2605 a_6328_4480# a_268_18520# 0.00226f
C2606 a_5516_10600# a_488_12040# 0.01742f
C2607 m1_3902_19900# m1_2956_19890# 0.09078f
C2608 a_488_17120# ta1 0.02807f
C2609 a_5524_11840# m1_6494_7910# 0.00501f
C2610 a_3048_16080# m1_9090_16790# 0.00555f
C2611 chain sel1 1.14624f
C2612 ta2 m1_6494_7910# 0.00144f
C2613 a_6884_4480# a_6984_3120# 0.01545f
C2614 a_2592_8154# a_5524_16920# 0.01674f
C2615 vbp_st vreset 0.03753f
C2616 vsrcp vdd 0.20828f
C2617 vbn_ax vsrcp 0.10977f
C2618 a_6680_5520# a_268_18520# 0
C2619 vbp_st a_2800_5520# 0
C2620 vbn_leak a_488_12040# 0.13196f
C2621 m1_2792_6140# a_6328_4480# 0.24643f
C2622 chain a_1892_3934# 0.57203f
C2623 a_2592_8154# a_6140_9234# 0.0112f
C2624 ta0 a_3136_4480# 0.04571f
C2625 vbn_leak m1_2862_14560# 0
C2626 a_6984_18520# a_5316_18520# 0.00663f
C2627 a_824_18520# a_2180_13234# 0.03002f
C2628 a_7540_18520# m1_7130_19630# 0.06921f
C2629 a_6328_4480# vss -0.06744f
C2630 a_3136_4480# vss 3.61197f
C2631 m1_2712_6970# vss 0.04237f
C2632 a_6594_420# vss 0.98079f
C2633 a_3272_6334# vss 2.75139f
C2634 m1_6968_10190# vss 0.23525f
C2635 a_2492_18520# vss -0.0781f
C2636 a_7540_3120# vss 0.47832f
C2637 a_2492_11000# vss 0.04827f
C2638 a_6984_18520# vss -0.1511f
C2639 vs vss 4.7439f
C2640 a_672_20034# vss 2.54825f
C2641 d1_bsel vss 1.08813f
C2642 a_2800_5520# vss -0.3675f
C2643 a_2492_16080# vss 0.07888f
C2644 hold vss 2.31858f
C2645 vbn_ax vss 3.19111f
C2646 m1_3902_19900# vss 0.93382f
C2647 tb3 vss 0.71872f
C2648 a_6672_9234# vss 0.64898f
C2649 m1_2112_14220# vss -0.09266f
C2650 a_5316_3120# vss 0.01703f
C2651 m1_5504_19890# vss 1.42486f
C2652 tb2 vss 0.16275f
C2653 chain vss 1.38853f
C2654 a_6140_9234# vss 1.26496f
C2655 a_7540_18520# vss 0.22713f
C2656 m1_7130_19630# vss 0.51784f
C2657 tb1 vss 0.57395f
C2658 m1_7702_10190# vss 0.47224f
C2659 a_5316_18520# vss -0.12516f
C2660 m1_8326_19030# vss 0.12587f
C2661 tb0 vss 0.69459f
C2662 m1_4882_3700# vss -0.19795f
C2663 m1_8466_10270# vss 0.07474f
C2664 m1_7790_19900# vss 0.15303f
C2665 a_5516_10600# vss 0.26257f
C2666 m1_6190_19900# vss 0.23525f
C2667 abus vss 3.90523f
C2668 sel0 vss 2.11182f
C2669 m1_5432_10260# vss 0.57574f
C2670 m1_9090_11710# vss -0.08187f
C2671 a_3212_19360# vss -0.31652f
C2672 m1_4568_19890# vss 0.03051f
C2673 a_824_16080# vss 0.03619f
C2674 a_488_17120# vss 1.2186f
C2675 m1_6716_11710# vss -0.09014f
C2676 m1_7930_11710# vss -0.09111f
C2677 m1_2722_2630# vss 0.24196f
C2678 pl_en vss 1.76005f
C2679 a_6884_4480# vss 0.06016f
C2680 a_4096_6334# vss 0.71604f
C2681 spk vss 5.66484f
C2682 a_2800_12040# vss 0.23699f
C2683 a_3048_16080# vss 1.39168f
C2684 m1_7684_7940# vss 0.05899f
C2685 a_4660_4480# vss -0.01626f
C2686 a_6680_5520# vss -0.42599f
C2687 m1_7158_7910# vss 0.12172f
C2688 a_6672_14314# vss 1.41506f
C2689 d1 vss 4.55583f
C2690 a_6140_14314# vss 1.10437f
C2691 m1_2112_9090# vss -0.09939f
C2692 m1_6494_7910# vss 0
C2693 a_5524_11840# vss 1.97045f
C2694 a_1480_3834# vss 0.46194f
C2695 m1_1046_17880# vss -0.18429f
C2696 m1_1046_10270# vss -0.15464f
C2697 a_824_11000# vss 0.07151f
C2698 m1_1080_6970# vss 0.22853f
C2699 m1_7206_18030# vss -0.17665f
C2700 m1_642_6980# vss 0.01031f
C2701 a_5268_9138# vss 1.75875f
C2702 vsrcp vss 2.06471f
C2703 m1_2712_15340# vss -0.08045f
C2704 m1_9090_16790# vss -0.09025f
C2705 a_5516_15680# vss 0.21107f
C2706 m1_2668_7940# vss 0.55418f
C2707 a_2592_8154# vss 1.75397f
C2708 m1_7150_9086# vss 0.06856f
C2709 m1_6716_16790# vss -0.09115f
C2710 m1_7930_16790# vss -0.07247f
C2711 vdd vss 99.93183f
C2712 m1_1968_380# vss 0.60451f
C2713 sel1 vss 0.8887f
C2714 a_2800_17120# vss -0.03576f
C2715 m1_2236_8010# vss -0.00817f
C2716 sta vss 0.92483f
C2717 m1_2792_6140# vss 0.72147f
C2718 vbp_st vss 1.61054f
C2719 m1_2708_380# vss 0.08605f
C2720 en vss 2.96057f
C2721 m1_2122_6150# vss -0.08974f
C2722 m1_910_6150# vss -0.08216f
C2723 m1_6968_15350# vss 0.09066f
C2724 a_5524_16920# vss 2.27694f
C2725 m1_7702_12990# vss 0.48303f
C2726 vbn_prb vss 4.78784f
C2727 a_4588_13668# vss 1.15811f
C2728 m1_5190_15350# vss 0.44116f
C2729 m1_7158_13030# vss -0.04292f
C2730 mreset vss 2.37863f
C2731 a_6984_3120# vss 0.06841f
C2732 m1_7206_2340# vss 0.1223f
C2733 m1_2062_6980# vss 0.95571f
C2734 m1_3676_6970# vss 0.95247f
C2735 m1_6494_13030# vss -0.03141f
C2736 a_488_12040# vss 2.5557f
C2737 m1_5286_6830# vss 0.14598f
C2738 a_5268_14218# vss 1.03815f
C2739 m1_2956_19890# vss 0.00858f
C2740 vbp_syn vss 0.38897f
C2741 a_728_3738# vss 0.4058f
C2742 vsrc vss 1.65267f
C2743 m1_2470_19900# vss -0.02625f
C2744 m1_2678_13100# vss 0.39773f
C2745 stb vss 1.47618f
C2746 a_4588_8588# vss 1.09553f
C2747 a_3048_11000# vss 0.66141f
C2748 ta3 vss 0.63043f
C2749 a_2492_3120# vss 0.15742f
C2750 sel2 vss 2.09905f
C2751 vreset vss 1.50514f
C2752 vbn_ref vss 0.4212f
C2753 m1_2862_14560# vss 0.11121f
C2754 d2 vss 3.43086f
C2755 a_2180_13234# vss 1.32792f
C2756 a_824_18520# vss -0.13679f
C2757 a_488_19360# vss 0.25454f
C2758 ta2 vss 0.91867f
C2759 m1_6940_14170# vss 0.29939f
C2760 a_3048_3120# vss 0.37201f
C2761 m1_7702_15650# vss 0.73958f
C2762 m1_8466_15350# vss 0.07059f
C2763 m1_5942_6980# vss 0.0784f
C2764 ta1 vss 0.79059f
C2765 a_824_3120# vss -0.00471f
C2766 a_488_5520# vss 0.12495f
C2767 el vss 5.06818f
C2768 a_3048_18520# vss -0.02442f
C2769 m1_4282_6970# vss 0.03581f
C2770 m1_6494_5850# vss 0.1321f
C2771 ta0 vss 0.45376f
C2772 a_268_18520# vss 1.98659f
C2773 a_1892_3934# vss 0.57403f
C2774 vbn_leak vss 12.42878f
C2775 a_8248_5320# vss 0.26283f
.ends
