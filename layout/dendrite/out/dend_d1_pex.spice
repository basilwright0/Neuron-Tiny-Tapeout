* NGSPICE file created from dend_d1.ext - technology: gf180mcuD

.subckt n_w4_l1 a_n188_n400# a_100_n400# a_n100_n444# VSUBS
X0 a_100_n400# a_n100_n444# a_n188_n400# VSUBS nfet_03v3 ad=1.76p pd=8.88u as=1.76p ps=8.88u w=4u l=1u
C0 a_n188_n400# a_100_n400# 0.07756f
C1 a_n100_n444# a_100_n400# 0.08505f
C2 a_n100_n444# a_n188_n400# 0.08505f
C3 a_100_n400# VSUBS 0.26859f
C4 a_n188_n400# VSUBS 0.26859f
.ends

.subckt n_w2_l4 a_400_n200# a_n400_n244# a_n488_n200# VSUBS
X0 a_400_n200# a_n400_n244# a_n488_n200# VSUBS nfet_03v3 ad=0.88p pd=4.88u as=0.88p ps=4.88u w=2u l=4u
C0 a_n488_n200# a_400_n200# 0.01073f
C1 a_n400_n244# a_400_n200# 0.07019f
C2 a_n400_n244# a_n488_n200# 0.07019f
C3 a_400_n200# VSUBS 0.41684f
C4 a_n488_n200# VSUBS 0.41684f
.ends

.subckt n_w1_l0p28 a_28_n100# a_n28_n144# a_n116_n100# VSUBS
X0 a_28_n100# a_n28_n144# a_n116_n100# VSUBS nfet_03v3 ad=0.44p pd=2.88u as=0.44p ps=2.88u w=1u l=0.28u
C0 a_n116_n100# a_28_n100# 0.04256f
C1 a_n28_n144# a_28_n100# 0.00769f
C2 a_n28_n144# a_n116_n100# 0.00769f
C3 a_28_n100# VSUBS 0.09911f
C4 a_n116_n100# VSUBS 0.09911f
.ends

.subckt p_w1_l0p28 w_n202_n230# a_28_n100# a_n28_n144# a_n116_n100# VSUBS
X0 a_28_n100# a_n28_n144# a_n116_n100# w_n202_n230# pfet_03v3 ad=0.44p pd=2.88u as=0.44p ps=2.88u w=1u l=0.28u
C0 a_n28_n144# a_n116_n100# 0.00769f
C1 a_28_n100# w_n202_n230# 0.01808f
C2 w_n202_n230# a_n116_n100# 0.01808f
C3 a_28_n100# a_n116_n100# 0.04256f
C4 w_n202_n230# a_n28_n144# 0.05841f
C5 a_28_n100# a_n28_n144# 0.00769f
C6 a_28_n100# VSUBS 0.0597f
C7 a_n116_n100# VSUBS 0.0597f
C8 w_n202_n230# VSUBS 0.55752f
.ends

.subckt p_w0p22_l1 a_100_n22# a_n100_n66# w_n278_n159# a_n192_n36# VSUBS
X0 a_100_n22# a_n100_n66# a_n192_n36# w_n278_n159# pfet_03v3 ad=0.1516p pd=1.64u as=0.1516p ps=1.64u w=0.22u l=1u
C0 a_n192_n36# a_n100_n66# 0.00509f
C1 a_100_n22# w_n278_n159# 0.00771f
C2 w_n278_n159# a_n100_n66# 0.13163f
C3 a_100_n22# a_n100_n66# 0.00509f
C4 w_n278_n159# a_n192_n36# 0.00771f
C5 a_100_n22# a_n192_n36# 0.00453f
C6 a_100_n22# VSUBS 0.05952f
C7 a_n192_n36# VSUBS 0.05952f
C8 w_n278_n159# VSUBS 0.53042f
.ends

.subckt n_w0p5_l1p5 a_150_n50# a_n238_n50# a_n150_n94# VSUBS
X0 a_150_n50# a_n150_n94# a_n238_n50# VSUBS nfet_03v3 ad=0.22p pd=1.88u as=0.22p ps=1.88u w=0.5u l=1.5u
C0 a_n238_n50# a_150_n50# 0.00671f
C1 a_n150_n94# a_150_n50# 0.01269f
C2 a_n150_n94# a_n238_n50# 0.01269f
C3 a_150_n50# VSUBS 0.17146f
C4 a_n238_n50# VSUBS 0.17146f
.ends

.subckt p_w2_l4 a_400_n200# a_n400_n244# w_n574_n330# a_n488_n200# VSUBS
X0 a_400_n200# a_n400_n244# a_n488_n200# w_n574_n330# pfet_03v3 ad=0.88p pd=4.88u as=0.88p ps=4.88u w=2u l=4u
C0 a_n400_n244# a_n488_n200# 0.07019f
C1 a_400_n200# w_n574_n330# 0.07409f
C2 w_n574_n330# a_n488_n200# 0.07409f
C3 a_400_n200# a_n488_n200# 0.01073f
C4 w_n574_n330# a_n400_n244# 0.42229f
C5 a_400_n200# a_n400_n244# 0.07019f
C6 a_400_n200# VSUBS 0.18936f
C7 a_n488_n200# VSUBS 0.18936f
C8 w_n574_n330# VSUBS 2.27304f
.ends

.subckt p_w1_l0p5 a_n138_n100# a_50_n100# a_n50_n144# w_n224_n230# VSUBS
X0 a_50_n100# a_n50_n144# a_n138_n100# w_n224_n230# pfet_03v3 ad=0.44p pd=2.88u as=0.44p ps=2.88u w=1u l=0.5u
C0 a_n50_n144# a_n138_n100# 0.01275f
C1 a_50_n100# w_n224_n230# 0.0205f
C2 w_n224_n230# a_n138_n100# 0.0205f
C3 a_50_n100# a_n138_n100# 0.03085f
C4 w_n224_n230# a_n50_n144# 0.07993f
C5 a_50_n100# a_n50_n144# 0.01275f
C6 a_50_n100# VSUBS 0.06546f
C7 a_n138_n100# VSUBS 0.06546f
C8 w_n224_n230# VSUBS 0.61824f
.ends

.subckt p_w1_l2 w_n374_n230# a_n288_n100# a_200_n100# a_n200_n144# VSUBS
X0 a_200_n100# a_n200_n144# a_n288_n100# w_n374_n230# pfet_03v3 ad=0.44p pd=2.88u as=0.44p ps=2.88u w=1u l=2u
C0 a_n200_n144# a_n288_n100# 0.02905f
C1 a_200_n100# w_n374_n230# 0.03135f
C2 w_n374_n230# a_n288_n100# 0.03135f
C3 a_200_n100# a_n288_n100# 0.01056f
C4 w_n374_n230# a_n200_n144# 0.22666f
C5 a_200_n100# a_n200_n144# 0.02905f
C6 a_200_n100# VSUBS 0.1047f
C7 a_n288_n100# VSUBS 0.1047f
C8 w_n374_n230# VSUBS 1.03224f
.ends

.subckt n_w0p5_l0p28 a_n28_n94# a_n116_n50# a_28_n50# VSUBS
X0 a_28_n50# a_n28_n94# a_n116_n50# VSUBS nfet_03v3 ad=0.22p pd=1.88u as=0.22p ps=1.88u w=0.5u l=0.28u
C0 a_n116_n50# a_28_n50# 0.02085f
C1 a_n28_n94# a_28_n50# 0.00377f
C2 a_n28_n94# a_n116_n50# 0.00377f
C3 a_28_n50# VSUBS 0.07987f
C4 a_n116_n50# VSUBS 0.07987f
.ends

.subckt n_w0p5_l0p5 a_n138_n50# a_50_n50# a_n50_n94# VSUBS
X0 a_50_n50# a_n50_n94# a_n138_n50# VSUBS nfet_03v3 ad=0.22p pd=1.88u as=0.22p ps=1.88u w=0.5u l=0.5u
C0 a_n138_n50# a_50_n50# 0.01511f
C1 a_n50_n94# a_50_n50# 0.00625f
C2 a_n50_n94# a_n138_n50# 0.00625f
C3 a_50_n50# VSUBS 0.09639f
C4 a_n138_n50# VSUBS 0.09639f
.ends

.subckt n_w4_l2 a_n288_n400# a_200_n400# a_n200_n444# VSUBS
X0 a_200_n400# a_n200_n444# a_n288_n400# VSUBS nfet_03v3 ad=1.76p pd=8.88u as=1.76p ps=8.88u w=4u l=2u
C0 a_n288_n400# a_200_n400# 0.04287f
C1 a_n200_n444# a_200_n400# 0.11799f
C2 a_n200_n444# a_n288_n400# 0.11799f
C3 a_200_n400# VSUBS 0.34365f
C4 a_n288_n400# VSUBS 0.34365f
.ends

.subckt n_w3p54_l3p54 a_354_n354# a_n354_n398# a_n442_n354# VSUBS
X0 a_354_n354# a_n354_n398# a_n442_n354# VSUBS nfet_03v3 ad=1.5576p pd=7.96u as=1.5576p ps=7.96u w=3.54u l=3.54u
C0 a_n442_n354# a_354_n354# 0.02161f
C1 a_n354_n398# a_354_n354# 0.12189f
C2 a_n354_n398# a_n442_n354# 0.12189f
C3 a_354_n354# VSUBS 0.44156f
C4 a_n442_n354# VSUBS 0.44156f
.ends

.subckt n_w0p5_l0p6 a_n148_n50# a_60_n50# a_n60_n94# VSUBS
X0 a_60_n50# a_n60_n94# a_n148_n50# VSUBS nfet_03v3 ad=0.22p pd=1.88u as=0.22p ps=1.88u w=0.5u l=0.6u
C0 a_n148_n50# a_60_n50# 0.01345f
C1 a_n60_n94# a_60_n50# 0.00722f
C2 a_n60_n94# a_n148_n50# 0.00722f
C3 a_60_n50# VSUBS 0.1039f
C4 a_n148_n50# VSUBS 0.1039f
.ends

.subckt n_w1_l0p5 a_n138_n100# a_50_n100# a_n50_n144# VSUBS
X0 a_50_n100# a_n50_n144# a_n138_n100# VSUBS nfet_03v3 ad=0.44p pd=2.88u as=0.44p ps=2.88u w=1u l=0.5u
C0 a_n138_n100# a_50_n100# 0.03085f
C1 a_n50_n144# a_50_n100# 0.01275f
C2 a_n50_n144# a_n138_n100# 0.01275f
C3 a_50_n100# VSUBS 0.11563f
C4 a_n138_n100# VSUBS 0.11563f
.ends

.subckt n_w0p5_l3 a_n388_n50# a_300_n50# a_n300_n94# VSUBS
X0 a_300_n50# a_n300_n94# a_n388_n50# VSUBS nfet_03v3 ad=0.22p pd=1.88u as=0.22p ps=1.88u w=0.5u l=3u
C0 a_n388_n50# a_300_n50# 0.00348f
C1 a_n300_n94# a_300_n50# 0.01602f
C2 a_n300_n94# a_n388_n50# 0.01602f
C3 a_300_n50# VSUBS 0.28406f
C4 a_n388_n50# VSUBS 0.28406f
.ends

.subckt n_w1_l1 a_n188_n100# a_100_n100# a_n100_n144# VSUBS
X0 a_100_n100# a_n100_n144# a_n188_n100# VSUBS nfet_03v3 ad=0.44p pd=2.88u as=0.44p ps=2.88u w=1u l=1u
C0 a_n188_n100# a_100_n100# 0.0191f
C1 a_n100_n144# a_100_n100# 0.02094f
C2 a_n100_n144# a_n188_n100# 0.02094f
C3 a_100_n100# VSUBS 0.15316f
C4 a_n188_n100# VSUBS 0.15316f
.ends

.subckt p_w0p22_l4 a_n400_n66# a_n492_n36# w_n578_n159# a_400_n22# VSUBS
X0 a_400_n22# a_n400_n66# a_n492_n36# w_n578_n159# pfet_03v3 ad=0.1516p pd=1.64u as=0.1516p ps=1.64u w=0.22u l=4u
C0 a_n492_n36# a_n400_n66# 0.00842f
C1 a_400_n22# w_n578_n159# 0.0077f
C2 w_n578_n159# a_n400_n66# 0.43266f
C3 a_400_n22# a_n400_n66# 0.00842f
C4 w_n578_n159# a_n492_n36# 0.0077f
C5 a_400_n22# a_n492_n36# 0.00123f
C6 a_400_n22# VSUBS 0.13421f
C7 a_n492_n36# VSUBS 0.13421f
C8 w_n578_n159# VSUBS 1.10282f
.ends

.subckt n_w1_l4 a_n488_n100# a_400_n100# a_n400_n144# VSUBS
X0 a_400_n100# a_n400_n144# a_n488_n100# VSUBS nfet_03v3 ad=0.44p pd=2.88u as=0.44p ps=2.88u w=1u l=4u
C0 a_n488_n100# a_400_n100# 0.00531f
C1 a_n400_n144# a_400_n100# 0.03474f
C2 a_n400_n144# a_n488_n100# 0.03474f
C3 a_400_n100# VSUBS 0.37836f
C4 a_n488_n100# VSUBS 0.37836f
.ends

.subckt n_w2_l2 a_n288_n200# a_200_n200# a_n200_n244# VSUBS
X0 a_200_n200# a_n200_n244# a_n288_n200# VSUBS nfet_03v3 ad=0.88p pd=4.88u as=0.88p ps=4.88u w=2u l=2u
C0 a_n288_n200# a_200_n200# 0.02133f
C1 a_n200_n244# a_200_n200# 0.0587f
C2 a_n200_n244# a_n288_n200# 0.0587f
C3 a_200_n200# VSUBS 0.2667f
C4 a_n288_n200# VSUBS 0.2667f
.ends

.subckt n_w0p22_l2 a_200_n22# a_n200_n66# a_n292_n36# VSUBS
X0 a_200_n22# a_n200_n66# a_n292_n36# VSUBS nfet_03v3 ad=0.1516p pd=1.64u as=0.1516p ps=1.64u w=0.22u l=2u
C0 a_n200_n66# a_200_n22# 0.00705f
C1 a_n292_n36# a_200_n22# 0.00245f
C2 a_n292_n36# a_n200_n66# 0.00705f
C3 a_200_n22# VSUBS 0.20767f
C4 a_n292_n36# VSUBS 0.20767f
.ends

.subckt n_w7p07_l7p07 a_707_n707# a_n795_n707# a_n707_n751# VSUBS
X0 a_707_n707# a_n707_n751# a_n795_n707# VSUBS nfet_03v3 ad=3.1108p pd=15.02u as=3.1108p ps=15.02u w=7.07u l=7.07u
C0 a_n795_n707# a_707_n707# 0.0212f
C1 a_n707_n751# a_707_n707# 0.27012f
C2 a_n707_n751# a_n795_n707# 0.27012f
C3 a_707_n707# VSUBS 0.84237f
C4 a_n795_n707# VSUBS 0.84237f
.ends

.subckt dend_d1 vdd vss el vbn_leak vsrc vsrcp vbp_st vbn_ax vbn_ref vreset vbn_prb
+ abus sel0 sel2 mreset spk en pl_en chain sel1 d1_bsel sta stb hold ta0 ta1 ta2 ta3
+ tb0 tb1 tb2 tb3 vbp_syn d1 d2 vs
XXL1_XM2 a_2492_11000# a_3048_11000# a_3048_11000# vss n_w4_l1
XXEP_XS a_8248_5320# vbn_leak vss vss n_w2_l4
XXS_XL_XMT m1_1310_2210# vbn_leak vss vss n_w2_l4
XXWS a_268_18520# a_1892_3934# vs vss n_w1_l0p28
XXS_XD_Xi4_XP vdd spk a_3272_6334# vdd vss p_w1_l0p28
XXP1_XDT_XK a_6672_9234# a_5524_11840# vdd vdd vss p_w0p22_l1
XXR1_XP0 vdd a_3048_11000# ta0 m1_6440_6140# vss p_w1_l0p28
XXR1_XR2 m1_4330_6980# m1_2712_6970# vbn_leak vss n_w0p5_l1p5
XXA2_XA_XP2 a_3048_18520# a_488_19360# vdd vdd vss p_w2_l4
XXY2_XQB vdd vss vss m1_2678_13100# vss p_w1_l0p28
XXS_XL_XM1 a_488_5520# a_824_3120# el vss n_w4_l1
XXA2_XA_XMT m1_2712_18170# vbn_ax vss vss n_w2_l4
XXA2_XA_XHO vdd d2 hold a_3048_18520# vss p_w1_l0p28
XXR1_XP1 vdd a_3048_11000# ta1 m1_5286_6980# vss p_w1_l0p28
XXR1_XR3 m1_5946_6980# m1_4330_6980# vbn_leak vss n_w0p5_l1p5
XXT1_XME m1_7702_15540# en m1_8466_15350# vss n_w1_l0p28
XXS_XL_XM2 a_2492_3120# a_3048_3120# a_3048_3120# vss n_w4_l1
XXP2_XDT_XNE m1_7150_14166# a_5524_16920# vsrcp vss n_w1_l0p28
XXS_XD_XPI m1_910_6150# a_728_3738# vs vdd vss p_w1_l0p5
XXR1_XP2 vdd a_3048_11000# ta2 m1_3690_6830# vss p_w1_l0p28
XXEP_XPD vdd vdd a_8248_5320# a_8248_5320# vss p_w1_l2
XXR1_XN0 ta0 m1_6440_6140# a_488_12040# vss n_w0p5_l0p28
XXA2_XA_XM1 a_488_19360# a_824_18520# a_268_18520# vss n_w4_l1
XXY2_XNA a_2180_13234# d2 m1_2868_14560# vss n_w0p5_l0p28
XXS_XR_XNR a_6594_420# vbn_ref vss vss n_w2_l4
XXS_XR_XSW vreset vs a_6594_420# vss n_w0p5_l0p5
XXT1_XMF m1_7702_15540# vdd d2 vss n_w4_l2
XXT2_XSW m1_7702_10660# sel2 abus vss n_w1_l0p28
XXP2_XTP vdd vdd a_4588_13668# a_5524_16920# vss p_w1_l2
XXS_XL_XD2_a m1_1310_2210# a_2492_3120# a_2492_3120# vss n_w4_l1
XXR1_XP3 vdd a_3048_11000# ta3 m1_1996_6970# vss p_w1_l0p28
XXP1_XCT_XC vss a_4588_8588# vss vss n_w3p54_l3p54
XXR1_XN1 ta1 m1_5286_6980# a_488_12040# vss n_w0p5_l0p28
XXB_XP1 vdd a_2592_8154# d1_bsel stb vss p_w1_l0p28
XXA2_XA_XM2 a_2492_18520# a_3048_18520# a_3048_18520# vss n_w4_l1
XXY2_XNB vss d2 m1_2678_13100# vss n_w0p5_l0p28
XXR2_XRA vss m1_2470_19900# vbn_leak vss n_w0p5_l0p6
XXP2_XDT_XPI m1_6716_16790# a_5268_14218# d2 vdd vss p_w1_l0p5
XXS_XL_XD2_b a_2492_3120# m1_1310_2210# a_2492_3120# vss n_w4_l1
XXS_XD_XNI vsrc a_728_3738# vs vss n_w1_l0p5
XXR1_XL0 m1_5946_6980# m1_6440_6140# vbn_leak vss n_w0p5_l3
XXR1_XLT m1_5946_6980# vdd vbn_leak vss n_w0p5_l3
XXR1_XN2 ta2 m1_3690_6830# a_488_12040# vss n_w0p5_l0p28
XXY1_XWA m1_2236_8010# vbp_syn vdd m1_2112_9090# vss p_w2_l4
XXB_XP2 vdd a_2180_13234# a_672_20034# stb vss p_w1_l0p28
XXR2_XRB m1_2470_19900# m1_2956_19890# vbn_leak vss n_w0p5_l0p6
XXP2_XDT_XNH m1_7150_14166# a_5268_14218# d2 vss n_w1_l1
XXR1_XL1 m1_4330_6980# m1_5286_6980# vbn_leak vss n_w0p5_l3
XXR1_XN3 ta3 m1_1996_6970# a_488_12040# vss n_w0p5_l0p28
XXB_XN1 a_672_20034# stb a_2592_8154# vss n_w0p5_l0p28
XXY1_XWB m1_2668_7940# vbp_syn vdd m1_2112_9090# vss p_w2_l4
XXP2_XDT_XNI vsrcp a_5268_14218# d2 vss n_w1_l1
XXP1_XDT_XQ a_6140_9234# vdd vdd a_6672_9234# vss p_w0p22_l4
XXP2_XTS a_4588_13668# a_5524_16920# m1_6464_13090# vss n_w1_l0p28
XXR1_XL2 m1_2712_6970# m1_3690_6830# vbn_leak vss n_w0p5_l3
XXB_XN2 d1_bsel stb a_2180_13234# vss n_w0p5_l0p28
XXP2_XDT_XK a_6672_14314# a_5524_16920# vdd vdd vss p_w0p22_l1
XXA1_XB_XD2_a m1_4882_3750# a_5772_4480# a_5772_4480# vss n_w4_l1
XXR1_XL3 m1_1096_6970# m1_1996_6970# vbn_leak vss n_w0p5_l3
XXY2_XPH vdd vdd m1_2112_14220# hold vss p_w1_l2
XXP1_XTI vss m1_6494_7950# vbn_leak vss n_w1_l4
XXA1_XB_XD2_b a_5772_4480# m1_4882_3750# a_5772_4480# vss n_w4_l1
XXA1_XA_XD2_a m1_7206_2780# a_6984_3120# a_6984_3120# vss n_w4_l1
XXMR mreset a_6594_420# vdd vss n_w0p5_l0p28
XXP2_XS1 m1_7148_12980# m1_5190_15350# a_5524_16920# vss n_w1_l1
XXA1_XA_XD2_b a_6984_3120# m1_7206_2780# a_6984_3120# vss n_w4_l1
XXP2_XCT_XC vss a_4588_13668# vss vss n_w3p54_l3p54
XXT0_XMB vss m1_2708_380# vbn_prb vss n_w2_l2
XXP2_XS2 m1_7702_12990# m1_7148_12980# a_4588_13668# vss n_w1_l1
XXP2_XDT_XON a_6672_14314# vss a_5524_16920# vss n_w0p5_l0p28
XXY1_XQA vdd vss sta m1_2236_8010# vss p_w1_l0p28
XXP2_XOP1 a_2800_17120# a_2800_17120# vdd vdd vss p_w2_l4
XXEP_XPM vdd vdd a_3136_4480# a_8248_5320# vss p_w1_l2
XXP2_XS3 m1_6968_15350# m1_7702_12990# pl_en vss n_w1_l1
XXP1_XDT_XNE m1_7150_9212# a_5524_11840# vsrcp vss n_w1_l0p28
XXY1_XQB vdd vss a_2592_8154# m1_2668_7940# vss p_w1_l0p28
XXP2_XOP2 a_5516_15680# a_2800_17120# vdd vdd vss p_w2_l4
XXP2_XDT_XOP vdd a_5524_16920# a_6672_14314# vdd vss p_w1_l0p28
XXS_XD_XPS vdd vdd m1_910_6150# vbp_st vss p_w1_l2
XXS_XD_XS2 vdd vdd m1_2122_6150# vbp_st vss p_w1_l2
XXP2_XDT_XQ a_6140_14314# vdd vdd a_6672_14314# vss p_w0p22_l4
XXT0_XME m1_1946_330# en m1_2708_380# vss n_w1_l0p28
XXP1_XDT_XPI m1_6716_11710# a_5268_9138# d1 vdd vss p_w1_l0p5
XXS_XD_XS3 vdd vdd m1_2788_6140# vbp_st vss p_w1_l2
XXY1_XNA sta d1 m1_2236_8010# vss n_w0p5_l0p28
XXP2_XOM1 a_2800_17120# m1_5190_15350# a_3136_4480# vss n_w2_l2
XXT1_XSW m1_7702_15540# sel1 abus vss n_w1_l0p28
XXT0_XMF m1_1946_330# vdd vs vss n_w4_l2
XXP2_XDT_XS2 vdd vdd m1_7930_16790# vbp_st vss p_w1_l2
XXP2_XDT_XPS vdd vdd m1_6716_16790# vbp_st vss p_w1_l2
XXP1_XTP vdd vdd a_4588_8588# a_5524_11840# vss p_w1_l2
XXP1_XDT_XNH m1_7150_9212# a_5268_9138# d1 vss n_w1_l1
XXY1_XNB a_2592_8154# d1 m1_2668_7940# vss n_w0p5_l0p28
XXP2_XOM2 m1_5190_15350# a_5516_15680# a_5516_15680# vss n_w2_l2
XXP2_XDT_XS3 vdd vdd m1_9090_16790# vbp_st vss p_w1_l2
XXP2_XHP vdd d2 hold a_5516_15680# vss p_w1_l0p28
XXL2_XD1_a a_824_16080# m1_1860_15340# a_824_16080# vss n_w4_l1
XXP1_XDT_XNI vsrcp a_5268_9138# d1 vss n_w1_l1
XXS_XD_XP2 vdd a_1480_3834# a_728_3738# m1_2122_6150# vss p_w1_l0p28
XXR1_XRA vss m1_642_6980# vbn_leak vss n_w0p5_l0p6
XXB_XD1 d1_bsel vss a_2592_8154# vss n_w0p5_l0p28
XXA2_XB_XD1_a a_5316_18520# m1_6346_17880# a_5316_18520# vss n_w4_l1
XXL2_XD1_b m1_1860_15340# a_824_16080# a_824_16080# vss n_w4_l1
XXS_XD_XP3 vdd a_3272_6334# a_1480_3834# m1_2788_6140# vss p_w1_l0p28
XXR1_XRB m1_642_6980# m1_1096_6970# vbn_leak vss n_w0p5_l0p6
XXB_XD2 a_672_20034# vss a_2180_13234# vss n_w0p5_l0p28
XXL1_XD1_a a_824_11000# m1_1046_10270# a_824_11000# vss n_w4_l1
XXS_XD_XK a_3272_6334# spk vdd vdd vss p_w0p22_l1
XXA2_XB_XD1_b m1_6346_17880# a_5316_18520# a_5316_18520# vss n_w4_l1
XXA2_XA_XD1_a a_824_18520# m1_2712_18170# a_824_18520# vss n_w4_l1
XXP2_XDT_XP2 vdd a_6140_14314# a_5268_14218# m1_7930_16790# vss p_w1_l0p28
XXS_XD_XN2 a_1480_3834# a_728_3738# vsrc vss n_w0p22_l2
XXP1_XTS a_4588_8588# a_5524_11840# m1_6494_7950# vss n_w1_l0p28
XXL1_XD1_b m1_1046_10270# a_824_11000# a_824_11000# vss n_w4_l1
XXA1_XB_XP1 a_5524_5520# a_5524_5520# vdd vdd vss p_w2_l4
XXP2_XDT_XP3 vdd a_6672_14314# a_6140_14314# m1_9090_16790# vss p_w1_l0p28
XXS_XD_XN3 a_1480_3834# vsrc a_3272_6334# vss n_w0p5_l0p28
XXA2_XA_XD1_b m1_2712_18170# a_824_18520# a_824_18520# vss n_w4_l1
XXY1_XPH vdd vdd m1_2112_9090# hold vss p_w1_l2
XXA1_XB_XP2 a_6884_4480# a_5524_5520# vdd vdd vss p_w2_l4
XXY2_XHL vdd d2 hold a_3048_16080# vss p_w1_l0p28
XXP2_XDT_XN2 a_6140_14314# a_5268_14218# vsrcp vss n_w0p22_l2
XXP1_XDT_XON a_6672_9234# vss a_5524_11840# vss n_w0p5_l0p28
XXWC a_268_18520# chain d1 vss n_w1_l0p28
XXA1_XB_XMT m1_4882_3750# vbn_ax vss vss n_w2_l4
XXA1_XB_XHO vdd d1 hold a_6884_4480# vss p_w1_l0p28
XXP2_XDT_XN3 a_6140_14314# vsrcp a_6672_14314# vss n_w0p5_l0p28
XXY2_XMR vss vss vdd vss n_w0p5_l0p28
XXP1_XS1 m1_7158_7910# m1_5432_10180# a_5524_11840# vss n_w1_l1
XXL2_XP1 a_488_17120# a_488_17120# vdd vdd vss p_w2_l4
XXA1_XB_XM1 a_5524_5520# a_4660_4480# vs vss n_w4_l1
XXP1_XDT_XOP vdd a_5524_11840# a_6672_9234# vdd vss p_w1_l0p28
XXS_XR_XPC vdd a_6594_420# a_4096_6334# vdd vss p_w1_l0p28
XXP1_XS2 m1_7692_7940# m1_7158_7910# a_4588_8588# vss n_w1_l1
XXL2_XP2 a_3048_16080# a_488_17120# vdd vdd vss p_w2_l4
XXP1_XOP1 a_2800_12040# a_2800_12040# vdd vdd vss p_w2_l4
XXS_XR_Xi_XN spk vss a_4096_6334# vss n_w0p5_l0p28
XXA1_XB_XM2 a_5772_4480# a_6884_4480# a_6884_4480# vss n_w4_l1
XXP1_XS3 m1_6968_10660# m1_7692_7940# pl_en vss n_w1_l1
XXP2_XOTA vss m1_6968_15350# vbn_leak vss n_w4_l2
XXL2_XMT m1_1860_15340# vbn_leak vss vss n_w2_l4
XXS_XL_XD1_a a_824_3120# m1_1310_2210# a_824_3120# vss n_w4_l1
XXP1_XOP2 a_5516_10600# a_2800_12040# vdd vdd vss p_w2_l4
XXC1_XC vss vss d1 vss n_w7p07_l7p07
XXP1_XDT_XS2 vdd vdd m1_7930_11710# vbp_st vss p_w1_l2
XXP1_XDT_XPS vdd vdd m1_6716_11710# vbp_st vss p_w1_l2
XXP2_XOTB m1_6968_15350# vss vbn_leak vss n_w4_l2
XXL2_XM1 a_488_17120# a_824_16080# el vss n_w4_l1
XXS_XL_XD1_b m1_1310_2210# a_824_3120# a_824_3120# vss n_w4_l1
XXT2_XMB vss m1_8350_10270# vbn_prb vss n_w2_l2
XXS_XR_Xi_XP vdd a_4096_6334# spk vdd vss p_w1_l0p28
XXR2_XR1 m1_4568_19890# m1_2956_19890# vbn_leak vss n_w0p5_l1p5
XXA2_XB_XP1 a_4368_19360# a_4368_19360# vdd vdd vss p_w2_l4
XXP1_XDT_XS3 vdd vdd m1_9090_11710# vbp_st vss p_w1_l2
XXL2_XM2 a_2492_16080# a_3048_16080# a_3048_16080# vss n_w4_l1
XXP1_XOM1 a_2800_12040# m1_5432_10180# a_3136_4480# vss n_w2_l2
XXT0_XSW m1_1946_330# sel0 abus vss n_w1_l0p28
XXR2_XR2 m1_6190_19900# m1_4568_19890# vbn_leak vss n_w0p5_l1p5
XXR2_XP0 vdd a_3048_16080# tb0 m1_8326_19030# vss p_w1_l0p28
XXA2_XB_XP2 a_7540_18520# a_4368_19360# vdd vdd vss p_w2_l4
XXP1_XOM2 m1_5432_10180# a_5516_10600# a_5516_10600# vss n_w2_l2
XXR2_XR3 m1_7790_19900# m1_6190_19900# vbn_leak vss n_w0p5_l1p5
XXR2_XP1 vdd a_3048_16080# tb1 m1_7080_19410# vss p_w1_l0p28
XXA2_XB_XMT m1_6346_17880# vbn_ax vss vss n_w2_l4
XXA2_XB_XHO vdd a_268_18520# hold a_7540_18520# vss p_w1_l0p28
XXP1_XDT_XP2 vdd a_6140_9234# a_5268_9138# m1_7930_11710# vss p_w1_l0p28
XXP1_XHP vdd d1 hold a_5516_10600# vss p_w1_l0p28
XXT2_XME m1_7702_10660# en m1_8350_10270# vss n_w1_l0p28
XXA1_XB_XD1_a a_4660_4480# m1_4882_3750# a_4660_4480# vss n_w4_l1
XXR2_XN0 tb0 m1_8326_19030# a_488_17120# vss n_w0p5_l0p28
XXR2_XP2 vdd a_3048_16080# tb2 m1_5522_19900# vss p_w1_l0p28
XXA2_XB_XM1 a_4368_19360# a_5316_18520# d2 vss n_w4_l1
XXP1_XDT_XP3 vdd a_6672_9234# a_6140_9234# m1_9090_11710# vss p_w1_l0p28
XXA1_XB_XD1_b m1_4882_3750# a_4660_4480# a_4660_4480# vss n_w4_l1
XXT2_XMF m1_7702_10660# vdd d1 vss n_w4_l2
XXA1_XA_XD1_a a_5316_3120# m1_7206_2780# a_5316_3120# vss n_w4_l1
XXR2_XN1 tb1 m1_7080_19410# a_488_17120# vss n_w0p5_l0p28
XXR2_XP3 vdd a_3048_16080# tb3 m1_3870_19890# vss p_w1_l0p28
XXA2_XB_XM2 a_6984_18520# a_7540_18520# a_7540_18520# vss n_w4_l1
XXP1_XDT_XN2 a_6140_9234# a_5268_9138# vsrcp vss n_w0p22_l2
XXI_XN chain vss a_1892_3934# vss n_w0p5_l0p28
XXR2_XLT m1_7790_19900# vdd vbn_leak vss n_w0p5_l3
XXR2_XL0 m1_7790_19900# m1_8326_19030# vbn_leak vss n_w0p5_l3
XXR2_XN2 tb2 m1_5522_19900# a_488_17120# vss n_w0p5_l0p28
XXA1_XA_XD1_b m1_7206_2780# a_5316_3120# a_5316_3120# vss n_w4_l1
XXA1_XA_XP1 a_3956_5520# a_3956_5520# vdd vdd vss p_w2_l4
XXY2_XWA m1_2868_14560# vbp_syn vdd m1_2112_14220# vss p_w2_l4
XXP1_XDT_XN3 a_6140_9234# vsrcp a_6672_9234# vss n_w0p5_l0p28
XXA1_XA_XP2 a_7540_3120# a_3956_5520# vdd vdd vss p_w2_l4
XXR2_XL1 m1_6190_19900# m1_7080_19410# vbn_leak vss n_w0p5_l3
XXB_XI_XN d1_bsel vss a_672_20034# vss n_w0p5_l0p28
XXR2_XN3 tb3 m1_3870_19890# a_488_17120# vss n_w0p5_l0p28
XXY2_XWB m1_2678_13100# vbp_syn vdd m1_2112_14220# vss p_w2_l4
XXY1_XHL vdd d1 hold a_3048_11000# vss p_w1_l0p28
XXEP_XN el a_3136_4480# a_3136_4480# vss n_w4_l1
XXS_XHL vdd vs hold a_3048_3120# vss p_w1_l0p28
XXR2_XL2 m1_4568_19890# m1_5522_19900# vbn_leak vss n_w0p5_l3
XXA1_XA_XMT m1_7206_2780# vbn_ax vss vss n_w2_l4
XXA1_XA_XHO vdd vs hold a_7540_3120# vss p_w1_l0p28
XXI_XP vdd a_1892_3934# chain vdd vss p_w1_l0p28
XXY1_XMR vss vss vdd vss n_w0p5_l0p28
XXL2_XD2_a m1_1860_15340# a_2492_16080# a_2492_16080# vss n_w4_l1
XXL1_XP1 a_488_12040# a_488_12040# vdd vdd vss p_w2_l4
XXA1_XA_XM1 a_3956_5520# a_5316_3120# d1 vss n_w4_l1
XXR2_XL3 m1_2956_19890# m1_3870_19890# vbn_leak vss n_w0p5_l3
XXB_XI_XP vdd a_672_20034# d1_bsel vdd vss p_w1_l0p28
XXS_XC_XC vss vss vs vss n_w7p07_l7p07
XXA2_XB_XD2_a m1_6346_17880# a_6984_18520# a_6984_18520# vss n_w4_l1
XXP2_XTI vss m1_6464_13090# vbn_leak vss n_w1_l4
XXL2_XD2_b a_2492_16080# m1_1860_15340# a_2492_16080# vss n_w4_l1
XXL1_XP2 a_3048_11000# a_488_12040# vdd vdd vss p_w2_l4
XXL1_XD2_a m1_1046_10270# a_2492_11000# a_2492_11000# vss n_w4_l1
XXA1_XA_XM2 a_6984_3120# a_7540_3120# a_7540_3120# vss n_w4_l1
XXA2_XB_XD2_b a_6984_18520# m1_6346_17880# a_6984_18520# vss n_w4_l1
XXA2_XA_XD2_a m1_2712_18170# a_2492_18520# a_2492_18520# vss n_w4_l1
XXP1_XOTA vss m1_6968_10660# vbn_leak vss n_w4_l2
XXL1_XMT m1_1046_10270# vbn_leak vss vss n_w2_l4
XXL1_XD2_b a_2492_11000# m1_1046_10270# a_2492_11000# vss n_w4_l1
XXS_XD_Xi4_XN a_3272_6334# vss spk vss n_w0p5_l0p28
XXS_XL_XP1 a_488_5520# a_488_5520# vdd vdd vss p_w2_l4
XXA2_XA_XD2_b a_2492_18520# m1_2712_18170# a_2492_18520# vss n_w4_l1
XXP1_XOTB m1_6968_10660# vss vbn_leak vss n_w4_l2
XXL1_XM1 a_488_12040# a_824_11000# el vss n_w4_l1
XXT1_XMB vss m1_8466_15350# vbn_prb vss n_w2_l2
XXS_XL_XP2 a_3048_3120# a_488_5520# vdd vdd vss p_w2_l4
XXY2_XQA vdd vss a_2180_13234# m1_2868_14560# vss p_w1_l0p28
XXC2_XC vss vss d2 vss n_w7p07_l7p07
XXS_XR_XCR_XC vss a_6594_420# vss vss n_w3p54_l3p54
XXR1_XR1 m1_2712_6970# m1_1096_6970# vbn_leak vss n_w0p5_l1p5
XXA2_XA_XP1 a_488_19360# a_488_19360# vdd vdd vss p_w2_l4
C0 sel0 vbn_leak 0.0722f
C1 a_488_17120# a_824_16080# 0.05021f
C2 a_6672_14314# m1_8466_15350# 0.04904f
C3 a_3048_3120# a_268_18520# 0.1806f
C4 ta1 m1_7148_12980# 0.02672f
C5 sel1 a_672_20034# 0.00572f
C6 vbn_prb a_4096_6334# 0.07766f
C7 d2 a_6984_18520# 0.00127f
C8 a_268_18520# a_6672_9234# 0
C9 vbn_leak a_5524_11840# 0.09092f
C10 sel1 vbp_st 0.02232f
C11 stb chain 0.07769f
C12 a_6984_3120# vs 0
C13 pl_en a_4588_13668# 0.06831f
C14 ta2 tb0 0
C15 a_3956_5520# el 0.07725f
C16 m1_2788_6140# vs 0.02734f
C17 chain m1_6968_10660# 0.00138f
C18 a_268_18520# vbn_leak 0.31461f
C19 m1_4882_3750# ta0 0
C20 m1_7702_10660# ta3 0.01266f
C21 a_672_20034# chain 0.01205f
C22 a_6984_18520# m1_6716_16790# 0
C23 d2 a_488_19360# 0.00905f
C24 el a_3048_11000# 0.46053f
C25 m1_1860_15340# vbn_leak 0.11918f
C26 ta1 a_5516_15680# 0
C27 a_5268_14218# m1_7930_16790# 0.0608f
C28 sel0 vs 0.07464f
C29 a_5524_5520# m1_4330_6980# 0
C30 m1_3690_6830# m1_2788_6140# 0.11047f
C31 a_6140_9234# a_6672_9234# 0.60948f
C32 vbp_st chain 0.05475f
C33 vbp_st sel2 0.02702f
C34 vdd a_4588_8588# 0.13704f
C35 m1_2956_19890# d1_bsel 0.008f
C36 m1_7790_19900# ta3 0
C37 vsrc spk 0.20983f
C38 a_488_5520# m1_1096_6970# 0
C39 vdd a_5316_18520# 0.28541f
C40 a_268_18520# a_6984_18520# 0.02075f
C41 ta2 a_5524_5520# 0.00265f
C42 a_5268_9138# chain 0.04485f
C43 a_5268_14218# m1_7702_15540# 0.00737f
C44 m1_5522_19900# a_2592_8154# 0.03626f
C45 a_6140_9234# vbn_leak 0.01785f
C46 a_3272_6334# vbn_ref 0.04197f
C47 a_824_16080# a_2180_13234# 0.04279f
C48 spk en 0.09477f
C49 m1_4882_3750# a_3136_4480# 0.24197f
C50 a_3048_16080# m1_7790_19900# 0.00168f
C51 abus vbn_ref 0.1744f
C52 a_3272_6334# a_2492_3120# 0.01818f
C53 a_268_18520# vs 0.1278f
C54 m1_6968_15350# m1_7702_12990# 0.03517f
C55 vsrc a_4096_6334# 0.0349f
C56 ta1 m1_5286_6980# 0.1158f
C57 m1_4568_19890# a_4368_19360# 0.02007f
C58 vbn_leak a_5316_3120# 0
C59 sta m1_7150_14166# 0
C60 vreset vsrcp 0.0318f
C61 vbn_leak a_8248_5320# 0.08884f
C62 ta1 en 0.0099f
C63 a_268_18520# a_488_19360# 0.28372f
C64 a_2592_8154# m1_3870_19890# 0.03506f
C65 m1_5946_6980# a_6672_9234# 0
C66 a_4096_6334# en 0.20918f
C67 a_6672_14314# a_4588_13668# 0.00145f
C68 vbn_leak m1_7702_15540# 0.13235f
C69 d1 m1_5190_15350# 0
C70 a_3956_5520# chain 0.39157f
C71 pl_en ta2 0.02607f
C72 vdd m1_6190_19900# 0.09388f
C73 chain a_3048_11000# 0.13041f
C74 vbn_leak m1_5946_6980# 0.43333f
C75 m1_2868_14560# m1_2678_13100# 0.00307f
C76 vbn_ref a_6984_3120# 0.01152f
C77 vdd m1_2868_14560# 0.24357f
C78 a_6140_14314# m1_5190_15350# 0.00194f
C79 a_488_17120# m1_8466_15350# 0.05565f
C80 a_7540_18520# ta0 0.05267f
C81 a_3048_11000# sel2 0
C82 a_5268_14218# hold 0.15602f
C83 a_5316_3120# vs 0.03521f
C84 d2 m1_2112_14220# 0.02118f
C85 ta0 tb3 0.01261f
C86 m1_7080_19410# m1_7790_19900# 0
C87 a_8248_5320# vs 0.08167f
C88 a_488_12040# a_5268_14218# 0
C89 a_3048_3120# hold 0.00798f
C90 ta1 m1_6440_6140# 0.11241f
C91 m1_2236_8010# vdd 0.22158f
C92 m1_7692_7940# vdd 0
C93 vbp_syn m1_5432_10180# 0
C94 tb2 a_2592_8154# 0.02409f
C95 a_6672_9234# hold 0.05385f
C96 a_2592_8154# m1_6346_17880# 0.14756f
C97 vbp_st a_6594_420# 0.09793f
C98 m1_8350_10270# vbp_st 0
C99 a_488_17120# a_2180_13234# 0.31318f
C100 m1_7702_10660# vsrcp 0
C101 m1_3690_6830# a_8248_5320# 0.00111f
C102 a_488_12040# a_6672_9234# 0.01408f
C103 sel0 vbn_ref 0.24296f
C104 a_2492_11000# hold 0.0915f
C105 vbp_st vreset 0.03373f
C106 a_488_12040# a_2492_11000# 0.01268f
C107 a_5524_16920# a_5268_14218# 0.40714f
C108 d2 m1_3870_19890# 0
C109 a_3272_6334# el 0.21473f
C110 a_2592_8154# el 0.04315f
C111 pl_en m1_6968_15350# 0.37514f
C112 vbn_leak hold 1.12433f
C113 abus el 0.12928f
C114 a_488_12040# vbn_leak 0.2211f
C115 vbn_prb d1 0.14856f
C116 m1_5522_19900# a_268_18520# 0.03792f
C117 m1_2668_7940# vbn_leak 0.14779f
C118 m1_7148_12980# m1_5190_15350# 0.03285f
C119 a_2492_16080# vbn_leak 0
C120 vdd a_2800_17120# 1.169f
C121 a_4096_6334# a_5772_4480# 0
C122 mreset m1_4882_3750# 0.17673f
C123 a_268_18520# m1_9090_16790# 0.00149f
C124 vbn_ref a_268_18520# 0.00399f
C125 m1_3690_6830# m1_5946_6980# 0.16805f
C126 a_2492_3120# a_268_18520# 0.13107f
C127 spk a_1480_3834# 0.00307f
C128 m1_1860_15340# m1_2112_14220# 0.00184f
C129 a_6984_18520# hold 0.05109f
C130 a_6672_14314# ta2 0.01729f
C131 m1_910_6150# a_1480_3834# 0
C132 a_1892_3934# m1_4330_6980# 0.0293f
C133 vbn_prb a_6140_14314# 0.10468f
C134 a_7540_3120# m1_4882_3750# 0.30919f
C135 m1_4882_3750# ta3 0
C136 a_5524_16920# vbn_leak 0.17709f
C137 m1_7702_10660# m1_6968_10660# 0
C138 a_268_18520# m1_3870_19890# 0.05027f
C139 a_488_17120# a_3048_18520# 0.00469f
C140 d1_bsel vdd 0.73448f
C141 a_3956_5520# a_6594_420# 0.14878f
C142 a_2592_8154# sel1 0.27104f
C143 d2 m1_6346_17880# 0.01138f
C144 m1_4568_19890# en 0.04701f
C145 tb1 m1_7790_19900# 0.00871f
C146 vs hold 0.2628f
C147 sel1 abus 0.05223f
C148 el a_6984_3120# 0.03091f
C149 a_4096_6334# a_1480_3834# 0
C150 ta1 ta0 2.97489f
C151 a_5516_15680# m1_5190_15350# 0.01248f
C152 a_488_17120# a_4588_13668# 0.00106f
C153 m1_8350_10270# a_3048_11000# 0.02672f
C154 m1_7702_10660# vbp_st 0.00794f
C155 a_488_19360# hold 0.00504f
C156 a_488_17120# vbp_syn 0.04655f
C157 m1_3690_6830# hold 0.20642f
C158 a_4588_8588# a_6672_9234# 0.03549f
C159 d2 el 0.17763f
C160 spk a_3136_4480# 0.27703f
C161 m1_642_6980# a_488_5520# 0.0014f
C162 ta2 m1_5432_10180# 0.01154f
C163 a_488_12040# m1_3690_6830# 0.1301f
C164 m1_2112_9090# vbp_syn 0.31842f
C165 vbn_ref a_5316_3120# 0.00111f
C166 vbn_leak m1_7206_2780# 0.00501f
C167 m1_7702_10660# a_5268_9138# 0
C168 m1_1946_330# a_6594_420# 0.00743f
C169 vbn_ref a_8248_5320# 0.06353f
C170 a_3272_6334# chain 0
C171 m1_2122_6150# vdd 0.06887f
C172 a_5516_15680# a_6140_14314# 0.00242f
C173 a_2592_8154# chain 0.16318f
C174 vsrc d1 0.03592f
C175 m1_6968_15350# a_6672_14314# 0.08818f
C176 a_5516_15680# a_4368_19360# 0
C177 sel0 el 0.25172f
C178 ta1 a_3136_4480# 0.02659f
C179 abus sel2 0.08818f
C180 vbn_leak a_4588_8588# 0.4912f
C181 m1_7702_12990# m1_7150_14166# 0
C182 m1_7702_15540# m1_9090_16790# 0
C183 tb2 a_268_18520# 0.03852f
C184 a_268_18520# m1_6346_17880# 0.53581f
C185 vbn_leak a_5316_18520# 0.00207f
C186 a_4096_6334# a_3136_4480# 0.12255f
C187 m1_1996_6970# chain 0.0103f
C188 en m1_5190_15350# 0.03191f
C189 sta vdd 0.59202f
C190 d1 en 0.12961f
C191 el a_5524_11840# 0.17714f
C192 m1_7930_11710# ta3 0
C193 vsrc a_6140_14314# 0
C194 a_3048_18520# a_2180_13234# 0.04461f
C195 sel1 d2 0.12926f
C196 a_268_18520# el 0.77563f
C197 a_5316_18520# a_6984_18520# 0.00273f
C198 m1_7206_2780# vs 0.00748f
C199 ta1 m1_7158_7910# 0.01783f
C200 a_6140_14314# en 0.30969f
C201 a_7540_18520# ta3 0.06912f
C202 m1_1860_15340# el 0.22907f
C203 a_4368_19360# en 0
C204 ta3 tb3 0.00355f
C205 vbp_syn a_2180_13234# 0.15642f
C206 m1_7702_10660# a_3048_11000# 0.11695f
C207 a_2800_12040# m1_2678_13100# 0.02247f
C208 vdd a_2800_12040# 1.13604f
C209 m1_2788_6140# chain 0.14363f
C210 sel1 m1_6716_16790# 0
C211 a_7540_18520# a_3048_16080# 0.19981f
C212 d2 chain 0.02815f
C213 m1_5522_19900# hold 0.05258f
C214 a_3048_16080# tb3 0.0653f
C215 vsrc vbn_prb 0.17503f
C216 d1 m1_6440_6140# 0.14873f
C217 m1_3690_6830# a_4588_8588# 0
C218 a_6140_9234# el 0.1442f
C219 m1_2112_14220# hold 0.01197f
C220 m1_6190_19900# vbn_leak 0.40533f
C221 a_488_17120# ta2 0.00478f
C222 m1_7692_7940# a_6672_9234# 0.02936f
C223 vbn_leak m1_2868_14560# 0
C224 a_2492_16080# m1_2112_14220# 0.0039f
C225 sel1 a_268_18520# 0.10102f
C226 vdd m1_6716_11710# 0.0929f
C227 sel0 sel2 3.94813f
C228 a_5316_3120# el 0.00872f
C229 vbn_prb en 0.06486f
C230 vbn_ax vdd 0.79187f
C231 el a_8248_5320# 0.0257f
C232 m1_7692_7940# vbn_leak 0.00127f
C233 m1_2236_8010# vbn_leak 0.01335f
C234 chain a_5524_11840# 0.00657f
C235 chain m1_6716_16790# 0
C236 m1_6190_19900# a_6984_18520# 0
C237 a_3272_6334# a_6594_420# 0.01878f
C238 vdd a_488_5520# 1.42801f
C239 a_2592_8154# m1_8350_10270# 0.00832f
C240 pl_en m1_7150_14166# 0.06701f
C241 m1_5522_19900# a_5524_16920# 0.00311f
C242 m1_3870_19890# hold 0.13427f
C243 m1_7702_15540# el 0
C244 d1 a_5772_4480# 0.19805f
C245 mreset spk 3.99815f
C246 abus m1_8350_10270# 0.02396f
C247 sel2 a_5524_11840# 0.01566f
C248 m1_6464_13090# vbp_st 0
C249 a_5524_16920# m1_9090_16790# 0.01178f
C250 abus a_6594_420# 0.05219f
C251 a_3048_18520# vbp_syn 0.00473f
C252 a_3272_6334# vreset 0
C253 a_268_18520# chain 0.2068f
C254 vdd m1_8326_19030# 0.42076f
C255 m1_1996_6970# a_6594_420# 0
C256 abus vreset 0.16897f
C257 a_268_18520# sel2 0.02655f
C258 a_7540_18520# m1_7080_19410# 0.04672f
C259 a_4588_13668# vbp_syn 0.06251f
C260 mreset a_4096_6334# 0.1225f
C261 a_5524_16920# m1_3870_19890# 0.00674f
C262 m1_7080_19410# tb3 0.1739f
C263 ta1 ta3 0.2203f
C264 m1_1310_2210# spk 0.04681f
C265 vbn_leak a_2800_17120# 0.20561f
C266 a_5516_15680# en 0.03347f
C267 ta2 a_2180_13234# 0
C268 tb2 hold 0
C269 a_4096_6334# ta3 0
C270 a_7540_3120# a_4096_6334# 0.11751f
C271 a_4660_4480# vdd 0.14484f
C272 a_6140_9234# chain 0.0794f
C273 ta0 m1_5190_15350# 0.00913f
C274 m1_6346_17880# hold 0.08309f
C275 vbn_ref m1_7206_2780# 0.00941f
C276 d1 ta0 0.08048f
C277 sel1 m1_7702_15540# 0.08512f
C278 m1_910_6150# a_728_3738# 0.05258f
C279 a_6140_9234# sel2 0.00113f
C280 ta1 a_3048_16080# 0.0616f
C281 m1_7692_7940# m1_3690_6830# 0
C282 vsrc en 0.09826f
C283 m1_1310_2210# a_4096_6334# 0
C284 d1_bsel vbn_leak 0.53871f
C285 a_6984_3120# vreset 0
C286 chain a_5316_3120# 0.00173f
C287 m1_2788_6140# a_6594_420# 0.00568f
C288 m1_6968_15350# m1_8466_15350# -0
C289 a_6140_14314# ta0 0.0082f
C290 el hold 0.2037f
C291 m1_5286_6980# en 0.38404f
C292 a_488_12040# el 0.88316f
C293 m1_6464_13090# a_3048_11000# 0.02594f
C294 sta a_5268_14218# 0.00735f
C295 tb2 a_5524_16920# 0.00764f
C296 a_2592_8154# m1_7702_10660# 0.07961f
C297 a_2492_16080# el 0.0093f
C298 a_3136_4480# m1_5190_15350# 0.07211f
C299 a_5524_16920# m1_6346_17880# 0.0052f
C300 m1_2668_7940# el 0
C301 d1 a_3136_4480# 1.34612f
C302 m1_7702_10660# abus 0.03417f
C303 a_6672_14314# m1_7150_14166# 0.12097f
C304 sel0 a_6594_420# 0.2616f
C305 d1_bsel a_6984_18520# 0
C306 a_2592_8154# m1_7790_19900# 0.00252f
C307 vdd tb0 0.87919f
C308 sta a_6672_9234# 0.01085f
C309 a_7540_18520# stb 0
C310 sel0 vreset 0.17369f
C311 m1_2122_6150# vbn_leak 0
C312 m1_8350_10270# a_5524_11840# 0.16378f
C313 stb tb3 0
C314 a_3956_5520# m1_4882_3750# 0.004f
C315 m1_5946_6980# chain 0.08367f
C316 a_5524_16920# el 0.19304f
C317 a_2492_11000# sta 0.02324f
C318 a_6140_14314# a_3136_4480# 0.12081f
C319 ta1 a_5516_10600# 0
C320 m1_7930_11710# vbp_st 0.04836f
C321 tb1 tb3 0.07178f
C322 a_4368_19360# m1_2712_18170# 0.14411f
C323 a_268_18520# a_6594_420# 0.04696f
C324 ta2 a_4588_13668# 0.02235f
C325 sel1 hold 0.16908f
C326 a_7540_18520# a_672_20034# 0
C327 sta vbn_leak 0.5706f
C328 m1_5522_19900# m1_6190_19900# 0.01511f
C329 ta1 m1_7080_19410# 0.02428f
C330 m1_5286_6980# m1_6440_6140# 0.0167f
C331 d1_bsel a_488_19360# 0.0336f
C332 a_5524_5520# vdd 1.59258f
C333 d1 m1_7158_7910# 0
C334 m1_7930_11710# a_5268_9138# 0.00699f
C335 ta0 m1_7148_12980# 0.0131f
C336 a_672_20034# tb3 0.00789f
C337 a_268_18520# vreset 0
C338 m1_2868_14560# m1_2112_14220# 0.28551f
C339 a_7540_18520# vbp_st 0.00463f
C340 m1_6440_6140# en 0.0018f
C341 spk vsrcp 0.06488f
C342 vbp_st tb3 0
C343 m1_6346_17880# a_5316_18520# 0.29834f
C344 sta a_6984_18520# 0.04505f
C345 el m1_7206_2780# 0.03698f
C346 ta1 vsrcp 0.06217f
C347 a_2492_11000# a_2800_12040# 0.00223f
C348 a_6140_9234# m1_8350_10270# 0
C349 a_5524_16920# sel1 0.56662f
C350 chain hold 0.69659f
C351 m1_6190_19900# m1_3870_19890# 0.06001f
C352 d1 a_824_11000# 0.14423f
C353 vbn_prb a_3136_4480# 0.12376f
C354 vbn_ax a_5268_14218# 0.00105f
C355 a_488_12040# chain 0.01255f
C356 vdd a_6884_4480# 0.34575f
C357 vbn_leak a_2800_12040# 0.02489f
C358 a_5772_4480# en 0.06856f
C359 a_5516_15680# ta0 0
C360 m1_6968_15350# a_4588_13668# 0.00941f
C361 a_6594_420# a_5316_3120# 0
C362 a_3048_3120# a_488_5520# 0.00341f
C363 m1_7702_10660# a_5524_11840# 0.1509f
C364 vsrc a_1480_3834# 0.04738f
C365 m1_5286_6980# m1_6494_7950# 0.00754f
C366 a_5524_16920# chain 0.05046f
C367 pl_en vdd 0.16811f
C368 m1_7930_11710# a_3048_11000# 0
C369 a_8248_5320# vreset 0.04995f
C370 m1_6494_7950# en 0
C371 m1_7702_10660# a_268_18520# 0
C372 ta1 tb1 0
C373 vbn_ax vbn_leak 0.25202f
C374 mreset d1 0.34409f
C375 m1_2712_6970# a_1892_3934# 0.21741f
C376 a_5516_15680# a_3136_4480# 0.08227f
C377 tb2 m1_6190_19900# 0
C378 vbn_leak a_488_5520# 0.00157f
C379 m1_5286_6980# ta0 0.0358f
C380 ta1 m1_6968_10660# 0.05872f
C381 ta1 a_672_20034# 0
C382 spk vbp_st 0.15199f
C383 ta3 m1_5190_15350# 0.0079f
C384 ta0 en 0.00721f
C385 sel1 a_5316_18520# 0
C386 m1_5522_19900# d1_bsel 0.07673f
C387 m1_910_6150# vbp_st 0.01998f
C388 d1 ta3 0.22769f
C389 vbn_leak m1_8326_19030# 0.0758f
C390 a_7540_3120# d1 0.0635f
C391 m1_6440_6140# a_5772_4480# 0
C392 vbn_ax a_6984_18520# 0.08634f
C393 a_3048_3120# a_4660_4480# 0
C394 ta1 vbp_st 0.06185f
C395 vsrc a_3136_4480# 0.00174f
C396 chain m1_7206_2780# 0
C397 a_6140_9234# m1_7702_10660# 0.00672f
C398 m1_1310_2210# d1 0.00767f
C399 vdd m1_9090_11710# 0.07648f
C400 m1_2868_14560# el 0.06074f
C401 a_4096_6334# vbp_st 0.05136f
C402 a_6140_14314# ta3 0.03324f
C403 a_3272_6334# m1_4882_3750# 0.0759f
C404 a_4588_8588# chain 0.04524f
C405 ta1 a_5268_9138# 0.1757f
C406 d1_bsel m1_3870_19890# 0.15727f
C407 vbn_ax vs 0.00683f
C408 chain a_5316_18520# 0.00427f
C409 m1_4568_19890# m1_7080_19410# -0
C410 a_728_3738# d1 0.00645f
C411 a_3136_4480# en 0.81756f
C412 a_4660_4480# vbn_leak 0
C413 a_488_5520# vs 0.28967f
C414 a_6594_420# hold 0
C415 a_488_12040# m1_8350_10270# 0.04354f
C416 a_3048_16080# a_6140_14314# 0.08767f
C417 a_3048_16080# a_4368_19360# 0
C418 ta0 m1_6440_6140# 0.24816f
C419 m1_5522_19900# sta 0.00928f
C420 a_6672_14314# vdd 0.73739f
C421 mreset vbn_prb 0.03844f
C422 m1_6968_15350# ta2 0.02741f
C423 sel1 m1_6190_19900# 0.00272f
C424 a_3956_5520# spk 0.18042f
C425 vdd a_1892_3934# 0.45038f
C426 m1_5286_6980# m1_7158_7910# 0.01289f
C427 vbn_prb ta3 0
C428 a_7540_3120# vbn_prb 0.17701f
C429 tb2 d1_bsel 0
C430 d1 a_5516_10600# 0.23957f
C431 ta3 m1_7148_12980# 0.02536f
C432 m1_4882_3750# a_6984_3120# 0.00953f
C433 ta0 a_5772_4480# 0
C434 d1_bsel m1_6346_17880# 0
C435 vbn_leak tb0 0.18568f
C436 sta m1_3870_19890# 0.04823f
C437 m1_6440_6140# a_3136_4480# 0.01751f
C438 a_4660_4480# vs 0.29064f
C439 a_3956_5520# a_4096_6334# 0.27269f
C440 ta1 a_3048_11000# 0.10859f
C441 m1_2956_19890# a_2180_13234# 0
C442 m1_1310_2210# vbn_prb 0
C443 vdd m1_5432_10180# 0.00466f
C444 m1_6190_19900# chain 0.00745f
C445 m1_2788_6140# m1_4882_3750# 0
C446 a_3048_16080# vbn_prb 0.01787f
C447 a_4096_6334# a_3048_11000# 0
C448 a_824_16080# vdd 0.13579f
C449 m1_7930_11710# a_2592_8154# 0.00708f
C450 m1_4568_19890# stb 0.0383f
C451 m1_7080_19410# a_6140_14314# 0.00267f
C452 sel0 m1_4882_3750# 0.00371f
C453 m1_5190_15350# vsrcp 0.19525f
C454 a_5772_4480# a_3136_4480# 0.46354f
C455 a_5524_5520# vbn_leak 0.02079f
C456 d1 vsrcp 0.13744f
C457 a_5516_15680# ta3 0
C458 a_7540_18520# a_2592_8154# 0.43877f
C459 m1_5522_19900# vbn_ax 0.02625f
C460 vsrc mreset 0.03179f
C461 a_488_12040# m1_7702_10660# 0.09298f
C462 a_2592_8154# tb3 0.04808f
C463 m1_4568_19890# a_672_20034# 0.23358f
C464 vdd a_824_3120# 0
C465 m1_7206_2780# vreset 0
C466 tb2 sta 0
C467 pl_en a_5268_14218# 0.06793f
C468 vbn_ax vbn_ref 3.97162f
C469 a_6140_14314# vsrcp 0.31591f
C470 m1_7150_14166# a_4588_13668# 0.00167f
C471 sta m1_6346_17880# 0.02136f
C472 a_6140_9234# m1_6464_13090# 0.00122f
C473 a_5516_15680# a_3048_16080# 0.13452f
C474 vsrc a_7540_3120# 0.00973f
C475 a_268_18520# m1_4882_3750# 0.31775f
C476 m1_2956_19890# a_3048_18520# 0.00111f
C477 mreset en 0.19181f
C478 d1_bsel sel1 0.25243f
C479 m1_5522_19900# m1_8326_19030# 0.09697f
C480 vbn_leak a_6884_4480# 0
C481 pl_en a_6672_9234# 0.51072f
C482 chain a_2800_17120# 0
C483 a_3136_4480# a_1480_3834# 0
C484 m1_5286_6980# ta3 0.04791f
C485 sta el 0.02592f
C486 vbn_ax m1_3870_19890# 0.08468f
C487 m1_1310_2210# vsrc 0.16763f
C488 a_7540_3120# en 0.06951f
C489 ta3 en 0.05259f
C490 ta0 a_3136_4480# 0.04393f
C491 a_5524_5520# vs 0.30502f
C492 m1_2956_19890# vbp_syn 0
C493 vsrc a_728_3738# 0.11304f
C494 d1 m1_6968_10660# 0.1173f
C495 a_488_17120# vdd 2.58656f
C496 pl_en vbn_leak 0.329f
C497 m1_1310_2210# en 0
C498 d1_bsel chain 0.07369f
C499 m1_3870_19890# m1_8326_19030# 0.11327f
C500 a_5524_5520# m1_3690_6830# 0.01791f
C501 vdd m1_2112_9090# 0.28027f
C502 vbn_prb vsrcp 0.0974f
C503 a_3048_16080# en 0.0431f
C504 tb1 a_6140_14314# 0.00273f
C505 a_7540_18520# d2 0.01138f
C506 a_4368_19360# stb 0.00107f
C507 vbp_st m1_5190_15350# 0
C508 d1 vbp_st 0.55833f
C509 m1_7148_12980# vsrcp 0.04724f
C510 a_3272_6334# spk 0.16819f
C511 m1_4882_3750# a_5316_3120# 0.03421f
C512 el a_2800_12040# 0.5917f
C513 pl_en a_6984_18520# 0
C514 spk abus 0.53305f
C515 m1_4882_3750# a_8248_5320# 0.00915f
C516 ta0 m1_7158_7910# 0.00312f
C517 a_6672_9234# m1_9090_11710# 0.0533f
C518 sta sel1 0.37924f
C519 tb2 vbn_ax 0.02526f
C520 d1 m1_1046_10270# 0.37435f
C521 d1 a_5268_9138# 0.33561f
C522 a_4368_19360# a_672_20034# 0
C523 ta1 a_2592_8154# 0.04148f
C524 vbn_ax m1_6346_17880# 0.63799f
C525 m1_1996_6970# spk 0
C526 m1_6440_6140# ta3 0.02611f
C527 a_6672_14314# a_5268_14218# 0.18767f
C528 a_6140_14314# vbp_st 0.19182f
C529 m1_3690_6830# a_6884_4480# 0
C530 vdd m1_8466_15350# 0.03287f
C531 a_3272_6334# a_4096_6334# 0.15513f
C532 ta1 m1_1996_6970# 0.07149f
C533 abus a_4096_6334# 0.00772f
C534 m1_5522_19900# tb0 0.12168f
C535 tb2 m1_8326_19030# 0.10482f
C536 vbn_ax el 0.3204f
C537 mreset a_5772_4480# 0.00499f
C538 a_5516_15680# vsrcp 0
C539 a_7540_18520# a_268_18520# 0.2176f
C540 m1_6346_17880# m1_8326_19030# 0.00112f
C541 ta2 m1_7150_14166# 0.05739f
C542 a_3136_4480# m1_7158_7910# 0.00329f
C543 sta chain 0.13372f
C544 a_268_18520# tb3 0.03296f
C545 el a_488_5520# 0.169f
C546 m1_1996_6970# a_4096_6334# 0.00175f
C547 a_3048_3120# a_1892_3934# 0.10733f
C548 pl_en m1_3690_6830# 0
C549 a_5516_10600# en 0.02199f
C550 a_2180_13234# m1_2678_13100# 0.00352f
C551 m1_6464_13090# hold 0.00357f
C552 vdd a_2180_13234# 1.54026f
C553 a_5772_4480# ta3 0
C554 a_7540_3120# a_5772_4480# 0.01749f
C555 spk a_6984_3120# 0
C556 a_6140_9234# m1_7930_11710# 0.06805f
C557 el m1_8326_19030# 0
C558 a_3956_5520# d1 0.07187f
C559 a_6672_14314# vbn_leak 0.03429f
C560 vsrc vsrcp 3.99918f
C561 a_3048_11000# m1_5190_15350# 0.00712f
C562 spk m1_2788_6140# 0.04922f
C563 vbn_prb vbp_st 0.21294f
C564 m1_3870_19890# tb0 0.02965f
C565 d1 a_3048_11000# 0.30797f
C566 a_1892_3934# vbn_leak 0.15339f
C567 m1_5286_6980# vsrcp 0.01275f
C568 vbp_st m1_7148_12980# 0
C569 m1_5432_10180# a_6672_9234# 0.18156f
C570 a_4096_6334# a_6984_3120# 0.00123f
C571 ta1 m1_2788_6140# 0.00175f
C572 a_5524_16920# m1_6464_13090# 0.03914f
C573 en vsrcp 0.06856f
C574 vbn_ax sel1 0.02673f
C575 ta1 d2 0.03347f
C576 chain a_2800_12040# 0
C577 spk sel0 0.33135f
C578 m1_4882_3750# hold 0.00353f
C579 a_5268_9138# m1_7148_12980# 0.00556f
C580 m1_7790_19900# m1_6190_19900# 0
C581 a_4660_4480# el 0
C582 a_4096_6334# m1_2788_6140# 0.01569f
C583 m1_6968_15350# m1_7150_14166# 0.0128f
C584 ta0 ta3 0.13201f
C585 ta1 m1_7150_9212# 0.01227f
C586 vbn_leak m1_5432_10180# 0.26411f
C587 m1_1310_2210# a_1480_3834# 0
C588 chain m1_6716_11710# 0
C589 vdd a_3048_18520# 0.36794f
C590 sel0 a_4096_6334# 0.08735f
C591 a_5516_15680# vbp_st 0
C592 tb2 tb0 0.15067f
C593 spk a_268_18520# 0.12937f
C594 ta1 a_5524_11840# 0.07952f
C595 mreset a_3136_4480# 0.43845f
C596 vbn_ax chain 0.01509f
C597 a_1892_3934# vs 0.00744f
C598 a_728_3738# a_1480_3834# 0.13821f
C599 a_4588_13668# m1_2678_13100# 0
C600 m1_6346_17880# tb0 0
C601 a_3048_16080# ta0 0.04512f
C602 vbn_ax sel2 0.02691f
C603 stb en 0.0248f
C604 pl_en m1_5522_19900# 0.00637f
C605 chain a_488_5520# 0
C606 vbp_syn m1_2678_13100# 0.33846f
C607 vdd a_4588_13668# 0.19638f
C608 m1_2712_6970# m1_4330_6980# 0.00467f
C609 ta1 a_268_18520# 0.02804f
C610 vdd vbp_syn 2.35802f
C611 a_672_20034# m1_2470_19900# 0.00367f
C612 a_7540_3120# a_3136_4480# 0.23335f
C613 m1_6440_6140# vsrcp 0.0017f
C614 ta3 a_3136_4480# 0.11892f
C615 vsrc vbp_st 0.68152f
C616 m1_3690_6830# a_1892_3934# 0.10638f
C617 m1_7702_12990# el 0.11264f
C618 el tb0 0
C619 a_4096_6334# a_268_18520# 0.05438f
C620 vbn_prb a_3048_11000# 0.01258f
C621 m1_6968_10660# en 0.1409f
C622 a_488_17120# a_5268_14218# 0.0306f
C623 a_672_20034# en 0.15943f
C624 m1_4568_19890# a_2592_8154# 0.20136f
C625 a_3048_11000# m1_7148_12980# 0.01172f
C626 m1_1310_2210# a_3136_4480# 0.14327f
C627 a_3048_16080# a_3136_4480# 0.00273f
C628 pl_en m1_3870_19890# 0.01815f
C629 m1_1946_330# vbn_prb 0.06742f
C630 a_3048_16080# m1_2712_18170# 0.00253f
C631 vbp_st en 0.20021f
C632 m1_2708_380# vbn_prb 0.08916f
C633 m1_4882_3750# m1_7206_2780# 0.00905f
C634 a_5268_9138# m1_5286_6980# 0
C635 a_488_12040# m1_7930_11710# 0.00381f
C636 a_6140_9234# ta1 0.03216f
C637 ta3 m1_7158_7910# 0.07108f
C638 a_5268_9138# en 0.15675f
C639 spk a_5316_3120# 0
C640 a_5524_5520# el 0.00389f
C641 a_4660_4480# chain 0.0145f
C642 spk a_8248_5320# 0.28819f
C643 ta0 a_5516_10600# 0
C644 a_7540_18520# hold 0.2341f
C645 a_2492_11000# m1_2112_9090# 0.00143f
C646 hold tb3 0.00219f
C647 m1_7080_19410# ta0 0.07447f
C648 a_824_3120# vs 0.26816f
C649 a_488_17120# vbn_leak 0.09949f
C650 ta1 a_8248_5320# 0
C651 vbn_leak m1_2112_9090# 0
C652 d1 a_3272_6334# 0.05019f
C653 a_4096_6334# a_5316_3120# 0.46375f
C654 a_4096_6334# a_8248_5320# 0
C655 a_2592_8154# d1 0.35065f
C656 d1 abus 0.0442f
C657 vbp_st m1_6440_6140# 0
C658 vdd m1_4330_6980# 0
C659 a_7540_18520# a_5524_16920# 0
C660 a_488_17120# a_6984_18520# 0.00474f
C661 a_5516_10600# a_3136_4480# 0.06706f
C662 pl_en m1_6346_17880# 0.02829f
C663 m1_4568_19890# d2 0
C664 m1_1996_6970# d1 0.03584f
C665 ta0 vsrcp 0.10319f
C666 a_5524_16920# tb3 0.0048f
C667 a_6672_14314# m1_9090_16790# 0.02064f
C668 chain tb0 0
C669 a_3956_5520# en 0.00185f
C670 a_2592_8154# a_6140_14314# 0.50243f
C671 ta1 m1_5946_6980# 0.00973f
C672 abus a_6140_14314# 0.00189f
C673 ta2 vdd 0.30747f
C674 m1_5286_6980# a_3048_11000# 0.16394f
C675 m1_8466_15350# vbn_leak 0.01682f
C676 a_2592_8154# a_4368_19360# 0.08146f
C677 a_6594_420# a_488_5520# 0.00109f
C678 pl_en el 0.15358f
C679 vsrc m1_1946_330# 0.00763f
C680 vbn_ax vreset 0.04097f
C681 m1_642_6980# m1_1096_6970# 0.00895f
C682 a_3048_11000# en 0.15544f
C683 vsrc m1_2708_380# 0
C684 a_1892_3934# a_2492_3120# 0.00845f
C685 vbp_st a_5772_4480# 0
C686 a_488_17120# a_488_19360# 0.00541f
C687 mreset a_7540_3120# 0.51309f
C688 a_3136_4480# vsrcp 0.29749f
C689 m1_1946_330# en 0.05381f
C690 d1 a_6984_3120# 0
C691 vbn_leak a_2180_13234# 0.0591f
C692 stb ta0 0
C693 m1_2708_380# en 0.1144f
C694 a_5524_5520# chain 0.28776f
C695 m1_4568_19890# a_268_18520# 0.00575f
C696 a_7540_3120# ta3 0
C697 d1 m1_2788_6140# 0.28416f
C698 d2 m1_5190_15350# 0.17872f
C699 m1_1310_2210# mreset 0.00595f
C700 vbn_prb a_3272_6334# 0.40127f
C701 m1_2712_6970# m1_1096_6970# 0.0117f
C702 a_2592_8154# vbn_prb 0
C703 a_7540_18520# a_5316_18520# 0.11252f
C704 ta1 hold 0.01257f
C705 ta0 m1_6968_10660# 0.02107f
C706 vbn_prb abus 2.26243f
C707 ta1 a_488_12040# 0.04938f
C708 a_2592_8154# m1_7148_12980# 0.00164f
C709 m1_6968_15350# vdd 0.01603f
C710 a_4660_4480# a_6594_420# 0
C711 vbp_st a_1480_3834# 0.14551f
C712 d1 m1_7150_9212# 0.08949f
C713 pl_en sel1 0.04311f
C714 a_6984_18520# a_2180_13234# 0
C715 a_672_20034# ta0 0
C716 d1 sel0 0.03155f
C717 m1_1310_2210# a_7540_3120# 0
C718 a_4096_6334# hold 0.0096f
C719 m1_6440_6140# a_3048_11000# 0.65779f
C720 a_6140_14314# d2 0.07446f
C721 a_3048_16080# ta3 0.23541f
C722 chain a_6884_4480# 0.01274f
C723 m1_7158_7910# vsrcp 0.00114f
C724 a_5268_14218# a_4588_13668# 0.11529f
C725 vbp_st ta0 0.06667f
C726 a_4368_19360# d2 0.27798f
C727 d1 a_5524_11840# 0.58909f
C728 a_5268_14218# vbp_syn 0.00904f
C729 a_2492_3120# a_824_3120# 0.01027f
C730 a_3956_5520# a_5772_4480# 0
C731 a_5268_9138# ta0 0.18772f
C732 ta1 a_5524_16920# 0.04515f
C733 m1_6968_10660# a_3136_4480# 0.25097f
C734 pl_en chain 2.37403f
C735 m1_1310_2210# a_728_3738# 0
C736 d1 a_268_18520# 1.9516f
C737 vbn_ax m1_7790_19900# 0
C738 a_488_19360# a_2180_13234# 0.20402f
C739 a_6672_14314# el 0.04973f
C740 vbn_leak a_3048_18520# 0.00313f
C741 a_5772_4480# a_3048_11000# 0
C742 vbn_prb a_6984_3120# 0.08824f
C743 a_2492_11000# vbp_syn 0.00373f
C744 m1_1860_15340# m1_5190_15350# 0
C745 a_1892_3934# el 0.22199f
C746 vbp_st a_3136_4480# 0.16671f
C747 vbn_prb m1_2788_6140# 0
C748 a_7540_18520# m1_6190_19900# 0
C749 vbn_leak a_4588_13668# 0.35899f
C750 spk m1_7206_2780# 0
C751 vbn_prb d2 0.00119f
C752 m1_5522_19900# a_488_17120# 0.04117f
C753 a_6140_14314# a_268_18520# 0.00584f
C754 vbn_leak vbp_syn 0.67222f
C755 m1_6190_19900# tb3 0.05301f
C756 m1_7790_19900# m1_8326_19030# 0.12253f
C757 m1_1046_10270# a_3136_4480# 0
C758 a_5268_9138# a_3136_4480# 0.18169f
C759 a_488_17120# m1_9090_16790# 0.00236f
C760 a_4368_19360# a_268_18520# 0.31341f
C761 ta3 a_5516_10600# 0
C762 vsrc a_3272_6334# 0.69519f
C763 a_3956_5520# a_1480_3834# 0.0017f
C764 d2 m1_7148_12980# 0
C765 a_6140_9234# m1_5190_15350# 0
C766 vsrc abus 0.11909f
C767 vdd m1_1096_6970# 0.03919f
C768 m1_6968_10660# m1_7158_7910# 0.06397f
C769 a_2592_8154# m1_2470_19900# 0.07812f
C770 sta m1_6464_13090# 0.06201f
C771 m1_7080_19410# ta3 0.06747f
C772 vbn_prb sel0 0.37278f
C773 a_2592_8154# m1_5286_6980# 0.00657f
C774 a_6140_9234# d1 0.36817f
C775 ta1 a_4588_8588# 0.04547f
C776 a_824_16080# el 0.29107f
C777 a_3272_6334# en 0.194f
C778 a_4096_6334# m1_7206_2780# 0.16699f
C779 a_5524_5520# a_6594_420# 0.00596f
C780 a_6672_14314# sel1 0.12288f
C781 a_2592_8154# en 0.49897f
C782 mreset vsrcp 0.02796f
C783 abus en 0.01231f
C784 ta0 a_3048_11000# 0.1619f
C785 a_488_17120# m1_3870_19890# 0.04666f
C786 m1_1996_6970# m1_5286_6980# 0.3621f
C787 vbn_prb a_5524_11840# 0.21806f
C788 a_2492_18520# m1_2470_19900# 0
C789 d1 a_5316_3120# 0.03052f
C790 d1 a_8248_5320# 0.15315f
C791 m1_7080_19410# a_3048_16080# 0.31946f
C792 m1_1996_6970# en 0.04724f
C793 a_3048_18520# a_488_19360# 0.01269f
C794 ta3 vsrcp 0.11455f
C795 vbn_prb a_268_18520# 0.29158f
C796 a_5516_15680# d2 0.13826f
C797 a_3956_5520# a_3136_4480# 0.05471f
C798 m1_7930_16790# a_6140_14314# 0.0096f
C799 ta2 a_5268_14218# 0.07653f
C800 el a_824_3120# 0.08919f
C801 vsrc a_6984_3120# 0.01462f
C802 a_6672_14314# chain 0.00598f
C803 m1_4568_19890# hold 0
C804 a_3048_11000# a_3136_4480# 0.0336f
C805 m1_5522_19900# a_2180_13234# 0.00603f
C806 m1_2112_14220# a_2180_13234# 0.16517f
C807 a_6140_14314# m1_7702_15540# 0.07072f
C808 a_1892_3934# chain 0.19653f
C809 ta2 a_6672_9234# 0.00679f
C810 a_824_11000# m1_1046_10270# 0.2304f
C811 tb2 a_488_17120# 0.02073f
C812 m1_7790_19900# tb0 0.20038f
C813 en a_6984_3120# 0.00242f
C814 m1_2788_6140# m1_5286_6980# 0.02146f
C815 vbn_leak m1_4330_6980# 0.53289f
C816 a_488_17120# m1_6346_17880# 0.19905f
C817 a_6140_9234# vbn_prb 0
C818 a_7540_18520# d1_bsel 0.0069f
C819 ta1 m1_6190_19900# 0.00771f
C820 a_6140_9234# m1_7148_12980# 0.00121f
C821 d1_bsel tb3 0
C822 m1_2788_6140# en 0.13602f
C823 vsrc sel0 0.42975f
C824 m1_1996_6970# m1_6440_6140# 0.01555f
C825 d2 en 0.08029f
C826 tb1 ta3 0.00788f
C827 chain m1_5432_10180# 0.04181f
C828 ta2 vbn_leak 0.51605f
C829 m1_3870_19890# a_2180_13234# 0.03377f
C830 vbn_prb a_5316_3120# 0
C831 mreset vbp_st 0.11208f
C832 a_3048_11000# m1_7158_7910# 0
C833 ta3 m1_6968_10660# 0.08838f
C834 a_488_17120# el 0.18553f
C835 a_672_20034# ta3 0
C836 vsrc a_5524_11840# 0
C837 m1_7150_9212# en 0
C838 vbn_prb a_8248_5320# 0.0419f
C839 a_5516_15680# m1_1860_15340# 0
C840 m1_6968_15350# a_5268_14218# 0.05967f
C841 sel0 en 0.0755f
C842 a_3272_6334# a_5772_4480# 0.00209f
C843 m1_5286_6980# a_5524_11840# 0
C844 m1_5190_15350# hold 0.00923f
C845 tb1 a_3048_16080# 0.10187f
C846 d1 hold 0.61876f
C847 vbn_prb m1_7702_15540# 0.05512f
C848 vsrc a_268_18520# 0.00464f
C849 a_7540_3120# vbp_st 0.15172f
C850 a_5516_10600# vsrcp 0
C851 vbp_st ta3 0.06632f
C852 ta2 a_6984_18520# 0.02136f
C853 m1_4330_6980# vs 0
C854 en a_5524_11840# 0.18454f
C855 a_488_12040# d1 0.46552f
C856 vbn_ax m1_4882_3750# 0.13788f
C857 a_3048_16080# a_672_20034# 0
C858 m1_2668_7940# d1 0.05278f
C859 a_5268_9138# ta3 0.04863f
C860 a_2592_8154# m1_6494_7950# 0.0066f
C861 a_6140_14314# hold 0.04558f
C862 m1_1310_2210# vbp_st 0.28925f
C863 m1_2788_6140# m1_6440_6140# 0.07943f
C864 a_268_18520# en 0.19661f
C865 a_3272_6334# a_1480_3834# 0.26458f
C866 m1_3690_6830# m1_4330_6980# 0.08372f
C867 m1_6968_15350# vbn_leak 0.03369f
C868 a_3048_16080# vbp_st 0.11031f
C869 a_4368_19360# hold 0.06389f
C870 a_7540_18520# sta 0.04173f
C871 sta tb3 0
C872 a_5524_16920# m1_5190_15350# 0.45387f
C873 m1_5522_19900# vbp_syn 0
C874 m1_2956_19890# vdd 0.07915f
C875 a_488_17120# sel1 0.00698f
C876 a_728_3738# vbp_st 0.15037f
C877 a_5524_16920# d1 0
C878 vbp_syn m1_2112_14220# 0.31116f
C879 m1_6346_17880# a_2180_13234# 0.00422f
C880 m1_4568_19890# a_5316_18520# 0
C881 a_6140_9234# vsrc 0
C882 a_2592_8154# ta0 0.10309f
C883 m1_1996_6970# a_1480_3834# 0
C884 ta2 m1_3690_6830# 0.32151f
C885 a_3956_5520# mreset 0.2734f
C886 a_5772_4480# a_6984_3120# 0.00466f
C887 a_6140_9234# m1_5286_6980# 0
C888 m1_6968_15350# a_6984_18520# 0
C889 a_5524_16920# a_6140_14314# 0.4979f
C890 m1_7080_19410# stb 0.00193f
C891 m1_1996_6970# ta0 0.01066f
C892 el a_2180_13234# 0.22278f
C893 vsrc a_5316_3120# 0.00233f
C894 m1_2788_6140# a_5772_4480# 0.01146f
C895 a_1892_3934# a_6594_420# 0
C896 a_6140_9234# en 0.39112f
C897 m1_6968_10660# a_5516_10600# 0
C898 tb1 m1_7080_19410# 0.17109f
C899 ta1 d1_bsel 0
C900 vsrc a_8248_5320# 0.03622f
C901 m1_3870_19890# vbp_syn 0.02552f
C902 a_488_17120# chain 0.00838f
C903 a_3956_5520# a_7540_3120# 0.01709f
C904 a_4660_4480# m1_4882_3750# 0.21742f
C905 a_268_18520# m1_6440_6140# 0.0027f
C906 a_3272_6334# a_3136_4480# 0.15226f
C907 a_488_12040# vbn_prb 0
C908 a_2592_8154# a_3136_4480# 0.12119f
C909 sel1 m1_8466_15350# 0.01076f
C910 m1_7080_19410# a_672_20034# 0.00358f
C911 d1 m1_7206_2780# 0.0056f
C912 a_5316_3120# en 0.05482f
C913 m1_642_6980# vdd 0.01042f
C914 ta3 a_3048_11000# 0.37694f
C915 m1_7148_12980# hold 0.00103f
C916 abus a_3136_4480# 0.19294f
C917 a_2592_8154# m1_2712_18170# 0
C918 m1_1310_2210# a_3956_5520# 0.04652f
C919 m1_2712_18170# a_824_18520# 0.22127f
C920 m1_7080_19410# vbp_st 0
C921 d1 a_4588_8588# 0.12014f
C922 m1_2788_6140# a_1480_3834# 0.13871f
C923 a_5268_9138# a_5516_10600# 0.09601f
C924 m1_7702_10660# m1_9090_11710# 0
C925 m1_7702_15540# en 0.24084f
C926 vbn_leak m1_1096_6970# 0.19122f
C927 m1_4568_19890# m1_6190_19900# 0
C928 sel1 a_2180_13234# 0.0283f
C929 m1_6968_10660# vsrcp 0.02712f
C930 vbn_prb a_5524_16920# 0.04434f
C931 a_2492_18520# m1_2712_18170# 0.33965f
C932 a_7540_18520# vbn_ax 0.1203f
C933 m1_2788_6140# ta0 0.00121f
C934 m1_5946_6980# m1_5286_6980# 0.03162f
C935 a_268_18520# a_5772_4480# 0.03051f
C936 m1_2712_6970# vdd 0.00817f
C937 d2 ta0 0.01425f
C938 vbn_ax tb3 0.02585f
C939 a_5524_16920# m1_7148_12980# 0.07102f
C940 m1_6494_7950# a_5524_11840# 0
C941 m1_5946_6980# en 0.00708f
C942 a_5516_15680# hold 0.21867f
C943 vbp_syn m1_6346_17880# 0
C944 ta1 sta 0
C945 ta0 m1_7150_9212# 0.00561f
C946 vbp_st vsrcp 4.09023f
C947 a_4368_19360# a_5316_18520# 0.00643f
C948 m1_5522_19900# ta2 0.1243f
C949 m1_8326_19030# tb3 0.07615f
C950 a_3136_4480# a_6984_3120# 0.0029f
C951 a_4588_13668# el 0.62291f
C952 chain a_2180_13234# 0.02795f
C953 m1_6440_6140# a_8248_5320# 0.04285f
C954 m1_1046_10270# vsrcp 0
C955 a_5268_9138# vsrcp 0.23398f
C956 m1_2788_6140# a_3136_4480# 0.4858f
C957 ta0 a_5524_11840# 0.0395f
C958 vbp_syn el 0.47535f
C959 ta0 m1_6716_16790# 0.00188f
C960 d2 a_3136_4480# 0.2682f
C961 vbn_prb m1_7206_2780# 0.13152f
C962 a_268_18520# a_1480_3834# 0.00278f
C963 m1_1096_6970# vs 0.01827f
C964 d2 m1_2712_18170# 0.01053f
C965 a_5524_5520# m1_4882_3750# 0.1361f
C966 a_5516_15680# a_5524_16920# 0.21658f
C967 m1_2470_19900# hold 0
C968 a_672_20034# stb 0.84731f
C969 m1_5286_6980# hold 0.03664f
C970 a_268_18520# ta0 0.02856f
C971 tb1 a_672_20034# 0
C972 m1_7150_9212# a_3136_4480# 0.14893f
C973 a_3048_11000# a_5516_10600# 0.01872f
C974 sel0 a_3136_4480# 0.0494f
C975 ta2 m1_3870_19890# 0.0076f
C976 a_488_12040# m1_5286_6980# 0.0994f
C977 a_5316_3120# a_5772_4480# 0.01436f
C978 m1_3690_6830# m1_1096_6970# 0
C979 m1_5946_6980# m1_6440_6140# 0.08545f
C980 en hold 0.25516f
C981 a_488_12040# en 0.1884f
C982 pl_en m1_6464_13090# 0
C983 m1_7150_14166# a_5268_14218# 0.27061f
C984 a_3136_4480# a_5524_11840# 0.86372f
C985 a_3136_4480# m1_6716_16790# 0
C986 m1_2236_8010# d1 0.14287f
C987 sel1 a_4588_13668# 0
C988 vbn_ax spk 0.09142f
C989 mreset a_3272_6334# 0.28884f
C990 m1_4882_3750# a_6884_4480# 0.04659f
C991 vdd m1_2678_13100# 0.2597f
C992 a_268_18520# a_3136_4480# 3.03369f
C993 a_5268_9138# m1_6968_10660# 0.39321f
C994 m1_4568_19890# d1_bsel 0.18754f
C995 m1_7150_9212# m1_7158_7910# 0.0012f
C996 a_3048_11000# vsrcp 0.14116f
C997 a_6140_9234# ta0 0.04292f
C998 mreset abus 0.03445f
C999 m1_910_6150# a_488_5520# 0.01824f
C1000 a_5524_16920# en 0.0575f
C1001 a_268_18520# m1_2712_18170# 0.43599f
C1002 ta1 vbn_ax 0.00664f
C1003 a_7540_18520# tb0 0
C1004 a_7540_3120# a_3272_6334# 0.14837f
C1005 a_2592_8154# ta3 0.11445f
C1006 tb2 ta2 0.00114f
C1007 a_5516_15680# a_5316_18520# 0
C1008 a_5268_9138# vbp_st 0.34317f
C1009 ta2 m1_6346_17880# 0.04007f
C1010 tb0 tb3 0.08897f
C1011 a_4588_13668# chain 0.0075f
C1012 ta0 a_8248_5320# 0.02662f
C1013 m1_6440_6140# hold 0.33859f
C1014 m1_7158_7910# a_5524_11840# 0.1678f
C1015 m1_7150_14166# vbn_leak 0
C1016 vsrc m1_7206_2780# 0.00735f
C1017 m1_1996_6970# ta3 0.21761f
C1018 a_488_12040# m1_6440_6140# 0.10935f
C1019 m1_1310_2210# a_3272_6334# 0.61039f
C1020 m1_1996_6970# a_7540_3120# 0
C1021 a_6140_9234# a_3136_4480# 0.03636f
C1022 a_3048_16080# a_2592_8154# 0.34292f
C1023 ta2 el 0.0078f
C1024 a_3048_16080# abus 0
C1025 a_728_3738# a_3272_6334# 0.02853f
C1026 m1_2956_19890# vbn_leak 0.09687f
C1027 m1_7206_2780# en 0.02264f
C1028 mreset a_6984_3120# 0.10745f
C1029 a_4588_8588# m1_5286_6980# 0.21859f
C1030 a_5316_3120# a_3136_4480# 0.19445f
C1031 m1_5946_6980# ta0 0.04914f
C1032 a_4368_19360# a_2800_17120# 0
C1033 a_5772_4480# hold 0.17215f
C1034 a_8248_5320# a_3136_4480# 0.18861f
C1035 a_4588_8588# en 0.25191f
C1036 a_6672_14314# m1_6464_13090# 0
C1037 a_3048_16080# a_2492_18520# 0.00493f
C1038 mreset m1_2788_6140# 0.01894f
C1039 a_728_3738# m1_1996_6970# 0.00905f
C1040 a_3048_11000# m1_6968_10660# 0.00566f
C1041 en a_5316_18520# 0.04842f
C1042 a_3956_5520# vbp_st 0.00282f
C1043 a_488_17120# m1_7790_19900# 0
C1044 a_7540_3120# a_6984_3120# 0.36172f
C1045 m1_7702_15540# a_3136_4480# 0.26751f
C1046 a_4660_4480# a_4096_6334# 0.14003f
C1047 a_7540_3120# m1_2788_6140# 0.00175f
C1048 m1_2788_6140# ta3 0.17309f
C1049 m1_6494_7950# hold 0.00324f
C1050 vbp_st a_3048_11000# 0.15673f
C1051 d2 ta3 0.16161f
C1052 d1_bsel a_4368_19360# 0.02063f
C1053 mreset sel0 0.12895f
C1054 sel1 ta2 0.03193f
C1055 m1_1046_10270# a_3048_11000# 0.04576f
C1056 a_5268_9138# a_3048_11000# 0.03222f
C1057 m1_6968_15350# el 0.07289f
C1058 m1_642_6980# vbn_leak 0.02514f
C1059 ta3 m1_7150_9212# 0.00924f
C1060 m1_1946_330# vbp_st 0
C1061 a_7540_3120# sel0 0.01351f
C1062 m1_7080_19410# a_2592_8154# 0.08285f
C1063 m1_2708_380# vbp_st 0
C1064 ta0 hold 2.92713f
C1065 pl_en a_7540_18520# 0.0213f
C1066 a_3048_16080# d2 0.2143f
C1067 m1_2668_7940# a_1480_3834# 0
C1068 ta1 tb0 0
C1069 m1_4330_6980# chain 0
C1070 sta m1_5190_15350# 0.01516f
C1071 a_728_3738# m1_2788_6140# 0.0149f
C1072 a_488_12040# ta0 0.11436f
C1073 sta d1 0.26008f
C1074 mreset a_268_18520# 0.49406f
C1075 ta3 a_5524_11840# 0.11173f
C1076 m1_1310_2210# sel0 0
C1077 ta2 chain 0.01f
C1078 m1_2712_6970# vbn_leak 0.17187f
C1079 m1_6190_19900# en 0
C1080 a_3272_6334# vsrcp 0
C1081 a_5524_5520# spk 0
C1082 a_7540_3120# a_268_18520# 0.11924f
C1083 a_268_18520# ta3 0.07347f
C1084 a_5772_4480# m1_7206_2780# 0.00143f
C1085 a_2592_8154# vsrcp 0.23118f
C1086 sta a_6140_14314# 0.06051f
C1087 sta a_4368_19360# 0
C1088 abus vsrcp 0.11849f
C1089 a_5524_16920# ta0 0.03515f
C1090 m1_6968_15350# sel1 0.44917f
C1091 a_3136_4480# hold 0.3861f
C1092 m1_642_6980# vs 0.00816f
C1093 m1_7692_7940# m1_5286_6980# 0.07558f
C1094 m1_2712_18170# hold 0.07218f
C1095 ta1 a_5524_5520# 0.00247f
C1096 a_488_12040# a_3136_4480# 0.01832f
C1097 a_5516_15680# a_2800_17120# 0.00722f
C1098 m1_1996_6970# vsrcp 0
C1099 m1_1310_2210# a_268_18520# 0.04551f
C1100 a_3048_16080# a_268_18520# 0.2962f
C1101 a_5524_5520# a_4096_6334# 0.14158f
C1102 d1 a_2800_12040# 0.18232f
C1103 a_728_3738# a_268_18520# 0
C1104 a_5268_14218# m1_2678_13100# 0.001f
C1105 a_5268_14218# vdd 0.66744f
C1106 a_6140_9234# ta3 0.05383f
C1107 a_3048_16080# m1_1860_15340# 0.08201f
C1108 mreset a_5316_3120# 0.25189f
C1109 mreset a_8248_5320# 0.13004f
C1110 a_4588_8588# m1_6494_7950# 0.04246f
C1111 a_5524_16920# a_3136_4480# 0.18041f
C1112 a_3048_3120# vdd 1.13112f
C1113 m1_6968_15350# chain 0.00286f
C1114 a_2592_8154# stb 0.21508f
C1115 m1_7158_7910# hold 0
C1116 d1 m1_6716_11710# 0.06245f
C1117 stb a_824_18520# 0
C1118 vdd a_6672_9234# 0.72597f
C1119 m1_7930_16790# ta3 0.00107f
C1120 tb1 a_2592_8154# 0.04941f
C1121 a_7540_3120# a_5316_3120# 0.11842f
C1122 a_488_12040# m1_7158_7910# 0.0013f
C1123 ta3 a_8248_5320# 0
C1124 a_7540_3120# a_8248_5320# 0.00233f
C1125 vbn_ax d1 0.13186f
C1126 m1_2712_6970# m1_3690_6830# 0.03351f
C1127 a_2592_8154# m1_6968_10660# 0.03741f
C1128 a_5516_10600# a_5524_11840# 0.06135f
C1129 a_2800_17120# en 0
C1130 a_2492_11000# vdd 0.35213f
C1131 a_4588_8588# ta0 0.05434f
C1132 a_6672_14314# tb3 0
C1133 a_2592_8154# a_672_20034# 0.29129f
C1134 m1_1946_330# m1_2708_380# 0.25611f
C1135 pl_en ta1 0.01181f
C1136 d2 vsrcp 0.11697f
C1137 vbn_leak m1_2678_13100# 0.07685f
C1138 m1_1310_2210# a_5316_3120# 0
C1139 a_3272_6334# vbp_st 1.39564f
C1140 m1_7702_15540# ta3 0.01281f
C1141 vdd vbn_leak 3.55191f
C1142 a_2592_8154# vbp_st 0.06769f
C1143 vbn_ax a_6140_14314# 0.0011f
C1144 m1_7150_9212# vsrcp 0.35671f
C1145 abus vbp_st 0.16908f
C1146 sel0 vsrcp 0.03109f
C1147 a_3136_4480# m1_7206_2780# 0.10927f
C1148 a_488_12040# a_824_11000# 0.19028f
C1149 vbn_ax a_4368_19360# 0.09925f
C1150 m1_7080_19410# a_268_18520# 0.06593f
C1151 d1_bsel en 0.01078f
C1152 a_2592_8154# m1_1046_10270# 0
C1153 m1_5946_6980# ta3 0
C1154 m1_1996_6970# vbp_st 0.00233f
C1155 a_2592_8154# a_5268_9138# 0.23553f
C1156 a_3048_16080# m1_7702_15540# 0.01745f
C1157 a_4588_8588# a_3136_4480# 0.0314f
C1158 a_5516_15680# sta 0
C1159 m1_2956_19890# m1_3870_19890# 0.04635f
C1160 a_6140_14314# m1_8326_19030# 0
C1161 a_5524_11840# vsrcp 0.54771f
C1162 vdd a_6984_18520# 0.26787f
C1163 m1_1996_6970# a_5268_9138# 0
C1164 a_268_18520# vsrcp 0.07399f
C1165 d1 a_4660_4480# 0.07802f
C1166 a_6140_9234# a_5516_10600# 0.06855f
C1167 vdd vs 1.14578f
C1168 vbn_ax vbn_prb 0.23521f
C1169 m1_6190_19900# ta0 0.00363f
C1170 vbp_st a_6984_3120# 0.10373f
C1171 vdd a_488_19360# 1.48612f
C1172 a_3956_5520# a_3272_6334# 0.06795f
C1173 a_4588_8588# m1_7158_7910# 0.24401f
C1174 m1_6968_10660# m1_7150_9212# 0.02182f
C1175 vbp_st m1_2788_6140# 0.2298f
C1176 a_7540_3120# hold 0.03142f
C1177 ta3 hold 0.06533f
C1178 vdd m1_3690_6830# 0.87691f
C1179 m1_7150_14166# el 0
C1180 a_488_12040# ta3 0.43867f
C1181 sta en 0.15297f
C1182 vbp_st d2 0.32789f
C1183 ta1 a_6672_14314# 0.03697f
C1184 spk a_1892_3934# 0.00506f
C1185 a_2592_8154# a_3048_11000# 0.21985f
C1186 a_6140_9234# vsrcp 0.14105f
C1187 m1_910_6150# a_1892_3934# 0
C1188 stb a_268_18520# 0.00346f
C1189 m1_6968_10660# a_5524_11840# 0.08147f
C1190 a_3048_16080# hold 0.67222f
C1191 sel0 vbp_st 0.12201f
C1192 tb1 a_268_18520# 0.01277f
C1193 m1_1996_6970# a_3048_11000# 0.00548f
C1194 m1_1946_330# a_3272_6334# 0
C1195 a_5268_9138# m1_7150_9212# 0.08357f
C1196 a_3048_16080# a_2492_16080# 0.19474f
C1197 a_5524_16920# ta3 0.12166f
C1198 m1_2708_380# a_3272_6334# 0
C1199 m1_7702_10660# ta2 0
C1200 vbp_st a_5524_11840# 0.2269f
C1201 a_5516_15680# vbn_ax 0.00231f
C1202 vbp_st m1_6716_16790# 0.06587f
C1203 m1_2708_380# abus 0.05049f
C1204 m1_1946_330# abus 0.09411f
C1205 a_4096_6334# a_1892_3934# 0.02062f
C1206 a_672_20034# a_268_18520# 0
C1207 a_6140_14314# tb0 0
C1208 a_7540_18520# a_488_17120# 0.0024f
C1209 a_2800_12040# en 0
C1210 ta2 m1_7790_19900# 0
C1211 ta1 m1_5432_10180# 0.00802f
C1212 m1_7692_7940# a_3136_4480# 0.01311f
C1213 a_5268_9138# a_5524_11840# 0.1872f
C1214 a_488_17120# tb3 0.0101f
C1215 sel1 m1_7150_14166# 0
C1216 vbp_st a_268_18520# 0.80599f
C1217 a_3048_16080# a_5524_16920# 0.02338f
C1218 d1 a_5524_5520# 0.08081f
C1219 m1_4568_19890# pl_en 0
C1220 vsrc vbn_ax 0.08023f
C1221 mreset m1_7206_2780# 0.2881f
C1222 m1_6464_13090# a_4588_13668# 0.04051f
C1223 a_3956_5520# m1_2788_6140# 0.0082f
C1224 m1_5946_6980# vsrcp 0
C1225 vsrc a_488_5520# 0.1743f
C1226 a_6140_9234# m1_6968_10660# 0
C1227 m1_2788_6140# a_3048_11000# 0.16586f
C1228 a_5516_10600# hold 0.14954f
C1229 d1_bsel ta0 0
C1230 d2 a_3048_11000# 0
C1231 a_7540_3120# m1_7206_2780# 0.7247f
C1232 vbn_ax en 0.02583f
C1233 vsrc m1_8326_19030# 0
C1234 a_488_12040# a_5516_10600# 0.01052f
C1235 m1_2112_14220# m1_2678_13100# 0.01685f
C1236 m1_7080_19410# hold 0.0035f
C1237 m1_5522_19900# vdd 0.47584f
C1238 m1_7150_14166# chain 0
C1239 a_4588_8588# ta3 0.04605f
C1240 m1_7692_7940# m1_7158_7910# 0.04406f
C1241 vdd m1_2112_14220# 0.21031f
C1242 a_2800_17120# a_3136_4480# 0.00721f
C1243 d1 a_6884_4480# 0.19121f
C1244 a_6140_9234# vbp_st 0.33813f
C1245 m1_2712_18170# a_2800_17120# 0.01573f
C1246 vdd m1_9090_16790# 0.07864f
C1247 vdd vbn_ref 0.1742f
C1248 m1_1310_2210# m1_7206_2780# 0
C1249 a_3048_11000# m1_7150_9212# 0
C1250 m1_7702_12990# m1_7148_12980# 0.09932f
C1251 vdd a_2492_3120# 0.1608f
C1252 a_5268_14218# vbn_leak 0.1365f
C1253 a_6140_9234# a_5268_9138# 0.28115f
C1254 m1_7930_16790# vbp_st 0.02136f
C1255 vbp_st a_5316_3120# 0.02562f
C1256 vbp_st a_8248_5320# 0.07631f
C1257 m1_2122_6150# a_1480_3834# 0.03782f
C1258 pl_en m1_5190_15350# 0.03748f
C1259 a_3956_5520# a_268_18520# 0.1128f
C1260 a_3048_3120# vbn_leak 0.09959f
C1261 a_3048_11000# a_5524_11840# 0.07746f
C1262 pl_en d1 0.04487f
C1263 a_7540_18520# a_2180_13234# 0.15972f
C1264 a_3048_16080# a_5316_18520# 0.09907f
C1265 m1_1946_330# sel0 0.0294f
C1266 hold vsrcp 0.20053f
C1267 m1_7080_19410# a_5524_16920# 0.00767f
C1268 vdd m1_3870_19890# 0.24578f
C1269 m1_2708_380# sel0 0.01101f
C1270 a_488_12040# vsrcp 0.01246f
C1271 vbn_leak a_6672_9234# 0.19762f
C1272 a_2180_13234# tb3 0.00108f
C1273 a_5268_14218# a_6984_18520# 0
C1274 vbp_st m1_7702_15540# 0.0017f
C1275 m1_2668_7940# vsrcp 0.01319f
C1276 vbn_ax m1_6440_6140# 0
C1277 a_2492_11000# vbn_leak 0
C1278 a_488_17120# ta1 0.00462f
C1279 sta ta0 0
C1280 pl_en a_6140_14314# 0.30751f
C1281 a_4660_4480# en 0.00887f
C1282 pl_en a_4368_19360# 0
C1283 a_2592_8154# a_824_18520# 0.0045f
C1284 a_5524_16920# vsrcp 0.46219f
C1285 m1_1996_6970# a_3272_6334# 0
C1286 m1_6190_19900# ta3 0.00179f
C1287 m1_1996_6970# a_2592_8154# 0.08035f
C1288 stb hold 0.25875f
C1289 a_3048_3120# vs 0.02179f
C1290 vsrc tb0 0
C1291 a_2592_8154# a_2492_18520# 0.00364f
C1292 d1 m1_9090_11710# 0
C1293 vbn_ax a_5772_4480# 0
C1294 a_4588_8588# a_5516_10600# 0.17981f
C1295 a_6140_9234# a_3048_11000# 0.26963f
C1296 vbn_leak a_6984_18520# 0.00174f
C1297 tb2 vdd 0.55136f
C1298 a_3956_5520# a_5316_3120# 0
C1299 a_2492_18520# a_824_18520# 0.01207f
C1300 vdd m1_6346_17880# 0.10081f
C1301 m1_6968_10660# hold 0.05534f
C1302 m1_7930_11710# a_4588_13668# 0
C1303 sta a_3136_4480# 0.21431f
C1304 a_3048_16080# m1_6190_19900# 0
C1305 a_3048_3120# m1_3690_6830# 0.00554f
C1306 m1_7692_7940# ta3 0.02123f
C1307 a_488_12040# m1_6968_10660# 0.25672f
C1308 a_672_20034# hold 0.00227f
C1309 a_3048_16080# m1_2868_14560# 0
C1310 el m1_2678_13100# 0.10764f
C1311 a_3048_11000# a_8248_5320# 0.06911f
C1312 vbn_leak vs 0.20396f
C1313 a_3272_6334# a_6984_3120# 0.17487f
C1314 pl_en m1_7148_12980# 0.01099f
C1315 a_6672_14314# m1_5190_15350# 0.00317f
C1316 vdd el 1.40418f
C1317 vbp_st hold 0.24355f
C1318 a_7540_18520# vbp_syn 0.00389f
C1319 a_488_12040# vbp_st 0.08958f
C1320 tb1 a_5524_16920# 0.00248f
C1321 vbn_leak a_488_19360# 0.00357f
C1322 a_3272_6334# m1_2788_6140# 0.11522f
C1323 ta0 m1_6716_11710# 0.0017f
C1324 a_2592_8154# m1_2788_6140# 0.00118f
C1325 ta1 a_2180_13234# 0.00137f
C1326 m1_3690_6830# vbn_leak 0.29249f
C1327 a_4588_8588# vsrcp 0.20016f
C1328 m1_1046_10270# hold 0.18265f
C1329 a_5268_9138# hold 0.19982f
C1330 a_728_3738# m1_2236_8010# 0
C1331 d1 a_1892_3934# 0.06287f
C1332 a_488_5520# a_1480_3834# 0.10832f
C1333 a_5524_5520# m1_5286_6980# 0.00281f
C1334 a_2592_8154# d2 0.08828f
C1335 a_2800_12040# a_3136_4480# 0.0356f
C1336 a_488_12040# m1_1046_10270# 0.05521f
C1337 a_488_12040# a_5268_9138# 0.14826f
C1338 vbn_ax ta0 0.00798f
C1339 a_5524_5520# en 0.0784f
C1340 a_6672_14314# a_6140_14314# 0.82774f
C1341 m1_1996_6970# m1_2788_6140# 0.09121f
C1342 m1_5946_6980# a_3048_11000# 0.00101f
C1343 m1_2668_7940# m1_1046_10270# 0
C1344 m1_2668_7940# a_5268_9138# 0
C1345 a_2592_8154# m1_7150_9212# 0.00319f
C1346 a_3272_6334# sel0 0.46499f
C1347 a_4660_4480# a_5772_4480# 0.02712f
C1348 a_5524_16920# vbp_st 0.12932f
C1349 sel0 abus 4.01583f
C1350 pl_en a_5516_15680# 0.00549f
C1351 vbn_prb m1_9090_11710# 0
C1352 d1 m1_5432_10180# 0.01738f
C1353 a_2492_18520# d2 0.02299f
C1354 sel1 vdd 0.05265f
C1355 a_2592_8154# a_5524_11840# 0.09226f
C1356 a_5524_16920# a_5268_9138# 0
C1357 a_3048_16080# a_2800_17120# 0.39827f
C1358 m1_7080_19410# m1_6190_19900# 0.10019f
C1359 abus a_5524_11840# 0.01658f
C1360 d1_bsel ta3 0
C1361 vbn_ax a_3136_4480# 0.01372f
C1362 vbn_ax m1_2712_18170# 0.37449f
C1363 a_3272_6334# a_268_18520# 0.19475f
C1364 a_3956_5520# hold 0.00415f
C1365 a_6884_4480# en 0
C1366 m1_3690_6830# vs 0.00432f
C1367 m1_1996_6970# a_5524_11840# 0
C1368 a_2592_8154# a_268_18520# 0.17138f
C1369 m1_2788_6140# a_6984_3120# 0
C1370 abus a_268_18520# 0.08026f
C1371 a_4588_8588# m1_6968_10660# 0.00987f
C1372 a_268_18520# a_824_18520# 0.21527f
C1373 pl_en m1_5286_6980# 0.00449f
C1374 a_3048_11000# hold 0.53074f
C1375 vbn_prb a_6672_14314# 0.0506f
C1376 vbp_st m1_7206_2780# 0.25702f
C1377 a_5524_5520# m1_6440_6140# 0.20291f
C1378 vdd chain 1.17436f
C1379 a_3048_16080# d1_bsel 0
C1380 a_6672_14314# m1_7148_12980# 0
C1381 a_488_12040# a_3048_11000# 1.20282f
C1382 a_672_20034# a_5316_18520# 0.00113f
C1383 a_3048_3120# a_2492_3120# 0.07922f
C1384 vdd sel2 0.19424f
C1385 pl_en en 2.42171f
C1386 a_2492_18520# a_268_18520# 0.14939f
C1387 sel0 a_6984_3120# 0
C1388 m1_2668_7940# a_3048_11000# 0.00551f
C1389 vbp_st a_4588_8588# 0
C1390 ta1 a_4588_13668# 0.02439f
C1391 a_7540_18520# ta2 0.03408f
C1392 m1_5522_19900# vbn_leak 0.48338f
C1393 sel0 m1_2788_6140# 0.00347f
C1394 a_6140_9234# a_2592_8154# 0.15957f
C1395 vbn_leak m1_2112_14220# 0.00104f
C1396 m1_7692_7940# vsrcp 0.0202f
C1397 a_5268_9138# a_4588_8588# 0.17039f
C1398 a_6140_9234# abus 0
C1399 ta2 tb3 0.10573f
C1400 vbn_ref vbn_leak 0.37111f
C1401 a_5524_16920# a_3048_11000# 0.00547f
C1402 a_5524_5520# a_5772_4480# 0.02096f
C1403 a_2492_3120# vbn_leak 0
C1404 a_4660_4480# a_3136_4480# 0.00124f
C1405 m1_6440_6140# a_6884_4480# 0.08928f
C1406 a_6140_9234# m1_1996_6970# 0
C1407 d2 m1_6716_16790# 0.05527f
C1408 a_3272_6334# a_5316_3120# 0.10579f
C1409 a_268_18520# a_6984_3120# 0.01068f
C1410 a_2592_8154# m1_7930_16790# 0.00735f
C1411 m1_6190_19900# stb 0.07889f
C1412 ta0 tb0 0
C1413 a_3272_6334# a_8248_5320# 0.0794f
C1414 a_728_3738# m1_2122_6150# 0.02712f
C1415 abus a_8248_5320# 0.00916f
C1416 m1_7150_9212# a_5524_11840# 0.23741f
C1417 tb1 m1_6190_19900# 0
C1418 m1_2788_6140# a_268_18520# 0.00942f
C1419 a_268_18520# d2 0.47915f
C1420 vbn_leak m1_3870_19890# 0.56669f
C1421 a_3048_16080# sta 0.04223f
C1422 a_3956_5520# m1_7206_2780# 0
C1423 d1 m1_2112_9090# 0.00845f
C1424 a_2592_8154# m1_7702_15540# 0.07429f
C1425 a_5268_14218# m1_6346_17880# 0
C1426 a_728_3738# sta 0
C1427 abus m1_7702_15540# 0.08884f
C1428 a_672_20034# m1_6190_19900# 0.01992f
C1429 m1_4568_19890# a_2180_13234# 0.00564f
C1430 m1_7080_19410# d1_bsel 0
C1431 m1_1860_15340# d2 0.01232f
C1432 sel0 a_268_18520# 0.17661f
C1433 a_6884_4480# a_5772_4480# 0.02458f
C1434 a_488_17120# a_6140_14314# 0.09182f
C1435 vsrc a_6672_14314# 0
C1436 a_2592_8154# m1_5946_6980# 0
C1437 vbn_ref vs 0.09067f
C1438 a_488_17120# a_4368_19360# 0.01109f
C1439 m1_3870_19890# a_6984_18520# 0.00268f
C1440 vsrc a_1892_3934# 0
C1441 a_5524_5520# ta0 0.00649f
C1442 a_2492_3120# vs 0.03256f
C1443 m1_7692_7940# m1_6968_10660# 0.04726f
C1444 a_4588_8588# a_3048_11000# 0
C1445 a_268_18520# a_5524_11840# 0
C1446 a_5268_14218# el 0.01208f
C1447 a_268_18520# m1_6716_16790# 0
C1448 a_6672_14314# en 0.00765f
C1449 vbn_ax mreset 0.53595f
C1450 a_1892_3934# m1_5286_6980# 0
C1451 m1_1996_6970# m1_5946_6980# 0.02268f
C1452 a_5316_3120# a_6984_3120# 0.01031f
C1453 a_3048_3120# el 0.29986f
C1454 a_1892_3934# en 0.00533f
C1455 a_8248_5320# a_6984_3120# 0.00253f
C1456 tb2 vbn_leak 0.25163f
C1457 vdd m1_8350_10270# 0.14781f
C1458 el a_6672_9234# 0.02966f
C1459 vbn_leak m1_6346_17880# 0
C1460 m1_2788_6140# a_8248_5320# 0.35292f
C1461 vdd a_6594_420# 0.54787f
C1462 sta a_5516_10600# 0.18061f
C1463 m1_7930_16790# d2 0.01187f
C1464 vbn_ax ta3 0.05493f
C1465 vbn_ax a_7540_3120# 0.00948f
C1466 a_4096_6334# m1_4330_6980# 0
C1467 a_5524_5520# a_3136_4480# 0.00993f
C1468 ta0 a_6884_4480# 0.00869f
C1469 ta1 ta2 3.2547f
C1470 pl_en m1_6494_7950# 0
C1471 m1_2236_8010# m1_1046_10270# 0.0019f
C1472 a_2492_11000# el 0.13664f
C1473 a_6140_14314# m1_8466_15350# 0.07902f
C1474 m1_5286_6980# m1_5432_10180# 0.03202f
C1475 vdd vreset 0.17429f
C1476 a_488_17120# vbn_prb 0
C1477 m1_7080_19410# sta 0
C1478 a_6140_9234# a_5524_11840# 0.50552f
C1479 sel0 a_5316_3120# 0
C1480 m1_5432_10180# en 0.25589f
C1481 vbn_leak el 5.18971f
C1482 d2 m1_7702_15540# 0.24541f
C1483 a_2592_8154# hold 0.44704f
C1484 sel0 a_8248_5320# 0.22991f
C1485 a_488_12040# a_2592_8154# 0.22346f
C1486 a_824_18520# hold 0
C1487 m1_6346_17880# a_6984_18520# 0.39498f
C1488 ta3 m1_8326_19030# 0
C1489 a_3048_16080# vbn_ax 0.27057f
C1490 sel1 a_5268_14218# 0.0591f
C1491 d1_bsel stb 0.77502f
C1492 m1_1310_2210# a_488_5520# 0.00274f
C1493 a_2592_8154# m1_2668_7940# 0.31892f
C1494 a_6140_9234# a_268_18520# 0
C1495 pl_en ta0 0.01028f
C1496 tb1 d1_bsel 0
C1497 m1_1996_6970# hold 0.04941f
C1498 a_4368_19360# a_2180_13234# 0.3649f
C1499 m1_4568_19890# vbp_syn 0.02135f
C1500 vsrc a_824_3120# 0.14495f
C1501 mreset a_4660_4480# 0.02474f
C1502 a_728_3738# a_488_5520# 0.3301f
C1503 a_488_12040# m1_1996_6970# 0.09283f
C1504 sta vsrcp 0.04768f
C1505 a_2492_18520# hold 0.04062f
C1506 a_6884_4480# a_3136_4480# 0.22802f
C1507 a_2800_12040# a_5516_10600# 0.08397f
C1508 m1_7930_16790# a_268_18520# 0
C1509 a_3048_16080# m1_8326_19030# 0.45961f
C1510 a_268_18520# a_5316_3120# 0.14988f
C1511 m1_1996_6970# m1_2668_7940# 0.01768f
C1512 d1_bsel a_672_20034# 1.17863f
C1513 a_268_18520# a_8248_5320# 0.06792f
C1514 m1_2868_14560# a_3048_11000# 0
C1515 a_2492_18520# a_2492_16080# 0.00112f
C1516 a_2592_8154# a_5524_16920# 0.01914f
C1517 a_5524_16920# abus 0.04773f
C1518 ta1 m1_6968_15350# 0.01914f
C1519 vbn_prb m1_8466_15350# 0.1944f
C1520 a_7540_3120# a_4660_4480# 0.40622f
C1521 a_4660_4480# ta3 0.00109f
C1522 a_5268_14218# chain 0.00824f
C1523 a_488_17120# a_5516_15680# 0.00795f
C1524 sel1 vbn_leak 0.14365f
C1525 el vs 0.24898f
C1526 m1_2236_8010# a_3048_11000# 0
C1527 pl_en a_3136_4480# 0.15266f
C1528 a_268_18520# m1_7702_15540# 0
C1529 a_6984_3120# hold -0
C1530 a_3048_3120# chain 0.17683f
C1531 m1_5946_6980# a_5524_11840# 0
C1532 m1_7692_7940# a_3048_11000# 0.0404f
C1533 m1_7702_10660# vdd 0.08241f
C1534 chain a_6672_9234# 0.00803f
C1535 m1_2788_6140# hold 0.28252f
C1536 sel2 a_6672_9234# 0.00551f
C1537 sta stb 0.35638f
C1538 a_2800_12040# vsrcp 0
C1539 a_4588_13668# m1_5190_15350# 0.36869f
C1540 a_488_17120# vsrc 0
C1541 d2 hold 0.69367f
C1542 m1_7080_19410# vbn_ax 0.54268f
C1543 a_488_12040# d2 0.1731f
C1544 d1 a_4588_13668# 0
C1545 vbp_syn m1_5190_15350# 0.03527f
C1546 sel1 a_6984_18520# 0.02557f
C1547 vdd m1_7790_19900# -0
C1548 a_3272_6334# m1_7206_2780# 0.32053f
C1549 m1_5522_19900# m1_3870_19890# 1.08092f
C1550 m1_2668_7940# m1_2788_6140# 0
C1551 m1_2122_6150# vbp_st 0.01097f
C1552 m1_7150_9212# hold 0
C1553 d1 vbp_syn 0.32482f
C1554 sta m1_6968_10660# 0.02508f
C1555 m1_7702_12990# ta3 0
C1556 a_4368_19360# a_3048_18520# 0.0062f
C1557 vbn_leak chain 0.60045f
C1558 vbn_leak sel2 0.02692f
C1559 ta3 tb0 0.24246f
C1560 pl_en m1_7158_7910# 0.07542f
C1561 a_488_12040# m1_7150_9212# 0
C1562 a_488_17120# en 0.07148f
C1563 sta a_672_20034# 0.0097f
C1564 a_2592_8154# a_4588_8588# 0.47822f
C1565 m1_7080_19410# m1_8326_19030# 0.00985f
C1566 a_6140_14314# a_4588_13668# 0.08898f
C1567 a_6672_14314# ta0 0.09533f
C1568 a_2592_8154# a_5316_18520# 0.13096f
C1569 m1_910_6150# m1_1096_6970# 0.00187f
C1570 a_1892_3934# a_1480_3834# 0.35987f
C1571 a_5524_11840# hold 0.15108f
C1572 a_6140_14314# vbp_syn 0
C1573 sta vbp_st 0.09296f
C1574 m1_6716_16790# hold 0.00913f
C1575 vbn_ax vsrcp 0.06986f
C1576 m1_7930_16790# m1_7702_15540# 0
C1577 a_5524_16920# d2 0.25375f
C1578 a_4368_19360# vbp_syn 0.13414f
C1579 mreset a_5524_5520# 0.11493f
C1580 m1_1996_6970# a_4588_8588# 0.04994f
C1581 a_488_12040# a_5524_11840# 0.03869f
C1582 chain a_6984_18520# 0
C1583 a_3048_16080# tb0 0.08664f
C1584 m1_5432_10180# m1_6494_7950# 0.0539f
C1585 sta m1_1046_10270# 0.15746f
C1586 sta a_5268_9138# 0.21636f
C1587 a_5516_15680# a_2180_13234# 0
C1588 a_268_18520# hold 0.32712f
C1589 m1_8326_19030# vsrcp 0
C1590 a_5524_5520# ta3 0.20731f
C1591 a_7540_3120# a_5524_5520# 0.14492f
C1592 tb2 m1_5522_19900# 0.41983f
C1593 chain vs 0.1889f
C1594 m1_1860_15340# hold 0.38488f
C1595 m1_5522_19900# m1_6346_17880# 0
C1596 a_5524_16920# a_5524_11840# 0
C1597 ta0 m1_5432_10180# 0.00746f
C1598 m1_7206_2780# a_6984_3120# 0.571f
C1599 m1_8466_15350# en 0.09735f
C1600 a_6672_14314# a_3136_4480# 0.10702f
C1601 m1_1860_15340# a_2492_16080# 0.35455f
C1602 m1_2788_6140# m1_7206_2780# 0
C1603 a_1892_3934# a_3136_4480# 0
C1604 mreset a_6884_4480# 0.01397f
C1605 m1_2470_19900# a_2180_13234# 0
C1606 m1_3690_6830# chain 0.12099f
C1607 a_5524_16920# a_268_18520# 0.06656f
C1608 a_4588_13668# m1_7148_12980# 0.20195f
C1609 tb1 vbn_ax 0.08839f
C1610 m1_2788_6140# a_4588_8588# 0.00418f
C1611 a_6140_9234# hold 0.17944f
C1612 el m1_2112_14220# 0.1328f
C1613 a_2592_8154# m1_6190_19900# 0
C1614 en a_2180_13234# 0.05725f
C1615 tb2 m1_3870_19890# 0.10453f
C1616 vbn_ref el 0.46119f
C1617 a_7540_3120# a_6884_4480# 0.05176f
C1618 a_3048_3120# a_6594_420# 0.03943f
C1619 a_6884_4480# ta3 0
C1620 m1_1046_10270# a_2800_12040# 0.07555f
C1621 a_6140_9234# a_488_12040# 0.43946f
C1622 sel0 m1_7206_2780# 0.07612f
C1623 m1_3870_19890# m1_6346_17880# 0.02947f
C1624 d2 a_5316_18520# 0.19822f
C1625 a_2492_3120# el 0.0318f
C1626 a_824_3120# a_1480_3834# 0.0157f
C1627 vbp_st m1_6716_11710# 0.00371f
C1628 m1_8350_10270# a_6672_9234# 0.02006f
C1629 vbn_ax a_672_20034# 0
C1630 a_4588_8588# m1_7150_9212# 0
C1631 m1_5432_10180# a_3136_4480# 0.07019f
C1632 ta2 m1_5190_15350# 0.01392f
C1633 m1_7080_19410# tb0 0.10097f
C1634 tb1 m1_8326_19030# 0.21843f
C1635 a_5316_3120# hold 0
C1636 a_8248_5320# hold 0.00823f
C1637 d1 ta2 0.08533f
C1638 sta a_3048_11000# 0.09587f
C1639 vbn_ax vbp_st 5.20145f
C1640 pl_en ta3 0.11668f
C1641 a_488_12040# a_8248_5320# 0
C1642 m1_2236_8010# a_2592_8154# 0.08541f
C1643 a_5268_9138# m1_6716_11710# 0.00589f
C1644 vbp_st a_488_5520# 0.2541f
C1645 vbn_leak a_6594_420# 0.74864f
C1646 m1_8350_10270# vbn_leak 0
C1647 a_4588_8588# a_5524_11840# 0.28798f
C1648 a_6140_9234# a_5524_16920# 0
C1649 a_5516_15680# a_4588_13668# 0.11449f
C1650 a_268_18520# m1_7206_2780# 0.04689f
C1651 m1_5522_19900# sel1 0.00377f
C1652 m1_1996_6970# m1_2236_8010# 0.00229f
C1653 m1_7692_7940# m1_1996_6970# 0.03835f
C1654 a_5516_15680# vbp_syn 0.0128f
C1655 ta2 a_6140_14314# 0.02783f
C1656 vbp_st m1_8326_19030# 0
C1657 vbn_leak vreset 0.19656f
C1658 m1_7702_12990# vsrcp 0.08882f
C1659 pl_en a_3048_16080# 0.026f
C1660 tb0 vsrcp 0
C1661 a_3048_18520# m1_2470_19900# 0.00262f
C1662 m1_5946_6980# hold 0.063f
C1663 m1_5432_10180# m1_7158_7910# 0.07086f
C1664 a_268_18520# a_5316_18520# 0.1179f
C1665 tb2 m1_6346_17880# 0
C1666 a_3048_11000# a_2800_12040# 0.32985f
C1667 a_488_17120# ta0 0.00469f
C1668 m1_6968_15350# m1_5190_15350# 0
C1669 a_5524_16920# m1_7702_15540# 0.00259f
C1670 vdd m1_4882_3750# 0.01619f
C1671 ta1 m1_7150_14166# 0.03868f
C1672 sel1 m1_3870_19890# 0.04224f
C1673 m1_5522_19900# chain 0.00255f
C1674 d2 m1_2868_14560# 0.09823f
C1675 a_4660_4480# vbp_st 0
C1676 a_6594_420# vs 0.50072f
C1677 a_4588_13668# en 0.63173f
C1678 vbn_prb ta2 0
C1679 vbp_syn en 0.0365f
C1680 a_6140_9234# a_4588_8588# 0.28699f
C1681 stb tb0 0
C1682 m1_7702_10660# a_6672_9234# 0.09629f
C1683 m1_6968_15350# a_6140_14314# 0.03308f
C1684 a_2492_18520# a_2800_17120# 0.00237f
C1685 vbn_ref sel2 0.02687f
C1686 vreset vs 0.45265f
C1687 a_2492_3120# chain 0.01266f
C1688 a_5316_3120# m1_7206_2780# 0.24207f
C1689 a_3956_5520# a_488_5520# 0.00323f
C1690 a_2592_8154# d1_bsel 0.37309f
C1691 a_8248_5320# m1_7206_2780# 0.06324f
C1692 vbn_ax a_3048_11000# 0
C1693 ta2 m1_7148_12980# 0.02345f
C1694 tb1 tb0 0.68964f
C1695 m1_3690_6830# a_6594_420# 0
C1696 pl_en a_5516_10600# 0.00391f
C1697 a_488_17120# a_3136_4480# 0.00164f
C1698 d1_bsel a_824_18520# 0
C1699 mreset a_1892_3934# 0
C1700 a_488_17120# m1_2712_18170# 0.07408f
C1701 a_6672_14314# ta3 0.00742f
C1702 m1_7692_7940# m1_7150_9212# 0
C1703 m1_3870_19890# chain 0.04359f
C1704 a_488_12040# hold 0.02294f
C1705 pl_en m1_7080_19410# 0
C1706 a_672_20034# tb0 0
C1707 m1_7702_10660# vbn_leak 0.03656f
C1708 a_2492_16080# hold 0.12441f
C1709 m1_2668_7940# hold 0.01313f
C1710 m1_7702_12990# vbp_st 0
C1711 vbp_st tb0 0
C1712 m1_7790_19900# vbn_leak 0.38451f
C1713 m1_7692_7940# a_5524_11840# 0
C1714 sel1 m1_6346_17880# 0.02848f
C1715 m1_2122_6150# a_3272_6334# 0.00578f
C1716 a_3048_16080# a_6672_14314# 0.01132f
C1717 m1_910_6150# m1_642_6980# 0.00143f
C1718 a_5516_15680# ta2 0
C1719 d2 a_2800_17120# 0.00378f
C1720 a_5524_16920# hold 0.22066f
C1721 m1_7702_12990# a_5268_9138# 0
C1722 m1_1310_2210# a_1892_3934# 0.00162f
C1723 m1_1860_15340# m1_2868_14560# 0.00315f
C1724 ta0 a_2180_13234# 0.00296f
C1725 a_3956_5520# a_4660_4480# 0.0542f
C1726 d1 m1_1096_6970# 0.01074f
C1727 m1_5946_6980# a_4588_8588# 0.00801f
C1728 m1_7930_11710# vdd 0.07886f
C1729 a_488_12040# a_5524_16920# 0
C1730 pl_en vsrcp 0.52069f
C1731 m1_1996_6970# m1_2122_6150# 0
C1732 ta3 m1_5432_10180# 0.00777f
C1733 m1_6968_15350# m1_7148_12980# 0.03266f
C1734 m1_8466_15350# a_3136_4480# 0.00277f
C1735 sel1 el 0.00814f
C1736 a_2592_8154# sta 0.33527f
C1737 a_728_3738# a_1892_3934# 0.02976f
C1738 a_4660_4480# a_3048_11000# 0
C1739 m1_5286_6980# m1_4330_6980# 0.14603f
C1740 d1_bsel d2 0
C1741 m1_2712_6970# spk 0
C1742 chain m1_6346_17880# 0.03464f
C1743 a_7540_18520# vdd 0.32166f
C1744 m1_1996_6970# sta 0
C1745 m1_4330_6980# en 0.00567f
C1746 vdd tb3 0.3076f
C1747 ta2 m1_5286_6980# 0.1124f
C1748 a_824_16080# a_3048_16080# 0
C1749 m1_2712_18170# a_2180_13234# 0.25966f
C1750 a_268_18520# a_2800_17120# 0.00202f
C1751 chain el 0.25358f
C1752 ta2 en 0.02936f
C1753 pl_en stb 0.05619f
C1754 a_5516_15680# m1_6968_15350# 0
C1755 el sel2 0.02824f
C1756 vbn_ref a_6594_420# 0.27366f
C1757 a_4588_8588# hold 0.2002f
C1758 m1_7080_19410# a_6672_14314# 0.00252f
C1759 m1_2122_6150# m1_2788_6140# 0.0011f
C1760 a_488_12040# a_4588_8588# 0.00824f
C1761 m1_1860_15340# a_2800_17120# 0.1152f
C1762 a_5316_18520# hold 0.22583f
C1763 vbp_st a_6884_4480# 0
C1764 pl_en m1_6968_10660# 0.074f
C1765 m1_7702_12990# a_3048_11000# 0.0062f
C1766 vbn_ref vreset 4.35253f
C1767 m1_2668_7940# a_4588_8588# 0.00447f
C1768 m1_1310_2210# a_824_3120# 0.23943f
C1769 pl_en a_672_20034# 0.0791f
C1770 d1_bsel a_268_18520# 0.02527f
C1771 a_4588_13668# ta0 0.03998f
C1772 m1_4330_6980# m1_6440_6140# 0
C1773 pl_en vbp_st 0.00263f
C1774 sta d2 0.0435f
C1775 a_728_3738# a_824_3120# 0.01381f
C1776 m1_4568_19890# m1_2956_19890# -0.00608f
C1777 vbn_ax a_3272_6334# 0.1162f
C1778 a_3956_5520# a_5524_5520# 0.10032f
C1779 m1_5432_10180# a_5516_10600# 0.14584f
C1780 a_6672_14314# vsrcp 0.45306f
C1781 sel1 chain 1.14655f
C1782 a_5524_16920# a_5316_18520# 0.00102f
C1783 vbn_ax a_2592_8154# 0.24078f
C1784 vbn_ax abus 0.11887f
C1785 a_488_17120# ta3 0.00784f
C1786 a_3272_6334# a_488_5520# 0.21243f
C1787 ta2 m1_6440_6140# 0.09437f
C1788 pl_en a_5268_9138# 0.05894f
C1789 m1_6968_15350# en 0.03594f
C1790 a_5524_5520# a_3048_11000# 0.52107f
C1791 a_3048_18520# m1_2712_18170# 0.0806f
C1792 vdd spk 4.81628f
C1793 m1_6464_13090# vbn_leak 0.00507f
C1794 m1_910_6150# vdd 0.06214f
C1795 a_2592_8154# m1_8326_19030# 0.12263f
C1796 m1_7150_14166# m1_5190_15350# 0
C1797 m1_1996_6970# a_488_5520# 0.00187f
C1798 sta a_5524_11840# 0.13371f
C1799 a_4588_13668# a_3136_4480# 0.01275f
C1800 sta m1_6716_16790# 0.00535f
C1801 vbn_ax a_2492_18520# 0
C1802 vbp_syn a_3136_4480# 0.04993f
C1803 ta1 vdd 0.52938f
C1804 a_488_17120# a_3048_16080# 0.97924f
C1805 vbp_syn m1_2712_18170# 0.01683f
C1806 m1_6190_19900# hold 0.0039f
C1807 m1_5432_10180# vsrcp 0.06869f
C1808 d2 a_2800_12040# 0
C1809 m1_2868_14560# hold 0
C1810 sta a_268_18520# 0.1281f
C1811 vdd a_4096_6334# 0.50147f
C1812 vbp_st m1_9090_11710# 0.00112f
C1813 a_488_12040# m1_2868_14560# 0.00569f
C1814 a_6884_4480# a_3048_11000# 0.06485f
C1815 a_2492_16080# m1_2868_14560# 0
C1816 tb1 a_6672_14314# 0.00354f
C1817 m1_5522_19900# m1_7790_19900# 0.01008f
C1818 m1_7150_14166# a_6140_14314# 0.00221f
C1819 a_4660_4480# a_3272_6334# 0
C1820 vbn_ax a_6984_3120# 0
C1821 m1_2236_8010# hold 0.00599f
C1822 a_6594_420# el 0.17549f
C1823 m1_7692_7940# a_488_12040# 0.05702f
C1824 vbn_ax m1_2788_6140# 0.00579f
C1825 a_2800_12040# a_5524_11840# 0.01005f
C1826 m1_2236_8010# m1_2668_7940# 0.01739f
C1827 pl_en a_3048_11000# 0.04638f
C1828 vbn_ax d2 0.11007f
C1829 el vreset 0.06387f
C1830 m1_1996_6970# a_4660_4480# 0
C1831 a_3048_16080# m1_8466_15350# 0.0495f
C1832 a_6672_14314# vbp_st 0.0605f
C1833 a_6140_9234# sta 0.08521f
C1834 ta3 a_2180_13234# 0
C1835 m1_2956_19890# a_4368_19360# 0.03947f
C1836 m1_7790_19900# m1_3870_19890# 0.00417f
C1837 vbn_ax sel0 0.25214f
C1838 a_1892_3934# vbp_st 0.16713f
C1839 ta2 ta0 0.02346f
C1840 a_488_17120# m1_7080_19410# 0.13713f
C1841 m1_6968_10660# m1_5432_10180# 0
C1842 a_2800_17120# hold 0.34346f
C1843 m1_4882_3750# vs 0.0069f
C1844 a_3048_16080# a_2180_13234# 0.06777f
C1845 m1_642_6980# d1 0
C1846 m1_7702_12990# a_2592_8154# 0.00525f
C1847 a_2592_8154# tb0 0.09045f
C1848 m1_7150_14166# m1_7148_12980# 0.0013f
C1849 a_2492_16080# a_2800_17120# 0.00537f
C1850 vbn_ax a_268_18520# 0.79735f
C1851 a_3048_11000# m1_9090_11710# 0.00497f
C1852 a_6140_9234# a_2800_12040# 0
C1853 a_4660_4480# m1_2788_6140# 0
C1854 ta2 a_3136_4480# 0.05219f
C1855 d1_bsel hold 0.03732f
C1856 a_268_18520# a_488_5520# 0
C1857 a_5268_9138# m1_5432_10180# 0.25439f
C1858 a_488_17120# vsrcp 0
C1859 tb2 m1_7790_19900# 0.11536f
C1860 a_5524_16920# a_2800_17120# 0.0011f
C1861 a_5524_5520# a_3272_6334# 0
C1862 a_268_18520# m1_8326_19030# 0.0999f
C1863 m1_7702_10660# el 0
C1864 m1_6968_15350# ta0 0.00732f
C1865 a_7540_18520# vbn_leak 0.00537f
C1866 a_6594_420# chain 0.05999f
C1867 m1_7692_7940# a_4588_8588# 0.15597f
C1868 a_6140_9234# m1_6716_11710# 0.00981f
C1869 m1_8350_10270# sel2 0.00835f
C1870 vbn_leak tb3 0.26176f
C1871 a_6672_14314# a_3048_11000# 0
C1872 a_3956_5520# a_1892_3934# 0.02278f
C1873 a_4588_13668# ta3 0.10345f
C1874 m1_4568_19890# vdd 0.02218f
C1875 a_3048_16080# a_3048_18520# 0
C1876 sel2 vreset 0.02688f
C1877 ta2 m1_7158_7910# 0.02935f
C1878 a_7540_18520# a_6984_18520# 0.29754f
C1879 vbn_ax m1_7930_16790# 0
C1880 a_3272_6334# a_6884_4480# 0.00251f
C1881 a_4660_4480# a_268_18520# 0.00718f
C1882 vbn_ax a_8248_5320# 0.24826f
C1883 m1_6968_15350# a_3136_4480# 0.57704f
C1884 a_6984_18520# tb3 0
C1885 a_488_17120# tb1 0.04714f
C1886 sta hold 1.58189f
C1887 a_3048_16080# vbp_syn 0.12146f
C1888 a_488_12040# sta 0.01622f
C1889 a_3048_11000# m1_5432_10180# 0
C1890 a_3048_3120# spk 0.20462f
C1891 m1_2668_7940# sta 0.00379f
C1892 m1_7150_14166# en 0
C1893 ta1 a_5268_14218# 0.25154f
C1894 pl_en a_2592_8154# 0.1146f
C1895 a_1480_3834# m1_1096_6970# 0
C1896 a_488_17120# vbp_st 0.34122f
C1897 m1_2956_19890# m1_2470_19900# 0
C1898 a_5524_5520# m1_2788_6140# 0.37214f
C1899 m1_5190_15350# m1_2678_13100# 0
C1900 vdd m1_5190_15350# 0.00945f
C1901 d1 vdd 2.95234f
C1902 sta a_5524_16920# 0.12347f
C1903 ta1 a_6672_9234# 0.00805f
C1904 d1_bsel a_5316_18520# 0.00207f
C1905 a_3048_3120# a_4096_6334# 0.0702f
C1906 a_268_18520# tb0 0.03116f
C1907 spk vbn_leak 0.77498f
C1908 m1_1046_10270# m1_2112_9090# 0.00319f
C1909 a_2800_12040# hold 0.09061f
C1910 m1_910_6150# vbn_leak 0.00535f
C1911 m1_7702_10660# sel2 0.11285f
C1912 a_4660_4480# a_5316_3120# 0.01285f
C1913 a_6884_4480# a_6984_3120# 0.00291f
C1914 a_488_12040# a_2800_12040# 0.01359f
C1915 a_4588_13668# a_5516_10600# 0
C1916 vdd a_6140_14314# 1.08264f
C1917 stb a_2180_13234# 0.11935f
C1918 ta1 vbn_leak 0.39358f
C1919 m1_4330_6980# ta3 0
C1920 vbp_syn a_5516_10600# 0.0205f
C1921 a_4368_19360# vdd 1.35862f
C1922 m1_2788_6140# a_6884_4480# 0.18225f
C1923 m1_6716_11710# hold 0.00763f
C1924 m1_8466_15350# vbp_st 0.00978f
C1925 a_4096_6334# vbn_leak 0.08965f
C1926 a_2592_8154# m1_9090_11710# 0
C1927 a_5524_5520# a_268_18520# 0.06036f
C1928 a_488_12040# m1_6716_11710# 0.00537f
C1929 ta2 ta3 3.00015f
C1930 a_6140_9234# m1_7702_12990# 0
C1931 vbn_ax hold 0.10806f
C1932 ta1 a_6984_18520# 0.00874f
C1933 a_672_20034# a_2180_13234# 0.13827f
C1934 a_6594_420# vreset 0.08488f
C1935 pl_en d2 0.18542f
C1936 sta a_4588_8588# 0.13733f
C1937 m1_6464_13090# el 0.28661f
C1938 spk vs 8.20526f
C1939 m1_910_6150# vs 0.00751f
C1940 a_4588_13668# vsrcp 0.20747f
C1941 pl_en m1_7150_9212# 0.19277f
C1942 vbp_syn vsrcp 0.03859f
C1943 a_3048_16080# ta2 0.07823f
C1944 a_2592_8154# a_6672_14314# 0.03038f
C1945 a_5524_16920# m1_6716_11710# 0
C1946 d1_bsel m1_6190_19900# 0.04901f
C1947 vbn_prb vdd 0.34789f
C1948 a_6672_14314# abus 0.05686f
C1949 m1_2712_6970# m1_5286_6980# 0
C1950 m1_2112_9090# a_3048_11000# 0.00118f
C1951 a_268_18520# a_6884_4480# 0.04f
C1952 a_3272_6334# a_1892_3934# 0.17002f
C1953 spk m1_3690_6830# 0.00375f
C1954 vdd m1_7148_12980# 0.0028f
C1955 vbn_ax a_5524_16920# 0.00475f
C1956 a_7540_18520# m1_5522_19900# 0
C1957 a_2592_8154# a_1892_3934# 0
C1958 pl_en a_5524_11840# 0.2306f
C1959 stb a_3048_18520# 0
C1960 a_4096_6334# vs 0.39463f
C1961 m1_5522_19900# tb3 0.75312f
C1962 ta1 m1_3690_6830# 0.05669f
C1963 m1_9090_16790# tb3 0
C1964 m1_6968_15350# ta3 0.06596f
C1965 a_5524_16920# m1_8326_19030# 0
C1966 m1_1996_6970# a_1892_3934# 0.06846f
C1967 a_5524_5520# a_5316_3120# 0
C1968 a_5524_5520# a_8248_5320# 0
C1969 a_4660_4480# hold 0
C1970 m1_3690_6830# a_4096_6334# 0.05482f
C1971 a_4588_8588# a_2800_12040# 0
C1972 pl_en a_268_18520# 0.02917f
C1973 stb vbp_syn 0.05216f
C1974 a_2592_8154# m1_5432_10180# 0.10907f
C1975 a_672_20034# a_3048_18520# 0.0043f
C1976 m1_7150_14166# ta0 0.01386f
C1977 a_7540_18520# m1_3870_19890# 0.00856f
C1978 m1_7702_10660# m1_8350_10270# 0.13934f
C1979 a_824_16080# a_824_18520# 0.0013f
C1980 a_5516_15680# vdd 0.22463f
C1981 m1_3870_19890# tb3 0.82465f
C1982 m1_1996_6970# m1_5432_10180# 0.00419f
C1983 ta2 a_5516_10600# 0
C1984 vbn_ax m1_7206_2780# 0.51099f
C1985 sta m1_6190_19900# 0.00913f
C1986 m1_7080_19410# ta2 0.0088f
C1987 a_672_20034# vbp_syn 0.0583f
C1988 a_5524_5520# m1_5946_6980# 0
C1989 m1_9090_11710# a_5524_11840# 0.00191f
C1990 a_6672_14314# d2 0.01853f
C1991 vbp_st a_4588_13668# 0.00132f
C1992 a_6884_4480# a_8248_5320# 0.01279f
C1993 m1_6464_13090# chain 0.01209f
C1994 pl_en a_6140_9234# 0.07996f
C1995 vbn_ax a_5316_18520# 0.03876f
C1996 vsrc vdd 0.26712f
C1997 a_3272_6334# a_824_3120# 0.14782f
C1998 a_1892_3934# m1_2788_6140# 0.25953f
C1999 m1_2236_8010# sta 0.15275f
C2000 m1_7150_14166# a_3136_4480# 0
C2001 a_5268_9138# a_4588_13668# 0.00108f
C2002 vdd m1_2470_19900# 0.00895f
C2003 vdd m1_5286_6980# 0.04423f
C2004 m1_4568_19890# vbn_leak 0.2118f
C2005 a_5268_9138# vbp_syn 0
C2006 m1_1046_10270# vbp_syn 0.06158f
C2007 ta2 vsrcp 0.03905f
C2008 a_7540_18520# tb2 0.00167f
C2009 a_5268_14218# m1_5190_15350# 0.41665f
C2010 vdd en 0.28679f
C2011 a_7540_18520# m1_6346_17880# 0.24948f
C2012 tb2 tb3 1.04374f
C2013 a_6672_14314# a_5524_11840# 0
C2014 spk vbn_ref 0.32145f
C2015 m1_7930_11710# el 0.00259f
C2016 m1_6346_17880# tb3 0.00951f
C2017 m1_5522_19900# ta1 0.03258f
C2018 spk a_2492_3120# 0.00216f
C2019 chain m1_4882_3750# 0.0945f
C2020 a_3048_3120# d1 0.17164f
C2021 m1_7702_12990# a_5524_16920# 0
C2022 a_824_16080# d2 0.01618f
C2023 a_5524_5520# hold 0.58318f
C2024 a_6672_14314# a_268_18520# 0.00457f
C2025 a_6140_9234# m1_9090_11710# 0.10894f
C2026 d1 a_6672_9234# 0.0813f
C2027 a_5268_14218# a_6140_14314# 0.1508f
C2028 pl_en m1_5946_6980# 0
C2029 a_488_17120# a_2592_8154# 0.33167f
C2030 a_4096_6334# vbn_ref 0.14229f
C2031 a_1892_3934# a_268_18520# 0.02698f
C2032 a_728_3738# m1_1096_6970# 0.03712f
C2033 a_2492_11000# d1 0.18013f
C2034 a_488_17120# a_824_18520# 0.04803f
C2035 a_2592_8154# m1_2112_9090# 0.04726f
C2036 m1_2712_6970# a_1480_3834# 0.00475f
C2037 m1_5432_10180# a_5524_11840# 0.28414f
C2038 vbn_leak m1_5190_15350# 0.15861f
C2039 ta1 m1_3870_19890# 0.02039f
C2040 d1 vbn_leak 0.81795f
C2041 tb1 ta2 0
C2042 a_4588_13668# a_3048_11000# 0.17736f
C2043 m1_6968_15350# vsrcp 0.04857f
C2044 m1_1996_6970# m1_2112_9090# 0
C2045 vdd m1_6440_6140# 0.58792f
C2046 ta2 m1_6968_10660# 0.11184f
C2047 vbp_syn a_3048_11000# 0.15437f
C2048 a_488_17120# a_2492_18520# 0.04019f
C2049 sta d1_bsel 0.24051f
C2050 a_6884_4480# hold 0.09558f
C2051 m1_6190_19900# m1_8326_19030# 0
C2052 ta2 a_672_20034# 0
C2053 a_6140_14314# vbn_leak 0.16759f
C2054 a_7540_18520# sel1 0.04366f
C2055 a_2592_8154# m1_8466_15350# 0
C2056 ta2 vbp_st 0.07482f
C2057 a_4368_19360# vbn_leak 0.26493f
C2058 pl_en hold 0.04679f
C2059 sel1 tb3 0
C2060 a_824_16080# m1_1860_15340# 0.25825f
C2061 abus m1_8466_15350# 0.02564f
C2062 pl_en a_488_12040# 0.07894f
C2063 a_3048_3120# vbn_prb 0
C2064 vdd a_5772_4480# 0.10134f
C2065 ta2 a_5268_9138# 0.08652f
C2066 vbn_prb a_6672_9234# 0.0453f
C2067 a_6672_14314# m1_7702_15540# 0.07603f
C2068 tb2 ta1 0
C2069 d1 vs 0.12088f
C2070 a_6140_9234# m1_5432_10180# 0.19245f
C2071 ta1 m1_6346_17880# 0.06916f
C2072 a_268_18520# a_824_3120# 0.00395f
C2073 a_488_17120# d2 0.32558f
C2074 a_2592_8154# a_2180_13234# 0.38278f
C2075 spk el 0.59596f
C2076 vbn_ax a_2800_17120# 0.06571f
C2077 a_7540_18520# chain 0.02313f
C2078 a_824_18520# a_2180_13234# 0.0383f
C2079 pl_en a_5524_16920# 0.08324f
C2080 d1 m1_3690_6830# 0.00581f
C2081 vbn_prb vbn_leak 0.4003f
C2082 m1_7150_14166# ta3 0.04732f
C2083 ta1 el 0.00791f
C2084 a_3956_5520# m1_4330_6980# 0
C2085 a_5516_15680# a_5268_14218# 0.0043f
C2086 a_2492_18520# a_2180_13234# 0.13889f
C2087 vdd a_1480_3834# 0.39672f
C2088 a_1892_3934# m1_5946_6980# 0
C2089 m1_6968_15350# vbp_st 0
C2090 a_4096_6334# el 0.08834f
C2091 a_488_17120# m1_6716_16790# 0.00791f
C2092 vbn_ax d1_bsel 0
C2093 a_6884_4480# m1_7206_2780# 0
C2094 a_4368_19360# a_488_19360# 0.00313f
C2095 vdd ta0 1.1984f
C2096 m1_4568_19890# m1_5522_19900# 0.09117f
C2097 m1_6968_15350# a_5268_9138# 0
C2098 m1_8466_15350# d2 -0
C2099 m1_6190_19900# tb0 0.00595f
C2100 a_488_17120# a_268_18520# 0.44988f
C2101 ta2 a_3048_11000# 0.08184f
C2102 m1_5946_6980# m1_5432_10180# 0
C2103 sta a_2800_12040# 0.01127f
C2104 a_3048_3120# vsrc 0.01326f
C2105 a_6672_14314# hold 0.07524f
C2106 a_488_17120# m1_1860_15340# 0.0075f
C2107 vbn_prb vs 0.23057f
C2108 ta1 sel1 0.02017f
C2109 a_5516_15680# vbn_leak 0.20637f
C2110 a_2592_8154# a_3048_18520# 0.01449f
C2111 vsrc a_6672_9234# 0
C2112 pl_en a_4588_8588# 0.02234f
C2113 a_5268_14218# en 0.04532f
C2114 d2 a_2180_13234# 0.37306f
C2115 vdd a_3136_4480# 1.31454f
C2116 pl_en a_5316_18520# 0.02377f
C2117 m1_4568_19890# m1_3870_19890# 0.00399f
C2118 m1_2122_6150# a_488_5520# 0.01157f
C2119 a_1892_3934# hold 0
C2120 vdd m1_2712_18170# 0.09862f
C2121 m1_5286_6980# a_6672_9234# 0.00655f
C2122 sta m1_6716_11710# 0.0056f
C2123 a_2592_8154# a_4588_13668# 0
C2124 a_3048_3120# en 0
C2125 a_2592_8154# vbp_syn 0.31516f
C2126 m1_2668_7940# a_1892_3934# 0
C2127 spk chain 0.07502f
C2128 a_2492_18520# a_3048_18520# 0.08841f
C2129 vbn_ax sta 0.03096f
C2130 spk sel2 0.06649f
C2131 vsrc vbn_leak 4.50187f
C2132 a_6672_9234# en 0.0027f
C2133 a_6672_14314# a_5524_16920# 0.54371f
C2134 vbn_leak m1_2470_19900# 0.03967f
C2135 vbp_st m1_1096_6970# 0.03008f
C2136 ta1 chain 0.0122f
C2137 m1_1996_6970# vbp_syn 0.00556f
C2138 m1_6968_15350# a_3048_11000# 0
C2139 vbn_leak m1_5286_6980# 0.17505f
C2140 m1_5432_10180# hold 0.01487f
C2141 d1 vbn_ref 0.03714f
C2142 a_488_12040# m1_5432_10180# 0
C2143 a_2492_18520# vbp_syn 0
C2144 vbn_leak en 0.54952f
C2145 d1 a_2492_3120# 0.00767f
C2146 a_4096_6334# chain 0.13724f
C2147 m1_2668_7940# m1_5432_10180# 0
C2148 a_824_16080# a_2492_16080# 0.02842f
C2149 m1_5522_19900# a_6140_14314# 0.00182f
C2150 a_268_18520# a_2180_13234# 0.33698f
C2151 a_488_17120# m1_7702_15540# 0.04144f
C2152 a_6140_14314# m1_9090_16790# 0.06226f
C2153 m1_1860_15340# a_2180_13234# 0.12471f
C2154 d2 a_3048_18520# 0.15125f
C2155 d1_bsel tb0 0
C2156 m1_7150_14166# vsrcp 0.05488f
C2157 pl_en m1_6190_19900# 0.00328f
C2158 vsrc vs 0.88383f
C2159 vdd a_824_11000# 0.17462f
C2160 d2 a_4588_13668# 0.02432f
C2161 m1_5286_6980# vs 0
C2162 d2 vbp_syn 0.52303f
C2163 a_4368_19360# m1_3870_19890# 0.00971f
C2164 en vs 0.15483f
C2165 pl_en m1_7692_7940# 0.03236f
C2166 vbn_leak m1_6440_6140# 0.20216f
C2167 a_2592_8154# m1_4330_6980# 0.00107f
C2168 a_1892_3934# a_4588_8588# 0.00147f
C2169 m1_8466_15350# m1_7702_15540# 0.08725f
C2170 m1_3690_6830# m1_5286_6980# 0.0479f
C2171 vbn_prb m1_9090_16790# 0
C2172 a_4588_13668# a_5524_11840# 0
C2173 vbn_prb vbn_ref 0.7771f
C2174 m1_3690_6830# en 0.02335f
C2175 a_268_18520# a_3048_18520# 0.04751f
C2176 m1_1996_6970# m1_4330_6980# 0.0494f
C2177 a_2592_8154# ta2 0.02964f
C2178 vbp_syn a_5524_11840# 0.03906f
C2179 vbn_ax m1_8326_19030# 0.08746f
C2180 sta tb0 0
C2181 mreset vdd 0.73825f
C2182 a_4588_8588# m1_5432_10180# 0.19868f
C2183 a_488_17120# hold 0.28706f
C2184 spk a_6594_420# 0.96158f
C2185 m1_1996_6970# ta2 0.14673f
C2186 m1_2112_9090# hold 0.02572f
C2187 m1_2956_19890# stb 0
C2188 m1_6494_7950# a_6672_9234# 0
C2189 el m1_5190_15350# 0.2144f
C2190 pl_en a_2800_17120# 0
C2191 a_488_17120# a_2492_16080# 0.01233f
C2192 tb2 a_6140_14314# 0.00181f
C2193 a_268_18520# vbp_syn 0.11576f
C2194 a_7540_18520# m1_7790_19900# 0
C2195 spk vreset 0.28714f
C2196 a_7540_3120# vdd 0.25106f
C2197 a_3048_3120# a_1480_3834# 0.01149f
C2198 d1 el 1.80873f
C2199 a_5268_14218# ta0 0.24373f
C2200 vdd ta3 0.97319f
C2201 a_4368_19360# m1_6346_17880# -0
C2202 m1_7790_19900# tb3 0.07367f
C2203 m1_2668_7940# m1_2112_9090# 0.03949f
C2204 m1_1860_15340# vbp_syn 0.09677f
C2205 a_4096_6334# a_6594_420# 0.32515f
C2206 m1_1310_2210# vdd 0.08211f
C2207 vbn_leak m1_6494_7950# -0.00668f
C2208 ta0 a_6672_9234# 0.01242f
C2209 a_3048_16080# m1_2678_13100# 0.0052f
C2210 a_488_17120# a_5524_16920# 0.18996f
C2211 a_6140_14314# el 0
C2212 a_3048_16080# vdd 1.78626f
C2213 m1_2956_19890# a_672_20034# 0.00369f
C2214 a_4096_6334# vreset 0.0448f
C2215 m1_2788_6140# m1_4330_6980# 0.00667f
C2216 m1_3690_6830# m1_6440_6140# 0.23342f
C2217 m1_6968_15350# a_2592_8154# 0.32654f
C2218 pl_en d1_bsel 0.03808f
C2219 a_728_3738# vdd 0.64516f
C2220 vbn_leak a_1480_3834# 0.00905f
C2221 a_6140_9234# a_4588_13668# 0.00124f
C2222 a_6140_9234# vbp_syn 0
C2223 a_5268_14218# a_3136_4480# 0.17669f
C2224 ta2 m1_2788_6140# 0.01101f
C2225 sel1 m1_5190_15350# 0
C2226 vbn_leak ta0 0.19134f
C2227 vsrc vbn_ref 0.45679f
C2228 ta2 d2 0.07766f
C2229 a_3048_3120# a_3136_4480# 0.49132f
C2230 vsrc a_2492_3120# 0.00502f
C2231 a_6672_9234# a_3136_4480# 0.03557f
C2232 m1_5522_19900# en 0.01501f
C2233 ta2 m1_7150_9212# 0.01222f
C2234 a_2180_13234# hold 0.23065f
C2235 a_488_12040# a_2180_13234# 0.00102f
C2236 a_2492_16080# a_2180_13234# 0.11461f
C2237 a_5524_16920# m1_8466_15350# 0
C2238 vbn_ax tb0 0.05303f
C2239 vbn_ref en 0.00484f
C2240 sel1 a_6140_14314# 0.30322f
C2241 ta0 a_6984_18520# 0.02252f
C2242 sel1 a_4368_19360# 0
C2243 vbn_prb el 0.30801f
C2244 ta2 a_5524_11840# 0.1094f
C2245 vbn_leak a_3136_4480# 1.2289f
C2246 a_1480_3834# vs 0.01592f
C2247 m1_7692_7940# m1_5432_10180# 0.02256f
C2248 ta1 m1_7702_10660# 0
C2249 vdd a_5516_10600# 0.22262f
C2250 el m1_7148_12980# 0.08198f
C2251 chain m1_5190_15350# 0.02403f
C2252 a_488_17120# a_5316_18520# 0.00599f
C2253 vbn_leak m1_2712_18170# 0.06323f
C2254 m1_642_6980# vbp_st 0.00866f
C2255 a_4588_8588# m1_2112_9090# 0
C2256 pl_en sta 0.02062f
C2257 d1 chain 0.32374f
C2258 d1 sel2 0.02828f
C2259 m1_7080_19410# vdd 0.52098f
C2260 tb0 m1_8326_19030# 0.34378f
C2261 m1_3870_19890# en 0.0277f
C2262 a_6672_9234# m1_7158_7910# 0.07814f
C2263 m1_6968_15350# d2 0.2777f
C2264 ta2 a_268_18520# 0.02996f
C2265 ta1 m1_7790_19900# 0
C2266 a_3272_6334# m1_1096_6970# 0.01287f
C2267 vbn_ax a_5524_5520# 0
C2268 a_6140_14314# chain 0.03664f
C2269 a_3136_4480# a_6984_18520# 0
C2270 a_4368_19360# chain 0
C2271 m1_3690_6830# ta0 0.38848f
C2272 vsrcp m1_2678_13100# 0.00612f
C2273 m1_1996_6970# m1_1096_6970# 0.0648f
C2274 vbn_leak m1_7158_7910# 0.00105f
C2275 vdd vsrcp 0.2155f
C2276 vbn_prb sel1 0.0451f
C2277 a_3048_18520# hold 0.22954f
C2278 pl_en a_2800_12040# 0
C2279 a_3136_4480# vs 0.04324f
C2280 a_6140_9234# ta2 0.02839f
C2281 a_4588_13668# hold 0.2179f
C2282 vbn_ax a_6884_4480# 0.03499f
C2283 a_2492_11000# a_824_11000# 0.01393f
C2284 a_488_12040# a_4588_13668# 0.04746f
C2285 a_488_19360# m1_2712_18170# 0.01864f
C2286 vbp_syn hold 0.43367f
C2287 m1_3690_6830# a_3136_4480# 0
C2288 a_488_12040# vbp_syn 0.05612f
C2289 m1_6346_17880# en 0.04823f
C2290 vsrc el 1.15833f
C2291 a_2492_16080# vbp_syn 0.00443f
C2292 ta2 a_8248_5320# 0
C2293 m1_2668_7940# vbp_syn 0.45237f
C2294 a_5316_18520# a_2180_13234# 0.07139f
C2295 a_5524_5520# a_4660_4480# 0.14923f
C2296 m1_2122_6150# a_1892_3934# 0.00969f
C2297 vbn_prb sel2 0.52519f
C2298 pl_en vbn_ax 0.00946f
C2299 vdd stb 0.19743f
C2300 a_3048_3120# mreset 0
C2301 el en 0.25033f
C2302 sta a_6672_14314# 0.01244f
C2303 a_5268_14218# ta3 0.06434f
C2304 a_5516_15680# sel1 0
C2305 a_5524_16920# a_4588_13668# 0.59434f
C2306 tb1 vdd 1.11286f
C2307 m1_5946_6980# m1_4330_6980# 0
C2308 m1_2236_8010# m1_2112_9090# 0.3251f
C2309 a_5524_16920# vbp_syn 0.03661f
C2310 a_3956_5520# m1_2712_6970# 0
C2311 vdd m1_6968_10660# 0.00627f
C2312 a_3048_3120# a_7540_3120# 0.00567f
C2313 vdd a_672_20034# 0.42911f
C2314 ta2 m1_5946_6980# 0.0638f
C2315 a_3048_16080# a_5268_14218# 0
C2316 ta3 a_6672_9234# 0.00954f
C2317 d1 a_6594_420# 0.18434f
C2318 d1 m1_8350_10270# 0.00744f
C2319 m1_5522_19900# ta0 0.02732f
C2320 mreset vbn_leak 0.06231f
C2321 a_2492_3120# a_1480_3834# 0
C2322 a_4660_4480# a_6884_4480# 0
C2323 vdd vbp_st 5.45587f
C2324 d1 vreset 0.00289f
C2325 m1_1310_2210# a_3048_3120# 0.02447f
C2326 a_5516_15680# chain 0
C2327 sta m1_5432_10180# 0.14102f
C2328 vdd m1_1046_10270# 0.15697f
C2329 vdd a_5268_9138# 0.63358f
C2330 a_488_17120# a_2800_17120# 0.1733f
C2331 vbn_leak ta3 0.33644f
C2332 a_3048_3120# a_728_3738# 0.00246f
C2333 a_7540_3120# vbn_leak 0.00154f
C2334 sel1 en 0.30952f
C2335 m1_6190_19900# a_2180_13234# 0.0032f
C2336 a_2592_8154# m1_7150_14166# 0.00169f
C2337 m1_4330_6980# hold 0
C2338 m1_2868_14560# a_2180_13234# 0.10664f
C2339 m1_6968_15350# m1_7702_15540# 0.05906f
C2340 m1_3870_19890# ta0 0.07221f
C2341 vsrc chain 0
C2342 m1_1310_2210# vbn_leak 0.10775f
C2343 a_4588_8588# vbp_syn 0.02603f
C2344 a_4588_13668# a_5316_18520# 0
C2345 a_3048_16080# vbn_leak 0.33956f
C2346 vsrc sel2 0.02671f
C2347 ta2 hold 0.01209f
C2348 vbp_syn a_5316_18520# 0.00839f
C2349 ta3 a_6984_18520# 0.0204f
C2350 vbn_ref a_3136_4480# 0
C2351 m1_5286_6980# chain 0.32741f
C2352 m1_2956_19890# a_2592_8154# 0.31611f
C2353 vbn_ax a_6672_14314# 0.00295f
C2354 a_2492_3120# a_3136_4480# 0.0028f
C2355 mreset vs 0.18624f
C2356 a_728_3738# vbn_leak 0.04347f
C2357 a_488_12040# ta2 0.10544f
C2358 chain en 0.85023f
C2359 a_2800_12040# m1_5432_10180# -0.02133f
C2360 a_7540_18520# tb3 0.00409f
C2361 sel2 en 0
C2362 ta3 vs 0.024f
C2363 a_3956_5520# vdd 1.6973f
C2364 a_7540_3120# vs 0.1878f
C2365 vbn_prb m1_8350_10270# 0.22054f
C2366 a_3048_16080# a_6984_18520# 0.28304f
C2367 pl_en tb0 0
C2368 vbn_prb a_6594_420# 0.58957f
C2369 a_4096_6334# m1_4882_3750# 0.10725f
C2370 pl_en m1_7702_12990# 0.06249f
C2371 a_1892_3934# a_488_5520# 0.02698f
C2372 a_6672_14314# m1_8326_19030# 0.00183f
C2373 a_3048_11000# m1_2678_13100# 0.0051f
C2374 m1_7702_10660# d1 0.41582f
C2375 a_5524_16920# ta2 0.0748f
C2376 tb2 ta0 0
C2377 vbn_prb vreset 4.23453f
C2378 vdd a_3048_11000# 1.93216f
C2379 m1_1310_2210# vs 0.10104f
C2380 a_5524_5520# a_6884_4480# 0.03887f
C2381 a_7540_3120# m1_3690_6830# 0
C2382 m1_3690_6830# ta3 0.31708f
C2383 ta0 m1_6346_17880# 0.04458f
C2384 a_2800_17120# a_2180_13234# 0.02093f
C2385 m1_7150_14166# d2 0.09841f
C2386 el a_1480_3834# 0.19244f
C2387 vbn_leak a_5516_10600# 0.00526f
C2388 a_5268_14218# vsrcp 0.44679f
C2389 m1_6968_15350# hold 0.08184f
C2390 m1_1946_330# vdd 0.01974f
C2391 a_728_3738# vs 0.1784f
C2392 a_488_17120# sta 0.00525f
C2393 m1_2708_380# vdd 0.02849f
C2394 m1_7080_19410# vbn_leak 0.05179f
C2395 chain m1_6440_6140# 0.10518f
C2396 ta0 el 0.0081f
C2397 sta m1_2112_9090# 0.14859f
C2398 m1_2868_14560# vbp_syn 0.25278f
C2399 m1_1996_6970# m1_642_6980# 0
C2400 a_6672_9234# vsrcp 0.33943f
C2401 m1_2956_19890# d2 0.02586f
C2402 d1_bsel a_2180_13234# 0.20744f
C2403 a_4588_8588# m1_4330_6980# 0
C2404 m1_2712_6970# a_3272_6334# 0.00838f
C2405 m1_2236_8010# vbp_syn 0.21777f
C2406 a_2592_8154# m1_2712_6970# 0.00117f
C2407 m1_6968_15350# a_5524_16920# 0.0138f
C2408 m1_7080_19410# a_6984_18520# 0
C2409 ta2 a_4588_8588# 0.02454f
C2410 vbn_leak vsrcp 0.99418f
C2411 a_488_5520# a_824_3120# 0.07743f
C2412 chain a_5772_4480# 0.29149f
C2413 vsrc a_6594_420# 0.05149f
C2414 el a_3136_4480# 0.42347f
C2415 m1_1996_6970# m1_2712_6970# 0.07774f
C2416 m1_7702_10660# vbn_prb 0.20838f
C2417 a_3048_18520# a_2800_17120# 0.01291f
C2418 a_7540_18520# ta1 0.04113f
C2419 a_6672_14314# tb0 0
C2420 m1_7702_12990# a_6672_14314# 0.00269f
C2421 vsrc vreset 0.08795f
C2422 sel1 ta0 0.00594f
C2423 ta1 tb3 0.11379f
C2424 mreset vbn_ref 0.02798f
C2425 m1_8350_10270# en 0.07183f
C2426 m1_2956_19890# a_268_18520# 0
C2427 a_6594_420# en 0.1967f
C2428 chain m1_6494_7950# 0.0058f
C2429 m1_5522_19900# ta3 0.18101f
C2430 m1_6968_10660# a_6672_9234# 0.01828f
C2431 vbp_syn a_2800_17120# 0.18338f
C2432 a_5268_14218# vbp_st 0.20739f
C2433 sta a_2180_13234# 0.04299f
C2434 d1_bsel a_3048_18520# 0
C2435 chain a_1480_3834# 0.00279f
C2436 a_7540_3120# vbn_ref 0.00168f
C2437 a_488_17120# vbn_ax 0.67606f
C2438 stb vbn_leak 0.26409f
C2439 a_3048_3120# vbp_st 0.00833f
C2440 tb1 vbn_leak 0.01512f
C2441 chain ta0 0
C2442 vbp_st a_6672_9234# 0.20882f
C2443 sel1 a_3136_4480# 0.39622f
C2444 m1_5522_19900# a_3048_16080# 0.11168f
C2445 m1_2712_6970# m1_2788_6140# 0.04795f
C2446 vbn_leak m1_6968_10660# 0.50886f
C2447 a_3048_16080# m1_2112_14220# 0.0015f
C2448 a_3048_16080# m1_9090_16790# 0.00556f
C2449 d1_bsel vbp_syn 0.08753f
C2450 a_488_17120# m1_8326_19030# 0.08919f
C2451 ta2 m1_6190_19900# 0.00765f
C2452 m1_3870_19890# ta3 0.00166f
C2453 m1_6464_13090# m1_5190_15350# 0.01383f
C2454 stb a_6984_18520# 0
C2455 a_672_20034# vbn_leak 0.30151f
C2456 m1_1310_2210# a_2492_3120# 0.32365f
C2457 a_5268_9138# a_6672_9234# 0.00342f
C2458 vdd a_3272_6334# 1.01191f
C2459 a_2592_8154# vdd 1.4f
C2460 m1_7150_14166# m1_7702_15540# 0
C2461 a_824_11000# el 0.15185f
C2462 vdd abus 0.24177f
C2463 vbp_st vbn_leak 0.29495f
C2464 a_2492_11000# m1_1046_10270# 0.246f
C2465 vdd a_824_18520# 0.28423f
C2466 m1_1996_6970# vdd 0.18623f
C2467 m1_7692_7940# ta2 0
C2468 chain a_3136_4480# 0.35712f
C2469 a_672_20034# a_6984_18520# 0
C2470 a_3048_16080# m1_3870_19890# 0.12591f
C2471 m1_1046_10270# vbn_leak 0.1363f
C2472 a_5268_9138# vbn_leak 0.38402f
C2473 sel2 a_3136_4480# 0.03867f
C2474 a_2492_18520# vdd 0.22884f
C2475 stb a_488_19360# 0.0205f
C2476 m1_7702_10660# en 0.0802f
C2477 vbp_st a_6984_18520# 0.00221f
C2478 d1 m1_4882_3750# 0.36391f
C2479 spk a_4096_6334# 0.26673f
C2480 a_3048_3120# a_3956_5520# 0.42842f
C2481 a_5268_14218# a_3048_11000# 0
C2482 pl_en a_6672_14314# 0.1406f
C2483 vbn_ax a_2180_13234# 0.19089f
C2484 sta a_4588_13668# 0.0244f
C2485 tb2 ta3 0.00917f
C2486 sta vbp_syn 0.29178f
C2487 m1_6346_17880# ta3 0.01598f
C2488 m1_5522_19900# m1_7080_19410# 0.10836f
C2489 mreset el 0.05079f
C2490 a_3048_3120# a_3048_11000# 0.00617f
C2491 vbp_st vs 0.19404f
C2492 a_672_20034# a_488_19360# 0.02559f
C2493 vdd a_6984_3120# 0
C2494 a_3048_11000# a_6672_9234# 0.50713f
C2495 vdd m1_2788_6140# 1.42088f
C2496 d2 m1_2678_13100# 0.41552f
C2497 tb2 a_3048_16080# 0.12304f
C2498 a_7540_3120# el 0.01728f
C2499 a_3956_5520# vbn_leak 0.2637f
C2500 a_2492_11000# a_3048_11000# 0.10667f
C2501 el ta3 0.01598f
C2502 vdd d2 1.69849f
C2503 a_3048_16080# m1_6346_17880# 0.41219f
C2504 m1_7150_14166# hold 0.00219f
C2505 a_488_17120# tb0 0.0341f
C2506 a_6594_420# a_1480_3834# 0
C2507 pl_en m1_5432_10180# 0.0415f
C2508 vbn_leak a_3048_11000# 0.30484f
C2509 m1_7080_19410# m1_3870_19890# 0.15245f
C2510 d1_bsel ta2 0
C2511 a_4588_13668# a_2800_12040# 0.00126f
C2512 vbn_ref vsrcp 0.0396f
C2513 m1_1310_2210# el 0.1124f
C2514 vdd sel0 0.20235f
C2515 vbp_syn a_2800_12040# 0.25458f
C2516 a_3048_16080# el 0
C2517 a_728_3738# el 0.26617f
C2518 m1_2956_19890# hold 0.01489f
C2519 m1_2708_380# vbn_leak 0
C2520 vdd a_5524_11840# 0.98762f
C2521 vdd m1_6716_16790# 0.05811f
C2522 vbn_ax a_3048_18520# 0.00296f
C2523 vbn_prb m1_4882_3750# 0
C2524 m1_7930_11710# d1 0.00104f
C2525 a_5524_16920# m1_7150_14166# 0.1846f
C2526 a_3956_5520# vs 0.26683f
C2527 sel1 ta3 0.08054f
C2528 m1_5522_19900# stb 0.07582f
C2529 vbn_ax a_4588_13668# 0
C2530 vdd a_268_18520# 1.06146f
C2531 m1_8350_10270# a_3136_4480# 0.00261f
C2532 vbn_ax vbp_syn 0.08835f
C2533 a_6594_420# a_3136_4480# 0.17108f
C2534 m1_1860_15340# m1_2678_13100# 0.00242f
C2535 m1_5522_19900# tb1 0.07899f
C2536 tb2 m1_7080_19410# 0.14204f
C2537 a_3048_11000# vs 0.02405f
C2538 m1_1860_15340# vdd 0.16719f
C2539 a_3956_5520# m1_3690_6830# 0
C2540 mreset chain 0.01645f
C2541 m1_7080_19410# m1_6346_17880# 0.02339f
C2542 mreset sel2 3.94583f
C2543 a_3136_4480# vreset 0
C2544 a_3048_16080# sel1 0.03173f
C2545 m1_2236_8010# m1_1096_6970# 0
C2546 sta ta2 0
C2547 el a_5516_10600# 0.02853f
C2548 m1_5522_19900# a_672_20034# 0.07545f
C2549 chain ta3 0.00753f
C2550 m1_3690_6830# a_3048_11000# 0.32591f
C2551 m1_2708_380# vs 0.02439f
C2552 m1_1946_330# vs 0.1006f
C2553 a_7540_3120# chain 0.17459f
C2554 a_7540_18520# a_4368_19360# 0.01611f
C2555 stb m1_3870_19890# 0.43547f
C2556 a_6140_9234# vdd 1.52887f
C2557 tb1 m1_3870_19890# 0.03348f
C2558 m1_6464_13090# en 0
C2559 vbn_ref vbp_st 0.05134f
C2560 vbp_st m1_9090_16790# 0.01433f
C2561 pl_en a_488_17120# 0.01253f
C2562 m1_1310_2210# chain 0
C2563 vbp_st a_2492_3120# 0.15926f
C2564 a_2592_8154# a_5268_14218# 0.03709f
C2565 a_3048_16080# chain 0.02565f
C2566 m1_7930_16790# vdd 0.08469f
C2567 vdd a_5316_3120# 0.00174f
C2568 a_672_20034# m1_3870_19890# 0.34198f
C2569 a_3048_3120# a_3272_6334# 0.05199f
C2570 vdd a_8248_5320# 1.04957f
C2571 m1_7790_19900# ta0 0
C2572 a_728_3738# chain 0
C2573 m1_7930_11710# m1_7148_12980# 0
C2574 el vsrcp 0.44368f
C2575 a_2592_8154# a_6672_9234# 0.09032f
C2576 vdd m1_7702_15540# 0.08439f
C2577 vbp_st m1_3870_19890# 0
C2578 m1_2668_7940# m1_2712_6970# 0
C2579 abus a_6672_9234# 0.01933f
C2580 m1_6968_15350# sta 0.01435f
C2581 a_3048_3120# m1_1996_6970# 0
C2582 m1_7080_19410# sel1 0
C2583 tb2 stb 0
C2584 m1_4882_3750# en 0.04415f
C2585 m1_7702_10660# a_3136_4480# 0.02218f
C2586 m1_1996_6970# a_6672_9234# 0
C2587 d1 spk 0.30066f
C2588 a_3272_6334# vbn_leak 0.06013f
C2589 tb2 tb1 0.50497f
C2590 m1_910_6150# d1 0
C2591 vdd m1_5946_6980# -0
C2592 tb1 m1_6346_17880# 0.00305f
C2593 a_2592_8154# vbn_leak 1.01757f
C2594 abus vbn_leak 0.19959f
C2595 ta1 m1_5190_15350# 0.00907f
C2596 ta1 d1 0.08221f
C2597 m1_7702_12990# a_4588_13668# 0.08324f
C2598 vbn_ax ta2 0.00884f
C2599 tb2 a_672_20034# 0.00201f
C2600 m1_1996_6970# vbn_leak 1.03473f
C2601 chain a_5516_10600# 0
C2602 a_672_20034# m1_6346_17880# 0
C2603 sel1 vsrcp 0.00117f
C2604 tb1 el 0
C2605 tb2 vbp_st 0
C2606 d1 a_4096_6334# 0.16422f
C2607 a_2592_8154# a_6984_18520# 0.26638f
C2608 a_2492_18520# vbn_leak 0
C2609 m1_7080_19410# chain 0
C2610 pl_en a_2180_13234# 0.03612f
C2611 mreset a_6594_420# 0.03368f
C2612 a_5268_14218# d2 0.59755f
C2613 ta1 a_6140_14314# 0.01839f
C2614 vbp_st m1_6346_17880# 0.05524f
C2615 m1_2122_6150# m1_1096_6970# 0.00477f
C2616 a_3048_3120# m1_2788_6140# 0.00927f
C2617 mreset vreset 0.02797f
C2618 a_488_17120# a_6672_14314# 0.03309f
C2619 hold m1_2678_13100# 0.00914f
C2620 a_7540_3120# a_6594_420# 0.00159f
C2621 a_3272_6334# vs 0.48836f
C2622 vdd hold 4.0252f
C2623 abus vs 0.2363f
C2624 vbp_st el 0.63266f
C2625 a_488_12040# m1_2678_13100# 0.01982f
C2626 vbn_leak a_6984_3120# 0
C2627 sta m1_1096_6970# 0
C2628 a_488_12040# vdd 1.89906f
C2629 m1_1946_330# a_2492_3120# 0
C2630 a_7540_3120# vreset 0
C2631 m1_7150_9212# a_6672_9234# 0.00245f
C2632 chain vsrcp 0.07254f
C2633 vdd a_2492_16080# 0.3768f
C2634 a_5268_14218# m1_6716_16790# 0.00153f
C2635 a_2592_8154# a_488_19360# 0.10337f
C2636 sel2 vsrcp 0.02683f
C2637 m1_1996_6970# vs 0.06104f
C2638 m1_2668_7940# vdd 0.30182f
C2639 sel1 stb 0.14653f
C2640 m1_1310_2210# a_6594_420# 0.10909f
C2641 vbn_prb spk 0.30801f
C2642 m1_2788_6140# vbn_leak 0.16479f
C2643 a_2592_8154# m1_3690_6830# 0
C2644 m1_1046_10270# el 0.05479f
C2645 a_5268_9138# el 0.10261f
C2646 a_488_19360# a_824_18520# 0.1566f
C2647 vbn_leak d2 0.83388f
C2648 a_5268_14218# a_268_18520# 0.00703f
C2649 m1_4882_3750# a_5772_4480# 0.19434f
C2650 a_6672_9234# a_5524_11840# 0.63539f
C2651 a_5524_16920# m1_2678_13100# 0.00123f
C2652 m1_1996_6970# m1_3690_6830# 0.06717f
C2653 vbn_leak m1_7150_9212# 0.00561f
C2654 a_5524_16920# vdd 1.12082f
C2655 a_2492_18520# a_488_19360# 0.00885f
C2656 a_7540_18520# en 0.05526f
C2657 a_6984_3120# vss 0.01492f
C2658 a_6884_4480# vss 0.11494f
C2659 a_3136_4480# vss 3.37012f
C2660 a_7540_18520# vss 0.03311f
C2661 m1_2712_6970# vss 0.0533f
C2662 a_6594_420# vss 1.00676f
C2663 a_3272_6334# vss 2.41186f
C2664 m1_6968_10660# vss 0.17423f
C2665 a_2492_18520# vss -0.10831f
C2666 a_7540_3120# vss 0.62867f
C2667 a_2492_11000# vss -0.04198f
C2668 a_6984_18520# vss -0.13435f
C2669 vs vss 5.41233f
C2670 a_672_20034# vss 1.14178f
C2671 d1_bsel vss 1.4845f
C2672 a_3956_5520# vss -0.36312f
C2673 a_2492_16080# vss -0.02624f
C2674 hold vss 2.64345f
C2675 vbn_ax vss 3.13995f
C2676 m1_3870_19890# vss 2.25262f
C2677 tb3 vss 0.93703f
C2678 a_6672_9234# vss 1.19512f
C2679 m1_2112_14220# vss -0.02462f
C2680 a_5316_3120# vss 0.02268f
C2681 m1_7206_2780# vss 0.4316f
C2682 m1_5522_19900# vss 1.41029f
C2683 tb2 vss 0.46211f
C2684 chain vss 1.23436f
C2685 a_6140_9234# vss 0.64368f
C2686 m1_7080_19410# vss 0.489f
C2687 tb1 vss 0.37137f
C2688 m1_7702_10660# vss 0.65156f
C2689 a_5316_18520# vss -0.12685f
C2690 m1_8326_19030# vss 0.22351f
C2691 tb0 vss 0.55753f
C2692 m1_4882_3750# vss -0.22233f
C2693 m1_8350_10270# vss 0.2502f
C2694 m1_7790_19900# vss 0.056f
C2695 a_5516_10600# vss 0.32293f
C2696 m1_6190_19900# vss 0.07047f
C2697 abus vss 4.15945f
C2698 sel0 vss 2.13505f
C2699 m1_5432_10180# vss 0.66629f
C2700 a_2800_12040# vss 0.0101f
C2701 m1_9090_11710# vss -0.09115f
C2702 a_4368_19360# vss -0.31612f
C2703 m1_4568_19890# vss 0.01239f
C2704 a_824_16080# vss 0.02232f
C2705 a_488_17120# vss 1.75831f
C2706 m1_6716_11710# vss -0.09042f
C2707 m1_7930_11710# vss -0.07376f
C2708 m1_1310_2210# vss 0.0048f
C2709 pl_en vss 1.37339f
C2710 a_4096_6334# vss 0.77761f
C2711 spk vss 7.79267f
C2712 m1_7692_7940# vss 0.09383f
C2713 a_4660_4480# vss -0.04733f
C2714 a_5524_5520# vss -0.37155f
C2715 m1_7158_7910# vss 0.08198f
C2716 a_6672_14314# vss 1.42359f
C2717 d1 vss 4.66757f
C2718 a_6140_14314# vss 1.51162f
C2719 a_3048_16080# vss 1.00094f
C2720 m1_2112_9090# vss -0.08814f
C2721 m1_6494_7950# vss 0.03522f
C2722 a_5524_11840# vss 2.48781f
C2723 a_1480_3834# vss 0.34259f
C2724 m1_2712_18170# vss -0.15595f
C2725 m1_1046_10270# vss -0.15731f
C2726 a_824_11000# vss 0.06538f
C2727 m1_1096_6970# vss 0.09682f
C2728 m1_6346_17880# vss 0.06782f
C2729 m1_642_6980# vss 0.02521f
C2730 a_5268_9138# vss 1.06265f
C2731 vsrcp vss 2.52927f
C2732 m1_1860_15340# vss -0.01861f
C2733 m1_9090_16790# vss -0.09115f
C2734 a_5516_15680# vss 0.18884f
C2735 m1_2668_7940# vss 0.45825f
C2736 a_2592_8154# vss 2.6828f
C2737 m1_7150_9212# vss 0.09612f
C2738 m1_6716_16790# vss -0.09115f
C2739 m1_7930_16790# vss -0.05326f
C2740 vdd vss 97.98725f
C2741 m1_1946_330# vss 0.61076f
C2742 sel1 vss 0.80908f
C2743 a_2800_17120# vss -0.03042f
C2744 m1_2236_8010# vss -0.00339f
C2745 sta vss 1.28519f
C2746 m1_2788_6140# vss 0.40598f
C2747 vbp_st vss 2.22595f
C2748 m1_2708_380# vss 0.04586f
C2749 en vss 2.57863f
C2750 m1_2122_6150# vss -0.07089f
C2751 m1_910_6150# vss -0.08035f
C2752 m1_6968_15350# vss 0.01307f
C2753 a_5524_16920# vss 1.7477f
C2754 m1_7702_12990# vss 0.46805f
C2755 vbn_prb vss 4.269f
C2756 a_4588_13668# vss 1.07507f
C2757 m1_5190_15350# vss 0.52284f
C2758 m1_7148_12980# vss -0.01359f
C2759 mreset vss 2.07537f
C2760 m1_1996_6970# vss 1.86514f
C2761 a_5772_4480# vss -0.03791f
C2762 m1_3690_6830# vss 0.6546f
C2763 m1_6464_13090# vss -0.0139f
C2764 a_488_12040# vss 1.31268f
C2765 m1_5286_6980# vss 1.0721f
C2766 a_5268_14218# vss 1.12985f
C2767 m1_7150_14166# vss 0.07507f
C2768 m1_2956_19890# vss 0.03893f
C2769 vbp_syn vss 0.52603f
C2770 a_728_3738# vss 0.64256f
C2771 vsrc vss 1.6226f
C2772 m1_2470_19900# vss -0.01218f
C2773 m1_2678_13100# vss 0.7058f
C2774 stb vss 1.90871f
C2775 a_4588_8588# vss 1.76597f
C2776 a_3048_11000# vss 1.42247f
C2777 ta3 vss 0.4489f
C2778 a_2492_3120# vss 0.20858f
C2779 sel2 vss 2.34553f
C2780 m1_7702_15540# vss 0.52892f
C2781 vreset vss 1.92486f
C2782 vbn_ref vss 0.20584f
C2783 m1_2868_14560# vss 0.21643f
C2784 d2 vss 3.01482f
C2785 a_2180_13234# vss 1.09681f
C2786 a_824_18520# vss -0.12042f
C2787 a_488_19360# vss 0.11639f
C2788 ta2 vss 0.60027f
C2789 a_3048_3120# vss 0.10876f
C2790 m1_8466_15350# vss 0.19455f
C2791 m1_5946_6980# vss 0.01417f
C2792 ta1 vss 0.89776f
C2793 a_824_3120# vss 0.007f
C2794 a_488_5520# vss 0.20944f
C2795 el vss 6.97791f
C2796 a_3048_18520# vss -0.05171f
C2797 m1_4330_6980# vss 0.05683f
C2798 m1_6440_6140# vss 0.12239f
C2799 ta0 vss 0.38281f
C2800 a_268_18520# vss 1.72709f
C2801 a_1892_3934# vss 0.5721f
C2802 vbn_leak vss 13.66721f
C2803 a_8248_5320# vss 0.47529f
.ends
