* NGSPICE file created from dend_d1.ext - technology: gf180mcuD

.subckt n_w4_l0p5_k1 a_n188_n400# a_50_n400# a_n50_n444# VSUBS
X0 a_50_n400# a_n50_n444# a_n188_n400# VSUBS nfet_03v3 ad=2.76p pd=9.38u as=2.76p ps=9.38u w=4u l=0.5u
C0 a_n50_n444# a_50_n400# 0.04238f
C1 a_n188_n400# a_n50_n444# 0.04238f
C2 a_n188_n400# a_50_n400# 0.10174f
C3 a_50_n400# VSUBS 0.23105f
C4 a_n188_n400# VSUBS 0.23105f
.ends

.subckt n_w2_l4 a_400_n200# a_n400_n244# a_n488_n200# VSUBS
X0 a_400_n200# a_n400_n244# a_n488_n200# VSUBS nfet_03v3 ad=0.88p pd=4.88u as=0.88p ps=4.88u w=2u l=4u
C0 a_n400_n244# a_400_n200# 0.07019f
C1 a_n488_n200# a_n400_n244# 0.07019f
C2 a_n488_n200# a_400_n200# 0.01073f
C3 a_400_n200# VSUBS 0.41684f
C4 a_n488_n200# VSUBS 0.41684f
.ends

.subckt n_w1_l0p28 a_28_n100# a_n28_n144# a_n116_n100# VSUBS
X0 a_28_n100# a_n28_n144# a_n116_n100# VSUBS nfet_03v3 ad=0.44p pd=2.88u as=0.44p ps=2.88u w=1u l=0.28u
C0 a_n28_n144# a_28_n100# 0.00769f
C1 a_n116_n100# a_n28_n144# 0.00769f
C2 a_n116_n100# a_28_n100# 0.04256f
C3 a_28_n100# VSUBS 0.09911f
C4 a_n116_n100# VSUBS 0.09911f
.ends

.subckt p_w1_l0p28 w_n202_n230# a_28_n100# a_n28_n144# a_n116_n100# VSUBS
X0 a_28_n100# a_n28_n144# a_n116_n100# w_n202_n230# pfet_03v3 ad=0.44p pd=2.88u as=0.44p ps=2.88u w=1u l=0.28u
C0 a_n116_n100# a_28_n100# 0.04256f
C1 w_n202_n230# a_n116_n100# 0.01808f
C2 a_n28_n144# a_28_n100# 0.00769f
C3 a_n28_n144# w_n202_n230# 0.05841f
C4 a_n28_n144# a_n116_n100# 0.00769f
C5 w_n202_n230# a_28_n100# 0.01808f
C6 a_28_n100# VSUBS 0.0597f
C7 a_n116_n100# VSUBS 0.0597f
C8 w_n202_n230# VSUBS 0.55752f
.ends

.subckt p_w0p22_l1 a_100_n22# a_n100_n66# w_n278_n159# a_n192_n36# VSUBS
X0 a_100_n22# a_n100_n66# a_n192_n36# w_n278_n159# pfet_03v3 ad=0.1516p pd=1.64u as=0.1516p ps=1.64u w=0.22u l=1u
C0 a_n100_n66# a_100_n22# 0.00509f
C1 w_n278_n159# a_n100_n66# 0.13163f
C2 a_n192_n36# a_100_n22# 0.00453f
C3 a_n192_n36# w_n278_n159# 0.00771f
C4 a_n192_n36# a_n100_n66# 0.00509f
C5 w_n278_n159# a_100_n22# 0.00771f
C6 a_100_n22# VSUBS 0.05952f
C7 a_n192_n36# VSUBS 0.05952f
C8 w_n278_n159# VSUBS 0.53042f
.ends

.subckt n_w0p5_l1p5 a_150_n50# a_n238_n50# a_n150_n94# VSUBS
X0 a_150_n50# a_n150_n94# a_n238_n50# VSUBS nfet_03v3 ad=0.22p pd=1.88u as=0.22p ps=1.88u w=0.5u l=1.5u
C0 a_n150_n94# a_150_n50# 0.01269f
C1 a_n238_n50# a_n150_n94# 0.01269f
C2 a_n238_n50# a_150_n50# 0.00671f
C3 a_150_n50# VSUBS 0.17146f
C4 a_n238_n50# VSUBS 0.17146f
.ends

.subckt p_w2_l4 a_400_n200# a_n400_n244# w_n574_n330# a_n488_n200# VSUBS
X0 a_400_n200# a_n400_n244# a_n488_n200# w_n574_n330# pfet_03v3 ad=0.88p pd=4.88u as=0.88p ps=4.88u w=2u l=4u
C0 a_n488_n200# a_400_n200# 0.01073f
C1 w_n574_n330# a_n488_n200# 0.07409f
C2 a_n400_n244# a_400_n200# 0.07019f
C3 a_n400_n244# w_n574_n330# 0.42229f
C4 a_n400_n244# a_n488_n200# 0.07019f
C5 w_n574_n330# a_400_n200# 0.07409f
C6 a_400_n200# VSUBS 0.18936f
C7 a_n488_n200# VSUBS 0.18936f
C8 w_n574_n330# VSUBS 2.27304f
.ends

.subckt p_w1_l0p5 a_n138_n100# a_50_n100# a_n50_n144# w_n224_n230# VSUBS
X0 a_50_n100# a_n50_n144# a_n138_n100# w_n224_n230# pfet_03v3 ad=0.44p pd=2.88u as=0.44p ps=2.88u w=1u l=0.5u
C0 a_n138_n100# a_50_n100# 0.03085f
C1 w_n224_n230# a_n138_n100# 0.0205f
C2 a_n50_n144# a_50_n100# 0.01275f
C3 a_n50_n144# w_n224_n230# 0.07993f
C4 a_n50_n144# a_n138_n100# 0.01275f
C5 w_n224_n230# a_50_n100# 0.0205f
C6 a_50_n100# VSUBS 0.06546f
C7 a_n138_n100# VSUBS 0.06546f
C8 w_n224_n230# VSUBS 0.61824f
.ends

.subckt p_w1_l2 w_n374_n230# a_n288_n100# a_200_n100# a_n200_n144# VSUBS
X0 a_200_n100# a_n200_n144# a_n288_n100# w_n374_n230# pfet_03v3 ad=0.44p pd=2.88u as=0.44p ps=2.88u w=1u l=2u
C0 a_n288_n100# a_200_n100# 0.01056f
C1 w_n374_n230# a_n288_n100# 0.03135f
C2 a_n200_n144# a_200_n100# 0.02905f
C3 a_n200_n144# w_n374_n230# 0.22666f
C4 a_n200_n144# a_n288_n100# 0.02905f
C5 w_n374_n230# a_200_n100# 0.03135f
C6 a_200_n100# VSUBS 0.1047f
C7 a_n288_n100# VSUBS 0.1047f
C8 w_n374_n230# VSUBS 1.03224f
.ends

.subckt n_w0p5_l0p28 a_n28_n94# a_n116_n50# a_28_n50# VSUBS
X0 a_28_n50# a_n28_n94# a_n116_n50# VSUBS nfet_03v3 ad=0.22p pd=1.88u as=0.22p ps=1.88u w=0.5u l=0.28u
C0 a_n28_n94# a_28_n50# 0.00377f
C1 a_n116_n50# a_n28_n94# 0.00377f
C2 a_n116_n50# a_28_n50# 0.02085f
C3 a_28_n50# VSUBS 0.07987f
C4 a_n116_n50# VSUBS 0.07987f
.ends

.subckt n_w0p5_l0p5 a_n138_n50# a_50_n50# a_n50_n94# VSUBS
X0 a_50_n50# a_n50_n94# a_n138_n50# VSUBS nfet_03v3 ad=0.22p pd=1.88u as=0.22p ps=1.88u w=0.5u l=0.5u
C0 a_n50_n94# a_50_n50# 0.00625f
C1 a_n138_n50# a_n50_n94# 0.00625f
C2 a_n138_n50# a_50_n50# 0.01511f
C3 a_50_n50# VSUBS 0.09639f
C4 a_n138_n50# VSUBS 0.09639f
.ends

.subckt n_w4_l2 a_n288_n400# a_200_n400# a_n200_n444# VSUBS
X0 a_200_n400# a_n200_n444# a_n288_n400# VSUBS nfet_03v3 ad=1.76p pd=8.88u as=1.76p ps=8.88u w=4u l=2u
C0 a_n200_n444# a_200_n400# 0.11799f
C1 a_n288_n400# a_n200_n444# 0.11799f
C2 a_n288_n400# a_200_n400# 0.04287f
C3 a_200_n400# VSUBS 0.34365f
C4 a_n288_n400# VSUBS 0.34365f
.ends

.subckt n_w3p54_l3p54 a_354_n354# a_n354_n398# a_n442_n354# VSUBS
X0 a_354_n354# a_n354_n398# a_n442_n354# VSUBS nfet_03v3 ad=1.5576p pd=7.96u as=1.5576p ps=7.96u w=3.54u l=3.54u
C0 a_n354_n398# a_354_n354# 0.12189f
C1 a_n442_n354# a_n354_n398# 0.12189f
C2 a_n442_n354# a_354_n354# 0.02161f
C3 a_354_n354# VSUBS 0.44156f
C4 a_n442_n354# VSUBS 0.44156f
.ends

.subckt n_w0p5_l0p6 a_n148_n50# a_60_n50# a_n60_n94# VSUBS
X0 a_60_n50# a_n60_n94# a_n148_n50# VSUBS nfet_03v3 ad=0.22p pd=1.88u as=0.22p ps=1.88u w=0.5u l=0.6u
C0 a_n60_n94# a_60_n50# 0.00722f
C1 a_n148_n50# a_n60_n94# 0.00722f
C2 a_n148_n50# a_60_n50# 0.01345f
C3 a_60_n50# VSUBS 0.1039f
C4 a_n148_n50# VSUBS 0.1039f
.ends

.subckt n_w1_l0p5 a_n138_n100# a_50_n100# a_n50_n144# VSUBS
X0 a_50_n100# a_n50_n144# a_n138_n100# VSUBS nfet_03v3 ad=0.44p pd=2.88u as=0.44p ps=2.88u w=1u l=0.5u
C0 a_n50_n144# a_50_n100# 0.01275f
C1 a_n138_n100# a_n50_n144# 0.01275f
C2 a_n138_n100# a_50_n100# 0.03085f
C3 a_50_n100# VSUBS 0.11563f
C4 a_n138_n100# VSUBS 0.11563f
.ends

.subckt n_w0p5_l3 a_n388_n50# a_300_n50# a_n300_n94# VSUBS
X0 a_300_n50# a_n300_n94# a_n388_n50# VSUBS nfet_03v3 ad=0.22p pd=1.88u as=0.22p ps=1.88u w=0.5u l=3u
C0 a_n300_n94# a_300_n50# 0.01602f
C1 a_n388_n50# a_n300_n94# 0.01602f
C2 a_n388_n50# a_300_n50# 0.00348f
C3 a_300_n50# VSUBS 0.28406f
C4 a_n388_n50# VSUBS 0.28406f
.ends

.subckt n_w1_l1 a_n188_n100# a_100_n100# a_n100_n144# VSUBS
X0 a_100_n100# a_n100_n144# a_n188_n100# VSUBS nfet_03v3 ad=0.44p pd=2.88u as=0.44p ps=2.88u w=1u l=1u
C0 a_n100_n144# a_100_n100# 0.02094f
C1 a_n188_n100# a_n100_n144# 0.02094f
C2 a_n188_n100# a_100_n100# 0.0191f
C3 a_100_n100# VSUBS 0.15316f
C4 a_n188_n100# VSUBS 0.15316f
.ends

.subckt p_w0p22_l4 a_n400_n66# a_n492_n36# w_n578_n159# a_400_n22# VSUBS
X0 a_400_n22# a_n400_n66# a_n492_n36# w_n578_n159# pfet_03v3 ad=0.1516p pd=1.64u as=0.1516p ps=1.64u w=0.22u l=4u
C0 a_n400_n66# a_400_n22# 0.00842f
C1 w_n578_n159# a_n400_n66# 0.43266f
C2 a_n492_n36# a_400_n22# 0.00123f
C3 a_n492_n36# w_n578_n159# 0.0077f
C4 a_n492_n36# a_n400_n66# 0.00842f
C5 w_n578_n159# a_400_n22# 0.0077f
C6 a_400_n22# VSUBS 0.13421f
C7 a_n492_n36# VSUBS 0.13421f
C8 w_n578_n159# VSUBS 1.10282f
.ends

.subckt n_w1_l4 a_n488_n100# a_400_n100# a_n400_n144# VSUBS
X0 a_400_n100# a_n400_n144# a_n488_n100# VSUBS nfet_03v3 ad=0.44p pd=2.88u as=0.44p ps=2.88u w=1u l=4u
C0 a_n400_n144# a_400_n100# 0.03474f
C1 a_n488_n100# a_n400_n144# 0.03474f
C2 a_n488_n100# a_400_n100# 0.00531f
C3 a_400_n100# VSUBS 0.37836f
C4 a_n488_n100# VSUBS 0.37836f
.ends

.subckt n_w2_l2 a_n288_n200# a_200_n200# a_n200_n244# VSUBS
X0 a_200_n200# a_n200_n244# a_n288_n200# VSUBS nfet_03v3 ad=0.88p pd=4.88u as=0.88p ps=4.88u w=2u l=2u
C0 a_n200_n244# a_200_n200# 0.0587f
C1 a_n288_n200# a_n200_n244# 0.0587f
C2 a_n288_n200# a_200_n200# 0.02133f
C3 a_200_n200# VSUBS 0.2667f
C4 a_n288_n200# VSUBS 0.2667f
.ends

.subckt n_w0p22_l2 a_200_n22# a_n200_n66# a_n292_n36# VSUBS
X0 a_200_n22# a_n200_n66# a_n292_n36# VSUBS nfet_03v3 ad=0.1516p pd=1.64u as=0.1516p ps=1.64u w=0.22u l=2u
C0 a_n292_n36# a_200_n22# 0.00245f
C1 a_n200_n66# a_n292_n36# 0.00705f
C2 a_n200_n66# a_200_n22# 0.00705f
C3 a_200_n22# VSUBS 0.20767f
C4 a_n292_n36# VSUBS 0.20767f
.ends

.subckt n_w7p07_l7p07 a_707_n707# a_n795_n707# a_n707_n751# VSUBS
X0 a_707_n707# a_n707_n751# a_n795_n707# VSUBS nfet_03v3 ad=3.1108p pd=15.02u as=3.1108p ps=15.02u w=7.07u l=7.07u
C0 a_n707_n751# a_707_n707# 0.27012f
C1 a_n795_n707# a_n707_n751# 0.27012f
C2 a_n795_n707# a_707_n707# 0.0212f
C3 a_707_n707# VSUBS 0.84237f
C4 a_n795_n707# VSUBS 0.84237f
.ends

.subckt n_w4_l1 a_n188_n400# a_100_n400# a_n100_n444# VSUBS
X0 a_100_n400# a_n100_n444# a_n188_n400# VSUBS nfet_03v3 ad=1.76p pd=8.88u as=1.76p ps=8.88u w=4u l=1u
C0 a_n100_n444# a_100_n400# 0.08505f
C1 a_n188_n400# a_n100_n444# 0.08505f
C2 a_n188_n400# a_100_n400# 0.07756f
C3 a_100_n400# VSUBS 0.26859f
C4 a_n188_n400# VSUBS 0.26859f
.ends

.subckt dend_d1 vdd vss el vbn_leak vsrc vsrcp vbp_st vbn_ax vbn_ref vreset vbn_prb
+ abus sel0 sel2 mreset spk en pl_en chain sel1 d1_bsel sta stb hold ta0 ta1 ta2 ta3
+ tb0 tb1 tb2 tb3 vbp_syn d1 d2 vs
XXL1_XM2 a_2542_11000# a_3098_11000# a_3098_11000# vss n_w4_l0p5_k1
XXEP_XS a_8248_5320# vbn_leak vss vss n_w2_l4
XXS_XL_XMT m1_2722_2630# vbn_leak vss vss n_w2_l4
XXWS a_318_18520# a_1892_3934# vs vss n_w1_l0p28
XXS_XD_Xi4_XP vdd spk a_3272_6334# vdd vss p_w1_l0p28
XXP1_XDT_XK a_6672_9234# a_5524_11840# vdd vdd vss p_w0p22_l1
XXR1_XP0 vdd a_3098_11000# ta0 m1_6494_5850# vss p_w1_l0p28
XXR1_XR2 m1_4282_6970# m1_2712_6970# vbn_leak vss n_w0p5_l1p5
XXA2_XA_XP2 a_3098_18520# a_488_19360# vdd vdd vss p_w2_l4
XXY2_XQB vdd vss vss m1_2678_13100# vss p_w1_l0p28
XXS_XL_XM1 a_488_5520# a_874_3120# el vss n_w4_l0p5_k1
XXA2_XA_XMT m1_1046_17880# vbn_ax vss vss n_w2_l4
XXA2_XA_XHO vdd d2 hold a_3098_18520# vss p_w1_l0p28
XXR1_XP1 vdd a_3098_11000# ta1 m1_5286_6830# vss p_w1_l0p28
XXR1_XR3 m1_5942_6980# m1_4282_6970# vbn_leak vss n_w0p5_l1p5
XXT1_XME m1_7702_15650# en m1_8466_15350# vss n_w1_l0p28
XXS_XL_XM2 a_2542_3120# a_3098_3120# a_3098_3120# vss n_w4_l0p5_k1
XXP2_XDT_XNE m1_6940_14170# a_5524_16920# vsrcp vss n_w1_l0p28
XXS_XD_XPI m1_910_6150# a_728_3738# vs vdd vss p_w1_l0p5
XXR1_XP2 vdd a_3098_11000# ta2 m1_3676_6970# vss p_w1_l0p28
XXEP_XPD vdd vdd a_8248_5320# a_8248_5320# vss p_w1_l2
XXR1_XN0 ta0 m1_6494_5850# a_488_12040# vss n_w0p5_l0p28
XXA2_XA_XM1 a_488_19360# a_874_18520# a_318_18520# vss n_w4_l0p5_k1
XXY2_XNA a_2180_13234# d2 m1_2862_14560# vss n_w0p5_l0p28
XXS_XR_XNR a_6594_420# vbn_ref vss vss n_w2_l4
XXS_XR_XSW vreset vs a_6594_420# vss n_w0p5_l0p5
XXT1_XMF m1_7702_15650# vdd d2 vss n_w4_l2
XXT2_XSW m1_7702_10190# sel2 abus vss n_w1_l0p28
XXP2_XTP vdd vdd a_4588_13668# a_5524_16920# vss p_w1_l2
XXS_XL_XD2_a m1_2722_2630# a_2542_3120# a_2542_3120# vss n_w4_l0p5_k1
XXR1_XP3 vdd a_3098_11000# ta3 m1_2062_6980# vss p_w1_l0p28
XXP1_XCT_XC vss a_4588_8588# vss vss n_w3p54_l3p54
XXR1_XN1 ta1 m1_5286_6830# a_488_12040# vss n_w0p5_l0p28
XXB_XP1 vdd a_2592_8154# d1_bsel stb vss p_w1_l0p28
XXA2_XA_XM2 a_2542_18520# a_3098_18520# a_3098_18520# vss n_w4_l0p5_k1
XXY2_XNB vss d2 m1_2678_13100# vss n_w0p5_l0p28
XXR2_XRA vss m1_2470_19900# vbn_leak vss n_w0p5_l0p6
XXP2_XDT_XPI m1_6716_16790# a_5268_14218# d2 vdd vss p_w1_l0p5
XXS_XL_XD2_b a_2542_3120# m1_2722_2630# a_2542_3120# vss n_w4_l0p5_k1
XXS_XD_XNI vsrc a_728_3738# vs vss n_w1_l0p5
XXR1_XL0 m1_5942_6980# m1_6494_5850# vbn_leak vss n_w0p5_l3
XXR1_XLT m1_5942_6980# vdd vbn_leak vss n_w0p5_l3
XXR1_XN2 ta2 m1_3676_6970# a_488_12040# vss n_w0p5_l0p28
XXY1_XWA m1_2236_8010# vbp_syn vdd m1_2112_9090# vss p_w2_l4
XXB_XP2 vdd a_2180_13234# a_672_20034# stb vss p_w1_l0p28
XXR2_XRB m1_2470_19900# m1_2956_19890# vbn_leak vss n_w0p5_l0p6
XXP2_XDT_XNH m1_6940_14170# a_5268_14218# d2 vss n_w1_l1
XXR1_XL1 m1_4282_6970# m1_5286_6830# vbn_leak vss n_w0p5_l3
XXR1_XN3 ta3 m1_2062_6980# a_488_12040# vss n_w0p5_l0p28
XXB_XN1 a_672_20034# stb a_2592_8154# vss n_w0p5_l0p28
XXY1_XWB m1_2668_7940# vbp_syn vdd m1_2112_9090# vss p_w2_l4
XXP2_XDT_XNI vsrcp a_5268_14218# d2 vss n_w1_l0p5
XXP1_XDT_XQ a_6140_9234# vdd vdd a_6672_9234# vss p_w0p22_l4
XXP2_XTS a_4588_13668# a_5524_16920# m1_6494_13030# vss n_w1_l0p28
XXR1_XL2 m1_2712_6970# m1_3676_6970# vbn_leak vss n_w0p5_l3
XXB_XN2 d1_bsel stb a_2180_13234# vss n_w0p5_l0p28
XXP2_XDT_XK a_6672_14314# a_5524_16920# vdd vdd vss p_w0p22_l1
XXA1_XB_XD2_a m1_4882_3700# a_6378_4480# a_6378_4480# vss n_w4_l0p5_k1
XXR1_XL3 m1_1080_6970# m1_2062_6980# vbn_leak vss n_w0p5_l3
XXY2_XPH vdd vdd m1_2112_14220# hold vss p_w1_l2
XXP1_XTI vss m1_6494_7910# vbn_leak vss n_w1_l4
XXA1_XB_XD2_b a_6378_4480# m1_4882_3700# a_6378_4480# vss n_w4_l0p5_k1
XXA1_XA_XD2_a m1_7206_2340# a_7034_3120# a_7034_3120# vss n_w4_l0p5_k1
XXMR mreset a_6594_420# vdd vss n_w0p5_l0p28
XXP2_XS1 m1_7158_13030# m1_5190_15350# a_5524_16920# vss n_w1_l1
XXA1_XA_XD2_b a_7034_3120# m1_7206_2340# a_7034_3120# vss n_w4_l0p5_k1
XXP2_XCT_XC vss a_4588_13668# vss vss n_w3p54_l3p54
XXT0_XMB vss m1_2708_380# vbn_prb vss n_w2_l2
XXP2_XS2 m1_7702_12990# m1_7158_13030# a_4588_13668# vss n_w1_l1
XXP2_XDT_XON a_6672_14314# vss a_5524_16920# vss n_w0p5_l0p28
XXY1_XQA vdd vss sta m1_2236_8010# vss p_w1_l0p28
XXP2_XOP1 a_2800_17120# a_2800_17120# vdd vdd vss p_w2_l4
XXEP_XPM vdd vdd a_3136_4480# a_8248_5320# vss p_w1_l2
XXP2_XS3 m1_6968_15350# m1_7702_12990# pl_en vss n_w1_l1
XXP1_XDT_XNE m1_7150_9086# a_5524_11840# vsrcp vss n_w1_l0p28
XXY1_XQB vdd vss a_2592_8154# m1_2668_7940# vss p_w1_l0p28
XXP2_XOP2 a_5516_15680# a_2800_17120# vdd vdd vss p_w2_l4
XXP2_XDT_XOP vdd a_5524_16920# a_6672_14314# vdd vss p_w1_l0p28
XXS_XD_XPS vdd vdd m1_910_6150# vbp_st vss p_w1_l2
XXS_XD_XS2 vdd vdd m1_2122_6150# vbp_st vss p_w1_l2
XXP2_XDT_XQ a_6140_14314# vdd vdd a_6672_14314# vss p_w0p22_l4
XXT0_XME m1_1968_380# en m1_2708_380# vss n_w1_l0p28
XXP1_XDT_XPI m1_6716_11710# a_5268_9138# d1 vdd vss p_w1_l0p5
XXS_XD_XS3 vdd vdd m1_2792_6140# vbp_st vss p_w1_l2
XXY1_XNA sta d1 m1_2236_8010# vss n_w0p5_l0p28
XXP2_XOM1 a_2800_17120# m1_5190_15350# a_3136_4480# vss n_w2_l2
XXT1_XSW m1_7702_15650# sel1 abus vss n_w1_l0p28
XXT0_XMF m1_1968_380# vdd vs vss n_w4_l2
XXP2_XDT_XS2 vdd vdd m1_7930_16790# vbp_st vss p_w1_l2
XXP2_XDT_XPS vdd vdd m1_6716_16790# vbp_st vss p_w1_l2
XXP1_XTP vdd vdd a_4588_8588# a_5524_11840# vss p_w1_l2
XXP1_XDT_XNH m1_7150_9086# a_5268_9138# d1 vss n_w1_l1
XXY1_XNB a_2592_8154# d1 m1_2668_7940# vss n_w0p5_l0p28
XXP2_XOM2 m1_5190_15350# a_5516_15680# a_5516_15680# vss n_w2_l2
XXP2_XDT_XS3 vdd vdd m1_9090_16790# vbp_st vss p_w1_l2
XXP2_XHP vdd d2 hold a_5516_15680# vss p_w1_l0p28
XXL2_XD1_a a_874_16080# m1_2712_15340# a_874_16080# vss n_w4_l0p5_k1
XXP1_XDT_XNI vsrcp a_5268_9138# d1 vss n_w1_l0p5
XXS_XD_XP2 vdd a_1480_3834# a_728_3738# m1_2122_6150# vss p_w1_l0p28
XXR1_XRA vss m1_642_6980# vbn_leak vss n_w0p5_l0p6
XXB_XD1 d1_bsel vss a_2592_8154# vss n_w0p5_l0p28
XXA2_XB_XD1_a a_5366_18520# m1_7206_18030# a_5366_18520# vss n_w4_l0p5_k1
XXL2_XD1_b m1_2712_15340# a_874_16080# a_874_16080# vss n_w4_l0p5_k1
XXS_XD_XP3 vdd a_3272_6334# a_1480_3834# m1_2792_6140# vss p_w1_l0p28
XXR1_XRB m1_642_6980# m1_1080_6970# vbn_leak vss n_w0p5_l0p6
XXB_XD2 a_672_20034# vss a_2180_13234# vss n_w0p5_l0p28
XXL1_XD1_a a_874_11000# m1_1046_10270# a_874_11000# vss n_w4_l0p5_k1
XXS_XD_XK a_3272_6334# spk vdd vdd vss p_w0p22_l1
XXA2_XB_XD1_b m1_7206_18030# a_5366_18520# a_5366_18520# vss n_w4_l0p5_k1
XXA2_XA_XD1_a a_874_18520# m1_1046_17880# a_874_18520# vss n_w4_l0p5_k1
XXP2_XDT_XP2 vdd a_6140_14314# a_5268_14218# m1_7930_16790# vss p_w1_l0p28
XXS_XD_XN2 a_1480_3834# a_728_3738# vsrc vss n_w0p22_l2
XXP1_XTS a_4588_8588# a_5524_11840# m1_6494_7910# vss n_w1_l0p28
XXL1_XD1_b m1_1046_10270# a_874_11000# a_874_11000# vss n_w4_l0p5_k1
XXA1_XB_XP1 a_6680_5520# a_6680_5520# vdd vdd vss p_w2_l4
XXP2_XDT_XP3 vdd a_6672_14314# a_6140_14314# m1_9090_16790# vss p_w1_l0p28
XXS_XD_XN3 a_1480_3834# vsrc a_3272_6334# vss n_w0p5_l0p28
XXA2_XA_XD1_b m1_1046_17880# a_874_18520# a_874_18520# vss n_w4_l0p5_k1
XXY1_XPH vdd vdd m1_2112_9090# hold vss p_w1_l2
XXA1_XB_XP2 a_6934_4480# a_6680_5520# vdd vdd vss p_w2_l4
XXY2_XHL vdd d2 hold a_3098_16080# vss p_w1_l0p28
XXP2_XDT_XN2 a_6140_14314# a_5268_14218# vsrcp vss n_w0p22_l2
XXP1_XDT_XON a_6672_9234# vss a_5524_11840# vss n_w0p5_l0p28
XXWC a_318_18520# chain d1 vss n_w1_l0p28
XXA1_XB_XMT m1_4882_3700# vbn_ax vss vss n_w2_l4
XXA1_XB_XHO vdd d1 hold a_6934_4480# vss p_w1_l0p28
XXP2_XDT_XN3 a_6140_14314# vsrcp a_6672_14314# vss n_w0p5_l0p28
XXY2_XMR vss vss vdd vss n_w0p5_l0p28
XXP1_XS1 m1_7158_7910# m1_5432_10260# a_5524_11840# vss n_w1_l1
XXL2_XP1 a_488_17120# a_488_17120# vdd vdd vss p_w2_l4
XXA1_XB_XM1 a_6680_5520# a_4710_4480# vs vss n_w4_l0p5_k1
XXP1_XDT_XOP vdd a_5524_11840# a_6672_9234# vdd vss p_w1_l0p28
XXS_XR_XPC vdd a_6594_420# a_4096_6334# vdd vss p_w1_l0p28
XXP1_XS2 m1_7684_7940# m1_7158_7910# a_4588_8588# vss n_w1_l1
XXL2_XP2 a_3098_16080# a_488_17120# vdd vdd vss p_w2_l4
XXP1_XOP1 a_2800_12040# a_2800_12040# vdd vdd vss p_w2_l4
XXS_XR_Xi_XN spk vss a_4096_6334# vss n_w0p5_l0p28
XXA1_XB_XM2 a_6378_4480# a_6934_4480# a_6934_4480# vss n_w4_l0p5_k1
XXP1_XS3 m1_6968_10190# m1_7684_7940# pl_en vss n_w1_l1
XXP2_XOTA vss m1_6968_15350# vbn_leak vss n_w4_l2
XXL2_XMT m1_2712_15340# vbn_leak vss vss n_w2_l4
XXS_XL_XD1_a a_874_3120# m1_2722_2630# a_874_3120# vss n_w4_l0p5_k1
XXP1_XOP2 a_5516_10600# a_2800_12040# vdd vdd vss p_w2_l4
XXC1_XC vss vss d1 vss n_w7p07_l7p07
XXP1_XDT_XS2 vdd vdd m1_7930_11710# vbp_st vss p_w1_l2
XXP1_XDT_XPS vdd vdd m1_6716_11710# vbp_st vss p_w1_l2
XXP2_XOTB m1_6968_15350# vss vbn_leak vss n_w4_l2
XXL2_XM1 a_488_17120# a_874_16080# el vss n_w4_l0p5_k1
XXS_XL_XD1_b m1_2722_2630# a_874_3120# a_874_3120# vss n_w4_l0p5_k1
XXT2_XMB vss m1_8466_10270# vbn_prb vss n_w2_l2
XXS_XR_Xi_XP vdd a_4096_6334# spk vdd vss p_w1_l0p28
XXR2_XR1 m1_4568_19890# m1_2956_19890# vbn_leak vss n_w0p5_l1p5
XXA2_XB_XP1 a_3212_19360# a_3212_19360# vdd vdd vss p_w2_l4
XXP1_XDT_XS3 vdd vdd m1_9090_11710# vbp_st vss p_w1_l2
XXL2_XM2 a_2542_16080# a_3098_16080# a_3098_16080# vss n_w4_l0p5_k1
XXP1_XOM1 a_2800_12040# m1_5432_10260# a_3136_4480# vss n_w2_l2
XXT0_XSW m1_1968_380# sel0 abus vss n_w1_l0p28
XXR2_XR2 m1_6190_19900# m1_4568_19890# vbn_leak vss n_w0p5_l1p5
XXR2_XP0 vdd a_3098_16080# tb0 m1_8326_19030# vss p_w1_l0p28
XXA2_XB_XP2 a_7590_18520# a_3212_19360# vdd vdd vss p_w2_l4
XXP1_XOM2 m1_5432_10260# a_5516_10600# a_5516_10600# vss n_w2_l2
XXR2_XR3 m1_7790_19900# m1_6190_19900# vbn_leak vss n_w0p5_l1p5
XXR2_XP1 vdd a_3098_16080# tb1 m1_7130_19630# vss p_w1_l0p28
XXA2_XB_XMT m1_7206_18030# vbn_ax vss vss n_w2_l4
XXA2_XB_XHO vdd a_318_18520# hold a_7590_18520# vss p_w1_l0p28
XXP1_XDT_XP2 vdd a_6140_9234# a_5268_9138# m1_7930_11710# vss p_w1_l0p28
XXP1_XHP vdd d1 hold a_5516_10600# vss p_w1_l0p28
XXT2_XME m1_7702_10190# en m1_8466_10270# vss n_w1_l0p28
XXA1_XB_XD1_a a_4710_4480# m1_4882_3700# a_4710_4480# vss n_w4_l0p5_k1
XXR2_XN0 tb0 m1_8326_19030# a_488_17120# vss n_w0p5_l0p28
XXR2_XP2 vdd a_3098_16080# tb2 m1_5504_19890# vss p_w1_l0p28
XXA2_XB_XM1 a_3212_19360# a_5366_18520# d2 vss n_w4_l0p5_k1
XXP1_XDT_XP3 vdd a_6672_9234# a_6140_9234# m1_9090_11710# vss p_w1_l0p28
XXA1_XB_XD1_b m1_4882_3700# a_4710_4480# a_4710_4480# vss n_w4_l0p5_k1
XXT2_XMF m1_7702_10190# vdd d1 vss n_w4_l2
XXA1_XA_XD1_a a_5366_3120# m1_7206_2340# a_5366_3120# vss n_w4_l0p5_k1
XXR2_XN1 tb1 m1_7130_19630# a_488_17120# vss n_w0p5_l0p28
XXR2_XP3 vdd a_3098_16080# tb3 m1_3902_19900# vss p_w1_l0p28
XXA2_XB_XM2 a_7034_18520# a_7590_18520# a_7590_18520# vss n_w4_l0p5_k1
XXP1_XDT_XN2 a_6140_9234# a_5268_9138# vsrcp vss n_w0p22_l2
XXI_XN chain vss a_1892_3934# vss n_w0p5_l0p28
XXR2_XLT m1_7790_19900# vdd vbn_leak vss n_w0p5_l3
XXR2_XL0 m1_7790_19900# m1_8326_19030# vbn_leak vss n_w0p5_l3
XXR2_XN2 tb2 m1_5504_19890# a_488_17120# vss n_w0p5_l0p28
XXA1_XA_XD1_b m1_7206_2340# a_5366_3120# a_5366_3120# vss n_w4_l0p5_k1
XXA1_XA_XP1 a_2800_5520# a_2800_5520# vdd vdd vss p_w2_l4
XXY2_XWA m1_2862_14560# vbp_syn vdd m1_2112_14220# vss p_w2_l4
XXP1_XDT_XN3 a_6140_9234# vsrcp a_6672_9234# vss n_w0p5_l0p28
XXA1_XA_XP2 a_7590_3120# a_2800_5520# vdd vdd vss p_w2_l4
XXR2_XL1 m1_6190_19900# m1_7130_19630# vbn_leak vss n_w0p5_l3
XXB_XI_XN d1_bsel vss a_672_20034# vss n_w0p5_l0p28
XXR2_XN3 tb3 m1_3902_19900# a_488_17120# vss n_w0p5_l0p28
XXY2_XWB m1_2678_13100# vbp_syn vdd m1_2112_14220# vss p_w2_l4
XXY1_XHL vdd d1 hold a_3098_11000# vss p_w1_l0p28
XXEP_XN el a_3136_4480# a_3136_4480# vss n_w4_l1
XXS_XHL vdd vs hold a_3098_3120# vss p_w1_l0p28
XXR2_XL2 m1_4568_19890# m1_5504_19890# vbn_leak vss n_w0p5_l3
XXA1_XA_XMT m1_7206_2340# vbn_ax vss vss n_w2_l4
XXA1_XA_XHO vdd vs hold a_7590_3120# vss p_w1_l0p28
XXI_XP vdd a_1892_3934# chain vdd vss p_w1_l0p28
XXY1_XMR vss vss vdd vss n_w0p5_l0p28
XXL2_XD2_a m1_2712_15340# a_2542_16080# a_2542_16080# vss n_w4_l0p5_k1
XXL1_XP1 a_488_12040# a_488_12040# vdd vdd vss p_w2_l4
XXA1_XA_XM1 a_2800_5520# a_5366_3120# d1 vss n_w4_l0p5_k1
XXR2_XL3 m1_2956_19890# m1_3902_19900# vbn_leak vss n_w0p5_l3
XXB_XI_XP vdd a_672_20034# d1_bsel vdd vss p_w1_l0p28
XXS_XC_XC vss vss vs vss n_w7p07_l7p07
XXA2_XB_XD2_a m1_7206_18030# a_7034_18520# a_7034_18520# vss n_w4_l0p5_k1
XXP2_XTI vss m1_6494_13030# vbn_leak vss n_w1_l4
XXL2_XD2_b a_2542_16080# m1_2712_15340# a_2542_16080# vss n_w4_l0p5_k1
XXL1_XP2 a_3098_11000# a_488_12040# vdd vdd vss p_w2_l4
XXL1_XD2_a m1_1046_10270# a_2542_11000# a_2542_11000# vss n_w4_l0p5_k1
XXA1_XA_XM2 a_7034_3120# a_7590_3120# a_7590_3120# vss n_w4_l0p5_k1
XXA2_XB_XD2_b a_7034_18520# m1_7206_18030# a_7034_18520# vss n_w4_l0p5_k1
XXA2_XA_XD2_a m1_1046_17880# a_2542_18520# a_2542_18520# vss n_w4_l0p5_k1
XXP1_XOTA vss m1_6968_10190# vbn_leak vss n_w4_l2
XXL1_XMT m1_1046_10270# vbn_leak vss vss n_w2_l4
XXL1_XD2_b a_2542_11000# m1_1046_10270# a_2542_11000# vss n_w4_l0p5_k1
XXS_XD_Xi4_XN a_3272_6334# vss spk vss n_w0p5_l0p28
XXS_XL_XP1 a_488_5520# a_488_5520# vdd vdd vss p_w2_l4
XXA2_XA_XD2_b a_2542_18520# m1_1046_17880# a_2542_18520# vss n_w4_l0p5_k1
XXP1_XOTB m1_6968_10190# vss vbn_leak vss n_w4_l2
XXL1_XM1 a_488_12040# a_874_11000# el vss n_w4_l0p5_k1
XXT1_XMB vss m1_8466_15350# vbn_prb vss n_w2_l2
XXS_XL_XP2 a_3098_3120# a_488_5520# vdd vdd vss p_w2_l4
XXY2_XQA vdd vss a_2180_13234# m1_2862_14560# vss p_w1_l0p28
XXC2_XC vss vss d2 vss n_w7p07_l7p07
XXS_XR_XCR_XC vss a_6594_420# vss vss n_w3p54_l3p54
XXR1_XR1 m1_2712_6970# m1_1080_6970# vbn_leak vss n_w0p5_l1p5
XXA2_XA_XP1 a_488_19360# a_488_19360# vdd vdd vss p_w2_l4
C0 spk a_5366_3120# 0.22727f
C1 vsrcp a_4588_8588# 0.21934f
C2 m1_7130_19630# a_3098_16080# 0.43611f
C3 a_8248_5320# a_3098_11000# 0.00912f
C4 m1_5432_10260# sta 0.05193f
C5 m1_9090_16790# a_318_18520# 0.00458f
C6 m1_2668_7940# sta 0.10139f
C7 vbn_leak vsrcp 0.18926f
C8 ta2 sta 0
C9 vbn_ref a_4096_6334# 0.3296f
C10 m1_7150_9086# a_488_12040# 0
C11 ta3 m1_7206_18030# 0.05601f
C12 a_2800_5520# vs 0.13597f
C13 vsrc a_318_18520# 0.78638f
C14 a_7034_18520# m1_7206_18030# 0.72111f
C15 a_6594_420# m1_2792_6140# 0
C16 a_2542_11000# sta 0.0075f
C17 sta a_4588_13668# 0.00909f
C18 a_3272_6334# a_318_18520# 0.28996f
C19 m1_7206_2340# a_6378_4480# 0.00175f
C20 vbp_st a_5516_15680# 0
C21 vsrc a_728_3738# 0.20398f
C22 a_2592_8154# vbp_st 0.10218f
C23 hold a_2180_13234# 0.9457f
C24 sel0 vbn_ax 0.04083f
C25 vbp_st en 0.37777f
C26 m1_5504_19890# ta0 0.00123f
C27 a_3272_6334# a_728_3738# 0.09442f
C28 a_6140_14314# ta2 0.01508f
C29 a_6140_9234# m1_9090_11710# 0.03128f
C30 vbn_leak a_3098_18520# 0.00745f
C31 a_6594_420# a_2542_3120# 0.0116f
C32 ta1 ta3 0.21453f
C33 vsrcp el 0.30532f
C34 vdd ta0 0.72756f
C35 a_7590_18520# a_5268_14218# 0
C36 a_6140_14314# a_4588_13668# 0.00759f
C37 a_7034_18520# ta1 0.0379f
C38 en m1_1968_380# 0.01856f
C39 m1_2668_7940# m1_1046_10270# 0
C40 a_3136_4480# m1_2678_13100# 0
C41 a_2592_8154# a_2542_18520# 0.0179f
C42 m1_2792_6140# ta1 0
C43 vs mreset 0.06088f
C44 ta2 m1_7130_19630# 0.00465f
C45 vsrcp chain 0.15942f
C46 a_5524_11840# ta1 0.04265f
C47 m1_1046_10270# a_2542_11000# 0.24461f
C48 a_874_11000# d1 0.02064f
C49 tb1 a_3098_16080# 0.31969f
C50 vsrcp m1_2062_6980# 0.0058f
C51 ta3 m1_3902_19900# 0.05242f
C52 stb a_672_20034# 0.8583f
C53 hold m1_6494_13030# 0.00122f
C54 a_5366_3120# a_7034_3120# 0.00274f
C55 d1 a_6378_4480# 0.46761f
C56 a_3212_19360# vbn_ax 0.31363f
C57 a_7034_18520# m1_3902_19900# 0.05563f
C58 a_874_3120# vdd 0.19827f
C59 m1_7702_15650# ta0 0
C60 a_6934_4480# vdd 0.28936f
C61 d2 a_5516_15680# 0.23879f
C62 a_3212_19360# a_488_17120# 0.0372f
C63 a_1480_3834# vbp_st 0.02174f
C64 m1_5286_6830# a_488_12040# 0.1293f
C65 a_5524_16920# vbp_st 0.23413f
C66 pl_en a_5366_18520# 0.0272f
C67 a_3136_4480# a_488_12040# 0.06867f
C68 m1_6716_16790# a_5268_14218# 0.0231f
C69 hold vbp_syn 0.53848f
C70 sel1 m1_7930_16790# 0.00165f
C71 a_2592_8154# d2 0.12034f
C72 a_1892_3934# a_1480_3834# 0.05177f
C73 a_5268_9138# a_4588_8588# 0.22547f
C74 d2 en 0.25912f
C75 m1_2112_9090# vdd 0.26471f
C76 m1_4882_3700# a_8248_5320# 0.00456f
C77 m1_5286_6830# m1_2712_6970# 0
C78 vbn_leak a_5268_9138# 0.72355f
C79 tb2 ta0 0
C80 a_2592_8154# a_3098_11000# 0.25435f
C81 sel1 a_318_18520# 0.00967f
C82 a_2592_8154# a_874_18520# 0.0124f
C83 spk vbn_ref 0.1566f
C84 vs hold 0.24888f
C85 a_3098_11000# en 0.1679f
C86 vbn_leak a_4588_8588# 0.44169f
C87 m1_6968_10190# ta1 0.04882f
C88 vbn_prb m1_8466_10270# 0.1764f
C89 a_672_20034# m1_7206_18030# 0
C90 m1_2792_6140# vsrc 0.05966f
C91 tb3 a_6672_14314# 0.00153f
C92 m1_2708_380# en 0.02156f
C93 a_3272_6334# m1_2792_6140# 0.06436f
C94 a_5516_15680# sta 0
C95 a_2180_13234# vdd 2.03921f
C96 vsrcp mreset 0.02676f
C97 m1_2236_8010# a_728_3738# 0
C98 a_5268_9138# el 0.1199f
C99 abus d1 0.15595f
C100 vsrc a_2542_3120# 0.0031f
C101 a_3136_4480# a_318_18520# 3.12658f
C102 a_2592_8154# sta 0.45882f
C103 sta en 0.23906f
C104 m1_1046_17880# a_2542_18520# 0.22662f
C105 ta1 a_672_20034# 0
C106 a_488_12040# m1_2678_13100# 0.00505f
C107 d2 a_5524_16920# 0.18537f
C108 a_3272_6334# a_2542_3120# 0.23655f
C109 vbn_leak a_7590_3120# 0.00392f
C110 m1_7150_9086# ta3 0.00769f
C111 vbn_leak el 4.95152f
C112 sel0 m1_7206_2340# 0.01755f
C113 a_5268_9138# chain 0.05288f
C114 vbp_st m1_7206_18030# 0.00885f
C115 chain a_4588_8588# 0.05952f
C116 a_5524_16920# a_3098_11000# 0
C117 a_6140_14314# a_5516_15680# 0.00254f
C118 a_1892_3934# a_6594_420# 0.1026f
C119 m1_6940_14170# m1_6968_15350# 0.01238f
C120 vreset a_6594_420# 0.0371f
C121 a_5268_9138# m1_2062_6980# 0
C122 d1 a_5516_10600# 0.15869f
C123 abus m1_8466_15350# 0
C124 vbn_leak chain 0.29205f
C125 a_2592_8154# a_6140_14314# 0.41153f
C126 a_6594_420# m1_1968_380# 0.00191f
C127 m1_2062_6980# a_4588_8588# 0.09307f
C128 a_5524_11840# m1_7150_9086# 0.18314f
C129 a_6140_14314# en 0.21938f
C130 d1_bsel a_2180_13234# 0.07372f
C131 a_672_20034# m1_3902_19900# 0.15274f
C132 vbp_st m1_642_6980# 0.02048f
C133 vbn_leak m1_2062_6980# 0.44715f
C134 vbn_ref a_7034_3120# 0
C135 a_2180_13234# m1_2112_14220# 0.19927f
C136 a_2592_8154# m1_1046_10270# 0.2073f
C137 a_5366_18520# a_4588_13668# 0
C138 m1_1046_17880# d2 0.26736f
C139 m1_5504_19890# vbp_syn 0
C140 a_7590_3120# el 0.23117f
C141 hold vsrcp 0.01071f
C142 a_7590_18520# ta0 0.00744f
C143 a_2592_8154# m1_7130_19630# 0.10149f
C144 a_874_18520# stb 0
C145 m1_1080_6970# vbp_st 0.28405f
C146 vbp_st ta1 0.06294f
C147 vbp_syn vdd 2.37967f
C148 en m1_7130_19630# 0
C149 m1_3676_6970# d1 0
C150 a_5524_16920# sta 0.23481f
C151 ta3 sel1 0.06231f
C152 vsrcp a_6672_9234# 0.08968f
C153 m1_1046_17880# a_874_18520# 0.23134f
C154 a_2800_5520# vbn_leak 0.09842f
C155 a_874_11000# a_2542_11000# 0.01302f
C156 pl_en a_5516_10600# 0.00704f
C157 a_7034_18520# sel1 0.02085f
C158 m1_4882_3700# en 0.04948f
C159 a_7590_3120# chain 0.15745f
C160 chain el 0.20675f
C161 abus a_3098_16080# 0.00433f
C162 sel0 d1 0
C163 vs vdd 1.55668f
C164 vbn_prb a_6140_9234# 0.09215f
C165 m1_2712_15340# a_3098_16080# 0.27537f
C166 d2 m1_7206_18030# 0.00179f
C167 vbp_st m1_3902_19900# 0.02611f
C168 m1_6968_10190# m1_7150_9086# 0.02228f
C169 pl_en m1_3676_6970# 0
C170 a_6140_14314# a_5524_16920# 0.18956f
C171 hold a_3098_18520# 0.06269f
C172 stb sta 0.33157f
C173 m1_5286_6830# ta3 0.17913f
C174 chain m1_2062_6980# 0.1084f
C175 a_3136_4480# ta3 0.08007f
C176 a_2800_17120# a_2180_13234# 0.43267f
C177 m1_6716_16790# ta0 0.00135f
C178 d1_bsel vbp_syn 0.0566f
C179 vbn_prb vbn_ax 0.39061f
C180 a_2800_5520# a_7590_3120# -0.01518f
C181 a_2800_5520# el 0.10135f
C182 m1_5286_6830# m1_2792_6140# 0.00744f
C183 m1_9090_16790# vbp_st 0.00366f
C184 vbn_leak mreset 0.27295f
C185 vbp_syn m1_2112_14220# 0.30043f
C186 vbn_prb a_488_17120# 0
C187 a_5524_16920# m1_7130_19630# 0
C188 a_3136_4480# m1_2792_6140# 0.26831f
C189 tb3 ta0 0.00276f
C190 m1_2708_380# a_6594_420# 0
C191 vbp_st vsrc 0.11131f
C192 a_2800_5520# chain 0.20675f
C193 m1_4282_6970# m1_3676_6970# 0.03845f
C194 a_3136_4480# a_5524_11840# 0.02893f
C195 d2 ta1 0.08774f
C196 a_2592_8154# tb1 0.14295f
C197 m1_2862_14560# a_4588_13668# 0
C198 a_3272_6334# vbp_st 0.04204f
C199 a_2800_5520# m1_2062_6980# 0
C200 vreset vsrc 0.03644f
C201 ta1 a_3098_11000# 0.13619f
C202 a_5268_9138# m1_7702_10190# 0.2121f
C203 a_3136_4480# a_2542_3120# 0.00134f
C204 sta m1_7206_18030# 0.04316f
C205 vsrc m1_1968_380# 0.02404f
C206 a_1892_3934# a_3272_6334# 0.06832f
C207 stb m1_7130_19630# 0.00251f
C208 a_3272_6334# vreset 0.15737f
C209 vbn_leak m1_7702_10190# 0.07702f
C210 a_7590_18520# a_2180_13234# 0.00452f
C211 d2 m1_3902_19900# 0
C212 a_3272_6334# m1_1968_380# 0
C213 mreset el 0.10317f
C214 m1_2712_15340# a_4588_13668# 0
C215 a_3212_19360# pl_en 0
C216 vbn_prb m1_2722_2630# 0
C217 a_7590_3120# mreset 0.06228f
C218 m1_5432_10260# a_5516_10600# 0.14667f
C219 a_5268_9138# hold 0.25437f
C220 pl_en m1_5942_6980# 0
C221 a_8248_5320# abus 0.00851f
C222 ta2 a_5516_10600# 0
C223 hold a_4588_8588# 0.1482f
C224 vsrcp vdd 0.20828f
C225 a_2800_17120# vbp_syn 0.20291f
C226 a_2180_13234# a_488_19360# 0.18677f
C227 m1_5190_15350# m1_6968_15350# 0
C228 a_488_5520# m1_2722_2630# 0
C229 chain mreset 0
C230 a_5268_9138# a_6672_9234# 0.16422f
C231 vbn_leak hold 1.02524f
C232 a_4588_8588# a_6672_9234# 0
C233 a_5516_10600# a_4588_13668# 0.00191f
C234 a_5516_15680# a_5366_18520# 0.00338f
C235 ta1 sta 0
C236 a_728_3738# a_318_18520# 0
C237 m1_1080_6970# sta 0
C238 m1_6968_10190# a_3136_4480# 0.03234f
C239 pl_en m1_6940_14170# 0.05613f
C240 sel1 a_672_20034# 0.03541f
C241 m1_2722_2630# a_4096_6334# 0
C242 vbn_leak a_6672_9234# 0.07323f
C243 a_2592_8154# a_5366_18520# 0.20495f
C244 a_2180_13234# a_2542_16080# 0.07066f
C245 en a_5366_18520# 0.05076f
C246 vs a_5366_3120# 0.09148f
C247 a_5524_16920# tb1 0
C248 m1_4282_6970# m1_5942_6980# 0
C249 ta2 m1_3676_6970# 0.26868f
C250 m1_7130_19630# m1_7206_18030# 0.00515f
C251 a_4710_4480# m1_2722_2630# 0.00284f
C252 a_2180_13234# m1_6716_16790# 0.03501f
C253 vdd a_3098_18520# 0.35175f
C254 vsrcp m1_7702_15650# 0
C255 sta m1_3902_19900# 0.00832f
C256 a_6140_14314# ta1 0.00665f
C257 a_2800_5520# mreset 0.09941f
C258 ta3 a_488_12040# 0.11469f
C259 en a_6378_4480# 0.04029f
C260 hold a_7590_3120# 0.02695f
C261 hold el 0.0952f
C262 a_6680_5520# vbn_ax 0
C263 a_7590_18520# vbp_syn 0.00838f
C264 tb3 a_2180_13234# 0
C265 m1_910_6150# vs 0.01863f
C266 a_6672_9234# el 0.01573f
C267 vbp_st sel1 0.02457f
C268 a_8248_5320# m1_3676_6970# 0
C269 m1_2708_380# vsrc 0.06455f
C270 hold chain 0.24112f
C271 a_5524_11840# a_488_12040# 0.01764f
C272 ta1 m1_7130_19630# 0.01495f
C273 a_8248_5320# sel0 0.0175f
C274 m1_2708_380# a_3272_6334# 0.00148f
C275 spk vbn_ax 0.08504f
C276 vbn_prb m1_7206_2340# 0.16731f
C277 chain a_6672_9234# 0.03735f
C278 m1_2712_6970# m1_2792_6140# 0.03366f
C279 vbn_ax a_5268_14218# 0.0014f
C280 a_5524_16920# a_5366_18520# 0
C281 m1_7790_19900# ta0 0
C282 m1_2236_8010# vbp_st 0.0011f
C283 hold m1_2062_6980# 0.38855f
C284 m1_7158_13030# m1_6968_15350# 0.02564f
C285 ta3 m1_7930_16790# 0.00177f
C286 a_488_17120# a_5268_14218# 0.01493f
C287 a_2542_16080# vbp_syn 0.0036f
C288 m1_8326_19030# a_6672_14314# 0
C289 d1_bsel a_3098_18520# 0.00257f
C290 a_6672_14314# vbn_ax 0
C291 m1_2062_6980# a_6672_9234# 0
C292 m1_7150_9086# a_3098_11000# 0
C293 m1_5286_6830# vbp_st 0.13293f
C294 m1_3902_19900# m1_7130_19630# 0.15414f
C295 a_3098_3120# m1_2722_2630# 0.06438f
C296 ta2 m1_5942_6980# 0.15405f
C297 vsrcp sel2 0.02684f
C298 a_3136_4480# vbp_st 0.77677f
C299 a_6140_14314# m1_9090_16790# 0.05449f
C300 a_488_17120# a_6672_14314# 0.00495f
C301 ta3 a_318_18520# 0.02964f
C302 m1_7206_2340# a_4096_6334# 0.01832f
C303 a_2800_5520# hold 0.0022f
C304 tb1 m1_7206_18030# 0.0054f
C305 a_5268_9138# vdd 0.52903f
C306 vbn_ax m1_2956_19890# 0
C307 stb a_5366_18520# 0
C308 a_1892_3934# a_3136_4480# 0.0883f
C309 a_7034_18520# a_318_18520# 0.00995f
C310 a_3136_4480# vreset 0
C311 vdd a_4588_8588# 0.31132f
C312 ta2 m1_6940_14170# 0.03511f
C313 a_6140_14314# vsrc 0
C314 vbn_leak m1_5504_19890# 0.27024f
C315 abus en 0.00398f
C316 m1_2792_6140# a_318_18520# 0.02108f
C317 m1_6968_10190# a_488_12040# 0.02848f
C318 vbn_leak vdd 3.696f
C319 m1_5190_15350# d1 0
C320 a_5524_11840# a_318_18520# 0
C321 m1_6940_14170# a_4588_13668# 0.00961f
C322 spk m1_2722_2630# 0.018f
C323 d2 sel1 0.16835f
C324 m1_2792_6140# a_728_3738# 0.0106f
C325 vbn_prb d1 0.07591f
C326 a_318_18520# a_2542_3120# 0.3187f
C327 vs vbn_ref 0.46838f
C328 a_2592_8154# a_5516_10600# 0.11353f
C329 m1_4882_3700# vsrc 0.20993f
C330 en a_5516_10600# 0.03786f
C331 a_2800_17120# a_3098_18520# 0.01205f
C332 m1_6968_15350# a_5268_14218# 0.0764f
C333 d1 a_4096_6334# 0.14226f
C334 a_488_5520# m1_2122_6150# 0.01019f
C335 a_5366_18520# m1_7206_18030# 0.28757f
C336 vbn_ax a_7034_3120# 0
C337 vdd el 1.42206f
C338 pl_en m1_5190_15350# 0.02953f
C339 vbn_leak m1_7702_15650# 0.00106f
C340 a_7590_3120# vdd 0.35463f
C341 m1_2236_8010# a_3098_11000# 0.00195f
C342 vbn_prb m1_8466_15350# 0.19936f
C343 tb0 a_6672_14314# 0
C344 a_6672_14314# m1_6968_15350# 0.04948f
C345 d2 a_3136_4480# 0.21736f
C346 a_672_20034# m1_4568_19890# 0.13384f
C347 chain m1_5504_19890# 0.00469f
C348 a_4710_4480# d1 0.01158f
C349 m1_3902_19900# tb1 0.03968f
C350 vbn_leak d1_bsel 0.16533f
C351 a_5524_16920# abus 0.05583f
C352 en m1_3676_6970# 0.03294f
C353 m1_5286_6830# a_3098_11000# 0.67583f
C354 vbn_leak m1_2112_14220# 0.00104f
C355 chain vdd 0.95781f
C356 a_3136_4480# a_3098_11000# 0.0682f
C357 sel1 sta 0.44541f
C358 m1_2470_19900# a_672_20034# 0.00196f
C359 vbn_leak tb2 0.01842f
C360 sel0 en 0.07525f
C361 m1_2062_6980# vdd 0.2281f
C362 m1_5190_15350# a_3098_16080# 0.09323f
C363 m1_7702_10190# a_6672_9234# 0.30523f
C364 a_5268_9138# sel2 0
C365 m1_2236_8010# sta 0.21412f
C366 vbn_prb a_3098_16080# 0.00598f
C367 spk m1_7206_2340# 0.18632f
C368 a_6140_9234# ta0 0.02633f
C369 vbp_st a_488_12040# 0.06882f
C370 a_7034_18520# ta3 0.02114f
C371 a_6140_14314# sel1 0.16904f
C372 a_2800_5520# vdd 1.63478f
C373 m1_2792_6140# ta3 0.01084f
C374 vbn_leak sel2 0.39868f
C375 m1_2112_14220# el 0.03797f
C376 a_488_19360# a_3098_18520# 0.01063f
C377 a_672_20034# a_318_18520# 0
C378 m1_4282_6970# a_4096_6334# 0.00173f
C379 hold a_6672_9234# 0.00964f
C380 a_3136_4480# sta 0.08487f
C381 m1_6190_19900# ta0 0.02851f
C382 m1_2712_6970# vbp_st 0.10109f
C383 a_5524_11840# ta3 0.04737f
C384 a_2800_17120# vbn_leak 0.1952f
C385 d1_bsel chain 0.00882f
C386 vsrcp vbn_ref 0.0325f
C387 vbn_leak a_5366_3120# 0
C388 pl_en m1_7158_13030# 0.00148f
C389 d2 m1_2678_13100# 0.13831f
C390 sel1 m1_7130_19630# 0
C391 vbn_ax ta0 0.00354f
C392 a_2592_8154# a_3212_19360# 0.6087f
C393 a_3098_3120# d1 0.07455f
C394 a_3212_19360# en 0.00301f
C395 a_488_17120# ta0 0.03005f
C396 a_3098_11000# m1_2678_13100# 0
C397 a_6680_5520# d1 0.00218f
C398 m1_5942_6980# en 0.00706f
C399 vbp_st m1_7930_16790# 0.04584f
C400 a_6594_420# abus 0.32983f
C401 a_6140_14314# a_3136_4480# 0.00131f
C402 m1_2470_19900# a_2542_18520# 0
C403 a_2800_12040# d1 0.06075f
C404 ta2 m1_5190_15350# 0.01814f
C405 m1_7158_13030# m1_7702_12990# 0.09347f
C406 a_2592_8154# m1_6940_14170# 0.00195f
C407 sel2 el 0.02317f
C408 ta2 vbn_prb 0
C409 vdd mreset 0.29423f
C410 spk d1 0.26749f
C411 m1_910_6150# vbn_leak 0.00144f
C412 a_874_16080# a_2180_13234# 0.11297f
C413 vbp_st a_318_18520# 0.42043f
C414 m1_1046_10270# a_3136_4480# 0
C415 m1_5190_15350# a_4588_13668# 0.93999f
C416 a_1892_3934# a_318_18520# 0.10279f
C417 d2 a_488_12040# 0.08798f
C418 vreset a_318_18520# 0
C419 a_5366_3120# el 0.01345f
C420 a_7590_3120# a_5366_3120# 0.00253f
C421 vbn_ax a_6934_4480# 0.01409f
C422 vbp_st a_728_3738# 0.08389f
C423 m1_6968_10190# ta3 0.17922f
C424 a_7590_18520# vbn_leak 0.00734f
C425 a_2800_17120# chain 0
C426 a_2542_18520# a_318_18520# 0.07208f
C427 a_2800_12040# pl_en 0
C428 a_1892_3934# a_728_3738# 0
C429 vsrc a_6378_4480# 0
C430 m1_4882_3700# a_3136_4480# 0.34874f
C431 a_3098_11000# a_488_12040# 1.26056f
C432 chain a_5366_3120# 0.00441f
C433 m1_7206_2340# a_7034_3120# 0.55419f
C434 vbn_leak a_488_19360# 0.0059f
C435 a_8248_5320# vbn_prb 0.24885f
C436 m1_6968_10190# a_5524_11840# 0.08057f
C437 m1_7702_10190# vdd 0.06904f
C438 a_3098_3120# m1_4282_6970# 0.11683f
C439 pl_en a_5268_14218# 0.11336f
C440 m1_6716_11710# ta0 0.00172f
C441 a_6680_5520# m1_4282_6970# 0
C442 ta0 m1_6968_15350# 0.02472f
C443 a_6672_14314# m1_8466_15350# 0.02691f
C444 a_6672_14314# pl_en 0.24448f
C445 a_5524_16920# m1_6940_14170# 0.22761f
C446 vbn_leak a_2542_16080# 0
C447 d2 m1_7930_16790# 0.0033f
C448 hold m1_5504_19890# 0.00526f
C449 ta1 a_5516_10600# 0
C450 m1_6190_19900# a_2180_13234# 0
C451 a_6594_420# sel0 0.39478f
C452 a_8248_5320# a_4096_6334# 0
C453 a_874_3120# m1_2722_2630# 0.20306f
C454 a_7034_18520# a_672_20034# 0
C455 hold vdd 4.23644f
C456 sta a_488_12040# 0.00805f
C457 a_2800_5520# a_5366_3120# 0
C458 a_3212_19360# stb 0.01639f
C459 ta2 m1_7158_13030# 0.02821f
C460 vbn_leak m1_6716_16790# 0.00287f
C461 d2 a_318_18520# 0.57907f
C462 vdd a_6672_9234# 0.82058f
C463 a_2180_13234# vbn_ax 0.00332f
C464 m1_1046_17880# a_3212_19360# 0.05996f
C465 a_6672_14314# m1_7702_12990# 0.00914f
C466 a_5268_14218# a_3098_16080# 0.21204f
C467 a_488_17120# a_2180_13234# 0.56537f
C468 a_7590_18520# chain 0.00555f
C469 m1_7158_13030# a_4588_13668# 0.07628f
C470 d1 a_7034_3120# 0
C471 ta1 m1_3676_6970# 0.12322f
C472 a_874_18520# a_318_18520# 0.38473f
C473 vbn_leak tb3 0.57499f
C474 vbn_leak vbn_ref 0.1224f
C475 m1_1080_6970# m1_3676_6970# 0
C476 m1_6494_5850# d1 0.16294f
C477 a_6672_14314# a_3098_16080# 0.02976f
C478 abus vsrc 0.12132f
C479 a_2542_16080# el 0
C480 sel2 mreset 3.95824f
C481 hold m1_7702_15650# 0
C482 vbp_st ta3 0.17072f
C483 sel1 a_5366_18520# 0
C484 m1_2668_7940# a_3098_3120# 0.00412f
C485 a_3272_6334# abus 0
C486 m1_7684_7940# vsrcp 0.00771f
C487 ta2 a_3098_3120# 0
C488 a_7034_18520# vbp_st 0.00128f
C489 hold d1_bsel 0.12861f
C490 a_5366_3120# mreset 0.04739f
C491 ta2 a_6680_5520# 0.00179f
C492 vbp_st m1_2792_6140# 0.23881f
C493 m1_1046_10270# a_488_12040# 0.11559f
C494 hold m1_2112_14220# 0.03514f
C495 m1_5432_10260# a_2800_12040# -0.01766f
C496 sta a_318_18520# 0.01944f
C497 m1_2668_7940# a_2800_12040# 0
C498 a_1892_3934# m1_2792_6140# 0.06133f
C499 a_5524_11840# vbp_st 0.20359f
C500 chain m1_6716_16790# 0
C501 m1_4568_19890# m1_7130_19630# 0
C502 vbn_ref el 0.04756f
C503 hold tb2 0
C504 a_7590_3120# vbn_ref 0
C505 m1_5190_15350# a_5516_15680# 0.01237f
C506 m1_7702_10190# sel2 0.03119f
C507 a_2800_12040# a_4588_13668# 0.00126f
C508 vbn_ax vbp_syn 0.19483f
C509 a_2592_8154# m1_5190_15350# 0
C510 a_2800_12040# a_2542_11000# 0.01019f
C511 ta2 a_5268_14218# 0.06547f
C512 a_6140_14314# m1_7930_16790# 0.0141f
C513 a_488_17120# vbp_syn 0.03363f
C514 a_2180_13234# m1_6968_15350# 0
C515 m1_5190_15350# en 0.05447f
C516 a_8248_5320# a_6680_5520# 0
C517 a_1892_3934# a_2542_3120# 0.00731f
C518 a_6934_4480# m1_7206_2340# 0.00191f
C519 a_5268_14218# a_4588_13668# 0.04687f
C520 a_2592_8154# vbn_prb 0
C521 m1_4282_6970# m1_6494_5850# 0
C522 ta2 a_6672_14314# 0.00232f
C523 vbn_prb en 0.26154f
C524 a_6140_14314# a_318_18520# 0.1021f
C525 vs vbn_ax 0.00127f
C526 ta1 m1_5942_6980# 0.05495f
C527 a_2542_3120# m1_1968_380# 0
C528 m1_5286_6830# a_6378_4480# 0
C529 ta0 d1 0.11149f
C530 a_3136_4480# a_6378_4480# 0.17304f
C531 sel2 a_6672_9234# 0.03838f
C532 a_6672_14314# a_4588_13668# 0.06275f
C533 m1_5504_19890# vdd 0.28836f
C534 sel0 vsrc 0.29532f
C535 a_8248_5320# spk 0.35684f
C536 ta1 m1_6940_14170# 0.03814f
C537 a_2800_17120# hold 0.48665f
C538 d2 ta3 0.15782f
C539 en a_4096_6334# 0.15329f
C540 a_318_18520# m1_7130_19630# 0.02344f
C541 d2 a_7034_18520# 0.00165f
C542 a_3212_19360# m1_3902_19900# 0.01793f
C543 a_3272_6334# sel0 0.44095f
C544 m1_6968_10190# vbp_st 0
C545 ta3 a_3098_11000# 0.25516f
C546 m1_4882_3700# a_318_18520# 0.05101f
C547 a_4710_4480# en 0.01443f
C548 abus sel1 0.12574f
C549 pl_en ta0 0.05632f
C550 m1_2792_6140# a_3098_11000# 0.0088f
C551 a_5524_16920# m1_5190_15350# 0.44328f
C552 vs m1_2722_2630# 0.29218f
C553 a_6934_4480# d1 0.20632f
C554 a_5524_11840# a_3098_11000# 0.14952f
C555 a_5524_16920# vbn_prb 0.04795f
C556 vbn_leak m1_7790_19900# 0.32779f
C557 m1_7702_15650# vdd 0.24692f
C558 m1_7158_7910# ta0 0.01154f
C559 a_5268_9138# m1_8466_10270# 0.07723f
C560 a_2592_8154# m1_7158_13030# 0.01048f
C561 d1_bsel m1_5504_19890# 0.00917f
C562 m1_7684_7940# a_4588_8588# 0.04865f
C563 vsrcp a_6140_9234# 0.48518f
C564 a_488_5520# a_1480_3834# 0.11813f
C565 ta2 m1_6494_5850# 0.00644f
C566 m1_2112_9090# d1 0.10264f
C567 a_7590_18520# hold 0.15403f
C568 d1_bsel vdd 0.61589f
C569 vbn_leak m1_7684_7940# 0
C570 vbn_leak m1_8466_10270# 0.03433f
C571 vdd m1_2112_14220# 0.23047f
C572 vbn_ref mreset 0.05091f
C573 a_7034_18520# sta 0.04117f
C574 tb2 m1_5504_19890# 0.32468f
C575 a_3136_4480# abus 0.08779f
C576 a_1480_3834# a_4096_6334# 0
C577 ta0 a_3098_16080# 0.00668f
C578 hold a_488_19360# 0.01706f
C579 tb2 vdd 0.97839f
C580 vsrcp vbn_ax 0.10977f
C581 a_5524_11840# sta 0.5487f
C582 a_3136_4480# m1_2712_15340# 0
C583 m1_8326_19030# vsrcp 0
C584 a_318_18520# tb1 0.00959f
C585 a_8248_5320# a_7034_3120# 0.00186f
C586 a_488_17120# vsrcp 0
C587 a_8248_5320# m1_6494_5850# 0.0983f
C588 hold a_2542_16080# 0.05986f
C589 a_6140_14314# ta3 0.0435f
C590 a_3098_3120# en 0.00246f
C591 m1_6968_10190# a_3098_11000# 0.05039f
C592 a_874_11000# a_488_12040# 0.2038f
C593 a_6680_5520# en 0.04665f
C594 sel2 vdd 0.19715f
C595 a_3136_4480# a_5516_10600# 0.06677f
C596 hold m1_6716_16790# 0.01041f
C597 a_2592_8154# a_2800_12040# 0.07453f
C598 a_5524_16920# m1_7158_13030# 0.10224f
C599 vreset vbp_st 0.03753f
C600 a_1892_3934# vbp_st 0
C601 a_2800_12040# en 0
C602 a_5516_15680# a_5268_14218# 0.00364f
C603 ta3 m1_7130_19630# 0.05541f
C604 a_2800_17120# vdd 1.16314f
C605 vbn_ax a_3098_18520# 0.01591f
C606 a_7034_18520# m1_7130_19630# 0
C607 vbn_prb a_6594_420# 0.46801f
C608 spk en 0.02403f
C609 a_5366_3120# vdd 0.00349f
C610 a_2592_8154# a_5268_14218# 0.01655f
C611 d2 a_672_20034# 0.00133f
C612 vs m1_7206_2340# 0.15229f
C613 m1_5286_6830# m1_3676_6970# 0.13559f
C614 m1_5432_10260# ta0 0.03029f
C615 m1_2862_14560# m1_2678_13100# 0.1433f
C616 en a_5268_14218# 0.19293f
C617 hold tb3 0
C618 a_488_17120# a_3098_18520# 0.00622f
C619 ta2 ta0 0.04392f
C620 a_3136_4480# m1_3676_6970# 0.00381f
C621 a_2180_13234# pl_en 0.01055f
C622 m1_6968_10190# sta 0.02725f
C623 a_2592_8154# a_6672_14314# 0.09427f
C624 a_874_18520# a_672_20034# 0
C625 a_6672_14314# en 0.00236f
C626 m1_4882_3700# m1_2792_6140# 0.05658f
C627 a_318_18520# a_5366_18520# 0.07241f
C628 m1_2678_13100# m1_2712_15340# 0
C629 a_3136_4480# sel0 0
C630 ta0 a_4588_13668# 0.01405f
C631 a_1480_3834# a_3098_3120# 0.08603f
C632 a_6594_420# a_4096_6334# 0.27534f
C633 a_2592_8154# m1_2956_19890# 0.00195f
C634 a_3212_19360# sel1 0
C635 m1_910_6150# vdd 0.0564f
C636 ta1 m1_5190_15350# 0.00723f
C637 tb0 vsrcp 0
C638 vsrcp m1_6968_15350# 0.03522f
C639 a_488_5520# m1_642_6980# 0.00143f
C640 a_4710_4480# a_6594_420# 0
C641 vbp_syn d1 0.71603f
C642 a_5268_9138# a_6140_9234# 0.26755f
C643 a_7590_18520# m1_5504_19890# 0
C644 a_318_18520# a_6378_4480# 0.00216f
C645 a_8248_5320# ta0 0
C646 m1_2862_14560# a_488_12040# 0.00276f
C647 a_2180_13234# a_3098_16080# 0.18057f
C648 a_6140_9234# a_4588_8588# 0.00233f
C649 d2 vbp_st 0.22999f
C650 a_7590_18520# vdd 0.30586f
C651 m1_6940_14170# sel1 0
C652 a_488_5520# m1_1080_6970# 0.0065f
C653 vbn_leak a_6140_9234# 0.26806f
C654 a_874_16080# el 0.10928f
C655 a_672_20034# sta 0.01756f
C656 a_1480_3834# spk 0
C657 abus a_488_12040# 0
C658 a_5524_16920# a_5268_14218# 0.09837f
C659 vs d1 0.11591f
C660 vbp_st a_3098_11000# 0.52882f
C661 a_488_19360# vdd 1.57091f
C662 ta3 tb1 0.00669f
C663 m1_6190_19900# vbn_leak 0.22363f
C664 m1_2112_9090# m1_2668_7940# 0.04315f
C665 d2 a_2542_18520# 0.09601f
C666 a_1892_3934# a_3098_11000# 0
C667 vs m1_2122_6150# 0.00148f
C668 a_5524_16920# a_6672_14314# 0.6037f
C669 a_7034_18520# tb1 0
C670 m1_5286_6830# m1_5942_6980# 0.00111f
C671 vbn_leak m1_8326_19030# 0.02176f
C672 vbn_leak vbn_ax 1.28455f
C673 a_3136_4480# m1_5942_6980# 0
C674 en a_7034_3120# 0.01264f
C675 m1_2112_9090# a_2542_11000# 0.00239f
C676 a_2542_16080# vdd 0.29961f
C677 en m1_6494_5850# 0
C678 a_874_18520# a_2542_18520# 0.00839f
C679 vbn_leak a_488_17120# 0.03949f
C680 a_8248_5320# a_6934_4480# 0.00134f
C681 a_488_12040# a_5516_10600# 0.01742f
C682 a_3136_4480# m1_6940_14170# 0.00415f
C683 a_6140_9234# el 0.05543f
C684 m1_9090_16790# vbn_prb 0
C685 m1_6716_16790# vdd 0.08085f
C686 a_7590_18520# d1_bsel 0
C687 vbp_st sta 0.11138f
C688 m1_2708_380# m1_1968_380# 0.19165f
C689 a_3098_3120# a_6594_420# 0.07323f
C690 ta1 m1_7158_13030# 0.01823f
C691 a_672_20034# m1_7130_19630# 0.02047f
C692 ta2 a_2180_13234# 0
C693 vbn_prb vsrc 0.1796f
C694 tb3 m1_5504_19890# 0.67413f
C695 a_6680_5520# a_6594_420# 0.00626f
C696 a_6140_9234# chain 0.02683f
C697 vbp_syn a_3098_16080# 0.17408f
C698 d1_bsel a_488_19360# 0.03876f
C699 abus a_318_18520# 0.07878f
C700 vdd vbn_ref 0.17709f
C701 a_488_12040# m1_3676_6970# 0.15331f
C702 a_7590_18520# tb2 0.00124f
C703 tb3 vdd 0.4711f
C704 a_2180_13234# a_4588_13668# 0
C705 vbn_prb a_3272_6334# 0.27189f
C706 vbn_ax el 0.52553f
C707 m1_8326_19030# el 0
C708 stb m1_2956_19890# 0.01986f
C709 a_7590_3120# vbn_ax 0.01986f
C710 a_488_5520# vsrc 0.11634f
C711 m1_7702_10190# m1_8466_10270# 0.2351f
C712 m1_6190_19900# chain 0.00763f
C713 hold m1_7790_19900# 0
C714 vs m1_4282_6970# 0.00159f
C715 a_7034_18520# a_5366_18520# 0.00534f
C716 vbn_leak m1_2722_2630# 0.1071f
C717 d2 a_3098_11000# 0.02726f
C718 a_488_17120# el 0.10163f
C719 d2 a_874_18520# 0.00329f
C720 vsrc a_4096_6334# 0.06398f
C721 a_488_5520# a_3272_6334# 0.22361f
C722 spk a_6594_420# 0.09272f
C723 a_6140_14314# vbp_st 0.15075f
C724 chain vbn_ax 0.04902f
C725 m1_2712_6970# m1_3676_6970# 0.06435f
C726 a_5268_9138# m1_6716_11710# 0.00571f
C727 a_5268_9138# m1_6968_15350# 0
C728 a_2542_16080# m1_2112_14220# 0
C729 m1_7206_18030# a_5268_14218# 0
C730 a_488_17120# chain 0.03117f
C731 a_3272_6334# a_4096_6334# 0.07936f
C732 a_3098_3120# ta1 0
C733 ta3 a_6378_4480# 0
C734 a_5516_15680# ta0 0
C735 vsrcp d1 0.15008f
C736 vbn_leak tb0 0.16543f
C737 a_6680_5520# ta1 0.00305f
C738 vbn_leak m1_6968_15350# 0.19298f
C739 vbp_st m1_7130_19630# 0
C740 a_2592_8154# ta0 0.02764f
C741 a_6672_9234# m1_8466_10270# 0.00548f
C742 m1_2792_6140# a_6378_4480# 0.23091f
C743 en ta0 0.01877f
C744 tb3 d1_bsel 0
C745 m1_7930_11710# a_5268_9138# 0.04489f
C746 m1_4882_3700# vbp_st 0
C747 m1_2722_2630# el 0.20114f
C748 m1_5432_10260# vbp_syn 0
C749 m1_6494_13030# a_4588_13668# 0.00807f
C750 d2 sta 0.00799f
C751 m1_2668_7940# vbp_syn 0.44096f
C752 m1_7930_11710# vbn_leak 0.05133f
C753 ta1 a_5268_14218# 0.13142f
C754 vsrcp m1_8466_15350# 0
C755 a_672_20034# tb1 0
C756 tb3 tb2 0.40221f
C757 a_3098_11000# sta 0.01345f
C758 vsrcp pl_en 0.49915f
C759 sel0 a_318_18520# 0.0069f
C760 chain m1_2722_2630# 0
C761 a_2542_11000# vbp_syn 0.00151f
C762 vbp_syn a_4588_13668# 0.0694f
C763 a_3212_19360# m1_4568_19890# 0.01197f
C764 a_6672_14314# ta1 0.00373f
C765 a_2800_17120# a_2542_16080# 0.00412f
C766 m1_6968_15350# el 0.01806f
C767 tb0 el 0
C768 m1_6940_14170# a_488_12040# 0
C769 vsrcp m1_7158_7910# 0.08081f
C770 a_6140_14314# d2 0.07917f
C771 a_6934_4480# en 0
C772 vsrcp m1_7702_12990# 0.001f
C773 vbn_prb sel1 0.14483f
C774 vbn_leak m1_7206_2340# 0.17746f
C775 m1_6716_11710# chain 0
C776 chain m1_6968_15350# 0.00307f
C777 sel2 vbn_ref 0.02681f
C778 a_3098_3120# vsrc 0
C779 m1_2112_9090# a_2592_8154# 0.04425f
C780 a_5524_16920# ta0 0.07227f
C781 a_6594_420# a_7034_3120# 0
C782 m1_7930_11710# el 0
C783 a_6672_14314# m1_3902_19900# 0.00179f
C784 a_6680_5520# vsrc 0
C785 vsrcp a_3098_16080# 0.00183f
C786 a_2800_5520# m1_2722_2630# 0.04799f
C787 vbn_ax mreset 0.14511f
C788 a_3272_6334# a_3098_3120# 0.27638f
C789 vbp_st tb1 0.00201f
C790 a_8248_5320# vs 0.03666f
C791 a_5366_3120# vbn_ref 0
C792 m1_7790_19900# m1_5504_19890# 0.02813f
C793 m1_1046_10270# a_3098_11000# 0.07391f
C794 m1_7702_10190# a_6140_9234# 0.06132f
C795 m1_2956_19890# m1_3902_19900# 0.09078f
C796 a_3212_19360# a_318_18520# 0.00388f
C797 m1_7790_19900# vdd 0
C798 a_5524_11840# abus 0.04725f
C799 a_3136_4480# m1_5190_15350# 0.14973f
C800 a_672_20034# a_5366_18520# 0
C801 spk vsrc 0.13482f
C802 ta3 a_5516_10600# 0
C803 a_2180_13234# a_5516_15680# 0.16874f
C804 m1_9090_16790# a_6672_14314# 0.01482f
C805 stb ta0 0.00297f
C806 a_3136_4480# vbn_prb 0.07336f
C807 spk a_3272_6334# 0.16536f
C808 hold a_6140_9234# 0.08304f
C809 a_874_3120# a_1480_3834# 0.01036f
C810 a_7590_3120# m1_7206_2340# 0.12354f
C811 m1_7206_2340# el 0.00326f
C812 a_5268_9138# d1 0.68315f
C813 a_6140_14314# sta 0.04575f
C814 a_2180_13234# en 0.0071f
C815 a_2592_8154# a_2180_13234# 0.11432f
C816 ta1 m1_6494_5850# 0.07689f
C817 vdd m1_8466_10270# 0.00308f
C818 a_3098_18520# a_3098_16080# 0
C819 a_6672_14314# vsrc 0
C820 a_4588_8588# d1 0.16725f
C821 a_6140_9234# a_6672_9234# 0.72906f
C822 chain m1_7206_2340# 0.00953f
C823 a_5524_11840# a_5516_10600# 0.00581f
C824 vbn_leak d1 0.99228f
C825 m1_6190_19900# hold 0.05235f
C826 a_3136_4480# a_4096_6334# 0.05186f
C827 m1_2722_2630# mreset 0.07338f
C828 m1_1046_10270# sta 0.00501f
C829 ta3 m1_3676_6970# 0.22215f
C830 m1_5432_10260# vsrcp 0.37236f
C831 a_7590_18520# tb3 0.00107f
C832 sta m1_7130_19630# 0
C833 vbn_leak m1_2122_6150# 0
C834 m1_2668_7940# vsrcp 0.01895f
C835 ta2 vsrcp 0.00969f
C836 hold vbn_ax 0.1567f
C837 a_3136_4480# a_4710_4480# 0
C838 m1_2792_6140# m1_3676_6970# 0.00824f
C839 hold a_488_17120# 0.16169f
C840 a_5268_9138# pl_en 0.11759f
C841 vsrcp a_4588_13668# 0.19477f
C842 ta0 m1_7206_18030# 0.03835f
C843 pl_en a_4588_8588# 0.03827f
C844 m1_5190_15350# m1_2678_13100# 0
C845 m1_7790_19900# tb2 0.00854f
C846 a_5268_9138# m1_7158_7910# 0.00234f
C847 a_2800_5520# m1_7206_2340# 0
C848 a_6140_14314# m1_7130_19630# 0.00419f
C849 vbn_leak pl_en 0.16303f
C850 vbp_st a_6378_4480# 0.02408f
C851 a_7590_3120# d1 0.10908f
C852 d1 el 1.61517f
C853 m1_7158_7910# a_4588_8588# 0.27075f
C854 a_3136_4480# m1_7158_13030# 0.11839f
C855 vbp_syn a_5516_15680# 0.00665f
C856 a_5524_16920# a_2180_13234# 0.10318f
C857 a_5268_9138# m1_7702_12990# 0.00125f
C858 vbn_leak m1_7158_7910# 0.00249f
C859 a_2592_8154# vbp_syn 0.40175f
C860 vbp_syn en 0.05533f
C861 vsrc a_7034_3120# 0.13197f
C862 m1_6968_10190# a_5516_10600# 0.00293f
C863 m1_4282_6970# a_4588_8588# 0.01448f
C864 chain d1 0.16107f
C865 a_874_16080# vdd 0.13598f
C866 a_3272_6334# a_7034_3120# 0.00297f
C867 vbn_leak m1_4282_6970# 0.2419f
C868 ta1 ta0 2.96638f
C869 m1_2062_6980# d1 0.01756f
C870 vbn_leak a_3098_16080# 0.2434f
C871 vs en 0.53766f
C872 ta3 m1_5942_6980# 0
C873 a_5524_11840# m1_9090_11710# 0.01111f
C874 sel1 a_5268_14218# 0.07674f
C875 pl_en el 0.08198f
C876 a_2180_13234# stb 0.04572f
C877 m1_2062_6980# m1_2122_6150# 0.00283f
C878 m1_5286_6830# a_3098_3120# 0.00471f
C879 m1_6968_10190# m1_3676_6970# 0
C880 d2 a_5366_18520# 0.06777f
C881 a_3136_4480# a_3098_3120# 0.14454f
C882 m1_7930_11710# m1_7702_10190# 0
C883 vbn_prb a_488_12040# 0.00862f
C884 sel2 m1_8466_10270# 0.00909f
C885 hold m1_6716_11710# 0.00711f
C886 m1_7206_2340# mreset 0.06878f
C887 a_6680_5520# m1_5286_6830# 0.39973f
C888 ta3 m1_6940_14170# 0.01551f
C889 hold m1_6968_15350# 0.03063f
C890 a_6672_14314# sel1 0.15791f
C891 m1_1046_17880# a_2180_13234# 0.10072f
C892 a_3136_4480# a_6680_5520# 0.0194f
C893 a_5524_16920# m1_6494_13030# 0.00147f
C894 ta0 m1_3902_19900# 0.20562f
C895 pl_en chain 2.45993f
C896 a_2800_5520# d1 0.11247f
C897 a_6140_9234# vdd 1.17796f
C898 m1_7702_12990# el 0.11177f
C899 a_3136_4480# a_2800_12040# -0.01941f
C900 m1_6190_19900# m1_5504_19890# 0.1572f
C901 chain m1_7158_7910# 0
C902 abus vbp_st 0.1774f
C903 pl_en m1_2062_6980# 0
C904 a_3136_4480# spk 0.46262f
C905 a_874_11000# a_3098_11000# 0
C906 a_3098_16080# el 0
C907 a_5524_16920# vbp_syn 0
C908 a_6140_14314# tb1 0.00192f
C909 m1_6190_19900# vdd 0.02192f
C910 a_5268_9138# m1_5432_10260# 0.16385f
C911 a_3136_4480# a_5268_14218# 0.01882f
C912 m1_8326_19030# m1_5504_19890# 0.24875f
C913 m1_2668_7940# a_5268_9138# 0
C914 ta2 a_5268_9138# 0.04596f
C915 m1_7930_11710# a_6672_9234# 0
C916 vbn_ax m1_5504_19890# 0.50327f
C917 vreset abus 0.15561f
C918 a_3098_11000# a_6378_4480# 0
C919 chain m1_4282_6970# 0.00145f
C920 m1_2668_7940# a_4588_8588# 0.00351f
C921 m1_5432_10260# a_4588_8588# 0.23134f
C922 m1_8326_19030# vdd 0.31182f
C923 m1_7158_7910# m1_2062_6980# 0
C924 ta2 a_4588_8588# 0.04621f
C925 a_488_17120# m1_5504_19890# 0.15061f
C926 a_2180_13234# m1_7206_18030# 0.06507f
C927 vbn_ax vdd 0.74527f
C928 chain a_3098_16080# 0.00399f
C929 abus m1_1968_380# 0.05817f
C930 a_1480_3834# vs 0.01486f
C931 vbn_leak m1_5432_10260# 0.25859f
C932 a_3136_4480# a_6672_14314# 0.08131f
C933 m1_2668_7940# vbn_leak 0.00811f
C934 a_5268_9138# a_4588_13668# 0
C935 tb1 m1_7130_19630# 0.61127f
C936 a_488_17120# vdd 1.83915f
C937 vbn_leak ta2 0.38737f
C938 m1_4282_6970# m1_2062_6980# 0.18881f
C939 vbp_st a_5516_10600# 0
C940 stb vbp_syn 0.06888f
C941 vbn_prb a_318_18520# 0.11914f
C942 d1 mreset 0.18855f
C943 vbn_leak a_2542_11000# 0.00182f
C944 vbn_leak a_4588_13668# 0.2096f
C945 m1_7158_13030# a_488_12040# 0.00196f
C946 vsrcp a_5516_15680# 0.00436f
C947 m1_1046_17880# vbp_syn 0.02461f
C948 a_488_5520# a_318_18520# 0
C949 a_2180_13234# ta1 0
C950 a_2800_5520# m1_4282_6970# 0
C951 a_2592_8154# vsrcp 0.08919f
C952 m1_6190_19900# d1_bsel 0.07038f
C953 d2 m1_2862_14560# 0.08667f
C954 vsrcp en 0.06075f
C955 a_8248_5320# vbn_leak 0.28014f
C956 vbp_st m1_3676_6970# 0.25995f
C957 a_2800_12040# m1_2678_13100# 0.00238f
C958 a_318_18520# a_4096_6334# 0.04927f
C959 a_874_3120# vsrc 0.20189f
C960 a_488_5520# a_728_3738# 0.50228f
C961 ta2 el 0.03528f
C962 a_488_17120# m1_7702_15650# 0.05161f
C963 d1_bsel vbn_ax 0.09866f
C964 vdd m1_2722_2630# 0.02744f
C965 a_6934_4480# vsrc 0.00382f
C966 a_1892_3934# m1_3676_6970# 0
C967 a_874_3120# a_3272_6334# 0.03401f
C968 m1_7702_10190# d1 0.28672f
C969 m1_2678_13100# a_5268_14218# 0
C970 d1_bsel a_488_17120# 0
C971 sel0 vbp_st 0.03177f
C972 a_4710_4480# a_318_18520# 0
C973 m1_7150_9086# ta0 0.00336f
C974 a_3212_19360# a_672_20034# 0.00857f
C975 m1_5432_10260# chain 0.00555f
C976 a_2542_11000# el 0.01468f
C977 a_4588_13668# el 0.50602f
C978 d2 m1_2712_15340# 0.02154f
C979 vbn_ax tb2 0.04076f
C980 ta2 chain 0.05914f
C981 vbp_syn m1_7206_18030# 0.00626f
C982 a_2180_13234# m1_3902_19900# 0.05099f
C983 tb0 m1_5504_19890# 0.11066f
C984 m1_8326_19030# tb2 0.1236f
C985 vreset sel0 0.24797f
C986 a_3136_4480# a_7034_3120# 0.06619f
C987 m1_5286_6830# m1_6494_5850# 0.19112f
C988 tb3 m1_7790_19900# 0.22282f
C989 a_3136_4480# m1_6494_5850# 0.06773f
C990 m1_6716_11710# vdd 0.0873f
C991 a_6140_9234# sel2 0.00573f
C992 vdd m1_6968_15350# 0.01748f
C993 a_2592_8154# a_3098_18520# 0.0462f
C994 tb0 vdd 0.88189f
C995 sel0 m1_1968_380# 0.05533f
C996 m1_5432_10260# m1_2062_6980# 0
C997 a_874_11000# m1_1046_10270# 0.24052f
C998 hold d1 0.41342f
C999 a_488_17120# tb2 0.03115f
C1000 m1_2668_7940# m1_2062_6980# 0.0029f
C1001 vsrcp m1_6494_7910# 0.00243f
C1002 chain a_4588_13668# 0.02774f
C1003 vs a_6594_420# 0.7112f
C1004 a_8248_5320# el 0.16414f
C1005 ta2 m1_2062_6980# 0.12252f
C1006 a_2800_12040# a_488_12040# 0.05185f
C1007 a_8248_5320# a_7590_3120# 0.00793f
C1008 m1_2712_6970# a_3098_3120# 0.04721f
C1009 a_6672_9234# d1 0.34144f
C1010 m1_2708_380# abus 0.04074f
C1011 vbp_st m1_9090_11710# 0.03545f
C1012 vbn_ax sel2 0.02704f
C1013 a_3098_11000# a_5516_10600# 0.05006f
C1014 m1_7930_11710# vdd 0.07932f
C1015 a_5524_16920# vsrcp 0.29761f
C1016 m1_4882_3700# a_6378_4480# 0.07987f
C1017 vs m1_642_6980# 0
C1018 sel1 ta0 0.05312f
C1019 ta3 m1_5190_15350# 0.00849f
C1020 a_2800_17120# vbn_ax 0.00837f
C1021 spk m1_2712_6970# 0.00264f
C1022 vbp_st m1_5942_6980# 0
C1023 hold pl_en 0.08907f
C1024 m1_7702_15650# m1_6968_15350# 0
C1025 a_2800_17120# a_488_17120# 0.39821f
C1026 vbn_prb ta3 0
C1027 a_3098_3120# a_318_18520# 0.47149f
C1028 vs m1_1080_6970# 0.00791f
C1029 pl_en a_6672_9234# 0.0151f
C1030 a_3098_11000# m1_3676_6970# 0.34802f
C1031 a_874_16080# a_2542_16080# 0.00789f
C1032 a_6680_5520# a_318_18520# 0
C1033 hold m1_7158_7910# 0.00424f
C1034 a_5524_11840# m1_5190_15350# 0
C1035 m1_2956_19890# m1_4568_19890# 0.00533f
C1036 vbp_syn m1_3902_19900# 0.02566f
C1037 sta a_5516_10600# 0.00535f
C1038 a_3098_3120# a_728_3738# 0.0039f
C1039 hold m1_4282_6970# 0.00751f
C1040 a_2592_8154# a_5268_9138# 0.17639f
C1041 a_5524_11840# vbn_prb 0.03753f
C1042 m1_7930_16790# a_5268_14218# 0.0148f
C1043 tb0 tb2 0.28975f
C1044 ta3 a_4096_6334# 0
C1045 m1_5286_6830# ta0 0.10767f
C1046 a_5268_9138# en 0.34501f
C1047 a_2592_8154# a_4588_8588# 0.03843f
C1048 a_3136_4480# ta0 0.04571f
C1049 hold a_3098_16080# 0.31915f
C1050 vbn_leak a_5516_15680# 0.12818f
C1051 m1_2470_19900# m1_2956_19890# 0.00741f
C1052 spk a_318_18520# 0.15386f
C1053 en a_4588_8588# 0.17172f
C1054 a_318_18520# a_5268_14218# 0.04641f
C1055 a_2592_8154# vbn_leak 0.40683f
C1056 a_7590_18520# m1_8326_19030# 0
C1057 a_4710_4480# ta3 0
C1058 vbn_leak en 0.8318f
C1059 m1_2792_6140# a_4096_6334# 0.14642f
C1060 a_7590_18520# vbn_ax 0.01599f
C1061 m1_2708_380# sel0 0.01504f
C1062 a_5366_3120# m1_2722_2630# 0
C1063 a_6672_14314# a_318_18520# 0.05219f
C1064 a_7590_18520# a_488_17120# 0.26357f
C1065 a_4710_4480# m1_2792_6140# 0.0183f
C1066 m1_1046_17880# a_3098_18520# 0.06631f
C1067 d2 a_3212_19360# 0.15001f
C1068 a_488_12040# m1_6494_5850# 0.14142f
C1069 m1_5286_6830# a_6934_4480# 0.02782f
C1070 ta3 m1_7158_13030# 0.03572f
C1071 a_488_17120# a_488_19360# 0.00401f
C1072 a_8248_5320# mreset 0.04797f
C1073 m1_2112_9090# m1_2236_8010# 0.31298f
C1074 ta2 m1_7702_10190# 0
C1075 vdd d1 2.51152f
C1076 vs vsrc 0.99123f
C1077 a_3136_4480# a_6934_4480# 0.06005f
C1078 a_2592_8154# el 0.12066f
C1079 a_3098_11000# m1_5942_6980# 0.00142f
C1080 a_4588_8588# m1_6494_7910# 0.06759f
C1081 d2 m1_6940_14170# 0.0061f
C1082 a_7590_3120# en 0.04895f
C1083 vdd m1_2122_6150# 0.072f
C1084 en el 0.10477f
C1085 vs a_3272_6334# 0.3418f
C1086 vbn_leak m1_6494_7910# -0.01166f
C1087 a_488_17120# a_2542_16080# 0.00344f
C1088 a_2180_13234# sel1 0.06942f
C1089 m1_2112_9090# a_3136_4480# 0
C1090 hold m1_5432_10260# 0.07858f
C1091 chain a_5516_15680# 0
C1092 m1_2668_7940# hold 0
C1093 a_2592_8154# chain 0.03262f
C1094 ta2 hold 0.04053f
C1095 vsrcp ta1 0.01251f
C1096 chain en 0.72529f
C1097 vbn_leak a_1480_3834# 0.00946f
C1098 m1_5432_10260# a_6672_9234# 0.05627f
C1099 vbn_leak a_5524_16920# 0.35073f
C1100 m1_6190_19900# tb3 0.04661f
C1101 pl_en m1_5504_19890# 0.00164f
C1102 ta2 a_6672_9234# 0.0316f
C1103 hold a_4588_13668# 0.07335f
C1104 m1_8466_15350# vdd 0.03014f
C1105 a_3212_19360# sta 0
C1106 a_2592_8154# m1_2062_6980# 0
C1107 hold a_2542_11000# 0.16982f
C1108 pl_en vdd 0.13333f
C1109 m1_8326_19030# tb3 0.30812f
C1110 m1_2062_6980# en 0.06625f
C1111 vbn_ax vbn_ref 3.9836f
C1112 tb3 vbn_ax 0.13777f
C1113 a_6680_5520# ta3 0.52844f
C1114 a_7590_18520# tb0 0
C1115 a_318_18520# a_7034_3120# 0.18464f
C1116 tb3 a_488_17120# 0.03011f
C1117 a_3098_3120# m1_2792_6140# 0.36507f
C1118 a_3136_4480# a_2180_13234# 0
C1119 a_5366_3120# m1_7206_2340# 0.31597f
C1120 a_8248_5320# hold 0.0114f
C1121 a_6680_5520# m1_2792_6140# 0.2201f
C1122 vbn_leak stb 0.29548f
C1123 m1_6940_14170# sta 0.00297f
C1124 a_2800_5520# en 0.01822f
C1125 m1_4282_6970# vdd 0.01926f
C1126 a_488_12040# ta0 0.16428f
C1127 m1_5504_19890# a_3098_16080# 0.20407f
C1128 a_1480_3834# el 0.00367f
C1129 a_5524_16920# el 0.08116f
C1130 ta3 a_5268_14218# 0.04263f
C1131 m1_1046_17880# vbn_leak 0.04636f
C1132 chain m1_6494_7910# 0.00198f
C1133 m1_7702_15650# m1_8466_15350# 0.08616f
C1134 vdd a_3098_16080# 1.23459f
C1135 a_3098_3120# a_2542_3120# -0.10039f
C1136 a_5524_11840# a_2800_12040# 0
C1137 spk m1_2792_6140# 0.07027f
C1138 m1_7702_15650# pl_en 0
C1139 a_6672_14314# ta3 0.00619f
C1140 a_1480_3834# chain 0.01008f
C1141 m1_2062_6980# m1_6494_7910# 0.00166f
C1142 vbp_st m1_5190_15350# 0
C1143 a_5524_16920# chain 0.07493f
C1144 d1_bsel pl_en 0.00544f
C1145 vsrcp vsrc 4.0019f
C1146 a_6140_14314# m1_6940_14170# 0
C1147 vbn_prb vbp_st 0.11043f
C1148 a_1480_3834# m1_2062_6980# 0.00159f
C1149 sel2 d1 0.02383f
C1150 vsrcp a_3272_6334# 0
C1151 vbn_leak a_6594_420# 0.48957f
C1152 vbn_prb vreset 4.09469f
C1153 m1_2236_8010# vbp_syn 0.18718f
C1154 a_3136_4480# m1_6494_13030# 0.12386f
C1155 vbn_leak m1_7206_18030# 0
C1156 a_488_5520# vbp_st 0.06213f
C1157 en mreset 0.05745f
C1158 vbn_prb m1_1968_380# 0.03679f
C1159 m1_7702_15650# a_3098_16080# 0.33733f
C1160 tb0 tb3 0.21553f
C1161 a_5366_3120# d1 0.19058f
C1162 chain stb 0.07042f
C1163 vbp_st a_4096_6334# 0
C1164 a_1892_3934# a_488_5520# 0.00428f
C1165 ta0 a_318_18520# 0.02278f
C1166 a_2800_5520# a_1480_3834# 0.00884f
C1167 a_2180_13234# m1_2678_13100# 0.00512f
C1168 a_3136_4480# vbp_syn 0.23181f
C1169 m1_5432_10260# vdd 0
C1170 a_1892_3934# a_4096_6334# 0.18497f
C1171 vbn_leak m1_642_6980# 0.08297f
C1172 a_5268_9138# ta1 0.14236f
C1173 m1_2112_14220# a_3098_16080# 0
C1174 ta2 m1_5504_19890# 0.058f
C1175 vreset a_4096_6334# 0.09484f
C1176 m1_2668_7940# vdd 0.42647f
C1177 ta1 a_4588_8588# 0.03798f
C1178 ta2 vdd 0.22322f
C1179 vs m1_5286_6830# 0
C1180 tb2 a_3098_16080# 0.08272f
C1181 a_3136_4480# vs 0.05702f
C1182 vbn_leak m1_1080_6970# 0.12512f
C1183 vsrcp m1_7150_9086# 0.13847f
C1184 vbn_leak ta1 0.38789f
C1185 a_6594_420# el 0.06213f
C1186 a_7590_3120# a_6594_420# 0
C1187 m1_910_6150# d1 0
C1188 a_2592_8154# m1_7702_10190# 0.06824f
C1189 a_2800_17120# pl_en 0
C1190 vdd a_4588_13668# 0.16177f
C1191 m1_6190_19900# m1_7790_19900# -0.00611f
C1192 ta3 m1_6494_5850# 0.14137f
C1193 m1_7702_10190# en 0.2062f
C1194 a_2542_11000# vdd 0.29881f
C1195 m1_7684_7940# a_6140_9234# 0.00197f
C1196 d2 m1_5190_15350# 0.07416f
C1197 a_6140_9234# m1_8466_10270# 0.05745f
C1198 vbp_st m1_7158_13030# 0
C1199 d2 vbn_prb 0.00158f
C1200 hold a_5516_15680# 0.16039f
C1201 m1_8326_19030# m1_7790_19900# 0.07795f
C1202 m1_2792_6140# a_7034_3120# 0
C1203 chain a_6594_420# 0.04733f
C1204 a_2180_13234# a_488_12040# 0
C1205 chain m1_7206_18030# 0.05483f
C1206 a_488_17120# m1_7790_19900# 0
C1207 a_6934_4480# a_318_18520# 0.00112f
C1208 a_8248_5320# vdd 0.91686f
C1209 a_2592_8154# hold 0.6754f
C1210 vbn_ref m1_7206_2340# 0
C1211 ta2 m1_7702_15650# 0
C1212 hold en 0.33177f
C1213 vbn_leak m1_3902_19900# 0.46892f
C1214 vbn_prb a_3098_11000# 0
C1215 a_874_3120# a_728_3738# 0.00324f
C1216 en a_6672_9234# 0.09984f
C1217 a_2592_8154# a_6672_9234# 0.26097f
C1218 a_2800_17120# a_3098_16080# 0.05728f
C1219 ta1 el 0.07376f
C1220 vbp_syn m1_2678_13100# 0.46332f
C1221 a_2180_13234# m1_2470_19900# 0
C1222 m1_2862_14560# m1_2712_15340# 0
C1223 vsrcp sel1 0
C1224 a_2800_5520# a_6594_420# 0.13476f
C1225 a_7590_18520# pl_en 0.00945f
C1226 vbn_prb m1_2708_380# 0.05453f
C1227 a_3098_11000# a_4096_6334# 0
C1228 chain ta1 0.01948f
C1229 m1_2062_6980# m1_642_6980# 0
C1230 a_3098_3120# vbp_st 0.06071f
C1231 ta2 tb2 0
C1232 m1_5190_15350# sta 0.00845f
C1233 a_6680_5520# vbp_st 0.27221f
C1234 vbn_leak vsrc 3.96761f
C1235 a_1892_3934# a_3098_3120# 0.29967f
C1236 m1_2956_19890# a_672_20034# 0.0166f
C1237 hold m1_6494_7910# 0.00176f
C1238 ta1 m1_2062_6980# 0.10533f
C1239 a_1892_3934# a_6680_5520# 0.0816f
C1240 m1_1080_6970# m1_2062_6980# 0.1034f
C1241 vbn_leak a_3272_6334# 0.28483f
C1242 a_2180_13234# a_318_18520# 0.32097f
C1243 a_3212_19360# a_5366_18520# 0.00114f
C1244 ta3 ta0 0.07402f
C1245 a_6672_9234# m1_6494_7910# 0
C1246 vsrcp m1_5286_6830# 0
C1247 spk vbp_st 0.17464f
C1248 d2 m1_7158_13030# 0
C1249 hold a_5524_16920# 0.19528f
C1250 vbn_ref d1 0.00383f
C1251 chain m1_3902_19900# 0.00542f
C1252 vbp_syn a_488_12040# 0.04451f
C1253 a_3136_4480# vsrcp 0.64362f
C1254 vbp_st a_5268_14218# 0.37098f
C1255 a_7034_18520# ta0 0.06049f
C1256 tb0 m1_7790_19900# 0.17658f
C1257 a_7590_18520# a_3098_16080# 0.01988f
C1258 spk vreset 0.43172f
C1259 a_1892_3934# spk 0.05398f
C1260 m1_2792_6140# ta0 0
C1261 a_6140_14314# m1_5190_15350# 0.00311f
C1262 vbp_syn m1_4568_19890# 0.0339f
C1263 a_5524_11840# ta0 0.04367f
C1264 a_6672_14314# vbp_st 0.15811f
C1265 a_6140_14314# vbn_prb 0.01964f
C1266 a_6594_420# mreset 0.0201f
C1267 a_5268_9138# m1_7150_9086# 0.16011f
C1268 vsrc el 0.30087f
C1269 a_7590_3120# vsrc 0.08714f
C1270 m1_7150_9086# a_4588_8588# 0
C1271 a_2800_17120# a_4588_13668# 0.00355f
C1272 a_488_17120# a_874_16080# 0.04776f
C1273 a_3272_6334# el 0.3126f
C1274 vbn_leak m1_7150_9086# 0
C1275 hold stb 0.30673f
C1276 a_3272_6334# a_7590_3120# 0
C1277 chain vsrc 0
C1278 sel0 abus 4.14952f
C1279 a_6934_4480# ta3 0.00392f
C1280 a_2542_16080# a_3098_16080# 0.04976f
C1281 a_5516_15680# vdd 0.28121f
C1282 m1_1046_17880# hold 0.05689f
C1283 a_2592_8154# m1_5504_19890# 0.00782f
C1284 m1_5504_19890# en 0.00663f
C1285 a_3272_6334# chain 0.09364f
C1286 a_2592_8154# vdd 1.82802f
C1287 m1_4882_3700# vbn_prb 0
C1288 m1_2792_6140# a_6934_4480# 0.17152f
C1289 d2 a_2800_12040# 0.01063f
C1290 en vdd 0.44334f
C1291 vbp_syn a_318_18520# 0.09057f
C1292 a_6680_5520# a_3098_11000# 0.36739f
C1293 vsrcp m1_2678_13100# 0.02091f
C1294 d2 a_5268_14218# 0.38369f
C1295 a_7590_18520# ta2 0.00878f
C1296 a_2800_12040# a_3098_11000# 0.56531f
C1297 tb3 a_3098_16080# 0.10983f
C1298 a_874_3120# a_2542_3120# 0.00454f
C1299 m1_6968_10190# ta0 0.0174f
C1300 hold a_6594_420# 0
C1301 vs a_318_18520# 0.21893f
C1302 m1_4882_3700# a_4096_6334# 0.14393f
C1303 m1_6190_19900# vbn_ax 0.12153f
C1304 d2 a_6672_14314# 0.00307f
C1305 hold m1_7206_18030# 0.0722f
C1306 vbn_leak sel1 0.29904f
C1307 vbp_st m1_6494_5850# 0.00856f
C1308 a_2800_5520# a_3272_6334# 0.06171f
C1309 m1_8326_19030# vbn_ax 0.27207f
C1310 m1_4882_3700# a_4710_4480# 0.15135f
C1311 a_2592_8154# m1_7702_15650# 0.01927f
C1312 vreset a_7034_3120# 0
C1313 vs a_728_3738# 0.14531f
C1314 m1_7702_10190# ta1 0
C1315 m1_7702_15650# en 0.09677f
C1316 m1_8326_19030# a_488_17120# 0.19378f
C1317 d2 m1_2956_19890# 0
C1318 a_488_17120# vbn_ax 0.18867f
C1319 a_7034_18520# a_2180_13234# 0.02503f
C1320 a_2592_8154# d1_bsel 0.25572f
C1321 m1_2236_8010# vbn_leak 0.00188f
C1322 a_5524_16920# m1_5504_19890# 0.007f
C1323 d1_bsel en 0.08328f
C1324 a_2800_12040# sta 0
C1325 vsrcp a_488_12040# 0.07878f
C1326 a_3136_4480# a_5268_9138# 0.04662f
C1327 a_672_20034# ta0 0.00187f
C1328 a_1480_3834# vdd 0.51634f
C1329 m1_5286_6830# a_4588_8588# 0.00123f
C1330 a_5524_16920# vdd 1.10852f
C1331 hold ta1 0.03464f
C1332 a_3136_4480# a_4588_8588# 0.82936f
C1333 vbn_leak m1_5286_6830# 0.1445f
C1334 a_2592_8154# tb2 0.05831f
C1335 vbn_leak a_3136_4480# 1.60723f
C1336 sta a_5268_14218# 0.33845f
C1337 ta1 a_6672_9234# 0.02629f
C1338 vsrc mreset 0.1997f
C1339 a_3272_6334# mreset 0.44828f
C1340 a_6672_14314# sta 0.01745f
C1341 m1_5504_19890# stb 0.01469f
C1342 ta2 tb3 0.066f
C1343 chain sel1 1.14624f
C1344 d1 m1_8466_10270# 0.03178f
C1345 stb vdd 0.49119f
C1346 hold m1_3902_19900# 0.07525f
C1347 sel2 en 0
C1348 a_5524_16920# m1_7702_15650# 0.05892f
C1349 a_2800_17120# a_5516_15680# -0.03978f
C1350 a_6140_14314# a_5268_14218# 0.12929f
C1351 m1_5942_6980# m1_3676_6970# 0.15019f
C1352 m1_1046_17880# vdd 0.10563f
C1353 m1_5286_6830# el 0
C1354 m1_1046_10270# a_2800_12040# 0.18351f
C1355 m1_7930_11710# a_6140_9234# 0.00239f
C1356 vbp_st ta0 0.03639f
C1357 tb0 m1_8326_19030# 0.31287f
C1358 a_5524_11840# m1_6494_13030# 0
C1359 a_3136_4480# el 1.06676f
C1360 a_2800_17120# en 0
C1361 tb0 vbn_ax 0.12622f
C1362 vsrcp a_318_18520# 0.08058f
C1363 a_3136_4480# a_7590_3120# 0.06763f
C1364 m1_4882_3700# a_6680_5520# 0.0103f
C1365 a_3098_11000# m1_6494_5850# 0.29361f
C1366 a_6140_14314# a_6672_14314# 0.45916f
C1367 a_8248_5320# vbn_ref 0.00766f
C1368 a_5366_3120# en 0.06059f
C1369 tb0 a_488_17120# 0.03001f
C1370 m1_2470_19900# a_3098_18520# 0.00942f
C1371 m1_2236_8010# m1_2062_6980# 0
C1372 m1_5286_6830# chain 0.09332f
C1373 m1_7684_7940# pl_en 0.1173f
C1374 a_3136_4480# chain 0.17482f
C1375 vs ta3 0.05457f
C1376 a_5524_16920# tb2 0.00332f
C1377 a_5524_11840# vbp_syn 0
C1378 m1_5504_19890# m1_7206_18030# 0.00193f
C1379 m1_4882_3700# spk 0
C1380 vbn_leak m1_2678_13100# 0.05187f
C1381 a_6672_14314# m1_7130_19630# 0
C1382 a_6594_420# vdd 0.50846f
C1383 m1_5286_6830# m1_2062_6980# 0.10037f
C1384 vs m1_2792_6140# 0.12068f
C1385 m1_7684_7940# m1_7158_7910# 0.09133f
C1386 m1_7790_19900# a_3098_16080# 0
C1387 vdd m1_7206_18030# 0.03762f
C1388 d1_bsel stb 0.69475f
C1389 vsrc a_6672_9234# 0
C1390 a_3136_4480# m1_2062_6980# 0.13094f
C1391 vbp_st a_6934_4480# 0.06873f
C1392 a_7590_18520# a_5516_15680# 0.00152f
C1393 a_318_18520# a_3098_18520# 0.02848f
C1394 a_2180_13234# a_672_20034# 0.0498f
C1395 vdd m1_642_6980# 0.01007f
C1396 a_7590_18520# a_2592_8154# 0.22876f
C1397 vs a_2542_3120# 0.00901f
C1398 a_2800_5520# a_3136_4480# 0.02208f
C1399 m1_2112_9090# vbp_st 0
C1400 a_5268_9138# a_488_12040# 0.50236f
C1401 a_7590_18520# en 0.07647f
C1402 m1_5504_19890# ta1 0.00591f
C1403 a_6378_4480# a_4096_6334# 0.00193f
C1404 a_2800_17120# a_5524_16920# 0
C1405 vbn_ax m1_7206_2340# 0.41478f
C1406 a_488_12040# a_4588_8588# 0.00482f
C1407 m1_2678_13100# el 0.10427f
C1408 d2 ta0 0.01875f
C1409 ta1 vdd 0.29402f
C1410 m1_1080_6970# vdd 0.05163f
C1411 vbn_leak a_488_12040# 0.13196f
C1412 a_2592_8154# a_488_19360# 0.38526f
C1413 a_4710_4480# a_6378_4480# 0.01703f
C1414 vbn_leak m1_4568_19890# 0.2722f
C1415 a_3098_11000# ta0 0.22035f
C1416 d1_bsel m1_7206_18030# 0
C1417 vbn_leak m1_2712_6970# 0.12682f
C1418 m1_7150_9086# a_6672_9234# 0.02745f
C1419 m1_5504_19890# m1_3902_19900# 0.56713f
C1420 vbn_leak m1_2470_19900# 0.09964f
C1421 a_6140_9234# d1 0.07441f
C1422 a_2180_13234# vbp_st 0.22373f
C1423 ta2 m1_7790_19900# 0
C1424 m1_910_6150# a_1480_3834# 0
C1425 tb2 m1_7206_18030# 0
C1426 vdd m1_3902_19900# 0.23237f
C1427 a_6672_14314# tb1 0
C1428 vbn_prb abus 2.30398f
C1429 m1_5190_15350# m1_2712_15340# -0
C1430 a_2800_17120# m1_1046_17880# 0.02536f
C1431 a_3136_4480# mreset 0.25707f
C1432 m1_4882_3700# a_7034_3120# 0.0101f
C1433 m1_7684_7940# m1_5432_10260# 0.02268f
C1434 vsrcp ta3 0.0314f
C1435 m1_7702_15650# ta1 0
C1436 a_488_12040# el 1.76344f
C1437 a_7590_18520# a_5524_16920# 0
C1438 vbp_syn a_672_20034# 0.02558f
C1439 ta2 m1_7684_7940# 0.00309f
C1440 d1_bsel ta1 0
C1441 vbn_ax d1 0.08216f
C1442 a_2592_8154# tb3 0.052f
C1443 a_2180_13234# a_2542_18520# 0.20218f
C1444 m1_9090_16790# vdd 0.0909f
C1445 en vbn_ref 0.00221f
C1446 a_6934_4480# a_3098_11000# 0.09496f
C1447 hold sel1 0.07124f
C1448 chain a_488_12040# 0.02468f
C1449 abus a_4096_6334# 0.03346f
C1450 vbn_leak a_318_18520# 0.27105f
C1451 a_5524_11840# vsrcp 0.17102f
C1452 a_6140_9234# pl_en 0.25459f
C1453 tb2 ta1 0
C1454 vsrc vdd 0.84136f
C1455 m1_2112_9090# a_3098_11000# 0.00501f
C1456 a_6594_420# a_5366_3120# 0
C1457 vbn_leak a_728_3738# 0.0272f
C1458 m1_2062_6980# a_488_12040# 0.07223f
C1459 a_3136_4480# m1_7702_10190# 0
C1460 m1_6190_19900# pl_en 0.00308f
C1461 a_6680_5520# a_6378_4480# 0.00689f
C1462 m1_2712_6970# chain 0.02472f
C1463 a_3272_6334# vdd 0.91634f
C1464 m1_2236_8010# hold 0.00302f
C1465 a_6140_9234# m1_7158_7910# 0.00631f
C1466 vbp_st m1_6494_13030# 0
C1467 a_7590_18520# stb 0.01328f
C1468 d1_bsel m1_3902_19900# 0.01427f
C1469 a_6140_14314# ta0 0.00846f
C1470 a_7590_18520# m1_1046_17880# 0
C1471 pl_en vbn_ax 0.05473f
C1472 hold m1_5286_6830# 0.31175f
C1473 a_488_17120# m1_8466_15350# 0.05739f
C1474 a_488_17120# pl_en 0.03001f
C1475 m1_2712_6970# m1_2062_6980# 0.23642f
C1476 vbp_st vbp_syn 0.00655f
C1477 d2 a_2180_13234# 0.27349f
C1478 stb a_488_19360# 0.01987f
C1479 a_3136_4480# hold 0.24202f
C1480 tb2 m1_3902_19900# 0.00204f
C1481 m1_2722_2630# d1 0.27692f
C1482 spk a_6378_4480# 0
C1483 a_7590_3120# a_318_18520# 0.22212f
C1484 a_318_18520# el 0.99038f
C1485 m1_1046_17880# a_488_19360# 0.04316f
C1486 ta0 m1_7130_19630# 0.00383f
C1487 vbn_prb sel0 0.32478f
C1488 a_3136_4480# a_6672_9234# 0.07854f
C1489 a_874_18520# a_2180_13234# 0.02436f
C1490 m1_6190_19900# a_3098_16080# 0.00329f
C1491 m1_2112_9090# sta 0.27888f
C1492 tb3 a_5524_16920# 0.00473f
C1493 a_728_3738# el 0.01556f
C1494 a_2800_5520# m1_2712_6970# 0
C1495 vs vbp_st 0.07853f
C1496 chain a_318_18520# 0.14078f
C1497 m1_4882_3700# ta0 0
C1498 m1_6968_10190# vsrcp 0.16685f
C1499 vbn_ax a_3098_16080# 0.04441f
C1500 m1_8326_19030# a_3098_16080# 0.40241f
C1501 vs vreset 0.38978f
C1502 a_1892_3934# vs 0.01429f
C1503 m1_6716_11710# d1 0.08137f
C1504 a_7590_18520# m1_7206_18030# 0.45204f
C1505 a_488_17120# a_3098_16080# 0.8436f
C1506 chain a_728_3738# 0
C1507 vs m1_1968_380# 0.06706f
C1508 m1_910_6150# m1_642_6980# 0.00105f
C1509 sel0 a_4096_6334# 0.09006f
C1510 tb3 stb 0
C1511 vbn_prb m1_9090_11710# 0
C1512 m1_2862_14560# a_2800_12040# 0
C1513 m1_910_6150# m1_1080_6970# 0.00149f
C1514 m1_2062_6980# a_728_3738# 0.01428f
C1515 m1_7930_11710# d1 0
C1516 a_5268_9138# ta3 0.07877f
C1517 a_2180_13234# sta 0.51503f
C1518 a_2800_5520# a_318_18520# 0.00642f
C1519 ta3 a_4588_8588# 0.06326f
C1520 m1_5432_10260# a_6140_9234# 0.13241f
C1521 m1_2112_9090# m1_1046_10270# 0.00316f
C1522 ta2 a_6140_9234# 0.02791f
C1523 vbn_leak ta3 0.27014f
C1524 m1_5504_19890# sel1 0.00519f
C1525 m1_4882_3700# a_6934_4480# 0.03418f
C1526 hold m1_2678_13100# 0.01851f
C1527 pl_en m1_6968_15350# 0.17895f
C1528 d2 vbp_syn 0.49057f
C1529 a_7590_18520# ta1 0.00744f
C1530 sel2 vsrc 0.02673f
C1531 m1_2792_6140# a_4588_8588# 0
C1532 vbn_leak a_7034_18520# 0
C1533 m1_6940_14170# m1_5190_15350# 0.00269f
C1534 spk abus 0.58876f
C1535 a_5268_9138# a_5524_11840# 0.31373f
C1536 sel1 vdd 0.18153f
C1537 a_2592_8154# m1_7790_19900# 0.00261f
C1538 vbn_leak m1_2792_6140# 0.15187f
C1539 m1_6190_19900# ta2 0.0745f
C1540 a_3098_11000# vbp_syn 0.15622f
C1541 a_5524_11840# a_4588_8588# 0.30351f
C1542 m1_7702_10190# a_488_12040# 0.106f
C1543 a_5366_3120# vsrc 0.0045f
C1544 a_7034_3120# a_6378_4480# 0.00384f
C1545 d1 m1_7206_2340# 0.05719f
C1546 vbn_leak a_5524_11840# 0.1985f
C1547 m1_7702_12990# m1_6968_15350# 0.04012f
C1548 ta2 vbn_ax 0.00737f
C1549 a_6672_14314# abus 0.03501f
C1550 a_6594_420# vbn_ref 0.41409f
C1551 m1_2236_8010# vdd 0.1653f
C1552 a_2800_12040# a_5516_10600# -0.00222f
C1553 a_7590_18520# m1_3902_19900# 0.11038f
C1554 ta2 a_488_17120# 0.02755f
C1555 a_3272_6334# a_5366_3120# 0.00493f
C1556 tb3 m1_7206_18030# 0.02651f
C1557 a_672_20034# a_3098_18520# 0.00211f
C1558 tb0 a_3098_16080# 0.02756f
C1559 vbn_leak a_2542_3120# 0
C1560 vs a_3098_11000# 0.01106f
C1561 en m1_8466_10270# 0.14207f
C1562 m1_6494_13030# sta 0.00958f
C1563 m1_6968_15350# a_3098_16080# 0.05476f
C1564 ta3 el 0.09314f
C1565 a_3098_3120# m1_3676_6970# 0.019f
C1566 a_7590_3120# ta3 0.00175f
C1567 a_488_17120# a_4588_13668# 0.00565f
C1568 vsrcp vbp_st 4.03846f
C1569 a_318_18520# mreset 0.0877f
C1570 m1_5286_6830# vdd 0.77048f
C1571 hold a_488_12040# 0.11117f
C1572 a_2180_13234# m1_7130_19630# 0
C1573 a_6680_5520# m1_3676_6970# 0.00513f
C1574 m1_7702_15650# sel1 0.12518f
C1575 a_3136_4480# vdd 1.2828f
C1576 hold m1_4568_19890# 0
C1577 vsrcp vreset 0.03653f
C1578 a_488_12040# a_6672_9234# 0.01306f
C1579 m1_2792_6140# el 0.02012f
C1580 a_7590_3120# m1_2792_6140# 0.17773f
C1581 chain ta3 0.06295f
C1582 vbp_syn sta 0.39828f
C1583 d1_bsel sel1 0.3069f
C1584 vs m1_2708_380# 0.01205f
C1585 a_8248_5320# vbn_ax 0.14976f
C1586 m1_6968_10190# a_5268_9138# 0.38485f
C1587 a_5524_11840# el 0.09344f
C1588 a_7034_18520# chain 0
C1589 spk m1_3676_6970# 0
C1590 hold m1_2470_19900# 0
C1591 tb3 ta1 0.02484f
C1592 chain m1_2792_6140# 0.4824f
C1593 ta3 m1_2062_6980# 0.39476f
C1594 m1_6968_10190# a_4588_8588# 0.01666f
C1595 m1_6968_10190# vbn_leak 0.16235f
C1596 m1_7702_10190# a_318_18520# 0
C1597 a_2542_3120# el 0.21074f
C1598 a_5524_11840# chain 0.24317f
C1599 spk sel0 0.78178f
C1600 m1_2792_6140# m1_2062_6980# 0.02979f
C1601 a_6140_14314# vbp_syn 0
C1602 a_3136_4480# m1_7702_15650# 0.00397f
C1603 a_5524_11840# m1_2062_6980# 0
C1604 chain a_2542_3120# 0.00316f
C1605 ta0 a_6378_4480# 0
C1606 ta2 m1_6968_15350# 0.09622f
C1607 tb3 m1_3902_19900# 0.11134f
C1608 hold a_318_18520# 0.38048f
C1609 m1_1046_10270# vbp_syn 0.00937f
C1610 a_2542_18520# a_3098_18520# 0.07836f
C1611 a_2800_5520# m1_2792_6140# 0.03211f
C1612 a_318_18520# a_6672_9234# 0
C1613 d2 vsrcp 0.092f
C1614 m1_6968_15350# a_4588_13668# 0.06724f
C1615 vdd m1_2678_13100# 0.42332f
C1616 vbn_leak a_672_20034# 0.21735f
C1617 a_6680_5520# m1_5942_6980# 0
C1618 pl_en d1 0.04345f
C1619 m1_9090_16790# tb3 0
C1620 vsrcp a_3098_11000# 0.06412f
C1621 m1_7158_7910# d1 0
C1622 m1_7930_11710# a_4588_13668# 0
C1623 m1_6968_10190# chain 0.00295f
C1624 vsrc vbn_ref 0.04012f
C1625 m1_4882_3700# vs 0.27445f
C1626 a_6934_4480# a_6378_4480# 0.02874f
C1627 a_3136_4480# sel2 0.02953f
C1628 a_2592_8154# a_6140_9234# 0.0112f
C1629 a_3272_6334# vbn_ref 0.16746f
C1630 a_6140_9234# en 0.19204f
C1631 a_5268_9138# vbp_st 0.38946f
C1632 pl_en m1_8466_15350# 0.00174f
C1633 d2 a_3098_18520# 0.14882f
C1634 a_2592_8154# m1_6190_19900# 0
C1635 m1_6494_5850# m1_3676_6970# 0.1485f
C1636 vbp_st a_4588_8588# 0.03181f
C1637 a_488_12040# vdd 1.60202f
C1638 m1_6940_14170# a_5268_14218# 0.12261f
C1639 m1_5504_19890# m1_4568_19890# 0.09724f
C1640 a_2800_17120# a_3136_4480# 0.03038f
C1641 a_3212_19360# m1_2956_19890# 0.00517f
C1642 m1_6190_19900# en 0
C1643 a_3136_4480# a_5366_3120# 0.06387f
C1644 vsrcp sta 0.10222f
C1645 vbn_leak vbp_st 0.81393f
C1646 vdd m1_4568_19890# 0.02006f
C1647 sel0 a_7034_3120# 0.02161f
C1648 a_1892_3934# a_4588_8588# 0
C1649 a_488_17120# a_5516_15680# 0
C1650 pl_en m1_7158_7910# 0.13088f
C1651 m1_2678_13100# m1_2112_14220# 0.15231f
C1652 a_6672_14314# m1_6940_14170# 0.3436f
C1653 a_7590_18520# sel1 0.00356f
C1654 a_2592_8154# m1_8326_19030# 0.10021f
C1655 a_2592_8154# vbn_ax 0.14634f
C1656 vbn_leak vreset 0.3202f
C1657 a_1892_3934# vbn_leak 0.08786f
C1658 chain a_672_20034# 0.07421f
C1659 a_2180_13234# a_5366_18520# 0.02765f
C1660 vbn_ax en 0.05438f
C1661 m1_2712_6970# vdd 0.02665f
C1662 pl_en m1_7702_12990# 0.04781f
C1663 m1_7702_10190# ta3 0.01151f
C1664 a_2592_8154# a_488_17120# 0.31514f
C1665 m1_2470_19900# vdd 0.02516f
C1666 a_488_17120# en 0.08175f
C1667 m1_8466_15350# a_3098_16080# 0.04161f
C1668 vbn_leak a_2542_18520# 0.00199f
C1669 pl_en a_3098_16080# 0.0374f
C1670 m1_7790_19900# ta1 0
C1671 a_8248_5320# m1_7206_2340# 0.00888f
C1672 a_6140_14314# vsrcp 0.27092f
C1673 vbn_prb a_4096_6334# 0.05538f
C1674 ta0 a_5516_10600# 0
C1675 a_5524_11840# m1_7702_10190# 0.03217f
C1676 m1_7930_16790# vdd 0.07861f
C1677 a_7590_3120# vbp_st 0
C1678 hold ta3 0.2298f
C1679 vbp_st el 0.18944f
C1680 m1_5504_19890# a_318_18520# 0.00152f
C1681 ta3 a_6672_9234# 0.02112f
C1682 m1_5432_10260# d1 0.01382f
C1683 hold a_7034_18520# 0.05386f
C1684 a_1892_3934# el 0.05825f
C1685 a_1892_3934# a_7590_3120# 0.03152f
C1686 m1_2668_7940# d1 0.2881f
C1687 ta2 d1 0.12966f
C1688 vdd a_318_18520# 1.2313f
C1689 d1_bsel m1_4568_19890# 0.09598f
C1690 vreset el 0.03898f
C1691 a_7590_3120# vreset 0
C1692 hold m1_2792_6140# 0.13253f
C1693 m1_6716_16790# sel1 0
C1694 chain vbp_st 0.3909f
C1695 m1_7790_19900# m1_3902_19900# 0
C1696 en m1_2722_2630# 0.00345f
C1697 m1_5942_6980# m1_6494_5850# 0.05843f
C1698 a_5524_11840# hold 0.32016f
C1699 m1_8326_19030# a_5524_16920# 0.02685f
C1700 a_728_3738# vdd 0.74903f
C1701 ta0 m1_3676_6970# 0.1631f
C1702 a_2542_11000# d1 0
C1703 d1 a_4588_13668# 0
C1704 d1_bsel m1_2470_19900# 0.01201f
C1705 a_1892_3934# chain 0.57203f
C1706 a_5268_9138# a_3098_11000# 0.17514f
C1707 m1_7158_13030# m1_5190_15350# 0.04229f
C1708 a_5524_16920# vbn_ax 0.00524f
C1709 vbn_leak d2 0.33728f
C1710 vbp_st m1_2062_6980# 0.49165f
C1711 a_5524_11840# a_6672_9234# 0.59391f
C1712 a_4710_4480# a_4096_6334# 0.09823f
C1713 a_3098_11000# a_4588_8588# 0.0075f
C1714 a_5516_15680# m1_6968_15350# 0
C1715 a_5524_16920# a_488_17120# 0.09721f
C1716 vbp_syn a_5366_18520# 0.02355f
C1717 a_1892_3934# m1_2062_6980# 0
C1718 m1_5432_10260# pl_en 0.21769f
C1719 vbn_leak a_3098_11000# 0.21415f
C1720 a_2592_8154# m1_6968_15350# 0.2849f
C1721 a_2592_8154# tb0 0.08715f
C1722 a_8248_5320# d1 0.56008f
C1723 en m1_6968_15350# 0.15586f
C1724 m1_6190_19900# stb 0.08746f
C1725 ta2 pl_en 0.02607f
C1726 sel2 a_488_12040# 0
C1727 m1_2862_14560# a_2180_13234# 0.1087f
C1728 m1_7702_15650# a_318_18520# 0
C1729 a_2800_5520# vbp_st 0
C1730 m1_6968_10190# m1_7702_10190# 0.0118f
C1731 m1_5432_10260# m1_7158_7910# 0.09255f
C1732 vbn_ax stb 0.11836f
C1733 d1_bsel a_318_18520# 0.00378f
C1734 pl_en a_4588_13668# 0.03225f
C1735 vbn_leak m1_2708_380# 0
C1736 a_2800_5520# a_1892_3934# 0.49932f
C1737 ta2 m1_7158_7910# 0.08302f
C1738 a_2592_8154# m1_7930_11710# 0.01078f
C1739 a_6934_4480# m1_3676_6970# 0
C1740 a_5268_9138# sta 0.22835f
C1741 d2 el 0.5603f
C1742 a_2180_13234# m1_2712_15340# 0.24223f
C1743 m1_1046_17880# vbn_ax 0.03766f
C1744 a_3136_4480# vbn_ref 0
C1745 vbn_prb a_3098_3120# 0
C1746 ta2 m1_4282_6970# 0
C1747 sta a_4588_8588# 0.20927f
C1748 m1_6968_10190# hold 0.06074f
C1749 a_1480_3834# m1_2722_2630# 0.00591f
C1750 m1_1046_17880# a_488_17120# 0.13482f
C1751 tb2 a_318_18520# 0.00135f
C1752 vs a_6378_4480# 0.00427f
C1753 a_3098_11000# el 0.36665f
C1754 m1_7702_12990# a_4588_13668# 0.06567f
C1755 ta2 a_3098_16080# 0.04682f
C1756 vbn_leak sta 0.23614f
C1757 m1_6968_10190# a_6672_9234# 0.02525f
C1758 d2 chain 0.02618f
C1759 a_488_5520# a_3098_3120# 0.01209f
C1760 m1_5942_6980# ta0 0.02437f
C1761 a_4588_13668# a_3098_16080# 0.01356f
C1762 tb0 a_5524_16920# 0.00159f
C1763 chain a_3098_11000# 0.08597f
C1764 m1_6716_11710# a_5524_16920# 0
C1765 m1_5190_15350# a_5268_14218# 0.04278f
C1766 vbp_st mreset 0.02683f
C1767 a_3098_3120# a_4096_6334# 0.01303f
C1768 a_5524_16920# m1_6968_15350# 0.16727f
C1769 m1_5504_19890# ta3 0.1659f
C1770 spk vbn_prb 0.1561f
C1771 en m1_7206_2340# 0.07716f
C1772 m1_8326_19030# m1_7206_18030# 0.00118f
C1773 vbn_ax m1_7206_18030# 0.29044f
C1774 a_6680_5520# a_4096_6334# 0.15571f
C1775 sel2 a_318_18520# 0.02159f
C1776 m1_6940_14170# ta0 0.05847f
C1777 ta3 vdd 0.93426f
C1778 a_1892_3934# mreset 0
C1779 a_3098_11000# m1_2062_6980# 0.00447f
C1780 a_6672_14314# m1_5190_15350# 0.17374f
C1781 a_6140_14314# vbn_leak 0.07248f
C1782 a_4710_4480# a_3098_3120# 0
C1783 vreset mreset 0.16554f
C1784 m1_2862_14560# vbp_syn 0.10925f
C1785 hold a_672_20034# 0.05592f
C1786 a_488_17120# m1_7206_18030# 0.42004f
C1787 a_7034_18520# vdd 0.13057f
C1788 a_6140_9234# ta1 0.03802f
C1789 a_2800_17120# a_318_18520# 0.05523f
C1790 vbn_prb a_6672_14314# 0.06342f
C1791 a_5366_3120# a_318_18520# 0.12968f
C1792 a_6680_5520# a_4710_4480# 0.05149f
C1793 sta el 0.13145f
C1794 m1_2792_6140# vdd 0.99014f
C1795 spk a_4096_6334# 0.3365f
C1796 vbn_leak m1_1046_10270# 0.18587f
C1797 m1_6190_19900# ta1 0.0912f
C1798 a_5524_11840# vdd 1.01995f
C1799 vbn_leak m1_7130_19630# 0.04506f
C1800 m1_2668_7940# m1_5432_10260# 0
C1801 chain sta 0.11616f
C1802 ta2 m1_5432_10260# 0.01148f
C1803 m1_7702_10190# vbp_st 0.00102f
C1804 vbp_syn m1_2712_15340# 0.04651f
C1805 a_4710_4480# spk 0.02384f
C1806 vbn_ax ta1 0.00678f
C1807 a_488_17120# ta1 0.02807f
C1808 vs abus 0.04038f
C1809 vdd a_2542_3120# 0.00276f
C1810 m1_7702_15650# ta3 0.01251f
C1811 m1_2062_6980# sta 0
C1812 a_6140_14314# el 0
C1813 a_6594_420# m1_2722_2630# 0.10263f
C1814 a_2592_8154# d1 0.74367f
C1815 ta2 a_4588_13668# 0.04222f
C1816 en d1 0.20137f
C1817 vbp_syn a_5516_10600# 0.01959f
C1818 hold vbp_st 0.14421f
C1819 m1_6190_19900# m1_3902_19900# 0.20439f
C1820 d1_bsel a_7034_18520# 0
C1821 m1_910_6150# a_728_3738# 0.01414f
C1822 a_1892_3934# hold 0
C1823 m1_1046_10270# el 0.01709f
C1824 vbp_st a_6672_9234# 0.08278f
C1825 a_6140_14314# chain 0.0452f
C1826 m1_8326_19030# m1_3902_19900# 0.0045f
C1827 a_7590_18520# a_318_18520# 0.50043f
C1828 vbn_ax m1_3902_19900# 0.74376f
C1829 tb2 ta3 0.00845f
C1830 a_8248_5320# ta2 0
C1831 a_488_17120# m1_3902_19900# 0.17198f
C1832 a_6672_14314# m1_7158_13030# 0.00531f
C1833 pl_en a_5516_15680# 0.00865f
C1834 a_3212_19360# a_2180_13234# 0.00361f
C1835 hold a_2542_18520# 0.00848f
C1836 vbn_prb a_7034_3120# 0.00573f
C1837 m1_4882_3700# el 0.68588f
C1838 vbp_syn m1_3676_6970# 0
C1839 m1_6968_10190# vdd 0.00107f
C1840 a_6140_9234# vsrc 0
C1841 a_2592_8154# m1_8466_15350# 0.00224f
C1842 a_488_19360# a_318_18520# 0.10813f
C1843 a_6680_5520# a_3098_3120# 0
C1844 m1_4882_3700# a_7590_3120# 0.19931f
C1845 m1_8466_15350# en 0.09315f
C1846 a_2592_8154# pl_en 0.12622f
C1847 pl_en en 2.57937f
C1848 m1_8326_19030# m1_9090_16790# 0
C1849 m1_4882_3700# chain 0.06428f
C1850 vs m1_3676_6970# 0
C1851 m1_9090_16790# a_488_17120# 0
C1852 vbn_leak tb1 0.01121f
C1853 m1_7158_7910# en 0
C1854 a_7034_3120# a_4096_6334# 0
C1855 vbn_ax vsrc 0.26721f
C1856 spk a_3098_3120# 0.05531f
C1857 m1_8326_19030# vsrc 0
C1858 a_3136_4480# m1_7684_7940# 0.10946f
C1859 a_6680_5520# spk 0.1025f
C1860 a_5524_16920# d1 0
C1861 a_2592_8154# m1_7702_12990# 0.0169f
C1862 ta1 m1_6968_15350# 0.08837f
C1863 a_3272_6334# vbn_ax 0.14659f
C1864 m1_7702_10190# a_3098_11000# 0.10777f
C1865 a_5516_15680# a_3098_16080# 0.08954f
C1866 a_488_17120# vsrc 0
C1867 m1_5504_19890# a_672_20034# 0.05147f
C1868 vs sel0 0.39221f
C1869 m1_4282_6970# en 0.00648f
C1870 m1_2862_14560# vsrcp 0
C1871 a_1480_3834# m1_2122_6150# 0.03781f
C1872 d2 hold 0.46226f
C1873 a_2592_8154# a_3098_16080# 0.20435f
C1874 a_672_20034# vdd 0.43412f
C1875 a_5524_11840# sel2 0.03348f
C1876 en a_3098_16080# 0.47464f
C1877 a_318_18520# vbn_ref 0
C1878 m1_2792_6140# a_5366_3120# 0
C1879 a_6140_9234# m1_7150_9086# 0.28918f
C1880 vsrcp abus 0.14376f
C1881 tb3 a_318_18520# 0
C1882 a_2800_5520# m1_4882_3700# 0.01275f
C1883 hold a_3098_11000# 0.90591f
C1884 tb0 m1_3902_19900# 0
C1885 tb1 el 0
C1886 a_5524_16920# m1_8466_15350# 0
C1887 a_3098_11000# a_6672_9234# 0.1318f
C1888 a_5524_16920# pl_en 0.18638f
C1889 a_3212_19360# vbp_syn 0.13227f
C1890 m1_7158_7910# m1_6494_7910# 0
C1891 m1_5190_15350# ta0 0.00334f
C1892 a_6672_14314# a_5268_14218# 0.02127f
C1893 vsrc m1_2722_2630# 0.02436f
C1894 vbn_leak a_5366_18520# 0
C1895 vbp_st m1_5504_19890# 0
C1896 m1_910_6150# m1_2792_6140# 0
C1897 vsrcp a_5516_10600# 0
C1898 a_3272_6334# m1_2722_2630# 0.19584f
C1899 vbp_st vdd 6.09809f
C1900 a_7590_18520# ta3 0.03083f
C1901 a_5524_16920# m1_7702_12990# 0
C1902 d1_bsel a_672_20034# 0.54864f
C1903 a_7590_18520# a_7034_18520# 0.20275f
C1904 a_1892_3934# vdd 0.80604f
C1905 hold sta 0.82381f
C1906 ta2 a_5516_15680# 0
C1907 vreset vdd 0.17731f
C1908 a_2592_8154# m1_5432_10260# 0.09702f
C1909 tb0 vsrc 0
C1910 pl_en stb 0.0147f
C1911 a_2592_8154# ta2 0.0525f
C1912 a_2592_8154# m1_2668_7940# 0.07065f
C1913 m1_5432_10260# en 0.14416f
C1914 a_5524_16920# a_3098_16080# 0.05059f
C1915 tb2 a_672_20034# 0.00237f
C1916 vdd m1_1968_380# 0.11022f
C1917 m1_4882_3700# mreset 0
C1918 sta a_6672_9234# 0.00677f
C1919 ta2 en 0.18456f
C1920 vsrcp m1_3676_6970# 0
C1921 a_6594_420# d1 0.1239f
C1922 a_5516_15680# a_4588_13668# 0.14834f
C1923 a_2542_18520# vdd 0.21001f
C1924 m1_6190_19900# sel1 0.03427f
C1925 a_6680_5520# m1_6494_5850# 0.01437f
C1926 a_2592_8154# a_2542_11000# 0.01106f
C1927 a_2592_8154# a_4588_13668# 0.02005f
C1928 en a_4588_13668# 0.10186f
C1929 a_6140_14314# hold 0.02623f
C1930 vsrcp sel0 0.03161f
C1931 m1_7702_15650# vbp_st 0
C1932 vbn_ax sel1 0.03547f
C1933 a_488_5520# a_874_3120# 0.00696f
C1934 spk a_7034_3120# 0.03052f
C1935 d1 m1_642_6980# 0
C1936 m1_7684_7940# a_488_12040# 0.06178f
C1937 a_874_11000# el 0.05225f
C1938 a_488_17120# sel1 0.06743f
C1939 chain a_5366_18520# 0.0051f
C1940 spk m1_6494_5850# 0
C1941 a_488_12040# m1_8466_10270# 0.05409f
C1942 a_3136_4480# a_6140_9234# 0.01297f
C1943 m1_7158_13030# ta0 0.00719f
C1944 a_6378_4480# el 0.12527f
C1945 a_7590_3120# a_6378_4480# 0.13507f
C1946 m1_5432_10260# m1_6494_7910# 0
C1947 m1_1046_17880# a_3098_16080# 0.00371f
C1948 m1_1080_6970# d1 0.01931f
C1949 m1_1046_10270# hold 0.46891f
C1950 ta1 d1 0.16987f
C1951 pl_en m1_7206_18030# 0.04288f
C1952 ta2 m1_6494_7910# 0.00144f
C1953 tb3 ta3 0.00387f
C1954 hold m1_7130_19630# 0.00339f
C1955 d2 vdd 1.54047f
C1956 d1_bsel a_2542_18520# 0
C1957 vbn_leak m1_2862_14560# 0
C1958 tb3 a_7034_18520# 0
C1959 m1_5286_6830# vbn_ax 0
C1960 m1_2668_7940# a_1480_3834# 0
C1961 vsrc m1_7206_2340# 0.20526f
C1962 chain a_6378_4480# 0.08971f
C1963 m1_4882_3700# hold 0
C1964 ta2 a_5524_16920# 0.03854f
C1965 a_3136_4480# vbn_ax 0.09586f
C1966 a_3098_11000# vdd 1.87294f
C1967 a_874_18520# vdd 0.33898f
C1968 a_3272_6334# m1_7206_2340# 0.0222f
C1969 vbn_leak abus 0.24495f
C1970 a_3136_4480# a_488_17120# 0
C1971 a_5524_16920# a_4588_13668# 0.92146f
C1972 vbn_leak m1_2712_15340# 0.1325f
C1973 m1_7206_18030# a_3098_16080# 0.01567f
C1974 pl_en ta1 0.03708f
C1975 vbp_st sel2 0.03412f
C1976 a_6680_5520# ta0 0.00211f
C1977 a_5268_9138# a_5516_10600# 0.21177f
C1978 m1_2708_380# vdd 0.02691f
C1979 a_4588_8588# a_5516_10600# 0.05726f
C1980 vsrcp m1_6940_14170# 0.3853f
C1981 d2 m1_7702_15650# 0.3706f
C1982 vreset sel2 0.02697f
C1983 a_2800_5520# a_6378_4480# 0.00217f
C1984 m1_7158_7910# ta1 0.04727f
C1985 sel1 m1_6968_15350# 0.15492f
C1986 m1_5504_19890# sta 0.00521f
C1987 vbn_leak a_5516_10600# 0.16988f
C1988 m1_2862_14560# el 0.07504f
C1989 a_7590_18520# a_672_20034# 0.00117f
C1990 d2 d1_bsel 0.00261f
C1991 sta vdd 0.59526f
C1992 abus el 0.09812f
C1993 pl_en m1_3902_19900# 0.00378f
C1994 d2 m1_2112_14220# 0.00617f
C1995 ta0 a_5268_14218# 0.18521f
C1996 a_3212_19360# a_3098_18520# 0.0073f
C1997 a_3136_4480# m1_2722_2630# 0.08777f
C1998 vsrc d1 0.04777f
C1999 a_5268_9138# m1_3676_6970# 0
C2000 a_2800_17120# a_2542_18520# 0.00237f
C2001 ta1 a_3098_16080# 0.053f
C2002 d1_bsel a_874_18520# 0
C2003 a_488_19360# a_672_20034# 0.01864f
C2004 a_4588_8588# m1_3676_6970# 0.00461f
C2005 m1_2712_15340# el 0.02668f
C2006 a_3272_6334# d1 0.04029f
C2007 a_6672_14314# ta0 0.00416f
C2008 vbn_leak m1_3676_6970# 0.55125f
C2009 a_6680_5520# a_6934_4480# 0.04366f
C2010 m1_910_6150# vbp_st 0.01206f
C2011 vbp_syn m1_5190_15350# 0.00164f
C2012 a_6140_14314# m1_5504_19890# 0.00571f
C2013 a_3272_6334# m1_2122_6150# 0.00355f
C2014 a_3136_4480# m1_6968_15350# 0.06745f
C2015 a_6140_14314# vdd 0.97016f
C2016 a_5516_10600# el 0
C2017 vbn_leak sel0 0.04495f
C2018 a_6140_9234# a_488_12040# 0.078f
C2019 a_5516_15680# en 0.08257f
C2020 ta2 m1_7206_18030# 0.03107f
C2021 m1_7702_15650# sta 0
C2022 m1_3902_19900# a_3098_16080# 0.19354f
C2023 a_7590_18520# vbp_st 0.00373f
C2024 a_2592_8154# en 0.49585f
C2025 m1_5504_19890# m1_7130_19630# 0.12352f
C2026 m1_1046_10270# vdd 0.121f
C2027 chain a_5516_10600# 0.00217f
C2028 d1_bsel sta 0.25185f
C2029 vdd m1_7130_19630# 0.37159f
C2030 vs vbn_prb 0.20635f
C2031 a_2800_17120# d2 0.01454f
C2032 m1_7150_9086# d1 0.03685f
C2033 m1_6190_19900# m1_4568_19890# 0
C2034 tb3 a_672_20034# 0.00798f
C2035 m1_9090_16790# a_3098_16080# 0.00555f
C2036 m1_4882_3700# vdd 0.01418f
C2037 a_488_5520# vs 0.55936f
C2038 m1_5432_10260# ta1 0.01257f
C2039 vbn_leak m1_9090_11710# 0
C2040 ta2 ta1 3.25261f
C2041 a_6140_14314# m1_7702_15650# 0.01414f
C2042 hold a_5366_18520# 0.17459f
C2043 vbn_ax m1_4568_19890# 0.04087f
C2044 sel0 el 0.04803f
C2045 a_7590_3120# sel0 0
C2046 vs a_4096_6334# 0.66536f
C2047 a_488_19360# a_2542_18520# 0.00747f
C2048 chain m1_3676_6970# 0.10527f
C2049 m1_5942_6980# a_4588_8588# 0
C2050 m1_7684_7940# ta3 0.02408f
C2051 a_874_11000# hold 0.00181f
C2052 ta1 a_4588_13668# 0.03054f
C2053 vbn_leak a_3212_19360# 0.23245f
C2054 ta0 m1_6494_5850# 0.52283f
C2055 m1_6716_16790# vbp_st 0.03147f
C2056 a_3136_4480# m1_7206_2340# 0.17764f
C2057 vs a_4710_4480# 0.46926f
C2058 en m1_6494_7910# 0
C2059 vbn_leak m1_5942_6980# 0.5572f
C2060 a_5524_16920# a_5516_15680# 0.24409f
C2061 hold a_6378_4480# 0
C2062 m1_2062_6980# m1_3676_6970# 0.40027f
C2063 pl_en m1_7150_9086# 0.0045f
C2064 a_6140_9234# a_318_18520# 0
C2065 a_2542_16080# a_2542_18520# 0
C2066 a_6140_14314# tb2 0.00611f
C2067 a_2180_13234# a_5268_14218# 0.02343f
C2068 a_2592_8154# a_5524_16920# 0.01675f
C2069 ta2 m1_3902_19900# 0.0352f
C2070 d1_bsel m1_7130_19630# 0
C2071 abus mreset 0.04665f
C2072 a_8248_5320# ta1 0
C2073 a_5524_11840# m1_7684_7940# 0
C2074 vbn_leak m1_6940_14170# 0
C2075 a_5524_16920# en 0.22734f
C2076 tb3 vbp_st 0
C2077 vbp_st vbn_ref 0.03502f
C2078 m1_7150_9086# m1_7158_7910# 0
C2079 a_5524_11840# m1_8466_10270# 0
C2080 m1_9090_11710# el 0
C2081 a_7590_18520# d2 0.03163f
C2082 vbn_ax m1_7930_16790# 0
C2083 a_488_17120# m1_7930_16790# 0
C2084 vreset vbn_ref 4.48812f
C2085 m1_8326_19030# a_318_18520# 0.00728f
C2086 m1_5504_19890# tb1 0.08151f
C2087 tb2 m1_7130_19630# 0.18527f
C2088 vbn_ax a_318_18520# 0.43917f
C2089 d2 a_488_19360# 0.00821f
C2090 vdd tb1 0.33652f
C2091 a_6934_4480# a_7034_3120# 0.0115f
C2092 m1_2236_8010# d1 0.33342f
C2093 a_488_17120# a_318_18520# 1.26686f
C2094 a_2180_13234# m1_2956_19890# 0
C2095 a_6934_4480# m1_6494_5850# 0
C2096 vsrcp m1_5190_15350# 0.06274f
C2097 a_2592_8154# stb 0.17431f
C2098 stb en 0.00794f
C2099 a_488_12040# m1_6968_15350# 0.00261f
C2100 vbn_prb vsrcp 0.08844f
C2101 m1_8466_15350# sel1 0.25395f
C2102 a_874_18520# a_488_19360# 0.0814f
C2103 pl_en sel1 0.00203f
C2104 a_3212_19360# chain 0
C2105 m1_5286_6830# d1 0.09801f
C2106 m1_7702_10190# abus 0.0245f
C2107 a_2592_8154# m1_1046_17880# 0.01266f
C2108 m1_6940_14170# el 0.00122f
C2109 a_3136_4480# d1 0.86097f
C2110 chain m1_5942_6980# 0.05335f
C2111 a_2800_12040# vbp_syn 0.09634f
C2112 m1_2862_14560# hold 0.01207f
C2113 d2 m1_6716_16790# 0.01771f
C2114 vs a_3098_3120# 0.00197f
C2115 m1_6968_10190# m1_7684_7940# 0.11259f
C2116 m1_7930_11710# a_488_12040# 0.00715f
C2117 a_7590_18520# sta 0.00219f
C2118 a_6672_14314# m1_6494_13030# 0
C2119 vs a_6680_5520# 0.20467f
C2120 m1_5942_6980# m1_2062_6980# 0.08538f
C2121 vbp_syn a_5268_14218# 0.00519f
C2122 m1_2722_2630# a_318_18520# 0.1115f
C2123 a_8248_5320# vsrc 0.08141f
C2124 abus a_6672_9234# 0.04944f
C2125 a_5516_15680# m1_7206_18030# 0
C2126 hold m1_2712_15340# 0.04095f
C2127 sel1 a_3098_16080# 0.13926f
C2128 sel0 mreset 0.29701f
C2129 m1_4882_3700# a_5366_3120# 0.01359f
C2130 a_2592_8154# m1_7206_18030# 0.33822f
C2131 a_6594_420# en 0.14986f
C2132 a_8248_5320# a_3272_6334# 0.05577f
C2133 a_3136_4480# pl_en 0.12661f
C2134 vdd a_5366_18520# 0.25147f
C2135 en m1_7206_18030# 0.05474f
C2136 a_728_3738# m1_2722_2630# 0.00191f
C2137 vs spk 8.08403f
C2138 ta2 m1_7150_9086# 0.00928f
C2139 tb0 a_318_18520# 0.01179f
C2140 tb2 tb1 0.45124f
C2141 a_3136_4480# m1_7158_7910# 0.00607f
C2142 a_874_11000# vdd 0.14761f
C2143 hold a_5516_10600# 0.12075f
C2144 a_6140_9234# ta3 0.02919f
C2145 m1_2956_19890# vbp_syn 0.00947f
C2146 vdd a_6378_4480# 0.09326f
C2147 m1_5286_6830# m1_4282_6970# 0.04372f
C2148 a_3136_4480# m1_7702_12990# 0.10968f
C2149 m1_6716_16790# sta 0.00704f
C2150 m1_6190_19900# ta3 0
C2151 a_3136_4480# m1_4282_6970# 0
C2152 ta1 a_5516_15680# 0
C2153 m1_6190_19900# a_7034_18520# 0
C2154 a_7590_18520# m1_7130_19630# 0.06748f
C2155 a_2592_8154# ta1 0.0429f
C2156 a_2592_8154# m1_1080_6970# 0
C2157 a_5524_11840# a_6140_9234# 0.68871f
C2158 a_3136_4480# a_3098_16080# 0.08968f
C2159 ta1 en 0.0546f
C2160 vbn_ax ta3 0.00379f
C2161 hold m1_3676_6970# 0.29946f
C2162 tb3 sta 0
C2163 a_7034_18520# vbn_ax 0
C2164 a_488_17120# ta3 0.03778f
C2165 d1_bsel a_5366_18520# 0.00142f
C2166 m1_2792_6140# vbn_ax 0.01013f
C2167 a_488_17120# a_7034_18520# 0.06372f
C2168 ta2 sel1 0.03962f
C2169 a_5524_16920# m1_7206_18030# 0.00111f
C2170 a_5268_9138# vbn_prb 0.02765f
C2171 vbp_st m1_8466_10270# 0.00145f
C2172 a_2592_8154# m1_3902_19900# 0.25832f
C2173 en m1_3902_19900# 0.00539f
C2174 vbn_leak m1_5190_15350# 0.10871f
C2175 a_318_18520# m1_7206_2340# 0.32011f
C2176 a_488_12040# d1 0.21798f
C2177 a_6140_14314# tb3 0
C2178 a_2180_13234# ta0 0
C2179 m1_2668_7940# m1_2236_8010# 0.03107f
C2180 a_2800_12040# vsrcp 0
C2181 vbn_leak vbn_prb 0.65617f
C2182 m1_2862_14560# vdd 0.21616f
C2183 vs a_7034_3120# 0
C2184 m1_2712_6970# d1 0.00115f
C2185 m1_6968_10190# a_6140_9234# 0.05322f
C2186 stb m1_7206_18030# 0
C2187 spk vsrcp 0.06757f
C2188 ta2 m1_5286_6830# 0.05735f
C2189 vbn_leak a_488_5520# 0.0032f
C2190 a_3136_4480# m1_5432_10260# 0.03195f
C2191 vsrcp a_5268_14218# 0.3256f
C2192 abus vdd 0.24465f
C2193 a_1480_3834# m1_1080_6970# 0
C2194 m1_2668_7940# a_3136_4480# 0.00447f
C2195 a_5524_16920# ta1 0.06138f
C2196 m1_9090_11710# a_6672_9234# 0.02583f
C2197 ta2 a_3136_4480# 0.15188f
C2198 m1_2678_13100# a_3098_16080# 0.01156f
C2199 tb3 m1_7130_19630# 0.24812f
C2200 vbn_leak a_4096_6334# 0.10837f
C2201 vdd m1_2712_15340# 0.18067f
C2202 a_3212_19360# hold 0.29116f
C2203 vsrc en 0.30092f
C2204 pl_en a_488_12040# 0.11651f
C2205 vsrcp a_6672_14314# 0.57039f
C2206 a_7590_18520# tb1 0.00164f
C2207 m1_5190_15350# el 0.04146f
C2208 a_3136_4480# a_4588_13668# 0.53926f
C2209 tb0 ta3 0.23705f
C2210 hold m1_5942_6980# 0.01198f
C2211 ta3 m1_6968_15350# 0.06753f
C2212 a_3272_6334# en 0.25072f
C2213 vbn_leak a_4710_4480# 0
C2214 pl_en m1_4568_19890# 0
C2215 vbn_prb el 0.12003f
C2216 vbn_prb a_7590_3120# 0.01744f
C2217 m1_7158_7910# a_488_12040# 0.00264f
C2218 a_5524_16920# m1_3902_19900# 0.02063f
C2219 a_8248_5320# m1_5286_6830# 0.01761f
C2220 vdd a_5516_10600# 0.2387f
C2221 hold m1_6940_14170# 0.06608f
C2222 chain m1_5190_15350# 0.03294f
C2223 m1_2722_2630# a_2542_3120# 0.36314f
C2224 a_318_18520# d1 1.85907f
C2225 a_488_12040# m1_7702_12990# 0.00368f
C2226 a_488_5520# el 0.08154f
C2227 a_8248_5320# a_3136_4480# 0.27617f
C2228 a_5524_11840# m1_6716_11710# 0.00126f
C2229 m1_7702_15650# abus 0.09877f
C2230 a_5366_3120# a_6378_4480# 0.00251f
C2231 m1_7930_11710# ta3 0.00504f
C2232 m1_2862_14560# m1_2112_14220# 0.26305f
C2233 a_4096_6334# el 0.0745f
C2234 a_728_3738# d1 0
C2235 m1_6190_19900# a_672_20034# 0.10851f
C2236 a_7590_3120# a_4096_6334# 0.05315f
C2237 m1_7684_7940# a_3098_11000# 0.04186f
C2238 a_3098_11000# m1_8466_10270# 0.00268f
C2239 a_488_5520# chain 0.00131f
C2240 m1_9090_16790# a_5524_16920# 0.01091f
C2241 a_728_3738# m1_2122_6150# 0.02262f
C2242 m1_2712_6970# m1_4282_6970# 0.00211f
C2243 vdd m1_3676_6970# 0.42883f
C2244 a_2592_8154# m1_7150_9086# 0.00146f
C2245 a_4710_4480# a_7590_3120# 0.17841f
C2246 a_4710_4480# el 0.16038f
C2247 stb m1_3902_19900# 0.17077f
C2248 vbn_ax a_672_20034# 0.2937f
C2249 chain a_4096_6334# 0.16771f
C2250 m1_2112_14220# m1_2712_15340# 0
C2251 a_7590_18520# a_5366_18520# 0.22766f
C2252 m1_2956_19890# a_3098_18520# 0.00533f
C2253 pl_en a_318_18520# 0.01101f
C2254 a_1480_3834# vsrc 0.0532f
C2255 a_488_5520# m1_2062_6980# 0
C2256 sel0 vdd 0.18092f
C2257 tb3 tb1 0.1238f
C2258 a_4710_4480# chain 0.001f
C2259 m1_2062_6980# a_4096_6334# 0
C2260 a_1480_3834# a_3272_6334# 0.27707f
C2261 m1_2678_13100# a_4588_13668# 0
C2262 ta1 m1_7206_18030# 0.04239f
C2263 vsrcp m1_6494_5850# 0
C2264 a_3098_3120# a_4588_8588# 0
C2265 a_6140_9234# vbp_st 0.13381f
C2266 vbn_leak a_3098_3120# 0.1984f
C2267 m1_7158_13030# el 0.11099f
C2268 a_2800_5520# a_488_5520# 0.00598f
C2269 a_4710_4480# m1_2062_6980# 0
C2270 m1_2792_6140# m1_7206_2340# 0
C2271 vbn_leak a_6680_5520# 0.02514f
C2272 a_2800_12040# a_4588_8588# 0
C2273 abus sel2 0.08267f
C2274 sel1 a_5516_15680# 0
C2275 m1_5432_10260# a_488_12040# 0
C2276 a_2800_5520# a_4096_6334# 0.34646f
C2277 m1_1080_6970# m1_642_6980# 0.00279f
C2278 vbn_leak a_2800_12040# 0.34004f
C2279 m1_9090_11710# vdd 0.08576f
C2280 a_318_18520# a_3098_16080# 0.00827f
C2281 a_874_3120# vs 0.25784f
C2282 m1_2112_9090# vbp_syn 0.27359f
C2283 vbp_st vbn_ax 4.12235f
C2284 m1_8326_19030# vbp_st 0.01376f
C2285 a_2592_8154# sel1 0.21926f
C2286 ta2 a_488_12040# 0.06126f
C2287 d2 a_874_16080# 0.01761f
C2288 sel1 en 0.2153f
C2289 m1_3902_19900# m1_7206_18030# 0.2096f
C2290 a_488_17120# vbp_st 0.15358f
C2291 a_2800_5520# a_4710_4480# 0.08423f
C2292 vbn_leak spk 1.12333f
C2293 a_2800_17120# m1_2712_15340# 0.06801f
C2294 vreset vbn_ax 0.06641f
C2295 vbn_leak a_5268_14218# 0.21595f
C2296 a_3212_19360# vdd 1.27759f
C2297 a_2542_11000# a_488_12040# 0.01199f
C2298 a_488_12040# a_4588_13668# 0.01204f
C2299 a_874_16080# a_874_18520# 0
C2300 m1_7790_19900# m1_7130_19630# 0
C2301 vbn_prb mreset 0.56798f
C2302 m1_2668_7940# m1_2712_6970# 0.00447f
C2303 a_3098_3120# el 0.07022f
C2304 a_7590_3120# a_3098_3120# 0.00555f
C2305 m1_5942_6980# vdd 0.00601f
C2306 a_2592_8154# m1_2236_8010# 0.11023f
C2307 vbn_ax a_2542_18520# 0
C2308 ta3 d1 0.18893f
C2309 vbn_leak a_6672_14314# 0.00203f
C2310 a_6680_5520# a_7590_3120# 0.07067f
C2311 a_6680_5520# el 0.12495f
C2312 a_488_17120# a_2542_18520# 0.03281f
C2313 a_3136_4480# a_5516_15680# 0.00945f
C2314 a_8248_5320# a_488_12040# 0
C2315 a_2180_13234# vbp_syn 0.25638f
C2316 a_6594_420# vsrc 0.15906f
C2317 a_3098_3120# chain 0.23654f
C2318 m1_2792_6140# d1 0.19746f
C2319 m1_5286_6830# en 0.14781f
C2320 a_2800_12040# el 0.07909f
C2321 a_2592_8154# a_3136_4480# 0.1267f
C2322 ta1 m1_3902_19900# 0.11204f
C2323 vbn_leak m1_2956_19890# 0.30159f
C2324 a_3136_4480# en 0.11914f
C2325 mreset a_4096_6334# 0.25106f
C2326 a_6680_5520# chain 0.15606f
C2327 a_3272_6334# a_6594_420# 0.23924f
C2328 spk a_7590_3120# 0
C2329 spk el 0.16949f
C2330 m1_2792_6140# m1_2122_6150# 0.001f
C2331 a_5524_11840# d1 0.3923f
C2332 vsrcp ta0 0.00844f
C2333 a_3098_3120# m1_2062_6980# 0.03455f
C2334 vbn_prb m1_7702_10190# 0.03436f
C2335 a_5268_14218# el 0.00373f
C2336 a_2800_12040# chain 0
C2337 a_4710_4480# mreset 0.00342f
C2338 a_6140_9234# a_3098_11000# 0.05047f
C2339 ta2 a_318_18520# 0.0224f
C2340 a_1892_3934# m1_2722_2630# 0.00135f
C2341 a_6680_5520# m1_2062_6980# 0
C2342 a_5524_16920# sel1 0.0115f
C2343 sel0 sel2 3.94927f
C2344 pl_en ta3 0.08003f
C2345 a_3212_19360# d1_bsel 0.13439f
C2346 d1 a_2542_3120# 0.10236f
C2347 spk chain 0.2186f
C2348 a_6672_14314# el 0
C2349 d2 vbn_ax 0.4175f
C2350 a_318_18520# a_4588_13668# 0
C2351 m1_2722_2630# m1_1968_380# 0.00113f
C2352 hold m1_5190_15350# 0.00832f
C2353 chain a_5268_14218# 0.00715f
C2354 tb0 vbp_st 0.00177f
C2355 a_7034_18520# pl_en 0
C2356 vbp_st m1_6968_15350# 0
C2357 m1_6716_11710# vbp_st 0.01312f
C2358 m1_2862_14560# a_2542_16080# 0.00144f
C2359 d2 a_488_17120# 0.16978f
C2360 sel0 a_5366_3120# 0
C2361 a_2800_5520# a_3098_3120# 0.29521f
C2362 m1_7158_7910# ta3 0.04316f
C2363 spk m1_2062_6980# 0
C2364 vbn_ax a_3098_11000# 0
C2365 a_2800_5520# a_6680_5520# 0.14032f
C2366 a_5524_11840# pl_en 0.04245f
C2367 ta3 m1_7702_12990# 0.00665f
C2368 a_6672_14314# chain 0.01357f
C2369 a_3136_4480# m1_6494_7910# 0.09605f
C2370 vbn_prb a_6672_9234# 0.04464f
C2371 a_488_17120# a_874_18520# 0.03775f
C2372 vbn_leak a_7034_3120# 0
C2373 ta3 m1_4282_6970# 0.00262f
C2374 stb sel1 0.02825f
C2375 m1_7790_19900# tb1 0.0092f
C2376 m1_9090_16790# m1_3902_19900# 0
C2377 a_6140_9234# sta 0.17744f
C2378 a_8248_5320# a_318_18520# 0.03261f
C2379 vbn_leak m1_6494_5850# 0.31837f
C2380 m1_7930_11710# vbp_st 0.00193f
C2381 a_2542_16080# m1_2712_15340# 0.34987f
C2382 ta3 a_3098_16080# 0.06769f
C2383 a_3136_4480# a_1480_3834# 0
C2384 a_5524_11840# m1_7158_7910# 0.12257f
C2385 a_3136_4480# a_5524_16920# 0.19205f
C2386 a_2800_5520# spk 0.34953f
C2387 hold a_4096_6334# 0
C2388 m1_2792_6140# m1_4282_6970# 0.02646f
C2389 m1_6968_10190# d1 0.28566f
C2390 a_7034_18520# a_3098_16080# 0
C2391 m1_2112_9090# vsrcp 0
C2392 m1_6190_19900# sta 0.04884f
C2393 hold a_4710_4480# 0
C2394 abus vbn_ref 0.25853f
C2395 a_2800_17120# a_3212_19360# 0
C2396 vbn_ax sta 0.00828f
C2397 a_3098_3120# mreset 0.00151f
C2398 a_488_17120# sta 0.0372f
C2399 m1_7150_9086# ta1 0.00773f
C2400 a_7034_3120# el 0
C2401 a_6680_5520# mreset 0.08662f
C2402 a_7590_3120# a_7034_3120# 0.12757f
C2403 m1_6968_10190# pl_en 0.09687f
C2404 sel1 m1_7206_18030# 0.05194f
C2405 hold m1_7158_13030# 0.00151f
C2406 d2 m1_6968_15350# 0.12832f
C2407 a_2592_8154# a_488_12040# 0.58859f
C2408 a_6140_14314# m1_8326_19030# 0.00388f
C2409 spk mreset 4.3613f
C2410 chain m1_6494_5850# 0.00995f
C2411 a_488_12040# en 0.0605f
C2412 a_6140_14314# vbn_ax 0.0012f
C2413 a_3272_6334# vsrc 0.53485f
C2414 m1_5432_10260# ta3 0.00834f
C2415 m1_6968_10190# m1_7158_7910# 0.13643f
C2416 m1_6716_11710# a_3098_11000# 0.00833f
C2417 a_5268_9138# ta0 0.27585f
C2418 a_2592_8154# m1_4568_19890# 0.00463f
C2419 ta2 ta3 2.97202f
C2420 a_6140_14314# a_488_17120# 0.27144f
C2421 en m1_4568_19890# 0.02294f
C2422 m1_6190_19900# m1_7130_19630# 0.01807f
C2423 ta0 a_4588_8588# 0.04628f
C2424 m1_2062_6980# m1_6494_5850# 0.08641f
C2425 a_5524_16920# m1_2678_13100# 0
C2426 ta2 a_7034_18520# 0.03948f
C2427 vbn_leak ta0 0.34388f
C2428 m1_2668_7940# m1_2792_6140# 0
C2429 ta3 a_4588_13668# 0.08996f
C2430 m1_8326_19030# m1_7130_19630# 0.04548f
C2431 a_7590_18520# a_3212_19360# 0.00744f
C2432 vbn_ax m1_7130_19630# 0.25924f
C2433 a_2592_8154# m1_2470_19900# 0
C2434 ta2 m1_2792_6140# 0
C2435 a_5524_11840# m1_5432_10260# 0.27129f
C2436 m1_7930_11710# a_3098_11000# 0.02137f
C2437 ta1 sel1 0.05086f
C2438 a_3136_4480# a_6594_420# 0.33121f
C2439 m1_5190_15350# vdd 0.00898f
C2440 pl_en a_672_20034# 0.16941f
C2441 hold a_3098_3120# 0.00542f
C2442 ta2 a_5524_11840# 0.03673f
C2443 a_488_17120# m1_7130_19630# 0.08991f
C2444 a_2180_13234# a_3098_18520# 0.03242f
C2445 m1_4882_3700# vbn_ax 0.23793f
C2446 hold a_6680_5520# 0.07774f
C2447 vbp_st d1 0.43874f
C2448 vbn_prb vdd 0.46876f
C2449 a_2592_8154# m1_7930_16790# 0.01156f
C2450 a_3212_19360# a_488_19360# 0.0013f
C2451 en m1_7930_16790# 0
C2452 m1_6716_11710# sta 0.00566f
C2453 sel0 vbn_ref 0.45754f
C2454 sta m1_6968_15350# 0.0261f
C2455 a_5516_15680# a_318_18520# 0.01095f
C2456 a_1892_3934# d1 0.04357f
C2457 vbp_st m1_2122_6150# 0.01984f
C2458 m1_2236_8010# m1_1080_6970# 0
C2459 hold a_2800_12040# 0.33629f
C2460 vreset d1 0.03426f
C2461 a_488_5520# vdd 1.74937f
C2462 a_5524_16920# a_488_12040# 0.00144f
C2463 sel1 m1_3902_19900# 0.00567f
C2464 a_2592_8154# a_318_18520# 0.13191f
C2465 ta0 el 0.06004f
C2466 hold spk 0
C2467 a_8248_5320# m1_2792_6140# 0.06277f
C2468 vbn_leak a_6934_4480# 0
C2469 en a_318_18520# 0.19718f
C2470 m1_5286_6830# ta1 0.03007f
C2471 m1_2112_9090# a_5268_9138# 0
C2472 vsrcp vbp_syn 0.02346f
C2473 hold a_5268_14218# 0.40553f
C2474 vdd a_4096_6334# 0.58198f
C2475 a_3136_4480# ta1 0.06821f
C2476 vbp_st m1_8466_15350# 0.00153f
C2477 a_6140_14314# tb0 0.00465f
C2478 a_6140_14314# m1_6968_15350# 0.15403f
C2479 a_4710_4480# vdd 0.11096f
C2480 a_1480_3834# m1_2712_6970# 0.00387f
C2481 chain ta0 0.00353f
C2482 hold a_6672_14314# 0.0079f
C2483 pl_en vbp_st 0.00185f
C2484 m1_6968_10190# m1_5432_10260# 0.00259f
C2485 m1_9090_16790# sel1 0
C2486 vbn_prb m1_7702_15650# 0.03583f
C2487 a_7034_3120# mreset 0.08144f
C2488 m1_6968_10190# ta2 0.04282f
C2489 m1_2062_6980# ta0 0.13711f
C2490 hold m1_2956_19890# 0.01332f
C2491 a_874_3120# el 0.08978f
C2492 vbp_st m1_7702_12990# 0
C2493 vbn_ax tb1 0.1015f
C2494 tb0 m1_7130_19630# 0.04084f
C2495 stb m1_4568_19890# 0.12869f
C2496 m1_8326_19030# tb1 0.1073f
C2497 vbp_syn a_3098_18520# 0
C2498 a_7590_3120# a_6934_4480# 0.02764f
C2499 a_6934_4480# el 0.04762f
C2500 vbp_st m1_4282_6970# 0.04045f
C2501 a_488_17120# tb1 0.14452f
C2502 abus m1_8466_10270# 0.03053f
C2503 vbp_st a_3098_16080# 0.06906f
C2504 a_1480_3834# a_318_18520# 0.01547f
C2505 a_1892_3934# m1_4282_6970# 0.00264f
C2506 a_5524_16920# a_318_18520# 0.16557f
C2507 stb m1_2470_19900# 0.00249f
C2508 vbn_leak a_2180_13234# 0.10719f
C2509 chain a_6934_4480# 0.00676f
C2510 a_3098_11000# d1 0.6677f
C2511 a_1480_3834# a_728_3738# 0.2052f
C2512 a_2542_18520# a_3098_16080# 0.00771f
C2513 a_3136_4480# vsrc 0.09725f
C2514 vbn_prb sel2 0.52519f
C2515 a_2800_17120# m1_5190_15350# -0
C2516 d2 m1_8466_15350# 0
C2517 d2 pl_en 0.1431f
C2518 a_3136_4480# a_3272_6334# 0.29023f
C2519 a_3098_3120# vdd 0.6936f
C2520 hold m1_6494_5850# 0.06767f
C2521 ta3 a_5516_15680# 0
C2522 stb a_318_18520# 0.00759f
C2523 a_6680_5520# vdd 1.56168f
C2524 a_2592_8154# ta3 0.3083f
C2525 a_2180_13234# el 0.15713f
C2526 vbn_ax a_5366_18520# 0.00531f
C2527 pl_en a_3098_11000# 0.02714f
C2528 ta3 en 0.13589f
C2529 m1_1046_17880# a_318_18520# 0.47467f
C2530 sta d1 0.3215f
C2531 a_2800_12040# vdd 1.22682f
C2532 a_488_17120# a_5366_18520# 0.03838f
C2533 a_2592_8154# a_7034_18520# 0.23002f
C2534 vbn_leak m1_6494_13030# -0.02073f
C2535 a_7034_18520# en 0
C2536 m1_7684_7940# m1_3676_6970# 0
C2537 a_5268_9138# vbp_syn 0
C2538 tb0 tb1 0.39724f
C2539 m1_4882_3700# m1_7206_2340# 0.01396f
C2540 spk vdd 4.83829f
C2541 m1_2668_7940# vbp_st 0.01231f
C2542 a_2180_13234# chain 0.03981f
C2543 ta2 vbp_st 0.10813f
C2544 m1_2792_6140# en 0.04185f
C2545 ta1 a_488_12040# 0.11546f
C2546 vbp_syn a_4588_8588# 0.01924f
C2547 vdd a_5268_14218# 0.45332f
C2548 a_5366_3120# a_4096_6334# 0.17796f
C2549 vbn_ax a_6378_4480# 0.00106f
C2550 a_2592_8154# a_5524_11840# 0.01841f
C2551 d2 a_3098_16080# 0.12983f
C2552 m1_7930_16790# m1_7206_18030# 0
C2553 a_5524_11840# en 0.03361f
C2554 vbn_leak vbp_syn 0.57454f
C2555 a_3136_4480# m1_7150_9086# 0
C2556 a_3098_11000# m1_4282_6970# 0
C2557 vbp_st a_4588_13668# 0.00123f
C2558 a_6672_14314# vdd 0.76117f
C2559 a_6594_420# a_318_18520# 0.06961f
C2560 a_4710_4480# a_5366_3120# 0.00128f
C2561 a_874_16080# m1_2712_15340# 0.26139f
C2562 pl_en sta 0.05893f
C2563 m1_1080_6970# m1_2712_6970# 0.00114f
C2564 a_318_18520# m1_7206_18030# 0.20799f
C2565 en a_2542_3120# 0.00195f
C2566 m1_910_6150# a_488_5520# 0.02758f
C2567 vbn_leak vs 0.08309f
C2568 m1_2956_19890# vdd 0.0412f
C2569 a_6934_4480# mreset 0
C2570 a_8248_5320# vbp_st 0.1502f
C2571 m1_6494_13030# el 0.10079f
C2572 m1_1046_10270# d1 0.03391f
C2573 m1_3902_19900# m1_4568_19890# 0.01603f
C2574 m1_7702_15650# a_5268_14218# 0.00111f
C2575 a_5524_16920# ta3 0.10624f
C2576 a_8248_5320# vreset 0.13217f
C2577 hold ta0 2.8375f
C2578 a_5524_11840# m1_6494_7910# 0.00501f
C2579 a_6140_9234# abus 0.01802f
C2580 chain m1_6494_13030# 0.00258f
C2581 vbp_syn el 0.32243f
C2582 a_6140_14314# m1_8466_15350# 0.04098f
C2583 m1_4882_3700# d1 0.4027f
C2584 a_6140_14314# pl_en 0.56769f
C2585 ta1 a_318_18520# 0.02221f
C2586 a_1480_3834# m1_2792_6140# 0.12825f
C2587 ta0 a_6672_9234# 0.00771f
C2588 a_6672_14314# m1_7702_15650# 0.09415f
C2589 m1_6968_10190# a_2592_8154# 0.11806f
C2590 sta a_3098_16080# 0.00934f
C2591 a_5524_11840# a_5524_16920# 0.00142f
C2592 m1_6968_10190# en 0.10565f
C2593 a_3136_4480# sel1 0
C2594 d2 ta2 0.12651f
C2595 vs el 0.39274f
C2596 vs a_7590_3120# 0.31371f
C2597 abus vbn_ax 0.09496f
C2598 m1_1080_6970# a_728_3738# 0.00963f
C2599 m1_5432_10260# a_3098_11000# 0
C2600 pl_en m1_7130_19630# 0
C2601 a_7034_18520# stb 0
C2602 a_1480_3834# a_2542_3120# 0
C2603 ta2 a_3098_11000# 0.10226f
C2604 m1_2062_6980# vbp_syn 0
C2605 m1_2668_7940# a_3098_11000# 0.01533f
C2606 a_6140_9234# a_5516_10600# 0
C2607 d2 a_4588_13668# 0.18819f
C2608 d1_bsel m1_2956_19890# 0.14663f
C2609 vdd a_7034_3120# 0
C2610 vdd m1_6494_5850# 1.07669f
C2611 vs chain 0.06767f
C2612 a_318_18520# m1_3902_19900# 0.01052f
C2613 hold a_6934_4480# 0.06677f
C2614 a_488_17120# m1_2712_15340# 0.01454f
C2615 a_6140_14314# a_3098_16080# 0.25796f
C2616 vbn_prb vbn_ref 0.48952f
C2617 a_2542_11000# a_3098_11000# 0.0867f
C2618 a_3098_11000# a_4588_13668# 0
C2619 spk sel2 0.0766f
C2620 a_3136_4480# m1_5286_6830# 0.01216f
C2621 a_2592_8154# a_672_20034# 0.01084f
C2622 a_3272_6334# m1_2712_6970# 0.00957f
C2623 vs m1_2062_6980# 0.05765f
C2624 a_672_20034# en 0.13572f
C2625 m1_6968_10190# m1_6494_7910# 0
C2626 a_5268_9138# vsrcp 0.44928f
C2627 m1_2112_9090# hold 0.0122f
C2628 a_6378_4480# vss -0.0636f
C2629 a_3136_4480# vss 3.61856f
C2630 m1_2712_6970# vss 0.04237f
C2631 a_6594_420# vss 0.98291f
C2632 a_3272_6334# vss 2.76123f
C2633 m1_6968_10190# vss 0.23525f
C2634 a_2542_18520# vss -0.06157f
C2635 a_7590_3120# vss 0.45916f
C2636 a_2542_11000# vss 0.04015f
C2637 a_7034_18520# vss -0.13545f
C2638 vs vss 4.77138f
C2639 a_672_20034# vss 2.54835f
C2640 d1_bsel vss 1.08937f
C2641 a_2800_5520# vss -0.35978f
C2642 a_2542_16080# vss 0.06772f
C2643 hold vss 2.33481f
C2644 vbn_ax vss 3.19769f
C2645 m1_3902_19900# vss 0.94031f
C2646 tb3 vss 0.71956f
C2647 a_6672_9234# vss 0.64898f
C2648 m1_2112_14220# vss -0.09266f
C2649 a_5366_3120# vss 0.00739f
C2650 m1_5504_19890# vss 1.42486f
C2651 tb2 vss 0.16327f
C2652 chain vss 1.39068f
C2653 a_6140_9234# vss 1.26496f
C2654 a_7590_18520# vss 0.24658f
C2655 m1_7130_19630# vss 0.51872f
C2656 tb1 vss 0.57395f
C2657 m1_7702_10190# vss 0.47224f
C2658 a_5366_18520# vss -0.10683f
C2659 m1_8326_19030# vss 0.12587f
C2660 tb0 vss 0.69459f
C2661 m1_4882_3700# vss -0.19303f
C2662 m1_8466_10270# vss 0.07474f
C2663 m1_7790_19900# vss 0.15303f
C2664 a_5516_10600# vss 0.26257f
C2665 m1_6190_19900# vss 0.23525f
C2666 abus vss 3.90523f
C2667 sel0 vss 2.11183f
C2668 m1_5432_10260# vss 0.57574f
C2669 m1_9090_11710# vss -0.08187f
C2670 a_3212_19360# vss -0.3093f
C2671 m1_4568_19890# vss 0.03051f
C2672 a_874_16080# vss 0.0349f
C2673 a_488_17120# vss 1.24003f
C2674 m1_6716_11710# vss -0.09014f
C2675 m1_7930_11710# vss -0.09111f
C2676 m1_2722_2630# vss 0.26842f
C2677 pl_en vss 1.76005f
C2678 a_6934_4480# vss 0.05708f
C2679 a_4096_6334# vss 0.71894f
C2680 spk vss 5.67396f
C2681 a_2800_12040# vss 0.24096f
C2682 a_3098_16080# vss 1.38521f
C2683 m1_7684_7940# vss 0.05899f
C2684 a_4710_4480# vss -0.01505f
C2685 a_6680_5520# vss -0.41482f
C2686 m1_7158_7910# vss 0.12172f
C2687 a_6672_14314# vss 1.41506f
C2688 d1 vss 4.57089f
C2689 a_6140_14314# vss 1.10437f
C2690 m1_2112_9090# vss -0.09887f
C2691 m1_6494_7910# vss 0
C2692 a_5524_11840# vss 1.97045f
C2693 a_1480_3834# vss 0.4632f
C2694 m1_1046_17880# vss -0.18049f
C2695 m1_1046_10270# vss -0.14577f
C2696 a_874_11000# vss 0.06938f
C2697 m1_1080_6970# vss 0.22853f
C2698 m1_7206_18030# vss -0.17245f
C2699 m1_642_6980# vss 0.01031f
C2700 a_5268_9138# vss 1.75875f
C2701 vsrcp vss 2.06471f
C2702 m1_2712_15340# vss -0.06358f
C2703 m1_9090_16790# vss -0.09025f
C2704 a_5516_15680# vss 0.21128f
C2705 m1_2668_7940# vss 0.55418f
C2706 a_2592_8154# vss 1.7753f
C2707 m1_7150_9086# vss 0.06856f
C2708 m1_6716_16790# vss -0.09115f
C2709 m1_7930_16790# vss -0.07247f
C2710 vdd vss 0.10001p
C2711 m1_1968_380# vss 0.60451f
C2712 sel1 vss 0.88871f
C2713 a_2800_17120# vss -0.02909f
C2714 m1_2236_8010# vss -0.00817f
C2715 sta vss 0.92514f
C2716 m1_2792_6140# vss 0.72147f
C2717 vbp_st vss 1.61514f
C2718 m1_2708_380# vss 0.08605f
C2719 en vss 2.96064f
C2720 m1_2122_6150# vss -0.08974f
C2721 m1_910_6150# vss -0.08216f
C2722 m1_6968_15350# vss 0.09066f
C2723 a_5524_16920# vss 2.27809f
C2724 m1_7702_12990# vss 0.48303f
C2725 vbn_prb vss 4.78827f
C2726 a_4588_13668# vss 1.15811f
C2727 m1_5190_15350# vss 0.44116f
C2728 m1_7158_13030# vss -0.04292f
C2729 mreset vss 2.38224f
C2730 a_7034_3120# vss 0.06729f
C2731 m1_7206_2340# vss 0.13746f
C2732 m1_2062_6980# vss 0.95571f
C2733 m1_3676_6970# vss 0.95247f
C2734 m1_6494_13030# vss -0.03141f
C2735 a_488_12040# vss 2.56883f
C2736 m1_5286_6830# vss 0.14608f
C2737 a_5268_14218# vss 1.03815f
C2738 m1_2956_19890# vss 0.00879f
C2739 vbp_syn vss 0.39196f
C2740 a_728_3738# vss 0.40935f
C2741 vsrc vss 1.65535f
C2742 m1_2470_19900# vss -0.02625f
C2743 m1_2678_13100# vss 0.39773f
C2744 stb vss 1.47618f
C2745 a_4588_8588# vss 1.09553f
C2746 a_3098_11000# vss 0.65944f
C2747 ta3 vss 0.63104f
C2748 a_2542_3120# vss 0.11299f
C2749 sel2 vss 2.09905f
C2750 vreset vss 1.50514f
C2751 vbn_ref vss 0.42272f
C2752 m1_2862_14560# vss 0.11134f
C2753 d2 vss 3.44649f
C2754 a_2180_13234# vss 1.33945f
C2755 a_874_18520# vss -0.11828f
C2756 a_488_19360# vss 0.27014f
C2757 ta2 vss 0.91867f
C2758 m1_6940_14170# vss 0.29939f
C2759 a_3098_3120# vss 0.36283f
C2760 m1_7702_15650# vss 0.73958f
C2761 m1_8466_15350# vss 0.07059f
C2762 m1_5942_6980# vss 0.0784f
C2763 ta1 vss 0.7906f
C2764 a_874_3120# vss -0.01144f
C2765 a_488_5520# vss 0.1314f
C2766 el vss 5.02733f
C2767 a_3098_18520# vss -0.01679f
C2768 m1_4282_6970# vss 0.03581f
C2769 m1_6494_5850# vss 0.1321f
C2770 ta0 vss 0.45376f
C2771 a_318_18520# vss 1.99567f
C2772 a_1892_3934# vss 0.57684f
C2773 vbn_leak vss 12.43881f
C2774 a_8248_5320# vss 0.26313f
.ends
