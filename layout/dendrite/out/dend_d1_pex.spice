* NGSPICE file created from dend_d1.ext - technology: gf180mcuD

.subckt n_w4_l1 a_n188_n400# a_100_n400# a_n100_n444# VSUBS
X0 a_100_n400# a_n100_n444# a_n188_n400# VSUBS nfet_03v3 ad=1.76p pd=8.88u as=1.76p ps=8.88u w=4u l=1u
C0 a_n188_n400# a_n100_n444# 0.08505f
C1 a_100_n400# a_n100_n444# 0.08505f
C2 a_n188_n400# a_100_n400# 0.07756f
C3 a_100_n400# VSUBS 0.26859f
C4 a_n188_n400# VSUBS 0.26859f
.ends

.subckt n_w2_l4 a_400_n200# a_n400_n244# a_n488_n200# VSUBS
X0 a_400_n200# a_n400_n244# a_n488_n200# VSUBS nfet_03v3 ad=0.88p pd=4.88u as=0.88p ps=4.88u w=2u l=4u
C0 a_n488_n200# a_n400_n244# 0.07019f
C1 a_400_n200# a_n400_n244# 0.07019f
C2 a_n488_n200# a_400_n200# 0.01073f
C3 a_400_n200# VSUBS 0.41684f
C4 a_n488_n200# VSUBS 0.41684f
.ends

.subckt n_w1_l0p28 a_28_n100# a_n28_n144# a_n116_n100# VSUBS
X0 a_28_n100# a_n28_n144# a_n116_n100# VSUBS nfet_03v3 ad=0.44p pd=2.88u as=0.44p ps=2.88u w=1u l=0.28u
C0 a_n116_n100# a_n28_n144# 0.00769f
C1 a_28_n100# a_n28_n144# 0.00769f
C2 a_n116_n100# a_28_n100# 0.04256f
C3 a_28_n100# VSUBS 0.09911f
C4 a_n116_n100# VSUBS 0.09911f
.ends

.subckt p_w1_l0p28 w_n202_n230# a_28_n100# a_n28_n144# a_n116_n100# VSUBS
X0 a_28_n100# a_n28_n144# a_n116_n100# w_n202_n230# pfet_03v3 ad=0.44p pd=2.88u as=0.44p ps=2.88u w=1u l=0.28u
C0 a_n28_n144# w_n202_n230# 0.05841f
C1 a_n116_n100# w_n202_n230# 0.01808f
C2 w_n202_n230# a_28_n100# 0.01808f
C3 a_n28_n144# a_n116_n100# 0.00769f
C4 a_n28_n144# a_28_n100# 0.00769f
C5 a_n116_n100# a_28_n100# 0.04256f
C6 a_28_n100# VSUBS 0.0597f
C7 a_n116_n100# VSUBS 0.0597f
C8 w_n202_n230# VSUBS 0.55752f
.ends

.subckt p_w0p22_l1 a_100_n22# a_n100_n66# w_n278_n159# a_n192_n36# VSUBS
X0 a_100_n22# a_n100_n66# a_n192_n36# w_n278_n159# pfet_03v3 ad=0.1516p pd=1.64u as=0.1516p ps=1.64u w=0.22u l=1u
C0 a_n192_n36# w_n278_n159# 0.00771f
C1 a_n100_n66# w_n278_n159# 0.13163f
C2 w_n278_n159# a_100_n22# 0.00771f
C3 a_n192_n36# a_n100_n66# 0.00509f
C4 a_n192_n36# a_100_n22# 0.00453f
C5 a_n100_n66# a_100_n22# 0.00509f
C6 a_100_n22# VSUBS 0.05952f
C7 a_n192_n36# VSUBS 0.05952f
C8 w_n278_n159# VSUBS 0.53042f
.ends

.subckt n_w0p5_l1p5 a_150_n50# a_n238_n50# a_n150_n94# VSUBS
X0 a_150_n50# a_n150_n94# a_n238_n50# VSUBS nfet_03v3 ad=0.22p pd=1.88u as=0.22p ps=1.88u w=0.5u l=1.5u
C0 a_n238_n50# a_n150_n94# 0.01269f
C1 a_150_n50# a_n150_n94# 0.01269f
C2 a_n238_n50# a_150_n50# 0.00671f
C3 a_150_n50# VSUBS 0.17146f
C4 a_n238_n50# VSUBS 0.17146f
.ends

.subckt p_w2_l4 a_400_n200# a_n400_n244# w_n574_n330# a_n488_n200# VSUBS
X0 a_400_n200# a_n400_n244# a_n488_n200# w_n574_n330# pfet_03v3 ad=0.88p pd=4.88u as=0.88p ps=4.88u w=2u l=4u
C0 a_n400_n244# w_n574_n330# 0.42229f
C1 a_n488_n200# w_n574_n330# 0.07409f
C2 w_n574_n330# a_400_n200# 0.07409f
C3 a_n400_n244# a_n488_n200# 0.07019f
C4 a_n400_n244# a_400_n200# 0.07019f
C5 a_n488_n200# a_400_n200# 0.01073f
C6 a_400_n200# VSUBS 0.18936f
C7 a_n488_n200# VSUBS 0.18936f
C8 w_n574_n330# VSUBS 2.27304f
.ends

.subckt p_w1_l0p5 a_n138_n100# a_50_n100# a_n50_n144# w_n224_n230# VSUBS
X0 a_50_n100# a_n50_n144# a_n138_n100# w_n224_n230# pfet_03v3 ad=0.44p pd=2.88u as=0.44p ps=2.88u w=1u l=0.5u
C0 a_n50_n144# w_n224_n230# 0.07993f
C1 a_n138_n100# w_n224_n230# 0.0205f
C2 w_n224_n230# a_50_n100# 0.0205f
C3 a_n50_n144# a_n138_n100# 0.01275f
C4 a_n50_n144# a_50_n100# 0.01275f
C5 a_n138_n100# a_50_n100# 0.03085f
C6 a_50_n100# VSUBS 0.06546f
C7 a_n138_n100# VSUBS 0.06546f
C8 w_n224_n230# VSUBS 0.61824f
.ends

.subckt p_w1_l2 w_n374_n230# a_n288_n100# a_200_n100# a_n200_n144# VSUBS
X0 a_200_n100# a_n200_n144# a_n288_n100# w_n374_n230# pfet_03v3 ad=0.44p pd=2.88u as=0.44p ps=2.88u w=1u l=2u
C0 a_n200_n144# w_n374_n230# 0.22666f
C1 a_n288_n100# w_n374_n230# 0.03135f
C2 w_n374_n230# a_200_n100# 0.03135f
C3 a_n200_n144# a_n288_n100# 0.02905f
C4 a_n200_n144# a_200_n100# 0.02905f
C5 a_n288_n100# a_200_n100# 0.01056f
C6 a_200_n100# VSUBS 0.1047f
C7 a_n288_n100# VSUBS 0.1047f
C8 w_n374_n230# VSUBS 1.03224f
.ends

.subckt n_w0p5_l0p28 a_n28_n94# a_n116_n50# a_28_n50# VSUBS
X0 a_28_n50# a_n28_n94# a_n116_n50# VSUBS nfet_03v3 ad=0.22p pd=1.88u as=0.22p ps=1.88u w=0.5u l=0.28u
C0 a_n116_n50# a_n28_n94# 0.00377f
C1 a_28_n50# a_n28_n94# 0.00377f
C2 a_n116_n50# a_28_n50# 0.02085f
C3 a_28_n50# VSUBS 0.07987f
C4 a_n116_n50# VSUBS 0.07987f
.ends

.subckt n_w0p5_l0p5 a_n138_n50# a_50_n50# a_n50_n94# VSUBS
X0 a_50_n50# a_n50_n94# a_n138_n50# VSUBS nfet_03v3 ad=0.22p pd=1.88u as=0.22p ps=1.88u w=0.5u l=0.5u
C0 a_n138_n50# a_n50_n94# 0.00625f
C1 a_50_n50# a_n50_n94# 0.00625f
C2 a_n138_n50# a_50_n50# 0.01511f
C3 a_50_n50# VSUBS 0.09639f
C4 a_n138_n50# VSUBS 0.09639f
.ends

.subckt n_w4_l2 a_n288_n400# a_200_n400# a_n200_n444# VSUBS
X0 a_200_n400# a_n200_n444# a_n288_n400# VSUBS nfet_03v3 ad=1.76p pd=8.88u as=1.76p ps=8.88u w=4u l=2u
C0 a_n288_n400# a_n200_n444# 0.11799f
C1 a_200_n400# a_n200_n444# 0.11799f
C2 a_n288_n400# a_200_n400# 0.04287f
C3 a_200_n400# VSUBS 0.34365f
C4 a_n288_n400# VSUBS 0.34365f
.ends

.subckt n_w3p54_l3p54 a_354_n354# a_n354_n398# a_n442_n354# VSUBS
X0 a_354_n354# a_n354_n398# a_n442_n354# VSUBS nfet_03v3 ad=1.5576p pd=7.96u as=1.5576p ps=7.96u w=3.54u l=3.54u
C0 a_n442_n354# a_n354_n398# 0.12189f
C1 a_354_n354# a_n354_n398# 0.12189f
C2 a_n442_n354# a_354_n354# 0.02161f
C3 a_354_n354# VSUBS 0.44156f
C4 a_n442_n354# VSUBS 0.44156f
.ends

.subckt n_w0p5_l0p6 a_n148_n50# a_60_n50# a_n60_n94# VSUBS
X0 a_60_n50# a_n60_n94# a_n148_n50# VSUBS nfet_03v3 ad=0.22p pd=1.88u as=0.22p ps=1.88u w=0.5u l=0.6u
C0 a_n148_n50# a_n60_n94# 0.00722f
C1 a_60_n50# a_n60_n94# 0.00722f
C2 a_n148_n50# a_60_n50# 0.01345f
C3 a_60_n50# VSUBS 0.1039f
C4 a_n148_n50# VSUBS 0.1039f
.ends

.subckt n_w1_l0p5 a_n138_n100# a_50_n100# a_n50_n144# VSUBS
X0 a_50_n100# a_n50_n144# a_n138_n100# VSUBS nfet_03v3 ad=0.44p pd=2.88u as=0.44p ps=2.88u w=1u l=0.5u
C0 a_n138_n100# a_n50_n144# 0.01275f
C1 a_50_n100# a_n50_n144# 0.01275f
C2 a_n138_n100# a_50_n100# 0.03085f
C3 a_50_n100# VSUBS 0.11563f
C4 a_n138_n100# VSUBS 0.11563f
.ends

.subckt n_w0p5_l3 a_n388_n50# a_300_n50# a_n300_n94# VSUBS
X0 a_300_n50# a_n300_n94# a_n388_n50# VSUBS nfet_03v3 ad=0.22p pd=1.88u as=0.22p ps=1.88u w=0.5u l=3u
C0 a_n388_n50# a_n300_n94# 0.01602f
C1 a_300_n50# a_n300_n94# 0.01602f
C2 a_n388_n50# a_300_n50# 0.00348f
C3 a_300_n50# VSUBS 0.28406f
C4 a_n388_n50# VSUBS 0.28406f
.ends

.subckt n_w1_l1 a_n188_n100# a_100_n100# a_n100_n144# VSUBS
X0 a_100_n100# a_n100_n144# a_n188_n100# VSUBS nfet_03v3 ad=0.44p pd=2.88u as=0.44p ps=2.88u w=1u l=1u
C0 a_n188_n100# a_n100_n144# 0.02094f
C1 a_100_n100# a_n100_n144# 0.02094f
C2 a_n188_n100# a_100_n100# 0.0191f
C3 a_100_n100# VSUBS 0.15316f
C4 a_n188_n100# VSUBS 0.15316f
.ends

.subckt p_w0p22_l4 a_n400_n66# a_n492_n36# w_n578_n159# a_400_n22# VSUBS
X0 a_400_n22# a_n400_n66# a_n492_n36# w_n578_n159# pfet_03v3 ad=0.1516p pd=1.64u as=0.1516p ps=1.64u w=0.22u l=4u
C0 a_n492_n36# w_n578_n159# 0.0077f
C1 a_n400_n66# w_n578_n159# 0.43266f
C2 w_n578_n159# a_400_n22# 0.0077f
C3 a_n492_n36# a_n400_n66# 0.00842f
C4 a_n492_n36# a_400_n22# 0.00123f
C5 a_n400_n66# a_400_n22# 0.00842f
C6 a_400_n22# VSUBS 0.13421f
C7 a_n492_n36# VSUBS 0.13421f
C8 w_n578_n159# VSUBS 1.10282f
.ends

.subckt n_w1_l4 a_n488_n100# a_400_n100# a_n400_n144# VSUBS
X0 a_400_n100# a_n400_n144# a_n488_n100# VSUBS nfet_03v3 ad=0.44p pd=2.88u as=0.44p ps=2.88u w=1u l=4u
C0 a_n488_n100# a_n400_n144# 0.03474f
C1 a_400_n100# a_n400_n144# 0.03474f
C2 a_n488_n100# a_400_n100# 0.00531f
C3 a_400_n100# VSUBS 0.37836f
C4 a_n488_n100# VSUBS 0.37836f
.ends

.subckt n_w2_l2 a_n288_n200# a_200_n200# a_n200_n244# VSUBS
X0 a_200_n200# a_n200_n244# a_n288_n200# VSUBS nfet_03v3 ad=0.88p pd=4.88u as=0.88p ps=4.88u w=2u l=2u
C0 a_n288_n200# a_n200_n244# 0.0587f
C1 a_200_n200# a_n200_n244# 0.0587f
C2 a_n288_n200# a_200_n200# 0.02133f
C3 a_200_n200# VSUBS 0.2667f
C4 a_n288_n200# VSUBS 0.2667f
.ends

.subckt n_w0p22_l2 a_200_n22# a_n200_n66# a_n292_n36# VSUBS
X0 a_200_n22# a_n200_n66# a_n292_n36# VSUBS nfet_03v3 ad=0.1516p pd=1.64u as=0.1516p ps=1.64u w=0.22u l=2u
C0 a_n200_n66# a_n292_n36# 0.00705f
C1 a_200_n22# a_n292_n36# 0.00245f
C2 a_n200_n66# a_200_n22# 0.00705f
C3 a_200_n22# VSUBS 0.20767f
C4 a_n292_n36# VSUBS 0.20767f
.ends

.subckt n_w7p07_l7p07 a_707_n707# a_n795_n707# a_n707_n751# VSUBS
X0 a_707_n707# a_n707_n751# a_n795_n707# VSUBS nfet_03v3 ad=3.1108p pd=15.02u as=3.1108p ps=15.02u w=7.07u l=7.07u
C0 a_n795_n707# a_n707_n751# 0.27012f
C1 a_707_n707# a_n707_n751# 0.27012f
C2 a_n795_n707# a_707_n707# 0.0212f
C3 a_707_n707# VSUBS 0.84237f
C4 a_n795_n707# VSUBS 0.84237f
.ends

.subckt dend_d1 vdd vss el vbn_leak vsrc vsrcp vbp_st vbn_ax vbn_ref vreset vbn_prb
+ abus sel0 sel2 mreset spk en pl_en chain sel1 d1_bsel sta stb hold ta0 ta1 ta2 ta3
+ tb0 tb1 tb2 tb3 vbp_syn d1 d2 vs
XXL1_XM2 a_2492_11000# a_3048_11000# a_3048_11000# vss n_w4_l1
XXEP_XS a_8248_5320# vbn_leak vss vss n_w2_l4
XXS_XL_XMT m1_1300_2620# vbn_leak vss vss n_w2_l4
XXWS a_268_18520# a_1892_3934# vs vss n_w1_l0p28
XXS_XD_Xi4_XP vdd spk a_3272_6334# vdd vss p_w1_l0p28
XXP1_XDT_XK a_6672_9234# a_5524_11840# vdd vdd vss p_w0p22_l1
XXR1_XP0 vdd a_3048_11000# ta0 m1_6440_6140# vss p_w1_l0p28
XXR1_XR2 m1_4330_6980# m1_2712_6970# vbn_leak vss n_w0p5_l1p5
XXA2_XA_XP2 a_3048_18520# a_488_19360# vdd vdd vss p_w2_l4
XXY2_XQB vdd vss vss m1_2678_13100# vss p_w1_l0p28
XXS_XL_XM1 a_488_5520# a_824_3120# el vss n_w4_l1
XXA2_XA_XMT m1_1046_17880# vbn_ax vss vss n_w2_l4
XXA2_XA_XHO vdd d2 hold a_3048_18520# vss p_w1_l0p28
XXR1_XP1 vdd a_3048_11000# ta1 m1_5286_6980# vss p_w1_l0p28
XXR1_XR3 m1_5946_6980# m1_4330_6980# vbn_leak vss n_w0p5_l1p5
XXT1_XME m1_7702_15230# en m1_8466_15350# vss n_w1_l0p28
XXS_XL_XM2 a_2492_3120# a_3048_3120# a_3048_3120# vss n_w4_l1
XXP2_XDT_XNE m1_7096_14156# a_5524_16920# vsrcp vss n_w1_l0p28
XXS_XD_XPI m1_910_6150# a_728_3738# vs vdd vss p_w1_l0p5
XXR1_XP2 vdd a_3048_11000# ta2 m1_3680_6970# vss p_w1_l0p28
XXEP_XPD vdd vdd a_8248_5320# a_8248_5320# vss p_w1_l2
XXR1_XN0 ta0 m1_6440_6140# a_488_12040# vss n_w0p5_l0p28
XXA2_XA_XM1 a_488_19360# a_824_18520# a_268_18520# vss n_w4_l1
XXY2_XNA a_2180_13234# d2 m1_2862_14560# vss n_w0p5_l0p28
XXS_XR_XNR a_6594_420# vbn_ref vss vss n_w2_l4
XXS_XR_XSW vreset vs a_6594_420# vss n_w0p5_l0p5
XXT1_XMF m1_7702_15230# vdd d2 vss n_w4_l2
XXT2_XSW m1_7702_10190# sel2 abus vss n_w1_l0p28
XXP2_XTP vdd vdd a_4588_13668# a_5524_16920# vss p_w1_l2
XXS_XL_XD2_a m1_1300_2620# a_2492_3120# a_2492_3120# vss n_w4_l1
XXR1_XP3 vdd a_3048_11000# ta3 m1_2062_6980# vss p_w1_l0p28
XXP1_XCT_XC vss a_4588_8588# vss vss n_w3p54_l3p54
XXR1_XN1 ta1 m1_5286_6980# a_488_12040# vss n_w0p5_l0p28
XXB_XP1 vdd a_2592_8154# d1_bsel stb vss p_w1_l0p28
XXA2_XA_XM2 a_2492_18520# a_3048_18520# a_3048_18520# vss n_w4_l1
XXY2_XNB vss d2 m1_2678_13100# vss n_w0p5_l0p28
XXR2_XRA vss m1_2470_19900# vbn_leak vss n_w0p5_l0p6
XXP2_XDT_XPI m1_6716_16790# a_8240_16974# d2 vdd vss p_w1_l0p5
XXS_XL_XD2_b a_2492_3120# m1_1300_2620# a_2492_3120# vss n_w4_l1
XXS_XD_XNI vsrc a_728_3738# vs vss n_w1_l0p5
XXR1_XL0 m1_5946_6980# m1_6440_6140# vbn_leak vss n_w0p5_l3
XXR1_XLT m1_5946_6980# vdd vbn_leak vss n_w0p5_l3
XXR1_XN2 ta2 m1_3680_6970# a_488_12040# vss n_w0p5_l0p28
XXY1_XWA m1_2236_8010# vbp_syn vdd m1_2112_9090# vss p_w2_l4
XXB_XP2 vdd a_2180_13234# a_672_20034# stb vss p_w1_l0p28
XXR2_XRB m1_2470_19900# m1_2956_19890# vbn_leak vss n_w0p5_l0p6
XXP2_XDT_XNH m1_7096_14156# a_8240_16974# d2 vss n_w1_l1
XXR1_XL1 m1_4330_6980# m1_5286_6980# vbn_leak vss n_w0p5_l3
XXR1_XN3 ta3 m1_2062_6980# a_488_12040# vss n_w0p5_l0p28
XXB_XN1 a_672_20034# stb a_2592_8154# vss n_w0p5_l0p28
XXY1_XWB m1_2668_7940# vbp_syn vdd m1_2112_9090# vss p_w2_l4
XXP2_XDT_XNI vsrcp a_8240_16974# d2 vss n_w1_l0p5
XXP1_XDT_XQ a_6140_9234# vdd vdd a_6672_9234# vss p_w0p22_l4
XXP2_XTS a_4588_13668# a_5524_16920# m1_6494_12990# vss n_w1_l0p28
XXR1_XL2 m1_2712_6970# m1_3680_6970# vbn_leak vss n_w0p5_l3
XXB_XN2 d1_bsel stb a_2180_13234# vss n_w0p5_l0p28
XXP2_XDT_XK a_6672_14314# a_5524_16920# vdd vdd vss p_w0p22_l1
XXA1_XB_XD2_a m1_4882_3750# a_6328_4480# a_6328_4480# vss n_w4_l1
XXR1_XL3 m1_1096_6970# m1_2062_6980# vbn_leak vss n_w0p5_l3
XXY2_XPH vdd vdd m1_2112_14220# hold vss p_w1_l2
XXP1_XTI vss m1_6494_7910# vbn_leak vss n_w1_l4
XXA1_XB_XD2_b a_6328_4480# m1_4882_3750# a_6328_4480# vss n_w4_l1
XXA1_XA_XD2_a m1_5808_2480# a_6984_3120# a_6984_3120# vss n_w4_l1
XXMR mreset a_6594_420# vdd vss n_w0p5_l0p28
XXP2_XS1 m1_7148_12980# m1_5428_15340# a_5524_16920# vss n_w1_l1
XXA1_XA_XD2_b a_6984_3120# m1_5808_2480# a_6984_3120# vss n_w4_l1
XXP2_XCT_XC vss a_4588_13668# vss vss n_w3p54_l3p54
XXT0_XMB vss m1_2708_380# vbn_prb vss n_w2_l2
XXP2_XS2 m1_7702_12990# m1_7148_12980# a_4588_13668# vss n_w1_l1
XXP2_XDT_XON a_6672_14314# vss a_5524_16920# vss n_w0p5_l0p28
XXY1_XQA vdd vss sta m1_2236_8010# vss p_w1_l0p28
XXP2_XOP1 a_2800_17120# a_2800_17120# vdd vdd vss p_w2_l4
XXEP_XPM vdd vdd a_3136_4480# a_8248_5320# vss p_w1_l2
XXP2_XS3 m1_6716_15540# m1_7702_12990# pl_en vss n_w1_l1
XXP1_XDT_XNE m1_7150_9150# a_5524_11840# vsrcp vss n_w1_l0p28
XXY1_XQB vdd vss a_2592_8154# m1_2668_7940# vss p_w1_l0p28
XXP2_XOP2 a_5516_15680# a_2800_17120# vdd vdd vss p_w2_l4
XXP2_XDT_XOP vdd a_5524_16920# a_6672_14314# vdd vss p_w1_l0p28
XXS_XD_XPS vdd vdd m1_910_6150# vbp_st vss p_w1_l2
XXS_XD_XS2 vdd vdd m1_2122_6150# vbp_st vss p_w1_l2
XXP2_XDT_XQ a_6140_14314# vdd vdd a_6672_14314# vss p_w0p22_l4
XXT0_XME m1_1946_330# en m1_2708_380# vss n_w1_l0p28
XXP1_XDT_XPI m1_6716_11710# a_5268_9138# d1 vdd vss p_w1_l0p5
XXS_XD_XS3 vdd vdd m1_2792_6140# vbp_st vss p_w1_l2
XXY1_XNA sta d1 m1_2236_8010# vss n_w0p5_l0p28
XXP2_XOM1 a_2800_17120# m1_5428_15340# a_3136_4480# vss n_w2_l2
XXT1_XSW m1_7702_15230# sel1 abus vss n_w1_l0p28
XXT0_XMF m1_1946_330# vdd vs vss n_w4_l2
XXP2_XDT_XS2 vdd vdd m1_7930_16790# vbp_st vss p_w1_l2
XXP2_XDT_XPS vdd vdd m1_6716_16790# vbp_st vss p_w1_l2
XXP1_XTP vdd vdd a_4588_8588# a_5524_11840# vss p_w1_l2
XXP1_XDT_XNH m1_7150_9150# a_5268_9138# d1 vss n_w1_l1
XXY1_XNB a_2592_8154# d1 m1_2668_7940# vss n_w0p5_l0p28
XXP2_XOM2 m1_5428_15340# a_5516_15680# a_5516_15680# vss n_w2_l2
XXP2_XDT_XS3 vdd vdd m1_9090_16790# vbp_st vss p_w1_l2
XXP2_XHP vdd d2 hold a_5516_15680# vss p_w1_l0p28
XXL2_XD1_a a_824_16080# m1_2712_15340# a_824_16080# vss n_w4_l1
XXP1_XDT_XNI vsrcp a_5268_9138# d1 vss n_w1_l0p5
XXS_XD_XP2 vdd a_1480_3834# a_728_3738# m1_2122_6150# vss p_w1_l0p28
XXR1_XRA vss m1_642_6980# vbn_leak vss n_w0p5_l0p6
XXB_XD1 d1_bsel vss a_2592_8154# vss n_w0p5_l0p28
XXA2_XB_XD1_a a_5316_18520# m1_7206_17740# a_5316_18520# vss n_w4_l1
XXL2_XD1_b m1_2712_15340# a_824_16080# a_824_16080# vss n_w4_l1
XXS_XD_XP3 vdd a_3272_6334# a_1480_3834# m1_2792_6140# vss p_w1_l0p28
XXR1_XRB m1_642_6980# m1_1096_6970# vbn_leak vss n_w0p5_l0p6
XXB_XD2 a_672_20034# vss a_2180_13234# vss n_w0p5_l0p28
XXL1_XD1_a a_824_11000# m1_1860_10650# a_824_11000# vss n_w4_l1
XXS_XD_XK a_3272_6334# spk vdd vdd vss p_w0p22_l1
XXA2_XB_XD1_b m1_7206_17740# a_5316_18520# a_5316_18520# vss n_w4_l1
XXA2_XA_XD1_a a_824_18520# m1_1046_17880# a_824_18520# vss n_w4_l1
XXP2_XDT_XP2 vdd a_6140_14314# a_8240_16974# m1_7930_16790# vss p_w1_l0p28
XXS_XD_XN2 a_1480_3834# a_728_3738# vsrc vss n_w0p22_l2
XXP1_XTS a_4588_8588# a_5524_11840# m1_6494_7910# vss n_w1_l0p28
XXL1_XD1_b m1_1860_10650# a_824_11000# a_824_11000# vss n_w4_l1
XXA1_XB_XP1 a_5524_5520# a_5524_5520# vdd vdd vss p_w2_l4
XXP2_XDT_XP3 vdd a_6672_14314# a_6140_14314# m1_9090_16790# vss p_w1_l0p28
XXS_XD_XN3 a_1480_3834# vsrc a_3272_6334# vss n_w0p5_l0p28
XXA2_XA_XD1_b m1_1046_17880# a_824_18520# a_824_18520# vss n_w4_l1
XXY1_XPH vdd vdd m1_2112_9090# hold vss p_w1_l2
XXA1_XB_XP2 a_6884_4480# a_5524_5520# vdd vdd vss p_w2_l4
XXY2_XHL vdd d2 hold a_3048_16080# vss p_w1_l0p28
XXP2_XDT_XN2 a_6140_14314# a_8240_16974# vsrcp vss n_w0p22_l2
XXP1_XDT_XON a_6672_9234# vss a_5524_11840# vss n_w0p5_l0p28
XXWC a_268_18520# chain d1 vss n_w1_l0p28
XXA1_XB_XMT m1_4882_3750# vbn_ax vss vss n_w2_l4
XXA1_XB_XHO vdd d1 hold a_6884_4480# vss p_w1_l0p28
XXP2_XDT_XN3 a_6140_14314# vsrcp a_6672_14314# vss n_w0p5_l0p28
XXY2_XMR vss vss vdd vss n_w0p5_l0p28
XXP1_XS1 m1_7130_7810# m1_5190_10190# a_5524_11840# vss n_w1_l1
XXL2_XP1 a_488_17120# a_488_17120# vdd vdd vss p_w2_l4
XXA1_XB_XM1 a_5524_5520# a_4660_4480# vs vss n_w4_l1
XXP1_XDT_XOP vdd a_5524_11840# a_6672_9234# vdd vss p_w1_l0p28
XXS_XR_XPC vdd a_6594_420# a_4096_6334# vdd vss p_w1_l0p28
XXP1_XS2 m1_7702_7950# m1_7130_7810# a_4588_8588# vss n_w1_l1
XXL2_XP2 a_3048_16080# a_488_17120# vdd vdd vss p_w2_l4
XXP1_XOP1 a_2800_12040# a_2800_12040# vdd vdd vss p_w2_l4
XXS_XR_Xi_XN spk vss a_4096_6334# vss n_w0p5_l0p28
XXA1_XB_XM2 a_6328_4480# a_6884_4480# a_6884_4480# vss n_w4_l1
XXP1_XS3 m1_6968_10270# m1_7702_7950# pl_en vss n_w1_l1
XXP2_XOTA vss m1_6716_15540# vbn_leak vss n_w4_l2
XXL2_XMT m1_2712_15340# vbn_leak vss vss n_w2_l4
XXS_XL_XD1_a a_824_3120# m1_1300_2620# a_824_3120# vss n_w4_l1
XXP1_XOP2 a_5516_10600# a_2800_12040# vdd vdd vss p_w2_l4
XXC1_XC vss vss d1 vss n_w7p07_l7p07
XXP1_XDT_XS2 vdd vdd m1_7930_11710# vbp_st vss p_w1_l2
XXP1_XDT_XPS vdd vdd m1_6716_11710# vbp_st vss p_w1_l2
XXP2_XOTB m1_6716_15540# vss vbn_leak vss n_w4_l2
XXL2_XM1 a_488_17120# a_824_16080# el vss n_w4_l1
XXS_XL_XD1_b m1_1300_2620# a_824_3120# a_824_3120# vss n_w4_l1
XXT2_XMB vss m1_8466_10270# vbn_prb vss n_w2_l2
XXS_XR_Xi_XP vdd a_4096_6334# spk vdd vss p_w1_l0p28
XXR2_XR1 m1_4568_19890# m1_2956_19890# vbn_leak vss n_w0p5_l1p5
XXA2_XB_XP1 a_3212_19360# a_3212_19360# vdd vdd vss p_w2_l4
XXP1_XDT_XS3 vdd vdd m1_9090_11710# vbp_st vss p_w1_l2
XXL2_XM2 a_2492_16080# a_3048_16080# a_3048_16080# vss n_w4_l1
XXP1_XOM1 a_2800_12040# m1_5190_10190# a_3136_4480# vss n_w2_l2
XXT0_XSW m1_1946_330# sel0 abus vss n_w1_l0p28
XXR2_XR2 m1_6184_19890# m1_4568_19890# vbn_leak vss n_w0p5_l1p5
XXR2_XP0 vdd a_3048_16080# tb0 m1_8326_19030# vss p_w1_l0p28
XXA2_XB_XP2 a_7540_18520# a_3212_19360# vdd vdd vss p_w2_l4
XXP1_XOM2 m1_5190_10190# a_5516_10600# a_5516_10600# vss n_w2_l2
XXR2_XR3 m1_7790_19900# m1_6184_19890# vbn_leak vss n_w0p5_l1p5
XXR2_XP1 vdd a_3048_16080# tb1 m1_7130_19630# vss p_w1_l0p28
XXA2_XB_XMT m1_7206_17740# vbn_ax vss vss n_w2_l4
XXA2_XB_XHO vdd a_268_18520# hold a_7540_18520# vss p_w1_l0p28
XXP1_XDT_XP2 vdd a_6140_9234# a_5268_9138# m1_7930_11710# vss p_w1_l0p28
XXP1_XHP vdd d1 hold a_5516_10600# vss p_w1_l0p28
XXT2_XME m1_7702_10190# en m1_8466_10270# vss n_w1_l0p28
XXA1_XB_XD1_a a_4660_4480# m1_4882_3750# a_4660_4480# vss n_w4_l1
XXR2_XN0 tb0 m1_8326_19030# a_488_17120# vss n_w0p5_l0p28
XXR2_XP2 vdd a_3048_16080# tb2 m1_5512_19890# vss p_w1_l0p28
XXA2_XB_XM1 a_3212_19360# a_5316_18520# d2 vss n_w4_l1
XXP1_XDT_XP3 vdd a_6672_9234# a_6140_9234# m1_9090_11710# vss p_w1_l0p28
XXA1_XB_XD1_b m1_4882_3750# a_4660_4480# a_4660_4480# vss n_w4_l1
XXT2_XMF m1_7702_10190# vdd d1 vss n_w4_l2
XXA1_XA_XD1_a a_5316_3120# m1_5808_2480# a_5316_3120# vss n_w4_l1
XXR2_XN1 tb1 m1_7130_19630# a_488_17120# vss n_w0p5_l0p28
XXR2_XP3 vdd a_3048_16080# tb3 m1_3870_19890# vss p_w1_l0p28
XXA2_XB_XM2 a_6984_18520# a_7540_18520# a_7540_18520# vss n_w4_l1
XXP1_XDT_XN2 a_6140_9234# a_5268_9138# vsrcp vss n_w0p22_l2
XXI_XN chain vss a_1892_3934# vss n_w0p5_l0p28
XXR2_XLT m1_7790_19900# vdd vbn_leak vss n_w0p5_l3
XXR2_XL0 m1_7790_19900# m1_8326_19030# vbn_leak vss n_w0p5_l3
XXR2_XN2 tb2 m1_5512_19890# a_488_17120# vss n_w0p5_l0p28
XXA1_XA_XD1_b m1_5808_2480# a_5316_3120# a_5316_3120# vss n_w4_l1
XXA1_XA_XP1 a_2800_5520# a_2800_5520# vdd vdd vss p_w2_l4
XXY2_XWA m1_2862_14560# vbp_syn vdd m1_2112_14220# vss p_w2_l4
XXP1_XDT_XN3 a_6140_9234# vsrcp a_6672_9234# vss n_w0p5_l0p28
XXA1_XA_XP2 a_7540_3120# a_2800_5520# vdd vdd vss p_w2_l4
XXR2_XL1 m1_6184_19890# m1_7130_19630# vbn_leak vss n_w0p5_l3
XXB_XI_XN d1_bsel vss a_672_20034# vss n_w0p5_l0p28
XXR2_XN3 tb3 m1_3870_19890# a_488_17120# vss n_w0p5_l0p28
XXY2_XWB m1_2678_13100# vbp_syn vdd m1_2112_14220# vss p_w2_l4
XXY1_XHL vdd d1 hold a_3048_11000# vss p_w1_l0p28
XXEP_XN el a_3136_4480# a_3136_4480# vss n_w4_l1
XXS_XHL vdd vs hold a_3048_3120# vss p_w1_l0p28
XXR2_XL2 m1_4568_19890# m1_5512_19890# vbn_leak vss n_w0p5_l3
XXA1_XA_XMT m1_5808_2480# vbn_ax vss vss n_w2_l4
XXA1_XA_XHO vdd vs hold a_7540_3120# vss p_w1_l0p28
XXI_XP vdd a_1892_3934# chain vdd vss p_w1_l0p28
XXY1_XMR vss vss vdd vss n_w0p5_l0p28
XXL2_XD2_a m1_2712_15340# a_2492_16080# a_2492_16080# vss n_w4_l1
XXL1_XP1 a_488_12040# a_488_12040# vdd vdd vss p_w2_l4
XXA1_XA_XM1 a_2800_5520# a_5316_3120# d1 vss n_w4_l1
XXR2_XL3 m1_2956_19890# m1_3870_19890# vbn_leak vss n_w0p5_l3
XXB_XI_XP vdd a_672_20034# d1_bsel vdd vss p_w1_l0p28
XXS_XC_XC vss vss vs vss n_w7p07_l7p07
XXA2_XB_XD2_a m1_7206_17740# a_6984_18520# a_6984_18520# vss n_w4_l1
XXP2_XTI vss m1_6494_12990# vbn_leak vss n_w1_l4
XXL2_XD2_b a_2492_16080# m1_2712_15340# a_2492_16080# vss n_w4_l1
XXL1_XP2 a_3048_11000# a_488_12040# vdd vdd vss p_w2_l4
XXL1_XD2_a m1_1860_10650# a_2492_11000# a_2492_11000# vss n_w4_l1
XXA1_XA_XM2 a_6984_3120# a_7540_3120# a_7540_3120# vss n_w4_l1
XXA2_XB_XD2_b a_6984_18520# m1_7206_17740# a_6984_18520# vss n_w4_l1
XXA2_XA_XD2_a m1_1046_17880# a_2492_18520# a_2492_18520# vss n_w4_l1
XXP1_XOTA vss m1_6968_10270# vbn_leak vss n_w4_l2
XXL1_XMT m1_1860_10650# vbn_leak vss vss n_w2_l4
XXL1_XD2_b a_2492_11000# m1_1860_10650# a_2492_11000# vss n_w4_l1
XXS_XD_Xi4_XN a_3272_6334# vss spk vss n_w0p5_l0p28
XXS_XL_XP1 a_488_5520# a_488_5520# vdd vdd vss p_w2_l4
XXA2_XA_XD2_b a_2492_18520# m1_1046_17880# a_2492_18520# vss n_w4_l1
XXP1_XOTB m1_6968_10270# vss vbn_leak vss n_w4_l2
XXL1_XM1 a_488_12040# a_824_11000# el vss n_w4_l1
XXT1_XMB vss m1_8466_15350# vbn_prb vss n_w2_l2
XXS_XL_XP2 a_3048_3120# a_488_5520# vdd vdd vss p_w2_l4
XXY2_XQA vdd vss a_2180_13234# m1_2862_14560# vss p_w1_l0p28
XXC2_XC vss vss d2 vss n_w7p07_l7p07
XXS_XR_XCR_XC vss a_6594_420# vss vss n_w3p54_l3p54
XXR1_XR1 m1_2712_6970# m1_1096_6970# vbn_leak vss n_w0p5_l1p5
XXA2_XA_XP1 a_488_19360# a_488_19360# vdd vdd vss p_w2_l4
C0 m1_6716_16790# a_488_17120# 0.01955f
C1 tb0 vsrcp 0
C2 a_488_19360# d1_bsel 0.02481f
C3 m1_3870_19890# m1_6184_19890# 0.21066f
C4 sel0 vbn_ax 0.04041f
C5 a_3048_3120# m1_2792_6140# 0.07523f
C6 m1_7148_12980# m1_6494_12990# 0
C7 a_6672_14314# a_3136_4480# 0.26049f
C8 vbp_st tb1 0
C9 vbp_st en 0.37151f
C10 a_4588_13668# a_5316_18520# 0
C11 tb1 a_2592_8154# 0.19143f
C12 m1_3680_6970# m1_2792_6140# 0.00536f
C13 en a_2592_8154# 0.19795f
C14 m1_4882_3750# a_3272_6334# 0
C15 m1_5286_6980# a_5268_9138# 0
C16 vbp_st sta 0.07895f
C17 vbn_leak a_488_17120# 0.09011f
C18 m1_5512_19890# vdd 0.26314f
C19 m1_4882_3750# a_4096_6334# 0.08528f
C20 a_488_5520# vs 0.36129f
C21 a_2592_8154# sta 0.247f
C22 vdd pl_en 0.18288f
C23 vdd m1_7130_19630# 0.38746f
C24 a_4588_8588# a_4588_13668# 0
C25 m1_2708_380# vdd 0.02849f
C26 a_2800_17120# vdd 1.33718f
C27 a_5516_10600# ta0 0
C28 a_6984_3120# a_268_18520# 0.13973f
C29 vbn_prb a_6140_9234# 0.03619f
C30 m1_5512_19890# a_5524_16920# 0
C31 a_5524_16920# m1_7130_19630# 0
C32 vbn_leak m1_2470_19900# 0.0158f
C33 a_3136_4480# a_2492_3120# 0.01348f
C34 a_5524_16920# pl_en 0.24455f
C35 ta0 a_6140_14314# 0.05961f
C36 en a_2800_5520# 0.00212f
C37 m1_5286_6980# m1_4330_6980# 0.15627f
C38 d1 abus 0.10279f
C39 m1_7790_19900# tb2 0.00381f
C40 m1_5286_6980# m1_7130_7810# 0.05861f
C41 a_3048_16080# tb0 0.06195f
C42 a_4588_13668# m1_7096_14156# 0
C43 vbp_syn a_2492_18520# 0
C44 a_6594_420# m1_2708_380# 0
C45 a_7540_3120# chain 0.08971f
C46 m1_3870_19890# tb2 0
C47 a_6672_14314# a_6140_14314# 0.55457f
C48 ta0 a_2180_13234# 0
C49 tb3 a_2180_13234# 0
C50 d1_bsel a_2592_8154# 0.10995f
C51 a_6328_4480# a_4660_4480# 0.01106f
C52 ta1 stb 0
C53 vsrcp m1_2678_13100# 0.01461f
C54 vbn_prb a_3136_4480# 0.1243f
C55 a_824_3120# m1_1300_2620# 0.20244f
C56 m1_2062_6980# a_488_12040# 0.05285f
C57 m1_5512_19890# a_672_20034# 0.1653f
C58 ta3 tb0 0.23705f
C59 pl_en a_672_20034# 0.13282f
C60 m1_7130_19630# a_672_20034# 0.01503f
C61 a_488_5520# a_1480_3834# 0.12997f
C62 ta0 a_5268_9138# 0.35291f
C63 m1_2792_6140# abus 0
C64 a_6140_9234# sel2 0.03557f
C65 m1_2112_14220# hold 0.0337f
C66 tb3 m1_6184_19890# 0.04974f
C67 m1_6184_19890# ta0 0.04167f
C68 mreset m1_4882_3750# 0.00157f
C69 vbp_syn a_2592_8154# 0.4048f
C70 a_3048_18520# a_3212_19360# 0.00898f
C71 a_268_18520# tb0 0
C72 m1_5286_6980# vsrcp 0.00655f
C73 vdd tb1 0.33572f
C74 m1_2708_380# m1_1946_330# 0.25661f
C75 a_6984_3120# a_3272_6334# 0.00233f
C76 en vdd 0.42989f
C77 d1_bsel a_824_18520# 0
C78 vbp_st vsrc 0.10497f
C79 a_6984_3120# a_4096_6334# 0
C80 a_3212_19360# a_2180_13234# 0.01312f
C81 vdd sta 0.65004f
C82 vbn_leak ta2 0.92454f
C83 a_3048_16080# m1_7790_19900# 0
C84 m1_7130_7810# ta0 0.00519f
C85 a_3048_16080# m1_2678_13100# 0.00945f
C86 vbp_st vbn_ref 0.0347f
C87 a_5524_16920# tb1 0
C88 a_2492_3120# spk 0.00192f
C89 a_488_5520# a_268_18520# 0.00144f
C90 m1_7930_11710# el 0
C91 a_3136_4480# sel2 0.03141f
C92 a_4588_13668# a_3136_4480# 0.09727f
C93 a_5524_16920# en 0.56565f
C94 vbn_prb a_6140_14314# 0.01151f
C95 m1_2956_19890# a_268_18520# 0.17792f
C96 vbn_leak a_2800_12040# 0.01973f
C97 a_5524_16920# sta 0.11241f
C98 vbp_st a_7540_18520# 0.00447f
C99 m1_3870_19890# a_3048_16080# 0.0895f
C100 a_3136_4480# m1_1300_2620# 0.15015f
C101 a_4588_8588# a_6140_9234# 0.06773f
C102 a_8240_16974# a_488_12040# 0
C103 a_2592_8154# a_7540_18520# 0.15987f
C104 m1_8466_15350# m1_7702_15230# 0.1318f
C105 a_6594_420# en 0.07883f
C106 ta0 tb2 0
C107 vbn_prb a_6884_4480# 0.00111f
C108 a_6328_4480# a_5524_5520# 0.04272f
C109 vbp_st m1_2668_7940# 0.00113f
C110 tb3 tb2 0.40085f
C111 vbn_prb spk 0.20007f
C112 m1_2668_7940# a_2592_8154# 0.21986f
C113 sel0 m1_5808_2480# 0.10263f
C114 a_3048_11000# m1_2062_6980# 0.37943f
C115 ta1 a_5524_5520# 0.08403f
C116 hold a_5516_15680# 0.23655f
C117 vdd d1_bsel 0.4968f
C118 tb1 a_672_20034# 0
C119 ta3 m1_6440_6140# 0.11413f
C120 a_2492_11000# el 0.00452f
C121 ta3 m1_3870_19890# 0.05672f
C122 a_488_5520# a_728_3738# 0.36247f
C123 vbn_prb a_5268_9138# 0
C124 a_5516_10600# a_4588_13668# 0
C125 en a_672_20034# 0.10239f
C126 ta0 vsrcp 0.03692f
C127 d1 ta2 0.01461f
C128 a_672_20034# sta 0.01326f
C129 m1_6440_6140# a_8248_5320# 0.00143f
C130 a_4588_8588# a_3136_4480# 0.01127f
C131 m1_3870_19890# a_268_18520# 0.00152f
C132 vbn_ax el 0.49118f
C133 m1_5286_6980# ta3 0.1545f
C134 ta1 m1_7702_10190# 0
C135 a_4588_13668# a_6140_14314# 0.0013f
C136 hold m1_2062_6980# 0.24447f
C137 d1 a_2800_12040# 0.00964f
C138 a_6672_14314# vsrcp 0.00836f
C139 vbp_syn vdd 2.39084f
C140 mreset a_6984_3120# 0.08726f
C141 d2 m1_2712_15340# 0.02076f
C142 a_2800_17120# a_2492_16080# 0.0049f
C143 en m1_1946_330# 0.00951f
C144 vbn_ax vreset 0.0427f
C145 a_5316_3120# vbn_prb 0.00146f
C146 stb vbn_leak 0.37667f
C147 a_488_5520# a_3272_6334# 0.13306f
C148 vbn_leak a_4660_4480# 0.12479f
C149 a_5524_11840# m1_7150_9150# 0.1024f
C150 m1_7930_16790# a_6140_14314# 0.04521f
C151 a_3048_11000# m1_7702_12990# 0
C152 spk sel2 0.06984f
C153 m1_1860_10650# a_2800_12040# 0.1294f
C154 m1_7096_14156# a_3136_4480# 0.13794f
C155 m1_8466_10270# a_488_12040# 0
C156 d2 m1_7702_15230# 0.21524f
C157 d1_bsel a_672_20034# 0.66933f
C158 m1_5946_6980# a_2592_8154# 0
C159 sel0 abus 4.02855f
C160 vsrc vdd 0.22968f
C161 a_2492_3120# vs 0.12798f
C162 a_488_5520# m1_910_6150# 0.02024f
C163 vdd vbn_ref 0.1765f
C164 spk m1_1300_2620# 0.10208f
C165 vbp_st a_1892_3934# 0.01521f
C166 a_5516_10600# a_4588_8588# 0.06636f
C167 vbp_st a_6672_9234# 0.01898f
C168 a_3048_16080# ta0 0.00756f
C169 tb3 a_3048_16080# 0.09142f
C170 a_6672_9234# a_2592_8154# 0.04832f
C171 a_4588_13668# a_5268_9138# 0
C172 a_3048_11000# a_8240_16974# 0
C173 a_5516_15680# m1_6716_15540# 0
C174 hold m1_4882_3750# 0.00154f
C175 a_3048_11000# m1_2112_9090# 0.00306f
C176 vdd a_7540_18520# 0.31369f
C177 a_6672_14314# a_3048_16080# 0.90278f
C178 a_5316_18520# a_2180_13234# 0.21241f
C179 a_3136_4480# a_6140_9234# 0.41018f
C180 a_6140_14314# m1_8326_19030# 0.01066f
C181 vbp_syn a_672_20034# 0.00429f
C182 vbn_prb vs 0.13047f
C183 vdd m1_2668_7940# 0.39148f
C184 ta3 ta0 0.52543f
C185 ta3 tb3 0.00364f
C186 vbn_prb vsrcp 0.08435f
C187 a_5524_16920# a_7540_18520# 0
C188 hold a_8240_16974# 0.28788f
C189 a_6594_420# vsrc 0.1829f
C190 a_5516_15680# chain 0
C191 a_6594_420# vbn_ref 0.09422f
C192 a_1892_3934# a_2800_5520# 0.14748f
C193 hold m1_2112_9090# 0.01884f
C194 abus m1_7702_15230# 0.10499f
C195 a_488_17120# m1_2712_15340# 0.03438f
C196 ta0 a_268_18520# 0.06264f
C197 a_5316_3120# m1_1300_2620# 0
C198 d1 a_4660_4480# 0.07706f
C199 en a_7540_3120# 0.18585f
C200 a_6672_14314# ta3 0.00687f
C201 hold sel1 0.043f
C202 a_1480_3834# a_2492_3120# 0
C203 a_4588_8588# a_5268_9138# 0.39285f
C204 m1_2062_6980# chain 0.0173f
C205 a_5516_10600# a_6140_9234# 0
C206 a_488_17120# m1_7702_15230# 0.06403f
C207 a_6672_14314# a_268_18520# 0.20415f
C208 m1_7206_17740# a_8240_16974# 0.00256f
C209 vbn_leak a_5524_5520# 0.0733f
C210 a_7540_18520# a_672_20034# 0
C211 a_3048_11000# m1_8466_10270# 0.02921f
C212 m1_6716_15540# m1_7702_12990# 0.1064f
C213 vsrc m1_1946_330# 0
C214 m1_2792_6140# a_4660_4480# 0.00114f
C215 vbn_prb a_3048_16080# 0.01269f
C216 m1_7206_17740# sel1 0.05966f
C217 a_4588_8588# m1_4330_6980# 0.00585f
C218 a_4588_13668# vsrcp 0.16589f
C219 vsrcp sel2 0.02683f
C220 a_3048_3120# el 0.0866f
C221 vdd m1_5946_6980# 0.01263f
C222 vbn_leak m1_2862_14560# 0
C223 vs m1_1300_2620# 0.22519f
C224 a_4588_8588# m1_7130_7810# 0.08699f
C225 vbn_leak m1_7702_10190# 0.23386f
C226 a_8240_16974# m1_6716_15540# 0.05289f
C227 m1_2062_6980# m1_2236_8010# 0
C228 a_2492_3120# a_268_18520# 0.0565f
C229 a_5516_10600# a_3136_4480# 0.21247f
C230 vdd a_6672_9234# 1.06717f
C231 m1_4882_3750# chain 0.04588f
C232 a_1892_3934# vdd 0.41533f
C233 a_3212_19360# a_268_18520# 0.55104f
C234 ta3 vbn_prb 0
C235 el m1_5808_2480# 0.01303f
C236 m1_6716_15540# sel1 0.09794f
C237 a_3136_4480# a_6140_14314# 0.06639f
C238 a_5268_9138# a_6140_9234# 0.07559f
C239 vbn_prb a_8248_5320# 0.064f
C240 d2 el 0.32539f
C241 m1_5808_2480# vreset 0.02049f
C242 d1 a_5524_5520# 0.10834f
C243 a_8240_16974# chain 0.00349f
C244 vbn_prb a_268_18520# 0.47801f
C245 m1_8326_19030# tb2 0.09278f
C246 vbp_syn a_2492_16080# 0.00706f
C247 a_3136_4480# a_6884_4480# 0.05029f
C248 m1_9090_11710# vdd 0.0948f
C249 a_6594_420# a_1892_3934# 0.0494f
C250 m1_6440_6140# a_488_12040# 0.14113f
C251 a_3136_4480# spk 0.32731f
C252 a_4588_8588# vsrcp 0.36064f
C253 a_4588_13668# a_3048_16080# 0.0337f
C254 m1_8326_19030# vsrcp 0
C255 chain sel1 1.14469f
C256 vsrc a_7540_3120# 0
C257 d1 m1_7702_10190# 0.18854f
C258 a_5516_15680# a_2800_17120# 0.01848f
C259 a_5516_15680# pl_en 0.0058f
C260 ta1 vbn_leak 0.21461f
C261 a_7540_3120# vbn_ref 0.011f
C262 m1_7130_7810# a_6140_9234# 0.07445f
C263 a_1480_3834# m1_1300_2620# 0.00108f
C264 m1_5286_6980# a_488_12040# 0.10534f
C265 a_3136_4480# a_5268_9138# 0.03382f
C266 ta2 m1_7702_15230# 0
C267 m1_2792_6140# a_5524_5520# 0.42266f
C268 el abus 0.32978f
C269 a_824_3120# vs 0.05624f
C270 ta3 a_4588_13668# 0.01415f
C271 m1_2112_9090# m1_2236_8010# 0.31051f
C272 m1_7096_14156# vsrcp 0.09517f
C273 m1_1096_6970# m1_2712_6970# -0
C274 m1_5190_10190# m1_6440_6140# 0
C275 vreset abus 0.22376f
C276 a_2492_3120# a_3272_6334# 0.1002f
C277 vbn_leak m1_2712_6970# 0.28273f
C278 m1_6716_11710# vbn_leak 0
C279 a_3048_18520# a_2180_13234# 0.08228f
C280 a_5316_3120# a_3136_4480# 0.33896f
C281 a_268_18520# sel2 0.0249f
C282 a_4588_13668# a_268_18520# 0
C283 m1_3870_19890# m1_9090_16790# 0.00179f
C284 ta3 m1_7930_16790# 0
C285 a_6328_4480# d1 0.23267f
C286 a_5516_10600# a_5268_9138# 0.16899f
C287 el a_488_17120# 0.20203f
C288 hold m1_2956_19890# 0.00384f
C289 a_268_18520# m1_1300_2620# 0.24525f
C290 m1_5286_6980# m1_5190_10190# 0.15281f
C291 m1_1046_17880# a_488_19360# 0.06422f
C292 a_3048_16080# m1_8326_19030# 0.42337f
C293 vsrcp a_6140_9234# 0.74539f
C294 a_5524_11840# abus 0.05633f
C295 vbn_prb a_3272_6334# 0.27425f
C296 ta1 d1 0.17f
C297 vbn_prb a_4096_6334# 0.05854f
C298 m1_7148_12980# el 0.03734f
C299 ta3 a_4588_8588# 0.01862f
C300 a_5316_18520# a_268_18520# 0.03037f
C301 m1_7096_14156# a_3048_16080# 0
C302 a_3048_11000# m1_6440_6140# 0.27183f
C303 ta0 a_488_12040# 0.06509f
C304 pl_en m1_7702_12990# 0.05203f
C305 a_824_3120# a_1480_3834# 0.01332f
C306 m1_1046_17880# a_2492_18520# 0.22769f
C307 vdd m1_4568_19890# 0.0042f
C308 a_3136_4480# vs 0.21655f
C309 a_6328_4480# m1_2792_6140# 0.08223f
C310 d1 m1_2712_6970# 0.01253f
C311 m1_6716_11710# d1 0.06502f
C312 hold m1_2678_13100# 0.02571f
C313 a_5516_15680# en 0.03281f
C314 m1_6184_19890# a_2180_13234# 0.00105f
C315 hold m1_7790_19900# 0
C316 a_728_3738# m1_1300_2620# 0
C317 m1_2112_14220# vbp_syn 0.30415f
C318 m1_5286_6980# a_3048_11000# 0.13159f
C319 a_3136_4480# vsrcp 0.54566f
C320 a_5516_15680# sta 0
C321 a_8240_16974# pl_en 0.15617f
C322 a_268_18520# m1_8326_19030# 0
C323 ta1 m1_2792_6140# 0
C324 hold m1_6440_6140# 0.41418f
C325 ta3 m1_7096_14156# 0.03842f
C326 hold m1_3870_19890# 0.05901f
C327 m1_5512_19890# sel1 0.03361f
C328 a_1892_3934# a_7540_3120# 0
C329 vbn_leak m1_6494_12990# -0.00412f
C330 m1_2062_6980# en 0.0113f
C331 vbp_st m1_7930_11710# 0.04126f
C332 m1_1046_17880# a_2592_8154# 0.16825f
C333 m1_7130_19630# sel1 0
C334 pl_en sel1 0.0056f
C335 m1_7930_11710# a_2592_8154# 0.00754f
C336 m1_2062_6980# sta 0
C337 m1_5190_10190# ta0 0.04205f
C338 m1_7096_14156# a_268_18520# 0.03029f
C339 m1_5286_6980# hold 0.06009f
C340 a_824_3120# a_268_18520# 0
C341 m1_6716_16790# vbn_leak 0.0136f
C342 m1_2712_6970# m1_2792_6140# 0
C343 tb3 m1_9090_16790# 0
C344 a_3272_6334# m1_1300_2620# 0.33842f
C345 a_6140_14314# tb2 0.00233f
C346 m1_1096_6970# vbn_leak 0.16575f
C347 a_5516_10600# vsrcp 0.00144f
C348 ta3 a_6140_9234# 0.07585f
C349 m1_3870_19890# m1_7206_17740# 0.19436f
C350 mreset vbn_prb 0.24546f
C351 m1_4568_19890# a_672_20034# 0.06117f
C352 a_488_5520# chain 0.00234f
C353 vbn_ax a_2492_18520# 0
C354 ta2 el 0.0281f
C355 a_1480_3834# a_3136_4480# 0
C356 a_3048_16080# a_3136_4480# 0.3244f
C357 a_6672_14314# m1_9090_16790# 0.01581f
C358 a_268_18520# a_6140_9234# 0
C359 a_6140_14314# vsrcp 0.0912f
C360 m1_4882_3750# en 0.02936f
C361 a_3048_11000# ta0 0.09073f
C362 m1_7150_9150# a_2592_8154# 0.07753f
C363 el a_2800_12040# 0.27425f
C364 m1_1046_17880# a_824_18520# 0.22798f
C365 a_824_3120# a_728_3738# 0.00865f
C366 m1_8466_10270# pl_en 0.07149f
C367 vbp_syn a_5516_15680# 0.00595f
C368 spk vs 8.1194f
C369 vbp_st vbn_ax 4.15454f
C370 ta3 a_3136_4480# 0.05468f
C371 m1_6184_19890# tb2 0
C372 vbn_ax a_2592_8154# 0.13047f
C373 spk vsrcp 0.06848f
C374 a_5524_11840# ta2 0.05272f
C375 a_8240_16974# tb1 0
C376 a_6672_14314# a_3048_11000# 0
C377 en a_8240_16974# 0.08793f
C378 a_3136_4480# a_8248_5320# 0.33568f
C379 d2 m1_5428_15340# 0.00421f
C380 a_8240_16974# sta 0.00833f
C381 a_3136_4480# a_268_18520# 3.65323f
C382 m1_1096_6970# d1 0.01123f
C383 hold ta0 2.86578f
C384 vbp_syn m1_2062_6980# 0
C385 m1_2862_14560# m1_2712_15340# 0
C386 hold tb3 0
C387 vsrcp a_5268_9138# 0.22029f
C388 d1 vbn_leak 1.1514f
C389 a_3048_18520# a_3048_16080# 0.00373f
C390 mreset sel2 3.95862f
C391 m1_3870_19890# chain 0.00844f
C392 m1_2112_9090# sta 0.20178f
C393 a_5524_11840# a_2800_12040# 0
C394 m1_6440_6140# chain 0.1246f
C395 en sel1 0.21559f
C396 a_3048_16080# a_6140_14314# 0.11639f
C397 sel1 sta 0.41122f
C398 a_824_3120# a_3272_6334# 0.06905f
C399 hold a_6672_14314# 0.08118f
C400 mreset m1_1300_2620# 0.05408f
C401 m1_7930_11710# vdd 0.07941f
C402 vbn_prb m1_9090_16790# 0
C403 m1_1046_17880# vdd 0.12206f
C404 a_5516_10600# ta3 0
C405 a_5516_15680# a_7540_18520# 0
C406 a_5316_3120# vs 0.0543f
C407 m1_5286_6980# chain 0.28484f
C408 m1_1860_10650# vbn_leak 0.19342f
C409 a_4588_13668# a_488_12040# 0.0352f
C410 tb3 m1_7206_17740# 0.0171f
C411 a_3048_16080# a_2180_13234# 0.02014f
C412 m1_7206_17740# ta0 0.04f
C413 m1_5512_19890# tb0 0.10471f
C414 ta3 a_6140_14314# 0.04577f
C415 a_1480_3834# spk 0
C416 m1_7130_7810# vsrcp 0
C417 m1_7130_19630# tb0 0.0406f
C418 vbn_leak m1_2792_6140# 0.03953f
C419 el a_4660_4480# 0.01243f
C420 a_3048_18520# a_268_18520# 0.05766f
C421 a_3048_11000# vbn_prb 0
C422 hold a_3212_19360# 0.56969f
C423 a_3048_16080# m1_6184_19890# 0
C424 m1_2062_6980# m1_2668_7940# 0.00238f
C425 ta3 a_6884_4480# 0
C426 m1_7702_7950# m1_6440_6140# 0
C427 a_268_18520# a_6140_14314# 0.039f
C428 d1_bsel sel1 0.29461f
C429 a_6984_3120# en 0.0055f
C430 en m1_8466_10270# 0.11589f
C431 a_2492_11000# vdd 0.3809f
C432 ta0 m1_6716_15540# 0.02761f
C433 vbp_syn a_8240_16974# 0.00452f
C434 a_824_16080# m1_2712_15340# 0.26454f
C435 vbp_st m1_8466_15350# 0.00597f
C436 a_6884_4480# a_8248_5320# 0.00788f
C437 m1_5286_6980# m1_7702_7950# 0.08662f
C438 m1_8466_15350# a_2592_8154# 0.00224f
C439 a_268_18520# a_2180_13234# 0.30157f
C440 a_6884_4480# a_268_18520# 0
C441 a_8248_5320# spk 0.35593f
C442 vbp_syn m1_2112_9090# 0.29192f
C443 a_4588_8588# a_488_12040# 0.00548f
C444 vbn_ax vdd 0.65118f
C445 a_268_18520# spk 0.15933f
C446 a_3136_4480# a_3272_6334# 0.06548f
C447 m1_5286_6980# m1_6968_10270# 0.00193f
C448 m1_1860_10650# d1 0.01808f
C449 ta3 a_5268_9138# 0.12774f
C450 a_6672_14314# m1_6716_15540# 0.05626f
C451 ta1 m1_7702_15230# 0
C452 a_3136_4480# a_4096_6334# 0.10188f
C453 a_488_19360# d2 0.00471f
C454 ta3 m1_6184_19890# 0.00563f
C455 m1_7148_12980# m1_5428_15340# 0.02634f
C456 ta0 chain 0.00242f
C457 d1 m1_2792_6140# 0.10634f
C458 a_5524_16920# vbn_ax 0.01047f
C459 m1_6184_19890# a_268_18520# 0
C460 m1_5512_19890# m1_7790_19900# 0.16066f
C461 vbp_st a_3048_3120# 0.00581f
C462 m1_7790_19900# m1_7130_19630# 0
C463 vbp_st m1_3680_6970# 0.23943f
C464 ta3 m1_4330_6980# 0.00683f
C465 a_3048_11000# a_4588_13668# 0.01621f
C466 a_6672_14314# chain 0.01151f
C467 d2 a_2492_18520# 0.00779f
C468 a_8240_16974# a_7540_18520# 0
C469 m1_3680_6970# a_2592_8154# 0.00134f
C470 ta3 m1_7130_7810# 0.1227f
C471 m1_5512_19890# m1_3870_19890# 0.35453f
C472 a_3048_16080# tb2 0.13064f
C473 a_4588_8588# m1_5190_10190# 0.29071f
C474 m1_3870_19890# m1_7130_19630# 0.14253f
C475 m1_3870_19890# pl_en 0.0087f
C476 a_5316_3120# a_268_18520# 0.0156f
C477 m1_2062_6980# m1_5946_6980# 0
C478 m1_6440_6140# pl_en 0
C479 tb1 tb0 0.40057f
C480 vbp_st m1_5808_2480# 0
C481 el a_5524_5520# 0.11647f
C482 a_1480_3834# vs 0.10063f
C483 a_824_11000# a_2492_11000# 0.01767f
C484 a_1892_3934# m1_2062_6980# 0
C485 m1_2112_9090# m1_2668_7940# 0.04673f
C486 a_3048_16080# vsrcp 0.00715f
C487 sel1 a_7540_18520# 0.00549f
C488 m1_7702_7950# ta0 0.00305f
C489 a_488_12040# a_6140_9234# 0.05027f
C490 hold a_4588_13668# 0.19039f
C491 vbp_st d2 0.29028f
C492 a_2800_5520# a_3048_3120# 0.27115f
C493 m1_5286_6980# pl_en 0.00447f
C494 d2 a_2592_8154# 0.3472f
C495 ta3 tb2 0.00805f
C496 a_2492_3120# chain 0.0027f
C497 m1_6968_10270# ta0 0.0069f
C498 a_3212_19360# chain 0
C499 a_2800_5520# m1_3680_6970# 0
C500 m1_2862_14560# el 0.01233f
C501 mreset a_3136_4480# 0.19549f
C502 a_488_19360# a_488_17120# 0.01104f
C503 ta3 vs 0
C504 ta1 m1_6494_7910# 0
C505 spk a_3272_6334# 0.19447f
C506 a_3048_11000# a_4588_8588# 0
C507 ta2 m1_5428_15340# 0.01291f
C508 vsrc a_6984_3120# 0
C509 spk a_4096_6334# 0.21403f
C510 ta3 vsrcp 0.05767f
C511 a_8248_5320# vs 0.0495f
C512 sel0 vbn_leak 0.23344f
C513 a_6984_3120# vbn_ref 0
C514 vdd m1_8466_15350# 0.02935f
C515 vbn_prb chain 0.00442f
C516 a_268_18520# vs 0.2405f
C517 hold a_5316_18520# 0.14235f
C518 a_3136_4480# a_488_12040# 0.29415f
C519 vbp_st a_6984_18520# 0.00398f
C520 m1_5190_10190# a_6140_9234# 0.02338f
C521 a_268_18520# vsrcp 0.11644f
C522 a_2492_18520# a_488_17120# 0.02687f
C523 a_2592_8154# a_6984_18520# 0.33059f
C524 vbp_st abus 0.29503f
C525 a_5524_16920# m1_8466_15350# 0.00531f
C526 a_5524_11840# m1_7702_10190# 0.04919f
C527 hold a_4588_8588# 0.2171f
C528 vbn_leak m1_2712_15340# 0.13609f
C529 m1_7790_19900# tb1 0.0051f
C530 m1_5512_19890# ta0 0.00262f
C531 a_6328_4480# el 0.16668f
C532 a_4588_13668# m1_6716_15540# 0.1074f
C533 a_2492_18520# m1_2470_19900# 0
C534 m1_7206_17740# a_5316_18520# 0.33816f
C535 m1_2956_19890# d1_bsel 0.07852f
C536 m1_5512_19890# tb3 0.6109f
C537 a_5316_3120# a_3272_6334# 0.01663f
C538 vdd a_3048_3120# 0.51947f
C539 m1_3870_19890# tb1 0.01171f
C540 tb3 m1_7130_19630# 0.20485f
C541 ta0 m1_7130_19630# 0.00381f
C542 m1_3870_19890# en 0.05808f
C543 ta1 el 0.04789f
C544 a_5316_3120# a_4096_6334# 0.20917f
C545 m1_4330_6980# a_4096_6334# 0
C546 ta0 pl_en 0.04476f
C547 vbp_st a_488_17120# 0.19399f
C548 m1_3680_6970# vdd 0.90391f
C549 vbn_leak m1_7702_15230# 0.00295f
C550 a_488_17120# a_2592_8154# 0.19442f
C551 m1_3870_19890# sta 0.01251f
C552 a_728_3738# vs 0.25492f
C553 a_5516_10600# a_488_12040# 0.00213f
C554 m1_5512_19890# a_6672_14314# 0.00163f
C555 ta3 a_3048_16080# 0.06801f
C556 hold m1_7096_14156# 0
C557 a_3136_4480# m1_5190_10190# 0.00269f
C558 el a_824_16080# 0.15794f
C559 sel0 d1 0
C560 a_3048_11000# a_6140_9234# 0.21534f
C561 a_6672_14314# pl_en 0.04669f
C562 a_6672_14314# m1_7130_19630# 0.00419f
C563 m1_7206_17740# m1_8326_19030# 0.00343f
C564 m1_5286_6980# en 0.27342f
C565 a_3048_16080# a_268_18520# 0.06028f
C566 vbn_ax a_7540_3120# 0.0144f
C567 vbp_st m1_7148_12980# 0
C568 a_4588_13668# chain 0.00279f
C569 vsrc tb0 0
C570 vbp_syn m1_2956_19890# 0
C571 mreset spk 4.10998f
C572 a_1480_3834# a_268_18520# 0.00147f
C573 m1_7148_12980# a_2592_8154# 0.00864f
C574 m1_6716_11710# el 0.01955f
C575 vdd d2 1.80687f
C576 a_6594_420# a_3048_3120# 0.06546f
C577 ta1 a_5524_11840# 0.02345f
C578 chain m1_1300_2620# 0.0013f
C579 tb0 a_7540_18520# 0
C580 a_6594_420# m1_3680_6970# 0
C581 hold a_6140_9234# 0.03395f
C582 a_488_12040# a_2180_13234# 0
C583 a_3272_6334# vs 0.59148f
C584 a_5524_16920# d2 0.07343f
C585 m1_3870_19890# d1_bsel 0.09991f
C586 ta3 a_268_18520# 0.01224f
C587 a_488_5520# vsrc 0.07797f
C588 a_4096_6334# vs 0.71752f
C589 a_5516_10600# m1_5190_10190# 0.14112f
C590 a_3272_6334# vsrcp 0
C591 a_3048_11000# a_3136_4480# 0.74513f
C592 a_488_17120# a_824_18520# 0.04722f
C593 a_2800_17120# a_3212_19360# 0.00135f
C594 m1_910_6150# vs 0.10003f
C595 vbp_syn m1_2678_13100# 0.41308f
C596 a_5316_18520# chain 0.00612f
C597 a_8248_5320# a_268_18520# 0.09228f
C598 m1_8466_10270# a_6672_9234# 0.00558f
C599 a_1480_3834# a_728_3738# 0.11836f
C600 a_5524_11840# m1_6716_11710# 0
C601 a_488_12040# a_5268_9138# 0.19579f
C602 vdd a_6984_18520# 0.18483f
C603 mreset a_5316_3120# 0.0019f
C604 vbp_syn m1_3870_19890# 0.0679f
C605 vdd abus 0.22852f
C606 a_4588_8588# chain 0.04085f
C607 m1_9090_16790# a_6140_14314# 0.02495f
C608 vbn_prb m1_2708_380# 0.07701f
C609 vbn_prb pl_en 0.01418f
C610 hold a_3136_4480# 0.817f
C611 tb3 tb1 0.10615f
C612 d2 a_672_20034# 0
C613 m1_6494_7910# vbn_leak 0.03578f
C614 en ta0 0.01126f
C615 tb3 sta 0
C616 ta0 sta 0
C617 m1_9090_11710# m1_8466_10270# 0
C618 a_5516_10600# a_3048_11000# 0.05392f
C619 a_5524_16920# abus 0.08054f
C620 a_6672_14314# tb1 0.00304f
C621 m1_7130_7810# a_488_12040# 0.01721f
C622 a_6672_14314# en 0.01483f
C623 vbp_st ta2 0.06096f
C624 vdd a_488_17120# 2.40209f
C625 a_1480_3834# a_3272_6334# 0.34419f
C626 ta2 a_2592_8154# 0.06955f
C627 el m1_6494_12990# 0.04679f
C628 a_728_3738# a_268_18520# 0
C629 a_1480_3834# a_4096_6334# 0.00102f
C630 m1_5190_10190# a_5268_9138# 0.14276f
C631 a_6672_14314# sta 0.02407f
C632 a_6594_420# abus 0.46812f
C633 a_5524_16920# a_488_17120# 0.08721f
C634 m1_910_6150# a_1480_3834# 0
C635 hold a_5516_10600# 0.35764f
C636 vdd m1_2470_19900# 0.01291f
C637 mreset vs 0.29332f
C638 m1_7702_7950# a_4588_8588# 0.06965f
C639 a_672_20034# a_6984_18520# 0
C640 m1_3870_19890# a_7540_18520# 0.13018f
C641 mreset vsrcp 0.03603f
C642 a_3048_11000# a_6884_4480# 0
C643 a_4588_8588# m1_6968_10270# 0.01249f
C644 hold a_3048_18520# 0.03647f
C645 a_488_19360# stb 0.17888f
C646 hold a_6140_14314# 0.22167f
C647 ta3 a_4096_6334# 0
C648 a_6140_9234# chain 0.01573f
C649 vbn_leak el 4.80806f
C650 a_4588_13668# pl_en 0.02287f
C651 pl_en sel2 0
C652 a_4588_13668# a_2800_17120# 0
C653 a_5524_16920# m1_7148_12980# 0.1111f
C654 en a_3212_19360# 0.0088f
C655 vbn_leak vreset 0.06347f
C656 a_8248_5320# a_3272_6334# 0.0896f
C657 m1_7130_7810# m1_5190_10190# 0.19093f
C658 a_3136_4480# m1_6716_15540# 0.0248f
C659 a_3212_19360# sta 0
C660 a_268_18520# a_3272_6334# 0.25989f
C661 a_3048_3120# a_7540_3120# 0.0431f
C662 a_268_18520# a_4096_6334# 0.03964f
C663 a_488_12040# vsrcp 0.05729f
C664 a_3048_11000# a_5268_9138# 0.09882f
C665 a_488_5520# a_1892_3934# 0.01539f
C666 hold a_6884_4480# 0.04969f
C667 m1_3680_6970# a_7540_3120# 0
C668 stb a_2492_18520# 0.00658f
C669 a_488_17120# a_672_20034# 0
C670 hold a_2180_13234# 0.4113f
C671 m1_1946_330# abus 0.14911f
C672 m1_5512_19890# a_5316_18520# 0
C673 a_5524_11840# vbn_leak 0.31519f
C674 vbn_prb en 0.06138f
C675 a_5316_18520# pl_en 0.02375f
C676 m1_5808_2480# a_7540_3120# 0.24942f
C677 a_3136_4480# chain 0.29113f
C678 hold a_5268_9138# 0.37145f
C679 hold m1_6184_19890# 0.09163f
C680 m1_7702_7950# a_6140_9234# 0.03645f
C681 m1_7206_17740# a_2180_13234# 0.01805f
C682 a_3048_11000# m1_7130_7810# 0
C683 d1_bsel a_3212_19360# 0.05367f
C684 m1_5512_19890# m1_8326_19030# 0.28279f
C685 a_728_3738# a_3272_6334# 0.02436f
C686 m1_6968_10270# a_6140_9234# 0.11497f
C687 a_4588_8588# pl_en 0.00759f
C688 d1 el 1.68237f
C689 stb a_2592_8154# 0.25622f
C690 m1_5190_10190# vsrcp 0.05485f
C691 m1_7130_19630# m1_8326_19030# 0.05032f
C692 m1_6716_15540# a_6140_14314# 0.02925f
C693 vdd ta2 0.22588f
C694 d1 vreset 0.01247f
C695 m1_910_6150# a_728_3738# 0.04597f
C696 m1_5946_6980# m1_6440_6140# 0.14603f
C697 tb3 a_7540_18520# 0
C698 a_6672_14314# vsrc 0
C699 ta1 m1_5428_15340# 0.00559f
C700 ta0 a_7540_18520# 0.007f
C701 hold m1_7130_7810# 0.00105f
C702 m1_1860_10650# el 0.00359f
C703 vdd a_2800_12040# 1.28654f
C704 a_5516_10600# chain 0
C705 a_5516_15680# vbn_ax 0
C706 a_5524_16920# ta2 0.03504f
C707 m1_5286_6980# m1_5946_6980# 0.04296f
C708 vbp_syn a_3212_19360# 0.14244f
C709 mreset a_8248_5320# 0.07917f
C710 a_5524_11840# d1 0.43f
C711 m1_7096_14156# pl_en 0
C712 a_4588_13668# en 0.03086f
C713 m1_5286_6980# a_6672_9234# 0
C714 mreset a_268_18520# 0.73161f
C715 a_2800_5520# a_4660_4480# 0.02846f
C716 en sel2 0
C717 abus a_7540_3120# 0.109f
C718 el m1_2792_6140# 0.1f
C719 m1_642_6980# m1_1096_6970# 0.00895f
C720 ta3 a_488_12040# 0.10297f
C721 a_4588_13668# sta 0.00542f
C722 m1_1096_6970# m1_2122_6150# 0.00272f
C723 a_4096_6334# a_3272_6334# 0.06706f
C724 m1_642_6980# vbn_leak 0.00531f
C725 a_6140_14314# chain 0.10812f
C726 en m1_1300_2620# 0
C727 m1_2122_6150# vbn_leak 0
C728 a_3048_11000# vsrcp 0.06836f
C729 stb a_824_18520# 0.00181f
C730 hold tb2 0
C731 a_488_12040# a_8248_5320# 0.00204f
C732 m1_6716_15540# a_5268_9138# 0
C733 vsrc a_2492_3120# 0.04873f
C734 chain a_2180_13234# 0.02317f
C735 a_6884_4480# chain 0.00474f
C736 pl_en a_6140_9234# 0.16814f
C737 a_3048_16080# m1_9090_16790# 0.00364f
C738 spk chain 0.34269f
C739 hold vs 0.24351f
C740 en a_5316_18520# 0.04962f
C741 hold vsrcp 0.0702f
C742 a_488_17120# a_2492_16080# 0.01522f
C743 a_3212_19360# a_7540_18520# 0.00244f
C744 a_5516_10600# m1_6968_10270# 0
C745 vsrc vbn_prb 0.53904f
C746 ta3 m1_5190_10190# 0.00421f
C747 a_5268_9138# chain 0.07746f
C748 m1_7206_17740# tb2 0
C749 vbn_prb vbn_ref 0.15806f
C750 vbp_st a_5524_5520# 0.33199f
C751 a_4588_8588# en 0.14192f
C752 m1_6184_19890# chain 0.03211f
C753 m1_4882_3750# vbn_ax 0.1321f
C754 tb1 m1_8326_19030# 0.11399f
C755 m1_5946_6980# ta0 0.02802f
C756 a_4588_8588# sta 0.04424f
C757 m1_2956_19890# m1_4568_19890# 0
C758 stb vdd 1.00268f
C759 m1_642_6980# d1 0
C760 a_3136_4480# pl_en 0.10424f
C761 vdd a_4660_4480# 0.12731f
C762 ta0 a_6672_9234# 0.00864f
C763 a_2800_17120# a_3136_4480# 0.05881f
C764 m1_2112_9090# a_2492_11000# 0.00121f
C765 a_5316_3120# chain 0
C766 vbp_st m1_7702_10190# 0
C767 vbp_syn a_4588_13668# 0.08366f
C768 m1_4330_6980# chain 0
C769 mreset a_3272_6334# 0.44087f
C770 m1_7702_10190# a_2592_8154# 0.02453f
C771 m1_2112_14220# d2 0.00945f
C772 a_8240_16974# vbn_ax 0.01198f
C773 en m1_7096_14156# 0
C774 mreset a_4096_6334# 0.02603f
C775 m1_7130_7810# chain 0
C776 a_5316_18520# d1_bsel 0.00202f
C777 a_2800_5520# a_5524_5520# 0.09425f
C778 m1_6494_12990# m1_5428_15340# 0.03557f
C779 ta3 a_3048_11000# 0.29144f
C780 hold a_3048_16080# 0.5763f
C781 m1_6716_15540# vsrcp 0.0233f
C782 vbn_ax sel1 0.03222f
C783 a_6594_420# a_4660_4480# 0
C784 a_3048_11000# a_8248_5320# 0.00248f
C785 m1_6968_10270# a_5268_9138# 0.47589f
C786 vsrc sel2 0.02671f
C787 m1_2122_6150# m1_2792_6140# 0.00347f
C788 a_5516_10600# pl_en 0.00109f
C789 sel2 vbn_ref 0.02681f
C790 vbp_syn a_5316_18520# 0.01506f
C791 m1_3870_19890# m1_4568_19890# 0.04556f
C792 en a_6140_9234# 0.02462f
C793 m1_5512_19890# a_6140_14314# 0.00256f
C794 a_3048_18520# a_2800_17120# 0.00343f
C795 vsrc m1_1300_2620# 0.15797f
C796 a_6140_9234# sta 0.03525f
C797 hold ta3 0.02912f
C798 vbn_leak m1_5428_15340# 0.54094f
C799 m1_7206_17740# a_3048_16080# 0.01737f
C800 stb a_672_20034# 0.50543f
C801 a_4588_13668# a_7540_18520# 0
C802 vbp_st a_6328_4480# 0.14498f
C803 pl_en a_6140_14314# 0.11471f
C804 m1_7130_19630# a_6140_14314# 0.01074f
C805 a_1892_3934# a_2492_3120# 0.00461f
C806 chain vs 0.20655f
C807 hold a_8248_5320# 0.00353f
C808 m1_7702_7950# m1_7130_7810# 0.1232f
C809 vbp_syn a_4588_8588# 0.01028f
C810 ta1 vbp_st 0.12449f
C811 sel0 el 0.04719f
C812 ta1 a_2592_8154# 0.05183f
C813 vsrcp chain 0.09199f
C814 hold a_268_18520# 0.87953f
C815 pl_en a_2180_13234# 0.02326f
C816 m1_6968_10270# m1_7130_7810# 0.06606f
C817 m1_2062_6980# a_3048_3120# 0.00329f
C818 a_2800_17120# a_2180_13234# 0.07731f
C819 sel0 vreset 0.60831f
C820 en a_3136_4480# 0.05773f
C821 a_6984_3120# vbn_ax 0.00176f
C822 vdd a_5524_5520# 1.43712f
C823 m1_2062_6980# m1_3680_6970# 0.33865f
C824 vbn_prb a_6672_9234# 0.0413f
C825 a_5516_15680# d2 0.20772f
C826 ta3 m1_7206_17740# 0.07395f
C827 el m1_2712_15340# 0.37916f
C828 a_3048_16080# m1_6716_15540# 0.02001f
C829 a_3136_4480# sta 0.12441f
C830 a_5316_18520# a_7540_18520# 0.28103f
C831 m1_5512_19890# m1_6184_19890# 0.22289f
C832 vbp_st m1_2712_6970# 0.11741f
C833 vbp_st m1_6716_11710# 0
C834 pl_en a_5268_9138# 0.18784f
C835 vsrc m1_8326_19030# 0
C836 m1_2712_6970# a_2592_8154# 0.00585f
C837 m1_7206_17740# a_268_18520# 0.04521f
C838 m1_6184_19890# pl_en 0.00903f
C839 m1_6184_19890# m1_7130_19630# 0.01624f
C840 vsrcp m1_2236_8010# 0
C841 vdd m1_2862_14560# 0.21383f
C842 d1 m1_5428_15340# 0
C843 vdd m1_7702_10190# 0.03077f
C844 a_8240_16974# m1_8466_15350# 0.025f
C845 m1_7702_7950# vsrcp 0.00303f
C846 m1_8326_19030# a_7540_18520# 0
C847 ta3 m1_6716_15540# 0.03329f
C848 a_3048_16080# chain 0.00426f
C849 a_1480_3834# chain 0.00472f
C850 m1_6968_10270# vsrcp 0.03024f
C851 m1_9090_11710# vbn_prb 0
C852 a_6594_420# a_5524_5520# 0.06292f
C853 a_4588_8588# m1_2668_7940# 0
C854 a_824_3120# vsrc 0.23574f
C855 a_3048_11000# a_4096_6334# 0
C856 a_5516_10600# en 0.05164f
C857 m1_8466_15350# sel1 0.10258f
C858 a_2800_5520# m1_2712_6970# 0
C859 a_5516_10600# sta 0.02513f
C860 a_268_18520# m1_6716_15540# 0.11944f
C861 a_824_16080# a_824_18520# 0.0013f
C862 m1_7130_7810# pl_en 0.00622f
C863 tb1 a_6140_14314# 0.00277f
C864 m1_4882_3750# m1_5808_2480# 0.00894f
C865 a_6672_9234# sel2 0.03581f
C866 en a_6140_14314# 0.18195f
C867 a_488_19360# vbn_leak 0.00875f
C868 ta3 chain 0.04925f
C869 a_6140_14314# sta 0.06328f
C870 a_7540_3120# a_4660_4480# 0.13062f
C871 a_6328_4480# vdd 0.11231f
C872 hold a_4096_6334# 0.0024f
C873 vsrc a_6140_9234# 0
C874 m1_5512_19890# tb2 0.3327f
C875 vbn_ax tb0 0.06242f
C876 en a_2180_13234# 0.0391f
C877 a_1892_3934# m1_1300_2620# 0.00109f
C878 a_5516_15680# a_488_17120# 0.02223f
C879 m1_7130_19630# tb2 0.19023f
C880 a_268_18520# chain 0.11034f
C881 vbp_syn a_3136_4480# 0.01346f
C882 en spk 0.11403f
C883 vbp_st m1_6494_12990# 0
C884 sta a_2180_13234# 0.03762f
C885 ta1 vdd 0.92011f
C886 vbn_leak a_2492_18520# 0.01385f
C887 m1_2708_380# vs 0.02594f
C888 vdd a_824_16080# 0.13591f
C889 a_8240_16974# d2 0.51538f
C890 en a_5268_9138# 0.05219f
C891 ta1 a_5524_16920# 0.02568f
C892 a_2800_17120# vsrcp 0.00133f
C893 pl_en vsrcp 0.58611f
C894 a_3048_18520# d1_bsel 0
C895 m1_6184_19890# tb1 0
C896 m1_6716_16790# vbp_st 0.07358f
C897 en m1_6184_19890# 0
C898 a_4588_8588# m1_5946_6980# 0
C899 a_5268_9138# sta 0.24784f
C900 m1_4568_19890# a_3212_19360# 0.00344f
C901 vsrc a_3136_4480# 0
C902 vdd m1_2712_6970# 0.00491f
C903 ta3 m1_7702_7950# 0.00217f
C904 m1_6716_11710# vdd 0.08506f
C905 m1_6184_19890# sta 0.03035f
C906 a_3136_4480# vbn_ref 0.01055f
C907 m1_4882_3750# abus 0.00481f
C908 vbp_st m1_1096_6970# 0.16622f
C909 a_1892_3934# a_4588_8588# 0
C910 a_4588_8588# a_6672_9234# 0
C911 d2 sel1 0.22848f
C912 vbp_st vbn_leak 0.59822f
C913 ta3 m1_6968_10270# 0.16426f
C914 vbp_syn a_5516_10600# 0.00586f
C915 vbn_leak a_2592_8154# 0.42375f
C916 a_728_3738# chain 0
C917 a_5316_3120# en 0.08385f
C918 d1_bsel a_2180_13234# 0.04507f
C919 en m1_4330_6980# 0.01003f
C920 a_5524_16920# m1_6716_11710# 0
C921 a_8240_16974# a_6984_18520# 0
C922 a_3048_18520# vbp_syn 0.00414f
C923 ta1 a_672_20034# 0
C924 a_3048_11000# a_488_12040# 1.48659f
C925 vbp_syn a_6140_14314# 0
C926 a_5524_11840# m1_6494_7910# 0.02463f
C927 m1_5512_19890# a_3048_16080# 0.26271f
C928 a_3048_16080# pl_en 0.00316f
C929 a_3048_16080# m1_7130_19630# 0.44995f
C930 m1_6184_19890# d1_bsel 0.04181f
C931 vbn_ax m1_6440_6140# 0
C932 a_7540_3120# a_5524_5520# 0.11925f
C933 a_2800_5520# vbn_leak 0.33587f
C934 vbp_syn a_2180_13234# 0.26007f
C935 a_3048_16080# a_2800_17120# 0.07471f
C936 sel1 a_6984_18520# 0.02471f
C937 m1_3870_19890# vbn_ax 0.50287f
C938 a_728_3738# m1_2236_8010# 0.00158f
C939 a_6984_3120# m1_5808_2480# 0.4245f
C940 a_3272_6334# chain 0.01519f
C941 abus sel1 0.01391f
C942 tb1 tb2 0.45856f
C943 a_4096_6334# chain 0.09371f
C944 hold a_488_12040# 0.31231f
C945 a_8240_16974# a_488_17120# 0.31515f
C946 vsrc a_6140_14314# 0
C947 el vreset 0.04146f
C948 vbp_st d1 0.92272f
C949 m1_7148_12980# m1_7702_12990# 0.09139f
C950 a_5516_15680# ta2 0
C951 a_6672_9234# a_6140_9234# 0.89846f
C952 m1_5512_19890# ta3 0.15176f
C953 en vs 0.38817f
C954 vbp_syn a_5268_9138# 0.00867f
C955 d1 a_2592_8154# 0.425f
C956 ta3 m1_7130_19630# 0.05752f
C957 ta3 pl_en 0.09766f
C958 a_488_17120# sel1 0.04503f
C959 m1_2862_14560# a_2492_16080# 0.00274f
C960 en vsrcp 0.11656f
C961 m1_7148_12980# a_8240_16974# 0
C962 m1_5512_19890# a_268_18520# 0
C963 vsrc spk 0.59561f
C964 vsrcp sta 0.03755f
C965 a_5524_11840# el 0.05375f
C966 a_268_18520# m1_7130_19630# 0
C967 pl_en a_268_18520# 0.02431f
C968 spk vbn_ref 0.19946f
C969 m1_2062_6980# ta2 0.03522f
C970 m1_1860_10650# a_2592_8154# 0
C971 a_5524_16920# m1_6494_12990# 0.05657f
C972 m1_6716_16790# vdd 0.07195f
C973 a_7540_18520# a_2180_13234# 0.19956f
C974 a_2800_5520# d1 0.07176f
C975 hold m1_5190_10190# 0.05269f
C976 m1_9090_11710# a_6140_9234# 0.00829f
C977 a_6984_3120# abus 0
C978 m1_1096_6970# vdd 0.02187f
C979 vbp_st m1_2792_6140# 0.35975f
C980 m1_8466_10270# abus 0.03758f
C981 a_3136_4480# a_6672_9234# 0.16879f
C982 a_1892_3934# a_3136_4480# 0.0014f
C983 m1_2712_15340# m1_5428_15340# -0
C984 vdd vbn_leak 3.00314f
C985 m1_6716_16790# a_5524_16920# 0
C986 a_488_5520# a_3048_3120# 0.00486f
C987 a_6328_4480# a_7540_3120# 0.2954f
C988 ta0 m1_7150_9150# 0.00284f
C989 a_5524_16920# vbn_leak 0.3778f
C990 m1_1046_17880# a_3212_19360# 0.05842f
C991 a_5316_3120# vsrc 0
C992 m1_2668_7940# a_5268_9138# 0
C993 en a_3048_16080# 0.38852f
C994 tb3 vbn_ax 0.08866f
C995 a_3048_16080# tb1 0.31573f
C996 a_5316_3120# vbn_ref 0.00111f
C997 mreset chain 0
C998 vbn_ax ta0 0.01042f
C999 a_3048_16080# sta 0.00427f
C1000 a_2800_5520# m1_2792_6140# 0.49123f
C1001 m1_9090_11710# a_3136_4480# 0.00196f
C1002 a_6594_420# vbn_leak 0.08065f
C1003 hold a_3048_11000# 0.66554f
C1004 a_6672_14314# vbn_ax 0.00417f
C1005 a_488_12040# chain 0.00332f
C1006 a_824_16080# a_2492_16080# 0.01193f
C1007 m1_2956_19890# d2 0
C1008 vbp_syn vsrcp 0.0291f
C1009 a_8240_16974# ta2 0.09297f
C1010 ta3 tb1 0.0058f
C1011 ta3 en 0.1635f
C1012 ta3 sta 0
C1013 vdd d1 2.60117f
C1014 vbn_leak a_672_20034# 0.71151f
C1015 m1_2708_380# a_3272_6334# 0
C1016 a_268_18520# tb1 0
C1017 ta2 sel1 0.0303f
C1018 en a_268_18520# 0.30658f
C1019 a_268_18520# sta 0.66965f
C1020 vsrc vs 0.72271f
C1021 m1_3680_6970# m1_6440_6140# 0.25246f
C1022 a_5524_16920# d1 0
C1023 a_7540_18520# tb2 0.00152f
C1024 vbn_ref vs 0.25043f
C1025 m1_2062_6980# a_4660_4480# 0
C1026 vsrc vsrcp 3.99883f
C1027 m1_1860_10650# vdd 0.25219f
C1028 m1_2112_14220# m1_2862_14560# 0.26345f
C1029 vbn_ax a_3212_19360# 0.10833f
C1030 vsrcp vbn_ref 0.03216f
C1031 a_1892_3934# spk 0.03198f
C1032 d2 m1_2678_13100# 0.17341f
C1033 m1_5190_10190# chain 0.06889f
C1034 a_488_17120# tb0 0.03185f
C1035 m1_5286_6980# m1_3680_6970# 0.00247f
C1036 m1_7702_7950# a_488_12040# 0.04764f
C1037 hold m1_7206_17740# 0.04953f
C1038 a_6594_420# d1 0.06354f
C1039 vdd m1_2792_6140# 1.8388f
C1040 a_6672_9234# a_5268_9138# 0.04896f
C1041 m1_3870_19890# d2 0
C1042 m1_6968_10270# a_488_12040# 0.56032f
C1043 a_3048_11000# m1_6716_15540# 0.101f
C1044 vbp_syn a_3048_16080# 0.14718f
C1045 m1_7930_11710# a_4588_13668# 0
C1046 vbn_prb vbn_ax 0.29223f
C1047 m1_2668_7940# vsrcp 0.01752f
C1048 m1_4882_3750# a_4660_4480# 0.27778f
C1049 a_728_3738# sta 0.00203f
C1050 d1_bsel a_268_18520# 0.11184f
C1051 m1_4330_6980# m1_5946_6980# -0.00645f
C1052 vbp_st sel0 0.03823f
C1053 a_1892_3934# m1_4330_6980# 0.00259f
C1054 hold m1_6716_15540# 0.57934f
C1055 vsrc a_1480_3834# 0.09845f
C1056 a_3048_11000# chain 0.10312f
C1057 a_824_11000# d1 0.01538f
C1058 a_6672_14314# m1_8466_15350# 0.03017f
C1059 a_6594_420# m1_2792_6140# 0.06928f
C1060 m1_7702_7950# m1_5190_10190# 0.02609f
C1061 m1_3870_19890# a_6984_18520# 0.05464f
C1062 m1_2956_19890# m1_2470_19900# 0.00741f
C1063 m1_6968_10270# m1_5190_10190# 0
C1064 vbp_syn a_268_18520# 0.14975f
C1065 en a_3272_6334# 0.18405f
C1066 a_3048_16080# a_7540_18520# 0.01671f
C1067 en a_4096_6334# 0.07436f
C1068 vbn_leak a_7540_3120# 0.00399f
C1069 m1_1860_10650# a_824_11000# 0.24993f
C1070 el m1_5428_15340# 0.43851f
C1071 stb sel1 0.0337f
C1072 m1_7790_19900# a_488_17120# 0
C1073 m1_3680_6970# ta0 0.00829f
C1074 m1_2062_6980# a_5524_5520# 0.49148f
C1075 hold chain 0.5286f
C1076 a_488_12040# pl_en 0.19114f
C1077 a_1480_3834# m1_2668_7940# 0
C1078 a_4588_13668# vbn_ax 0
C1079 vbn_ax sel2 0.02691f
C1080 vbn_leak a_2492_16080# 0.00171f
C1081 vsrc a_8248_5320# 0.15388f
C1082 a_3048_11000# m1_2236_8010# 0
C1083 vbp_st m1_7702_15230# 0.00774f
C1084 m1_3870_19890# a_488_17120# 0.14372f
C1085 a_8248_5320# vbn_ref 0.17077f
C1086 m1_5946_6980# vsrcp 0
C1087 vsrc a_268_18520# 0.00436f
C1088 a_2592_8154# m1_7702_15230# 0.03921f
C1089 ta3 a_7540_18520# 0.03194f
C1090 a_268_18520# vbn_ref 0.01311f
C1091 a_1892_3934# vs 0.17729f
C1092 a_3048_11000# m1_7702_7950# 0.03087f
C1093 a_6672_9234# vsrcp 0.08787f
C1094 a_3048_11000# m1_6968_10270# 0.0011f
C1095 d2 ta0 0.03848f
C1096 m1_7930_16790# vbn_ax 0
C1097 a_5524_11840# m1_5428_15340# 0
C1098 m1_7206_17740# chain 0.04672f
C1099 m1_3870_19890# m1_2470_19900# 0
C1100 hold m1_2236_8010# 0.00782f
C1101 a_268_18520# a_7540_18520# 0.06778f
C1102 vbn_prb m1_8466_15350# 0.18868f
C1103 a_5316_18520# vbn_ax 0.04946f
C1104 m1_4882_3750# a_5524_5520# 0.17679f
C1105 m1_5190_10190# pl_en 0.00366f
C1106 a_6672_14314# d2 0.0658f
C1107 a_2492_3120# a_3048_3120# 0.10168f
C1108 a_4588_8588# m1_7150_9150# 0
C1109 d1 a_7540_3120# 0.10275f
C1110 m1_9090_16790# m1_7130_19630# 0
C1111 ta1 a_5516_15680# 0
C1112 hold m1_6968_10270# 0.04349f
C1113 vsrc a_728_3738# 0.28221f
C1114 m1_7930_11710# a_6140_9234# 0.00178f
C1115 m1_6716_15540# chain 0
C1116 ta0 a_6984_18520# 0.05606f
C1117 tb3 a_6984_18520# 0
C1118 vbn_ax m1_8326_19030# 0.19392f
C1119 mreset en 0.16251f
C1120 sel0 vdd 0.18176f
C1121 m1_2062_6980# a_6328_4480# 0
C1122 vbn_prb a_3048_3120# 0
C1123 a_1892_3934# a_1480_3834# 0.12967f
C1124 ta1 m1_2062_6980# 0.19379f
C1125 d2 a_3212_19360# 0.17563f
C1126 en a_488_12040# 0.22551f
C1127 a_3048_11000# pl_en 0.38588f
C1128 m1_2792_6140# a_7540_3120# 0.13333f
C1129 vdd m1_2712_15340# 0.11664f
C1130 a_6672_14314# abus 0.00838f
C1131 m1_6494_7910# a_2592_8154# 0
C1132 ta3 m1_5946_6980# 0.15534f
C1133 a_488_12040# sta 0.34846f
C1134 ta0 a_488_17120# 0.00613f
C1135 vsrc a_3272_6334# 0.30339f
C1136 tb3 a_488_17120# 0.03246f
C1137 m1_7790_19900# ta2 0
C1138 vsrc a_4096_6334# 0.16023f
C1139 a_3272_6334# vbn_ref 0.10836f
C1140 vbn_prb m1_5808_2480# 0.25117f
C1141 ta3 a_6672_9234# 0.00282f
C1142 a_6594_420# sel0 0.11844f
C1143 a_4096_6334# vbn_ref 0.19906f
C1144 m1_7150_9150# a_6140_9234# 0.00481f
C1145 m1_5512_19890# hold 0.00951f
C1146 a_2800_12040# m1_2678_13100# 0
C1147 m1_2062_6980# m1_2712_6970# 0.05097f
C1148 vbn_prb d2 0.00172f
C1149 vdd m1_7702_15230# 0.0288f
C1150 m1_3870_19890# ta2 0.04556f
C1151 m1_4882_3750# a_6328_4480# 0.27246f
C1152 ta2 m1_6440_6140# 0.01748f
C1153 hold pl_en 0.35339f
C1154 hold m1_7130_19630# 0.0033f
C1155 a_268_18520# a_6672_9234# 0.00106f
C1156 m1_2112_14220# vbn_leak 0.00156f
C1157 hold a_2800_17120# 0.0937f
C1158 a_6672_14314# a_488_17120# 0.04707f
C1159 a_1892_3934# a_268_18520# 0.12735f
C1160 m1_7148_12980# ta0 0.01305f
C1161 a_3272_6334# m1_2668_7940# 0
C1162 a_5524_16920# m1_7702_15230# 0.09238f
C1163 m1_5286_6980# ta2 0.22872f
C1164 en m1_5190_10190# 0.45915f
C1165 m1_5190_10190# sta 0.08756f
C1166 m1_5512_19890# m1_7206_17740# 0.00271f
C1167 vbp_st el 1.13599f
C1168 el a_2592_8154# 0.08735f
C1169 a_3048_18520# m1_1046_17880# 0.0683f
C1170 m1_7206_17740# pl_en 0.04449f
C1171 m1_7206_17740# m1_7130_19630# 0.06263f
C1172 m1_2956_19890# stb 0.07037f
C1173 a_3048_3120# m1_1300_2620# 0.0744f
C1174 m1_6968_10270# chain 0.00116f
C1175 ta1 a_8240_16974# 0.06497f
C1176 vbp_st vreset 0.03293f
C1177 sel0 m1_1946_330# 0.01538f
C1178 a_3136_4480# vbn_ax 0.06942f
C1179 vbn_prb abus 2.20457f
C1180 a_3212_19360# a_488_17120# 0
C1181 a_1892_3934# a_728_3738# 0.00246f
C1182 m1_8466_10270# m1_7702_10190# 0.12314f
C1183 vbp_syn a_488_12040# 0.03405f
C1184 a_4588_13668# d2 0.14423f
C1185 ta1 sel1 0.03328f
C1186 m1_1046_17880# a_2180_13234# 0.24607f
C1187 a_3048_11000# en 0.12469f
C1188 mreset vsrc 0.04329f
C1189 vbp_st a_5524_11840# 0.054f
C1190 pl_en m1_6716_15540# 0.03978f
C1191 vbn_prb a_488_17120# 0
C1192 mreset vbn_ref 0.16657f
C1193 a_2800_5520# el 0.08371f
C1194 a_3048_11000# sta 0.25678f
C1195 a_5524_11840# a_2592_8154# 0.31738f
C1196 m1_7930_16790# d2 0.0356f
C1197 a_4588_8588# m1_3680_6970# 0
C1198 a_5516_15680# vbn_leak 0.19729f
C1199 ta2 ta0 0.32959f
C1200 m1_7702_7950# m1_6968_10270# 0.05888f
C1201 m1_7930_11710# a_5268_9138# 0.06158f
C1202 m1_3870_19890# stb 0.06213f
C1203 tb3 ta2 0.06155f
C1204 hold en 0.44449f
C1205 m1_5512_19890# chain 0.03186f
C1206 a_1892_3934# a_3272_6334# 0.24488f
C1207 a_5316_18520# d2 0.06263f
C1208 a_6328_4480# a_6984_3120# 0.00279f
C1209 a_1892_3934# a_4096_6334# 0.09177f
C1210 hold sta 0.9573f
C1211 a_3048_18520# vbn_ax 0.0124f
C1212 m1_7130_19630# chain 0
C1213 a_2800_17120# chain 0
C1214 m1_2062_6980# m1_1096_6970# 0.03955f
C1215 pl_en chain 2.43197f
C1216 a_6672_14314# ta2 0.00516f
C1217 m1_2062_6980# vbn_leak 1.13109f
C1218 abus sel2 0.08978f
C1219 vbn_ax a_6140_14314# 0.00219f
C1220 sel0 a_7540_3120# 0.01536f
C1221 m1_7206_17740# tb1 0.01245f
C1222 vbn_ax a_2180_13234# 0.1357f
C1223 m1_7206_17740# en 0.05639f
C1224 vbn_ax a_6884_4480# 0.01296f
C1225 vbn_ax spk 0.07201f
C1226 vbp_st m1_642_6980# 0.0237f
C1227 a_4588_13668# a_488_17120# 0.03307f
C1228 m1_7206_17740# sta 0.04145f
C1229 a_5316_18520# a_6984_18520# 0.01038f
C1230 vbp_st m1_2122_6150# 0.00843f
C1231 a_5268_9138# m1_7150_9150# 0.17212f
C1232 vdd el 1.88391f
C1233 m1_4568_19890# a_268_18520# 0.00255f
C1234 vbp_syn a_3048_11000# 0.13208f
C1235 m1_7096_14156# d2 0.03905f
C1236 a_3136_4480# m1_8466_15350# 0
C1237 hold d1_bsel 0.01606f
C1238 vdd vreset 0.17665f
C1239 m1_2712_15340# a_2492_16080# 0.30649f
C1240 m1_4882_3750# vbn_leak 0
C1241 m1_7702_7950# pl_en 0.0466f
C1242 a_4588_13668# m1_7148_12980# 0.10027f
C1243 a_5524_16920# el 0.24323f
C1244 m1_6968_10270# pl_en 0.18566f
C1245 en m1_6716_15540# 0.07077f
C1246 m1_7930_16790# a_488_17120# 0.0017f
C1247 m1_5190_10190# m1_2668_7940# 0
C1248 m1_6716_16790# a_8240_16974# 0
C1249 m1_2062_6980# d1 0.02182f
C1250 m1_6716_15540# sta 0.55802f
C1251 a_5524_11840# vdd 1.02405f
C1252 a_5316_18520# a_488_17120# 0.00666f
C1253 mreset a_1892_3934# 0
C1254 vbn_prb ta2 0
C1255 a_6594_420# el 0.10464f
C1256 m1_7130_7810# m1_7150_9150# 0
C1257 hold vbp_syn 0.76845f
C1258 m1_7206_17740# d1_bsel 0
C1259 tb3 stb 0
C1260 stb ta0 0.00229f
C1261 a_8240_16974# vbn_leak 0.22947f
C1262 a_3136_4480# a_3048_3120# 0.18217f
C1263 a_6594_420# vreset 0.1017f
C1264 m1_6440_6140# a_5524_5520# 0.01073f
C1265 m1_2112_9090# vbn_leak 0
C1266 m1_2862_14560# m1_2678_13100# 0.1543f
C1267 m1_6716_16790# sel1 0
C1268 m1_3680_6970# a_3136_4480# 0.03189f
C1269 en chain 0.51082f
C1270 a_488_12040# a_6672_9234# 0.07961f
C1271 a_488_17120# m1_8326_19030# 0.12827f
C1272 chain sta 0.1327f
C1273 vbn_leak sel1 0.25457f
C1274 m1_5286_6980# a_5524_5520# 0.00158f
C1275 m1_8466_15350# a_6140_14314# 0
C1276 a_3136_4480# m1_5808_2480# 0.31303f
C1277 m1_2062_6980# m1_2792_6140# 0.02369f
C1278 a_3048_11000# m1_2668_7940# 0.01924f
C1279 vbp_syn m1_7206_17740# 0.00408f
C1280 m1_4882_3750# d1 0.17496f
C1281 a_824_11000# el 0.04081f
C1282 m1_5512_19890# pl_en 0.03166f
C1283 a_3136_4480# d2 0.09711f
C1284 m1_5512_19890# m1_7130_19630# 0.1313f
C1285 vbn_ax tb2 0.06775f
C1286 a_2800_17120# pl_en 0
C1287 hold a_7540_18520# 0.14487f
C1288 pl_en m1_7130_19630# 0
C1289 abus a_6140_9234# 0.04018f
C1290 vsrcp m1_7150_9150# 0.20658f
C1291 m1_1046_17880# a_3048_16080# 0.01313f
C1292 m1_5190_10190# m1_5946_6980# 0.00105f
C1293 vbn_ax vs 0.00191f
C1294 hold m1_2668_7940# 0.00136f
C1295 a_4588_13668# ta2 0.00254f
C1296 vbn_ax vsrcp 0.07388f
C1297 m1_642_6980# vdd 0.01042f
C1298 m1_5190_10190# a_6672_9234# 0
C1299 sta m1_2236_8010# 0.08776f
C1300 m1_7148_12980# m1_7096_14156# 0.00222f
C1301 stb a_3212_19360# 0.1898f
C1302 m1_2122_6150# vdd 0.06884f
C1303 d1_bsel chain 0.00698f
C1304 m1_2112_9090# d1 0.00692f
C1305 en m1_6968_10270# 0.13614f
C1306 a_6984_3120# vbn_leak 0
C1307 m1_4882_3750# m1_2792_6140# 0.01624f
C1308 vbp_st m1_5428_15340# 0.00129f
C1309 a_4588_13668# a_2800_12040# 0.00127f
C1310 ta1 m1_7790_19900# 0
C1311 a_2592_8154# m1_5428_15340# 0
C1312 m1_6968_10270# sta 0.02269f
C1313 vbn_leak m1_8466_10270# 0.0731f
C1314 m1_7206_17740# a_7540_18520# 0.41414f
C1315 a_6328_4480# m1_6440_6140# 0
C1316 ta3 m1_7930_11710# 0.00383f
C1317 m1_2112_14220# m1_2712_15340# 0.00406f
C1318 a_3136_4480# abus 0.13182f
C1319 m1_3680_6970# a_6884_4480# 0.01655f
C1320 a_3048_3120# spk 0.23602f
C1321 ta1 m1_6440_6140# 0.33089f
C1322 a_3048_18520# d2 0.12082f
C1323 ta1 m1_3870_19890# 0.12977f
C1324 ta0 a_5524_5520# 0.00383f
C1325 m1_1860_10650# m1_2112_9090# 0.0016f
C1326 a_3048_11000# m1_5946_6980# 0
C1327 m1_3680_6970# spk 0.00637f
C1328 d2 a_6140_14314# 0.21596f
C1329 m1_1046_17880# a_268_18520# 0.01746f
C1330 a_3048_11000# a_6672_9234# 0.0286f
C1331 m1_5808_2480# a_6884_4480# 0
C1332 m1_5286_6980# ta1 0.14423f
C1333 m1_5808_2480# spk 0.00395f
C1334 a_4588_8588# ta2 0.00893f
C1335 a_3136_4480# a_488_17120# 0
C1336 d2 a_2180_13234# 0.27472f
C1337 a_3048_16080# vbn_ax 0.11012f
C1338 ta0 m1_7702_10190# 0
C1339 el a_7540_3120# 0.04932f
C1340 m1_5512_19890# tb1 0.05772f
C1341 hold m1_5946_6980# 0.00613f
C1342 m1_5512_19890# en 0.04621f
C1343 vreset a_7540_3120# 0
C1344 a_6984_3120# d1 0
C1345 ta3 m1_7150_9150# 0.05305f
C1346 a_4588_8588# a_2800_12040# 0
C1347 el a_2492_16080# 0.13036f
C1348 tb1 m1_7130_19630# 0.54622f
C1349 m1_5512_19890# sta 0.0328f
C1350 en a_2800_17120# 0
C1351 en m1_2708_380# 0.0383f
C1352 vbp_syn m1_2236_8010# 0.18279f
C1353 hold a_6672_9234# 0.01932f
C1354 en pl_en 2.70895f
C1355 d1 m1_8466_10270# 0.02519f
C1356 m1_7148_12980# a_3136_4480# 0.00489f
C1357 a_488_19360# a_2492_18520# 0.0106f
C1358 en m1_7130_19630# 0
C1359 hold a_1892_3934# 0.00195f
C1360 a_6140_14314# a_6984_18520# 0
C1361 m1_7130_19630# sta 0
C1362 pl_en sta 0.15279f
C1363 m1_9090_11710# a_3048_11000# 0.00153f
C1364 m1_7096_14156# ta2 0.03309f
C1365 chain a_7540_18520# 0.00777f
C1366 ta3 vbn_ax 0.00358f
C1367 vbn_leak tb0 0.1859f
C1368 m1_3680_6970# m1_4330_6980# 0.02958f
C1369 m1_8466_15350# vsrcp 0.00102f
C1370 a_6984_18520# a_2180_13234# 0.00178f
C1371 a_5316_3120# m1_5808_2480# 0.24721f
C1372 vbn_ax a_8248_5320# 0.347f
C1373 a_5516_15680# m1_2712_15340# 0
C1374 a_3048_18520# a_488_17120# 0.00189f
C1375 vbn_ax a_268_18520# 1.06044f
C1376 a_488_5520# m1_1096_6970# 0
C1377 a_6328_4480# ta0 0
C1378 a_6984_3120# m1_2792_6140# 0.00344f
C1379 a_488_5520# vbn_leak 0.00151f
C1380 a_488_17120# a_6140_14314# 0.13981f
C1381 a_488_19360# a_2592_8154# 0.31089f
C1382 m1_2956_19890# vbn_leak 0.14398f
C1383 spk abus 0.16566f
C1384 ta2 a_6140_9234# 0.02841f
C1385 vdd m1_5428_15340# 0.01007f
C1386 m1_5512_19890# d1_bsel 0.05436f
C1387 ta1 tb3 0.02552f
C1388 ta1 ta0 3.05592f
C1389 stb a_5316_18520# 0
C1390 d1_bsel pl_en 0.00232f
C1391 a_3048_18520# m1_2470_19900# 0.00556f
C1392 d1_bsel m1_7130_19630# 0.00107f
C1393 m1_6184_19890# a_6984_18520# 0
C1394 a_3048_3120# vs 0.10788f
C1395 a_488_17120# a_2180_13234# 0.35524f
C1396 ta1 a_6672_14314# 0.01471f
C1397 m1_3680_6970# vs 0.00848f
C1398 m1_2668_7940# m1_2236_8010# 0.02107f
C1399 a_5524_16920# m1_5428_15340# 0.44915f
C1400 a_2492_18520# a_2592_8154# 0.34302f
C1401 vbn_prb m1_7702_10190# 0.02273f
C1402 a_3048_16080# m1_8466_15350# 0.04782f
C1403 m1_5512_19890# vbp_syn 0.00355f
C1404 m1_5808_2480# vs 0.00538f
C1405 m1_6716_11710# ta0 0.00127f
C1406 vbn_leak m1_2678_13100# 0.02092f
C1407 m1_2470_19900# a_2180_13234# 0
C1408 a_3136_4480# ta2 0.02864f
C1409 vbp_syn a_2800_17120# 0.24529f
C1410 m1_7790_19900# vbn_leak 0.2498f
C1411 m1_5946_6980# chain 0.02979f
C1412 a_488_19360# a_824_18520# 0.13798f
C1413 vbn_leak m1_6440_6140# 0.10546f
C1414 d2 vsrcp 0.09401f
C1415 vbp_st a_2592_8154# 0.10974f
C1416 m1_3870_19890# vbn_leak 0.28663f
C1417 en sta 0.15297f
C1418 a_6672_9234# chain 0.01224f
C1419 a_3136_4480# a_2800_12040# 0.07126f
C1420 a_1892_3934# chain 0.33761f
C1421 vbn_ax a_3272_6334# 0.41574f
C1422 m1_2112_14220# el 0.00235f
C1423 vsrc m1_2708_380# 0.00632f
C1424 m1_5286_6980# vbn_leak 0.39048f
C1425 a_2492_18520# a_824_18520# 0.01033f
C1426 a_6328_4480# vbn_prb 0
C1427 a_1480_3834# a_3048_3120# 0.03129f
C1428 a_5516_10600# ta2 0
C1429 m1_8466_15350# a_268_18520# 0.00171f
C1430 m1_5512_19890# a_7540_18520# 0
C1431 a_4588_13668# m1_2862_14560# 0
C1432 vbp_st a_2800_5520# 0.00151f
C1433 m1_7130_19630# a_7540_18520# 0.06768f
C1434 ta1 vbn_prb 0
C1435 pl_en a_7540_18520# 0.00838f
C1436 a_488_5520# m1_2792_6140# 0
C1437 m1_7702_10190# sel2 0.03019f
C1438 a_488_19360# vdd 1.49069f
C1439 abus vs 0.31897f
C1440 en d1_bsel 0.09079f
C1441 ta2 a_6140_14314# 0.03459f
C1442 abus vsrcp 0.11796f
C1443 ta3 a_3048_3120# 0
C1444 a_5516_10600# a_2800_12040# 0.00349f
C1445 a_8240_16974# m1_7702_15230# 0.06409f
C1446 m1_7702_7950# a_6672_9234# 0
C1447 a_3048_16080# d2 0.07545f
C1448 d1_bsel sta 0.24966f
C1449 a_488_17120# tb2 0.01795f
C1450 d1 m1_6440_6140# 0.05877f
C1451 ta3 m1_3680_6970# 0.0879f
C1452 a_2592_8154# a_824_18520# 0.03598f
C1453 m1_6968_10270# a_6672_9234# 0.06832f
C1454 a_3048_3120# a_268_18520# 0.23598f
C1455 m1_3680_6970# a_8248_5320# 0.00933f
C1456 vdd a_2492_18520# 0.24491f
C1457 sel1 m1_7702_15230# 0.10021f
C1458 vbp_syn en 0.04427f
C1459 sel0 a_6984_3120# 0.01307f
C1460 m1_5286_6980# d1 0
C1461 a_6672_14314# m1_6494_12990# 0
C1462 m1_6716_16790# ta0 0.00171f
C1463 a_488_17120# vsrcp 0
C1464 a_3136_4480# a_4660_4480# 0
C1465 vbp_syn sta 0.28863f
C1466 ta3 d2 0.12373f
C1467 m1_5808_2480# a_8248_5320# 0.04768f
C1468 ta2 a_5268_9138# 0.09372f
C1469 vbn_leak ta0 0.46262f
C1470 tb3 vbn_leak 0.74607f
C1471 m1_5808_2480# a_268_18520# 0.18744f
C1472 ta1 a_4588_13668# 0.0024f
C1473 m1_6184_19890# ta2 0.08565f
C1474 mreset vbn_ax 0.16446f
C1475 a_2492_11000# a_488_12040# 0.01081f
C1476 m1_7148_12980# vsrcp 0.00218f
C1477 m1_6440_6140# m1_2792_6140# 0
C1478 a_3048_16080# abus 0.00133f
C1479 vbp_st vdd 5.597f
C1480 a_488_19360# a_672_20034# 0.02964f
C1481 d2 a_268_18520# 0.20999f
C1482 vsrc en 0.18147f
C1483 a_488_12040# m1_7150_9150# 0.00143f
C1484 a_5268_9138# a_2800_12040# 0.00964f
C1485 vdd a_2592_8154# 1.34457f
C1486 a_3048_3120# a_728_3738# 0.00282f
C1487 a_6672_14314# vbn_leak 0.00344f
C1488 en vbn_ref 0.00142f
C1489 vbp_st a_5524_16920# 0.24618f
C1490 m1_4330_6980# ta2 0.01541f
C1491 a_5524_16920# a_2592_8154# 0.06749f
C1492 ta3 a_6984_18520# 0.01979f
C1493 tb1 a_7540_18520# 0.00132f
C1494 pl_en a_6672_9234# 0.03691f
C1495 m1_7130_7810# ta2 0.0422f
C1496 vbp_syn d1_bsel 0.20028f
C1497 en a_7540_18520# 0.07564f
C1498 a_3048_16080# a_488_17120# 0.87245f
C1499 a_7540_18520# sta 0.00398f
C1500 a_2492_18520# a_672_20034# 0
C1501 a_3048_18520# stb 0.01734f
C1502 a_2800_5520# vdd 1.71599f
C1503 a_6594_420# vbp_st 0
C1504 a_268_18520# a_6984_18520# 0.05094f
C1505 vbn_leak a_2492_3120# 0
C1506 a_8248_5320# abus 0.08997f
C1507 m1_2668_7940# sta 0.00157f
C1508 d1 ta0 0.02573f
C1509 a_3048_11000# m1_7930_11710# 0.01846f
C1510 a_3048_3120# a_3272_6334# 0.06025f
C1511 ta1 a_4588_8588# 0.01666f
C1512 a_268_18520# abus 0.31122f
C1513 vbn_leak a_3212_19360# 0.14628f
C1514 a_3048_3120# a_4096_6334# 0.14227f
C1515 m1_7702_10190# a_6140_9234# 0
C1516 vdd a_824_18520# 0.37694f
C1517 ta2 tb2 0
C1518 stb a_2180_13234# 0.18977f
C1519 ta3 a_488_17120# 0.00638f
C1520 m1_4882_3750# el 0.4845f
C1521 m1_3680_6970# a_4096_6334# 0.0406f
C1522 a_2592_8154# a_672_20034# 0.01925f
C1523 a_3136_4480# a_5524_5520# 0.00261f
C1524 el m1_7702_12990# 0.02549f
C1525 hold m1_1046_17880# 0.00149f
C1526 m1_5808_2480# a_3272_6334# 0.09121f
C1527 a_6594_420# a_2800_5520# 0.3078f
C1528 vbn_prb vbn_leak 0.24636f
C1529 m1_9090_16790# vbn_ax 0
C1530 a_488_17120# a_268_18520# 0.02546f
C1531 d1_bsel a_7540_18520# 0.0065f
C1532 m1_5808_2480# a_4096_6334# 0.02721f
C1533 ta3 m1_7148_12980# 0.03128f
C1534 ta2 vsrcp 0.04331f
C1535 ta1 m1_7096_14156# 0.02506f
C1536 stb m1_6184_19890# 0.07987f
C1537 ta0 m1_2792_6140# 0
C1538 a_8240_16974# el 0.01035f
C1539 a_3048_11000# a_2492_11000# 0.02378f
C1540 a_3048_11000# m1_7150_9150# 0.00103f
C1541 vsrcp a_2800_12040# 0.00163f
C1542 a_3136_4480# m1_7702_10190# 0
C1543 a_268_18520# m1_2470_19900# 0.00117f
C1544 m1_7148_12980# a_268_18520# 0
C1545 d1 a_2492_3120# 0.17308f
C1546 a_4588_13668# m1_6494_12990# 0.10848f
C1547 vbp_syn a_7540_18520# 0.0103f
C1548 en m1_5946_6980# 0.00661f
C1549 a_5316_3120# a_4660_4480# 0.01264f
C1550 hold a_2492_11000# 0.17928f
C1551 en a_6672_9234# 0.09835f
C1552 ta1 a_6140_9234# 0.0402f
C1553 m1_2062_6980# m1_642_6980# 0
C1554 vbp_syn m1_2668_7940# 0.49971f
C1555 a_6672_9234# sta 0.03755f
C1556 m1_6716_16790# a_4588_13668# 0
C1557 a_5524_16920# vdd 0.93661f
C1558 vsrc vbn_ref 0.53294f
C1559 m1_2062_6980# m1_2122_6150# 0.00506f
C1560 hold m1_7150_9150# 0
C1561 mreset a_3048_3120# 0.00145f
C1562 abus a_3272_6334# 0.40871f
C1563 vbn_prb d1 0.09542f
C1564 a_3048_16080# ta2 0.04407f
C1565 a_4096_6334# abus 0.18849f
C1566 vbn_leak sel2 0.09217f
C1567 a_4588_13668# vbn_leak 0.3306f
C1568 hold vbn_ax 0.07579f
C1569 m1_2712_15340# m1_2678_13100# 0
C1570 a_2492_18520# a_2492_16080# 0
C1571 a_6328_4480# a_3136_4480# 0.0189f
C1572 a_6594_420# vdd 0.45362f
C1573 vbn_leak m1_1300_2620# 0.26085f
C1574 a_6884_4480# a_5524_5520# 0.13263f
C1575 ta1 a_3136_4480# 0.03439f
C1576 m1_5512_19890# m1_4568_19890# 0.1406f
C1577 spk a_5524_5520# 0
C1578 mreset m1_5808_2480# 0.10499f
C1579 m1_4568_19890# m1_7130_19630# 0
C1580 vbp_st a_7540_3120# 0
C1581 a_6984_3120# el 0.00875f
C1582 ta3 ta2 3.183f
C1583 m1_3680_6970# a_488_12040# 0.14363f
C1584 m1_4568_19890# pl_en 0
C1585 vdd a_672_20034# 0.42414f
C1586 a_4660_4480# vs 0.28281f
C1587 m1_2862_14560# a_2180_13234# 0.12143f
C1588 m1_7206_17740# vbn_ax 0.46594f
C1589 vbn_prb m1_2792_6140# 0.22809f
C1590 a_6984_3120# vreset 0
C1591 ta2 a_8248_5320# 0
C1592 a_5316_18520# vbn_leak 0.00166f
C1593 ta2 a_268_18520# 0.04941f
C1594 a_824_11000# vdd 0.15236f
C1595 d2 a_488_12040# 0.0396f
C1596 a_4588_8588# vbn_leak 0.4772f
C1597 m1_1946_330# vdd 0.01721f
C1598 d1 sel2 0.11703f
C1599 a_4588_13668# d1 0
C1600 ta1 a_5516_10600# 0
C1601 a_2800_5520# a_7540_3120# -0.00965f
C1602 a_5524_11840# m1_8466_10270# 0.00803f
C1603 m1_7702_10190# a_5268_9138# 0.05518f
C1604 vbn_leak m1_8326_19030# 0.03241f
C1605 a_5316_3120# a_5524_5520# 0
C1606 d1 m1_1300_2620# 0.00156f
C1607 m1_4330_6980# a_5524_5520# 0
C1608 a_5516_15680# m1_5428_15340# 0.03136f
C1609 mreset abus 0.41147f
C1610 ta1 a_6140_14314# 0.04342f
C1611 m1_7096_14156# vbn_leak 0
C1612 vsrc a_6672_9234# 0
C1613 a_6328_4480# a_6884_4480# 0.04411f
C1614 a_6594_420# m1_1946_330# 0.00732f
C1615 el tb0 0
C1616 ta1 a_6884_4480# 0.03807f
C1617 vbn_ax chain 0.02822f
C1618 a_3048_11000# a_3048_3120# 0
C1619 a_824_16080# a_2180_13234# 0.04076f
C1620 a_4588_8588# d1 0.37857f
C1621 a_3048_11000# m1_3680_6970# 0.44287f
C1622 en m1_4568_19890# 0.02172f
C1623 a_5524_5520# vs 0.30518f
C1624 a_2492_11000# m1_2236_8010# 0
C1625 ta1 a_5268_9138# 0.24779f
C1626 vbn_leak a_6140_9234# 0.12388f
C1627 a_488_5520# el 0.15667f
C1628 ta3 a_4660_4480# 0
C1629 ta1 m1_6184_19890# 0.0563f
C1630 vdd a_7540_3120# 0.2415f
C1631 m1_6494_7910# m1_6440_6140# 0
C1632 a_3136_4480# m1_6494_12990# 0
C1633 ta0 m1_7702_15230# 0
C1634 stb a_268_18520# 0.44334f
C1635 m1_2712_6970# spk 0
C1636 hold a_3048_3120# 0.08933f
C1637 a_268_18520# a_4660_4480# 0
C1638 a_5316_3120# a_6328_4480# 0.00746f
C1639 m1_1860_10650# a_4588_8588# 0
C1640 vdd a_2492_16080# 0.33099f
C1641 hold m1_3680_6970# 0.33901f
C1642 m1_6968_10270# m1_7150_9150# 0.13304f
C1643 a_3048_11000# d2 0.01027f
C1644 m1_7702_10190# vsrcp 0.0054f
C1645 m1_6716_11710# a_5268_9138# 0.02519f
C1646 a_6672_14314# m1_7702_15230# 0.13162f
C1647 m1_1046_17880# a_2800_17120# 0.00897f
C1648 ta1 m1_7130_7810# 0.01954f
C1649 m1_7930_11710# pl_en 0
C1650 a_3136_4480# vbn_leak 0.49247f
C1651 el m1_2678_13100# 0.0688f
C1652 d1_bsel m1_4568_19890# 0.14588f
C1653 a_6594_420# a_7540_3120# 0
C1654 a_8240_16974# m1_5428_15340# 0.06057f
C1655 hold d2 0.98127f
C1656 sel0 vbn_prb 0.27441f
C1657 d1 a_6140_9234# 0.04112f
C1658 m1_9090_16790# a_488_17120# 0.00338f
C1659 m1_4330_6980# m1_2712_6970# -0.00594f
C1660 ta1 tb2 0
C1661 a_6328_4480# vs 0
C1662 vbp_syn m1_4568_19890# 0.03463f
C1663 a_5516_10600# vbn_leak 0.00103f
C1664 a_3048_16080# m1_2862_14560# 0.00193f
C1665 m1_7206_17740# d2 0.02791f
C1666 ta3 a_5524_5520# 0.00369f
C1667 pl_en m1_7150_9150# 0.00145f
C1668 ta1 vsrcp 0.03728f
C1669 hold a_6984_18520# 0.05909f
C1670 a_3048_18520# vbn_leak 0.06964f
C1671 m1_5512_19890# vbn_ax 0.08187f
C1672 a_5524_11840# m1_6440_6140# 0
C1673 a_3136_4480# d1 0.49549f
C1674 vbn_prb m1_7702_15230# 0.09855f
C1675 vbn_leak a_6140_14314# 0.50045f
C1676 vbn_ax m1_7130_19630# 0.1766f
C1677 vbn_ax pl_en 0.02905f
C1678 a_8248_5320# a_5524_5520# 0.0013f
C1679 a_2800_17120# vbn_ax 0.03628f
C1680 a_268_18520# a_5524_5520# 0
C1681 a_488_5520# m1_642_6980# 0.0014f
C1682 a_4096_6334# a_4660_4480# 0.12611f
C1683 a_5516_15680# vbp_st 0
C1684 a_488_5520# m1_2122_6150# 0.01212f
C1685 ta2 a_488_12040# 0.15904f
C1686 sel0 sel2 3.94927f
C1687 a_3048_3120# chain 0.24154f
C1688 ta3 m1_7702_10190# 0.01394f
C1689 m1_9090_11710# a_6672_9234# 0.02315f
C1690 vbn_leak a_6884_4480# 0
C1691 m1_5286_6980# a_5524_11840# 0.00206f
C1692 d2 m1_6716_15540# 0
C1693 vbn_leak a_2180_13234# 0.03585f
C1694 m1_3680_6970# chain 0.10107f
C1695 m1_1860_10650# a_3136_4480# 0.01409f
C1696 m1_7206_17740# a_6984_18520# 0.45179f
C1697 vbn_leak spk 1.02284f
C1698 a_488_12040# a_2800_12040# 0.26013f
C1699 hold a_488_17120# 0.11982f
C1700 vbp_st m1_2062_6980# 0.09578f
C1701 m1_7702_10190# a_268_18520# 0
C1702 m1_2112_14220# vdd 0.25075f
C1703 a_4588_13668# m1_2712_15340# -0
C1704 a_3136_4480# m1_2792_6140# 0.11385f
C1705 m1_2062_6980# a_2592_8154# 0.01087f
C1706 a_5516_10600# d1 0.21339f
C1707 vbn_leak a_5268_9138# 0.7334f
C1708 ta1 a_3048_16080# 0.01892f
C1709 hold m1_7148_12980# 0.0026f
C1710 m1_6184_19890# vbn_leak 0.31424f
C1711 el ta0 0.05993f
C1712 d2 chain 0.01392f
C1713 m1_5190_10190# ta2 0.01063f
C1714 m1_6716_15540# a_6984_18520# 0
C1715 m1_7206_17740# a_488_17120# 0.10422f
C1716 m1_1860_10650# a_5516_10600# 0
C1717 a_6672_14314# el 0
C1718 a_5316_3120# vbn_leak 0
C1719 m1_4330_6980# vbn_leak 0.28555f
C1720 m1_5190_10190# a_2800_12040# 0.00124f
C1721 vbp_st m1_4882_3750# 0.01639f
C1722 d1 a_6884_4480# 0.1503f
C1723 ta1 ta3 0.27782f
C1724 en m1_7150_9150# 0
C1725 a_1480_3834# m1_2712_6970# 0
C1726 a_6328_4480# a_268_18520# 0
C1727 m1_7130_7810# vbn_leak 0.00364f
C1728 a_2492_11000# sta 0.08285f
C1729 mreset a_4660_4480# 0.00106f
C1730 d1 spk 0.08014f
C1731 ta1 a_8248_5320# 0.01463f
C1732 a_5524_11840# ta0 0.01476f
C1733 vbp_st m1_7702_12990# 0
C1734 chain a_6984_18520# 0.00101f
C1735 vbn_ax tb1 0.13341f
C1736 ta1 a_268_18520# 0.09102f
C1737 en vbn_ax 0.04682f
C1738 a_2592_8154# m1_7702_12990# 0.01227f
C1739 a_4096_6334# a_5524_5520# 0.06068f
C1740 vbn_ax sta 0.03544f
C1741 a_3048_11000# ta2 0.06044f
C1742 d1 a_5268_9138# 0.84916f
C1743 m1_6494_12990# vsrcp 0
C1744 a_2492_3120# el 0.00523f
C1745 vbp_st a_8240_16974# 0.17088f
C1746 vbp_syn m1_1046_17880# 0.01541f
C1747 a_8240_16974# a_2592_8154# 0.55765f
C1748 vbn_leak tb2 0.08686f
C1749 m1_7148_12980# m1_6716_15540# 0.2071f
C1750 a_5516_15680# vdd 0.39765f
C1751 m1_4882_3750# a_2800_5520# 0.00289f
C1752 m1_2112_9090# a_2592_8154# 0.10896f
C1753 a_3048_11000# a_2800_12040# 0.72909f
C1754 a_6884_4480# m1_2792_6140# 0.26444f
C1755 m1_1096_6970# vs 0.00514f
C1756 a_488_17120# chain 0.04863f
C1757 m1_2792_6140# spk 0.08909f
C1758 vbn_leak vs 0.43695f
C1759 m1_1860_10650# a_5268_9138# 0.00788f
C1760 vbp_st sel1 0.08954f
C1761 a_5316_3120# d1 0.1539f
C1762 hold ta2 0.01764f
C1763 a_5516_15680# a_5524_16920# 0.15231f
C1764 a_2592_8154# sel1 0.37713f
C1765 vbn_leak vsrcp 0.19281f
C1766 vbn_prb el 0.32309f
C1767 m1_2062_6980# vdd 0.90354f
C1768 d1 m1_7130_7810# 0
C1769 m1_3680_6970# pl_en 0
C1770 hold a_2800_12040# 0.16166f
C1771 vbn_prb vreset 4.00735f
C1772 vbp_syn a_2492_11000# 0.00579f
C1773 m1_1046_17880# a_7540_18520# 0
C1774 m1_5428_15340# m1_2678_13100# 0
C1775 m1_7206_17740# ta2 0.03938f
C1776 a_6328_4480# a_4096_6334# 0.00117f
C1777 d2 pl_en 0.01403f
C1778 vbp_syn vbn_ax 0.10164f
C1779 a_2800_17120# d2 0.17539f
C1780 sel0 a_3136_4480# 0
C1781 mreset a_5524_5520# 0.03433f
C1782 vbn_prb a_5524_11840# 0.06299f
C1783 vbp_st a_6984_3120# 0
C1784 vbp_st m1_8466_10270# 0.00388f
C1785 m1_4882_3750# vdd 0.01172f
C1786 d1 vs 0.10627f
C1787 m1_8466_10270# a_2592_8154# 0
C1788 a_1480_3834# vbn_leak 0.0192f
C1789 en m1_8466_15350# 0.09285f
C1790 a_3048_16080# vbn_leak 0.33542f
C1791 d1 vsrcp 0.23031f
C1792 a_4588_13668# el 0.41967f
C1793 a_3136_4480# m1_2712_15340# 0.00747f
C1794 ta2 m1_6716_15540# 0.02115f
C1795 el sel2 0.02824f
C1796 a_4588_8588# m1_6494_7910# 0.04638f
C1797 vsrc vbn_ax 0.07308f
C1798 m1_2712_6970# a_3272_6334# 0.00424f
C1799 a_5524_16920# m1_7702_12990# 0.00525f
C1800 m1_2112_14220# a_2492_16080# 0.01516f
C1801 a_8240_16974# vdd 0.63927f
C1802 m1_7130_19630# a_6984_18520# 0
C1803 vreset sel2 0.02688f
C1804 vbn_ax vbn_ref 4.0475f
C1805 el m1_1300_2620# 0.01209f
C1806 m1_2712_6970# a_4096_6334# 0.00665f
C1807 pl_en a_6984_18520# 0
C1808 m1_2862_14560# a_488_12040# 0
C1809 ta3 vbn_leak 0.24651f
C1810 m1_2708_380# abus 0.03937f
C1811 a_6594_420# m1_4882_3750# 0
C1812 m1_2112_9090# vdd 0.28991f
C1813 a_488_12040# m1_7702_10190# 0.07942f
C1814 pl_en abus 0.00305f
C1815 a_3136_4480# m1_7702_15230# 0
C1816 m1_6716_16790# a_268_18520# 0.00608f
C1817 hold stb 0.29134f
C1818 hold a_4660_4480# 0.00227f
C1819 m1_2792_6140# vs 0.10856f
C1820 a_5524_16920# a_8240_16974# 0.26139f
C1821 vbn_ax a_7540_18520# 0.50512f
C1822 vbn_leak a_8248_5320# 0.03797f
C1823 en a_3048_3120# 0.00217f
C1824 ta2 chain 0.04644f
C1825 vdd sel1 0.12444f
C1826 a_4588_13668# a_5524_11840# 0
C1827 en m1_3680_6970# 0.03294f
C1828 vbn_leak a_268_18520# 0.30331f
C1829 a_5524_11840# sel2 0.03749f
C1830 m1_5512_19890# a_488_17120# 0.05534f
C1831 a_488_17120# pl_en 0.03889f
C1832 a_2800_12040# chain 0
C1833 a_488_17120# m1_7130_19630# 0.07174f
C1834 mreset a_6328_4480# 0
C1835 a_5524_16920# sel1 0.03839f
C1836 a_2800_17120# a_488_17120# 0.45051f
C1837 m1_7206_17740# stb 0
C1838 en m1_5808_2480# 0.13706f
C1839 a_4588_8588# el 0.01129f
C1840 tb0 a_2592_8154# 0.09091f
C1841 el m1_8326_19030# 0
C1842 sel0 spk 0.32803f
C1843 en d2 0.25786f
C1844 m1_6494_7910# a_6140_9234# 0
C1845 m1_7148_12980# pl_en 0.00476f
C1846 d2 sta 0.05531f
C1847 m1_1096_6970# a_728_3738# 0.0302f
C1848 ta3 d1 0.18429f
C1849 ta0 m1_5428_15340# 0.00607f
C1850 m1_2712_15340# a_2180_13234# 0.11649f
C1851 vbp_st a_488_5520# 0.08238f
C1852 vbn_leak a_728_3738# 0.03787f
C1853 m1_7702_7950# ta2 0.00151f
C1854 ta1 a_488_12040# 0.15266f
C1855 a_6984_3120# vdd 0
C1856 a_6140_14314# m1_7702_15230# 0.05286f
C1857 m1_2956_19890# a_2592_8154# 0.00188f
C1858 m1_7096_14156# el 0
C1859 a_3048_11000# a_5524_5520# 0.02874f
C1860 d1 a_8248_5320# 0.149f
C1861 m1_6968_10270# ta2 0.05335f
C1862 vdd m1_8466_10270# 0.01483f
C1863 a_824_3120# el 0.06941f
C1864 d1 a_268_18520# 1.80874f
C1865 a_1480_3834# m1_2792_6140# 0.0958f
C1866 a_4588_8588# a_5524_11840# 0.69271f
C1867 a_6672_14314# m1_5428_15340# 0
C1868 sel1 a_672_20034# 0.02837f
C1869 a_6672_9234# m1_7150_9150# 0.07651f
C1870 en a_6984_18520# 0
C1871 sel0 a_5316_3120# 0
C1872 sta a_6984_18520# 0.03627f
C1873 en abus 0
C1874 m1_6716_11710# a_488_12040# 0.00644f
C1875 a_3048_11000# m1_7702_10190# 0.02909f
C1876 d2 d1_bsel 0
C1877 vbn_ax a_6672_9234# 0
C1878 a_488_5520# a_2800_5520# 0.00648f
C1879 ta3 m1_2792_6140# 0.00378f
C1880 hold a_5524_5520# 0.37989f
C1881 vbn_leak a_3272_6334# 0.05075f
C1882 el a_6140_9234# 0.04747f
C1883 stb chain 0.0668f
C1884 vbn_leak a_4096_6334# 0.31489f
C1885 ta1 m1_5190_10190# 0.03556f
C1886 m1_7790_19900# a_2592_8154# 0.03233f
C1887 chain a_4660_4480# 0.05979f
C1888 m1_2792_6140# a_8248_5320# 0.09904f
C1889 m1_1096_6970# m1_910_6150# 0
C1890 m1_2792_6140# a_268_18520# 0.09381f
C1891 m1_910_6150# vbn_leak 0
C1892 vbp_st m1_6440_6140# 0.00377f
C1893 d1 a_728_3738# 0.0072f
C1894 hold m1_2862_14560# 0.00236f
C1895 en a_488_17120# 0.10233f
C1896 vbp_st m1_3870_19890# 0.03884f
C1897 a_488_17120# tb1 0.09363f
C1898 hold m1_7702_10190# 0
C1899 m1_6440_6140# a_2592_8154# 0
C1900 vsrc a_3048_3120# 0.01642f
C1901 m1_3870_19890# a_2592_8154# 0.21109f
C1902 m1_4882_3750# a_7540_3120# 0.37685f
C1903 a_488_17120# sta 0.00981f
C1904 vbp_syn d2 0.72302f
C1905 m1_5512_19890# ta2 0.01905f
C1906 ta2 m1_7130_19630# 0.00524f
C1907 ta2 pl_en 0.02912f
C1908 a_5524_11840# a_6140_9234# 0.47199f
C1909 d1_bsel a_6984_18520# 0
C1910 vdd tb0 0.86652f
C1911 m1_5286_6980# vbp_st 0.01402f
C1912 a_3048_11000# a_6328_4480# 0
C1913 sel0 vs 0.26108f
C1914 m1_5286_6980# a_2592_8154# 0.0054f
C1915 a_3136_4480# el 1.4095f
C1916 vsrc m1_5808_2480# 0.00296f
C1917 pl_en a_2800_12040# 0
C1918 sel0 vsrcp 0.03806f
C1919 a_3136_4480# vreset 0.00124f
C1920 ta1 a_3048_11000# 0.19256f
C1921 m1_7148_12980# sta 0
C1922 m1_5808_2480# vbn_ref 0.04196f
C1923 a_728_3738# m1_2792_6140# 0.00128f
C1924 d1 a_3272_6334# 0.02538f
C1925 d1 a_4096_6334# 0.14889f
C1926 a_488_5520# vdd 1.42618f
C1927 m1_2956_19890# vdd 0.02259f
C1928 hold a_6328_4480# 0.00424f
C1929 m1_910_6150# d1 0
C1930 a_5524_11840# a_3136_4480# 0.04611f
C1931 d2 a_7540_18520# 0.07906f
C1932 mreset vbn_leak 0.20619f
C1933 hold ta1 0.24057f
C1934 a_5516_10600# el 0.0502f
C1935 d1_bsel m1_2470_19900# 0.0019f
C1936 chain a_5524_5520# 0.18648f
C1937 vsrcp m1_7702_15230# 0.00304f
C1938 vbp_syn a_488_17120# 0.053f
C1939 m1_2792_6140# a_3272_6334# 0.15891f
C1940 a_4588_13668# m1_5428_15340# 0.45314f
C1941 el a_6140_14314# 0
C1942 m1_2792_6140# a_4096_6334# 0.08682f
C1943 vbn_leak a_488_12040# 0.70456f
C1944 vdd m1_2678_13100# 0.38285f
C1945 vbp_st tb3 0
C1946 a_488_19360# a_3212_19360# 0.00287f
C1947 vsrc abus 0.24675f
C1948 vbp_st ta0 0.07455f
C1949 tb3 a_2592_8154# 0.1631f
C1950 vdd m1_7790_19900# -0
C1951 abus vbn_ref 0.74695f
C1952 m1_910_6150# m1_2792_6140# 0
C1953 ta0 a_2592_8154# 0.05419f
C1954 hold m1_6716_11710# 0.00831f
C1955 ta1 m1_7206_17740# 0.04627f
C1956 a_7540_18520# a_6984_18520# 0.22632f
C1957 m1_5512_19890# stb 0.0418f
C1958 el a_6884_4480# 0.07159f
C1959 vdd m1_6440_6140# 0.45879f
C1960 a_5516_10600# a_5524_11840# 0.14762f
C1961 el a_2180_13234# 0.06333f
C1962 m1_3870_19890# vdd 0.29849f
C1963 stb m1_7130_19630# 0.00204f
C1964 a_6984_3120# a_7540_3120# 0.19958f
C1965 a_3048_16080# m1_2712_15340# 0.18908f
C1966 en ta2 0.12464f
C1967 a_6672_14314# vbp_st 0.14059f
C1968 stb pl_en 0.00424f
C1969 m1_2956_19890# a_672_20034# 0.00668f
C1970 ta2 sta 0
C1971 a_6672_14314# a_2592_8154# 0.00383f
C1972 m1_3680_6970# m1_5946_6980# 0
C1973 el spk 0.2914f
C1974 m1_6494_7910# m1_7130_7810# 0
C1975 a_1892_3934# a_3048_3120# 0.47728f
C1976 vsrc a_488_17120# 0
C1977 m1_3870_19890# a_5524_16920# 0.03196f
C1978 en a_2800_12040# 0
C1979 vreset spk 0.28722f
C1980 mreset d1 0.08931f
C1981 a_1892_3934# m1_3680_6970# 0
C1982 m1_5286_6980# vdd 0.07268f
C1983 sel0 a_8248_5320# 0.04057f
C1984 el a_5268_9138# 0.00176f
C1985 a_2800_12040# sta 0.00973f
C1986 sel0 a_268_18520# 0.02064f
C1987 m1_5190_10190# vbn_leak 0.27313f
C1988 ta1 m1_6716_15540# 0.02641f
C1989 a_3048_16080# m1_7702_15230# 0.17225f
C1990 a_488_17120# a_7540_18520# 0.04103f
C1991 a_3048_11000# m1_6494_12990# 0
C1992 d1 a_488_12040# 0.18642f
C1993 a_6328_4480# chain 0.14267f
C1994 a_3212_19360# a_2592_8154# 0.17926f
C1995 a_5316_3120# el 0.055f
C1996 m1_6494_7910# vsrcp 0.00191f
C1997 m1_6968_10270# m1_7702_10190# 0
C1998 a_5524_11840# a_5268_9138# 0.14063f
C1999 ta3 m1_7702_15230# 0.01664f
C2000 mreset m1_2792_6140# 0
C2001 ta1 chain 0.01486f
C2002 m1_3870_19890# a_672_20034# 0.20309f
C2003 m1_1860_10650# a_488_12040# 0.10494f
C2004 m1_7096_14156# m1_5428_15340# 0.00239f
C2005 a_3048_11000# vbn_leak 0.24124f
C2006 a_268_18520# m1_7702_15230# 0.00686f
C2007 vbp_st vbn_prb 0.18028f
C2008 vbn_prb a_2592_8154# 0
C2009 d1 m1_5190_10190# 0.03308f
C2010 hold m1_6716_16790# 0.00718f
C2011 m1_6716_11710# chain 0
C2012 vdd ta0 0.5024f
C2013 tb3 vdd 0.41345f
C2014 en stb 0.01423f
C2015 a_6672_9234# abus 0.11496f
C2016 en a_4660_4480# 0.00479f
C2017 a_5524_11840# m1_7130_7810# 0.08796f
C2018 vbp_syn a_2800_12040# 0.24506f
C2019 stb sta 0.32656f
C2020 hold vbn_leak 0.84018f
C2021 el vs 0.33954f
C2022 a_5524_16920# ta0 0.00905f
C2023 tb3 a_5524_16920# 0
C2024 m1_1860_10650# m1_5190_10190# 0.00192f
C2025 el vsrcp 0.68421f
C2026 a_6672_14314# vdd 0.70868f
C2027 sel0 a_3272_6334# 0.37354f
C2028 ta1 m1_6968_10270# 0.10107f
C2029 sel0 a_4096_6334# 0.04391f
C2030 vreset vs 0.1659f
C2031 vreset vsrcp 0.03185f
C2032 m1_7702_10190# pl_en 0.19587f
C2033 a_6672_14314# a_5524_16920# 0.53297f
C2034 a_3048_11000# d1 0.13699f
C2035 vbp_st a_4588_13668# 0.00418f
C2036 ta2 a_7540_18520# 0.00764f
C2037 m1_7206_17740# vbn_leak 0
C2038 vbp_st sel2 0.02695f
C2039 a_4588_13668# a_2592_8154# 0.00617f
C2040 m1_6716_15540# m1_6494_12990# 0.00356f
C2041 a_5516_15680# a_8240_16974# 0.00149f
C2042 a_3136_4480# m1_5428_15340# 0.08643f
C2043 m1_1046_17880# vbn_ax 0.22034f
C2044 stb d1_bsel 0.57306f
C2045 vdd a_2492_3120# 0.21784f
C2046 a_5524_11840# vsrcp 0.20721f
C2047 tb3 a_672_20034# 0.00798f
C2048 ta0 a_672_20034# 0.00143f
C2049 vdd a_3212_19360# 1.19561f
C2050 m1_1860_10650# a_3048_11000# 0.18033f
C2051 a_5516_15680# sel1 0
C2052 vbp_st m1_7930_16790# 0.01998f
C2053 hold d1 0.41457f
C2054 m1_7930_16790# a_2592_8154# 0.00931f
C2055 a_3048_16080# el 0.15888f
C2056 a_1480_3834# el 0.23945f
C2057 m1_6494_12990# chain 0.00304f
C2058 vbn_leak m1_6716_15540# -0.13952f
C2059 m1_5512_19890# ta1 0.01323f
C2060 vbp_syn stb 0.01773f
C2061 a_3048_11000# m1_2792_6140# 0
C2062 a_5316_18520# a_2592_8154# 0.12626f
C2063 vbn_prb vdd 0.63087f
C2064 ta1 pl_en 0.02571f
C2065 ta1 m1_7130_19630# 0.01601f
C2066 a_6594_420# a_2492_3120# 0.00331f
C2067 a_2800_5520# m1_1300_2620# 0.05528f
C2068 m1_1860_10650# hold 0.30308f
C2069 en a_5524_5520# 0.09504f
C2070 vbp_st a_4588_8588# 0.0041f
C2071 m1_6716_16790# chain 0
C2072 a_4588_8588# a_2592_8154# 0.7418f
C2073 a_5524_16920# vbn_prb 0.04795f
C2074 mreset sel0 0.07989f
C2075 ta3 el 0.03568f
C2076 m1_8326_19030# a_2592_8154# 0.11538f
C2077 hold m1_2792_6140# 0.1716f
C2078 a_6140_14314# m1_5428_15340# 0.00387f
C2079 vbn_leak chain 0.67627f
C2080 el a_8248_5320# 0.04456f
C2081 m1_642_6980# vs 0
C2082 a_3212_19360# a_672_20034# 0
C2083 m1_5946_6980# ta2 0.12081f
C2084 en m1_7702_10190# 0.10452f
C2085 el a_268_18520# 0.8209f
C2086 a_6594_420# vbn_prb 0.47535f
C2087 vreset a_8248_5320# 0.14668f
C2088 ta2 a_6672_9234# 0.00255f
C2089 stb a_7540_18520# 0.00317f
C2090 d1 m1_6716_15540# 0
C2091 vreset a_268_18520# 0.00137f
C2092 m1_7096_14156# a_2592_8154# 0.00776f
C2093 ta3 a_5524_11840# 0.04248f
C2094 m1_1946_330# a_2492_3120# 0
C2095 m1_1096_6970# m1_2236_8010# 0.00215f
C2096 vdd sel2 0.19783f
C2097 a_4588_13668# vdd 0.38127f
C2098 vbn_leak m1_2236_8010# 0.0046f
C2099 vdd m1_1300_2620# 0.06186f
C2100 m1_7702_7950# vbn_leak 0
C2101 a_5524_11840# a_268_18520# 0
C2102 a_8240_16974# sel1 0.04533f
C2103 vbp_st a_6140_9234# 0.16552f
C2104 a_4588_13668# a_5524_16920# 0.41515f
C2105 d1 chain 0.31283f
C2106 el a_728_3738# 0.18644f
C2107 m1_6968_10270# vbn_leak 0.03981f
C2108 a_2592_8154# a_6140_9234# 0.37876f
C2109 a_6328_4480# en 0.04362f
C2110 m1_7930_16790# vdd 0.08766f
C2111 vbn_prb m1_1946_330# 0.03606f
C2112 m1_2112_14220# m1_2678_13100# 0.15231f
C2113 ta1 en 0.01437f
C2114 a_1480_3834# m1_2122_6150# 0.03782f
C2115 a_5316_18520# vdd 0.28856f
C2116 ta1 sta 0
C2117 m1_4882_3750# a_6984_3120# 0.03726f
C2118 pl_en m1_6494_12990# 0.00153f
C2119 vbp_syn m1_2862_14560# 0.11335f
C2120 a_3048_18520# a_488_19360# 0.00874f
C2121 a_6594_420# m1_1300_2620# 0.07689f
C2122 a_4588_8588# vdd 0.20939f
C2123 vbp_st a_3136_4480# 0.89214f
C2124 a_5524_16920# a_5316_18520# 0
C2125 a_3136_4480# a_2592_8154# 0.07369f
C2126 el a_3272_6334# 0.16937f
C2127 m1_2792_6140# chain 0.2534f
C2128 d1 m1_2236_8010# 0.13997f
C2129 vdd m1_8326_19030# 0.32471f
C2130 el a_4096_6334# 0.05541f
C2131 m1_7702_7950# d1 0
C2132 vreset a_3272_6334# 0.0156f
C2133 m1_6716_11710# sta 0.00546f
C2134 vreset a_4096_6334# 0.01942f
C2135 m1_1046_17880# d2 0.14625f
C2136 a_488_19360# a_2180_13234# 0.19873f
C2137 m1_5512_19890# vbn_leak 0.60862f
C2138 m1_6968_10270# d1 0.08272f
C2139 a_5524_16920# m1_8326_19030# 0.00796f
C2140 a_3048_18520# a_2492_18520# 0.07021f
C2141 vbn_leak pl_en 0.28693f
C2142 vbn_leak m1_7130_19630# 0.02912f
C2143 m1_2708_380# vbn_leak 0
C2144 a_2800_17120# vbn_leak 0.12134f
C2145 a_824_3120# vdd 0
C2146 a_2800_5520# a_3136_4480# 0.02814f
C2147 a_488_5520# m1_2062_6980# 0.00102f
C2148 vsrcp m1_5428_15340# 0.19127f
C2149 a_5316_18520# a_672_20034# 0
C2150 vbn_prb a_7540_3120# 0.30944f
C2151 vbp_st a_5516_10600# 0
C2152 a_5524_16920# m1_7096_14156# 0.08444f
C2153 a_2492_18520# a_2180_13234# 0.22215f
C2154 m1_3680_6970# vbn_ax 0
C2155 a_3048_18520# a_2592_8154# 0.16098f
C2156 vbp_st a_6140_14314# 0.10045f
C2157 vdd a_6140_9234# 1.31472f
C2158 hold m1_2712_15340# 0.08794f
C2159 a_6140_14314# a_2592_8154# 0.05201f
C2160 m1_2122_6150# a_728_3738# 0.02887f
C2161 vbn_ax m1_5808_2480# 0.07624f
C2162 vbp_st a_6884_4480# 0.15125f
C2163 a_2592_8154# a_2180_13234# 0.36758f
C2164 mreset el 0.14542f
C2165 vbp_st spk 0.10734f
C2166 d1 pl_en 0.25159f
C2167 en m1_6494_12990# 0
C2168 vbn_ax d2 0.42084f
C2169 hold m1_7702_15230# 0
C2170 m1_6494_12990# sta 0.00806f
C2171 a_3048_16080# m1_5428_15340# 0.08144f
C2172 mreset vreset 0.05816f
C2173 m1_2062_6980# m1_6440_6140# 0.08079f
C2174 m1_1046_17880# a_488_17120# 0.06794f
C2175 m1_6494_7910# m1_5190_10190# 0.0152f
C2176 vbp_st a_5268_9138# 0.09875f
C2177 m1_5946_6980# a_5524_5520# 0
C2178 a_3136_4480# vdd 2.13543f
C2179 m1_6184_19890# a_2592_8154# 0
C2180 el a_488_12040# 0.79179f
C2181 a_5268_9138# a_2592_8154# 0.27288f
C2182 ta1 a_7540_18520# 0.00613f
C2183 m1_2122_6150# a_3272_6334# 0.00479f
C2184 m1_6716_16790# sta 0.00529f
C2185 a_1892_3934# a_5524_5520# 0
C2186 m1_5286_6980# m1_2062_6980# 0.06463f
C2187 en vbn_leak 0.45347f
C2188 vbn_leak tb1 0.04059f
C2189 m1_642_6980# m1_910_6150# 0.00143f
C2190 m1_1096_6970# sta 0
C2191 ta3 m1_5428_15340# 0.00659f
C2192 a_5524_16920# a_3136_4480# 0.12573f
C2193 a_2800_5520# spk 0.15548f
C2194 vbn_ax a_6984_18520# 0.0219f
C2195 vbn_leak sta 0.55673f
C2196 vbn_ax abus 0.2907f
C2197 vbp_st m1_4330_6980# 0.05483f
C2198 a_824_18520# a_2180_13234# 0.03797f
C2199 m1_4330_6980# a_2592_8154# 0.00221f
C2200 m1_7702_10190# a_6672_9234# 0.10238f
C2201 a_6594_420# a_3136_4480# 0.313f
C2202 a_5524_11840# a_488_12040# 0.04983f
C2203 m1_7130_7810# a_2592_8154# 0.0027f
C2204 a_5516_10600# vdd 0.19685f
C2205 a_8240_16974# m1_2678_13100# 0
C2206 m1_2712_6970# m1_2668_7940# 0.00701f
C2207 m1_6716_15540# m1_7702_15230# 0
C2208 stb m1_4568_19890# 0.05522f
C2209 a_3048_18520# vdd 0.37756f
C2210 vbn_ax a_488_17120# 0.60202f
C2211 a_5516_15680# ta0 0
C2212 vdd a_6140_14314# 1.27647f
C2213 m1_3870_19890# a_8240_16974# 0
C2214 a_5316_3120# a_2800_5520# 0
C2215 a_2800_5520# m1_4330_6980# 0
C2216 hold m1_6494_7910# 0.0022f
C2217 vbn_leak d1_bsel 0.27557f
C2218 en d1 0.37649f
C2219 a_2592_8154# tb2 0.0623f
C2220 d2 m1_8466_15350# 0.00149f
C2221 vdd a_6884_4480# 0.2208f
C2222 vbp_st vs 0.09039f
C2223 d1 sta 0.32642f
C2224 a_5524_16920# a_6140_14314# 0.25516f
C2225 vdd a_2180_13234# 1.50766f
C2226 m1_2062_6980# ta0 0.05135f
C2227 a_5524_11840# m1_5190_10190# 0.22524f
C2228 chain m1_7702_15230# 0
C2229 vbp_st vsrcp 4.24723f
C2230 m1_3870_19890# sel1 0.00854f
C2231 vdd spk 4.8287f
C2232 m1_3680_6970# a_3048_3120# 0.00627f
C2233 ta1 m1_5946_6980# 0.15455f
C2234 vsrcp a_2592_8154# 0.52452f
C2235 a_5524_16920# a_2180_13234# 0
C2236 ta1 a_6672_9234# 0.00579f
C2237 a_3048_11000# el 0.39225f
C2238 vbp_syn vbn_leak 0.60281f
C2239 m1_1860_10650# sta 0.13238f
C2240 vdd a_5268_9138# 0.53877f
C2241 m1_6184_19890# vdd 0.02549f
C2242 a_3048_18520# a_672_20034# 0
C2243 a_3048_16080# a_2492_18520# 0.00795f
C2244 en m1_2792_6140# 0.04674f
C2245 a_2800_5520# vs 0.21612f
C2246 a_5524_16920# a_5268_9138# 0
C2247 hold el 0.25145f
C2248 m1_8466_15350# abus 0.0224f
C2249 vsrc vbn_leak 4.15909f
C2250 a_1892_3934# m1_2712_6970# 0
C2251 a_6594_420# spk 0.56905f
C2252 m1_4882_3750# ta0 0
C2253 a_3048_11000# a_5524_11840# 0.11017f
C2254 a_488_19360# a_268_18520# 0.24963f
C2255 a_5316_3120# vdd 0.00144f
C2256 vbn_leak vbn_ref 0.035f
C2257 vdd m1_4330_6980# 0.00253f
C2258 a_672_20034# a_2180_13234# 0.12018f
C2259 vbp_st a_3048_16080# 0.13289f
C2260 vbp_st a_1480_3834# 0.04883f
C2261 ta2 m1_7150_9150# 0.04697f
C2262 a_3048_16080# a_2592_8154# 0.22256f
C2263 vbn_leak a_7540_18520# 0.00405f
C2264 vbp_syn d1 0.26886f
C2265 m1_8466_15350# a_488_17120# 0.05527f
C2266 a_8240_16974# ta0 0.04433f
C2267 vbn_leak m1_2668_7940# 0.12804f
C2268 a_2492_11000# a_2800_12040# 0
C2269 hold a_5524_11840# 0.51994f
C2270 a_2492_18520# a_268_18520# 0.0151f
C2271 vbn_ax ta2 0.00684f
C2272 sel0 m1_2708_380# 0.01247f
C2273 a_3136_4480# a_7540_3120# 0.13863f
C2274 m1_6184_19890# a_672_20034# 0.0659f
C2275 a_6594_420# a_5316_3120# 0.00111f
C2276 m1_6494_7910# chain 0.00272f
C2277 vdd tb2 0.84569f
C2278 a_6672_14314# a_8240_16974# 0.1467f
C2279 vbp_st ta3 0.11074f
C2280 ta0 sel1 0.04222f
C2281 ta3 a_2592_8154# 0.34947f
C2282 m1_1860_10650# vbp_syn 0.08639f
C2283 a_1480_3834# a_2800_5520# 0.00652f
C2284 a_2800_17120# m1_2712_15340# 0.05957f
C2285 m1_1046_17880# stb 0
C2286 vsrc d1 0.0037f
C2287 vdd vs 0.85369f
C2288 vbp_st a_8248_5320# 0.2506f
C2289 a_5524_16920# tb2 0
C2290 d1 vbn_ref 0.04427f
C2291 m1_5808_2480# abus 0.03627f
C2292 el m1_6716_15540# 0.14226f
C2293 vbp_st a_268_18520# 0.1404f
C2294 d2 a_6984_18520# 0.00727f
C2295 vdd vsrcp 0.1999f
C2296 a_6672_14314# sel1 0.07136f
C2297 a_268_18520# a_2592_8154# 0.62213f
C2298 m1_7790_19900# tb0 0.17666f
C2299 a_5516_15680# a_4588_13668# 0.10903f
C2300 m1_3870_19890# tb0 0
C2301 a_5524_16920# vsrcp 0.32235f
C2302 m1_4882_3750# vbn_prb 0.14063f
C2303 d1 m1_2668_7940# 0.17085f
C2304 a_488_12040# m1_5428_15340# 0.00437f
C2305 el chain 0.32556f
C2306 a_2800_5520# a_268_18520# 0.03664f
C2307 a_6594_420# vs 0.19545f
C2308 vbn_leak m1_5946_6980# 0.36641f
C2309 d2 a_488_17120# 0.78471f
C2310 a_672_20034# tb2 0.00242f
C2311 vbp_st a_728_3738# 0.24568f
C2312 a_3212_19360# sel1 0
C2313 vbn_leak a_6672_9234# 0.0781f
C2314 vbn_prb a_8240_16974# 0
C2315 a_1892_3934# vbn_leak 0.08361f
C2316 m1_2956_19890# m1_3870_19890# 0.05532f
C2317 a_6884_4480# a_7540_3120# 0.00121f
C2318 m1_1860_10650# m1_2668_7940# 0
C2319 a_5516_15680# a_5316_18520# 0
C2320 a_1480_3834# vdd 0.55671f
C2321 m1_7148_12980# d2 0
C2322 a_268_18520# a_824_18520# 0.05881f
C2323 stb vbn_ax 0
C2324 a_3048_16080# vdd 1.29555f
C2325 sel0 en 0.33655f
C2326 a_2492_16080# a_2180_13234# 0.13471f
C2327 a_5524_11840# chain 0.07746f
C2328 m1_2792_6140# m1_2668_7940# 0
C2329 vbn_prb sel1 0.12951f
C2330 a_5524_16920# a_3048_16080# 0.03657f
C2331 a_488_17120# a_6984_18520# 0.00149f
C2332 a_488_17120# abus 0
C2333 vbp_st a_3272_6334# 0.08058f
C2334 m1_9090_11710# vbn_leak 0
C2335 m1_1946_330# vs 0.11556f
C2336 vbp_st a_4096_6334# 0.0119f
C2337 ta3 vdd 0.64518f
C2338 m1_3870_19890# m1_7790_19900# 0
C2339 m1_2062_6980# a_4588_8588# 0.00458f
C2340 a_4588_13668# m1_7702_12990# 0.17635f
C2341 vbp_st m1_910_6150# 0.00319f
C2342 vdd a_8248_5320# 0.80749f
C2343 a_5316_3120# a_7540_3120# 0.10659f
C2344 d1 a_6672_9234# 0.46051f
C2345 ta3 a_5524_16920# 0.13396f
C2346 vdd a_268_18520# 1.48097f
C2347 a_1892_3934# d1 0.01518f
C2348 en m1_7702_15230# 0.10274f
C2349 tb3 tb0 0.16515f
C2350 m1_3680_6970# ta2 0.13396f
C2351 m1_7702_15230# sta 0
C2352 a_4588_13668# a_8240_16974# 0.06968f
C2353 m1_7702_7950# a_5524_11840# 0.00714f
C2354 a_5524_16920# a_268_18520# 0.15418f
C2355 a_3048_11000# m1_5428_15340# 0.00851f
C2356 vbn_prb a_6984_3120# 0.11261f
C2357 a_2800_5520# a_3272_6334# 0.05144f
C2358 a_5524_11840# m1_6968_10270# 0.15713f
C2359 a_6672_14314# tb0 0
C2360 a_2800_5520# a_4096_6334# 0.09827f
C2361 m1_5286_6980# m1_6440_6140# 0.0339f
C2362 vbn_prb m1_8466_10270# 0.08059f
C2363 a_4588_13668# sel1 0
C2364 m1_7930_16790# a_8240_16974# 0.02458f
C2365 m1_2122_6150# chain 0
C2366 d2 ta2 0.06108f
C2367 a_6594_420# a_268_18520# 0.17872f
C2368 a_1892_3934# m1_2792_6140# 0.08631f
C2369 vdd a_728_3738# 0.5681f
C2370 el pl_en 0.28616f
C2371 hold m1_5428_15340# 0.03942f
C2372 a_2800_17120# el 0.00521f
C2373 vbn_ax a_5524_5520# 0
C2374 a_7540_3120# vs 0.23743f
C2375 d2 a_2800_12040# 0.02165f
C2376 m1_7930_16790# sel1 0
C2377 mreset vbp_st 0.03611f
C2378 vbp_syn m1_2712_15340# 0.03938f
C2379 a_268_18520# a_672_20034# 0.02713f
C2380 a_5316_18520# sel1 0
C2381 sel0 vsrc 0.31833f
C2382 sel0 vbn_ref 0.11369f
C2383 m1_2112_14220# a_2180_13234# 0.13603f
C2384 a_5516_15680# a_3136_4480# 0.02913f
C2385 ta2 a_6984_18520# 0.04109f
C2386 m1_7096_14156# m1_7702_12990# 0
C2387 vbn_leak m1_4568_19890# 0.22875f
C2388 m1_7790_19900# ta0 0
C2389 tb3 m1_7790_19900# 0.14761f
C2390 vbp_st a_488_12040# 0.08754f
C2391 vdd a_3272_6334# 1.07826f
C2392 a_488_12040# a_2592_8154# 0.28213f
C2393 m1_8466_10270# sel2 0.00732f
C2394 a_5524_11840# pl_en 0.19328f
C2395 vdd a_4096_6334# 0.75104f
C2396 m1_3870_19890# ta0 0.20471f
C2397 tb3 m1_3870_19890# 0.09063f
C2398 ta0 m1_6440_6140# 0.14114f
C2399 m1_6494_7910# sta 0
C2400 a_8240_16974# m1_7096_14156# 0.22925f
C2401 m1_2956_19890# a_3212_19360# 0.00356f
C2402 m1_2062_6980# a_3136_4480# 0.00131f
C2403 mreset a_2800_5520# 0.15259f
C2404 a_3048_3120# a_4660_4480# 0.00296f
C2405 m1_910_6150# vdd 0.04784f
C2406 ta2 a_488_17120# 0.00613f
C2407 m1_5286_6980# ta0 0.09685f
C2408 a_6140_9234# m1_7702_12990# 0
C2409 a_6672_14314# m1_3870_19890# 0.00382f
C2410 m1_7096_14156# sel1 0
C2411 m1_6716_15540# m1_5428_15340# 0.00728f
C2412 a_6594_420# a_3272_6334# 0.07338f
C2413 ta1 m1_7150_9150# 0.02849f
C2414 stb d2 0
C2415 a_6328_4480# vbn_ax 0
C2416 a_6594_420# a_4096_6334# 0.34786f
C2417 a_3048_16080# a_2492_16080# 0.05767f
C2418 m1_5190_10190# a_2592_8154# 0.0212f
C2419 a_5516_15680# a_6140_14314# 0.01288f
C2420 m1_7148_12980# ta2 0.02334f
C2421 ta1 vbn_ax 0.00803f
C2422 el tb1 0
C2423 en el 0.24755f
C2424 vbp_st m1_9090_16790# 0.00856f
C2425 m1_4882_3750# a_3136_4480# 0.12726f
C2426 hold a_488_19360# 0.00594f
C2427 el sta 0.09409f
C2428 chain m1_5428_15340# 0.04699f
C2429 a_5516_15680# a_2180_13234# 0.0069f
C2430 a_3136_4480# m1_7702_12990# 0.00235f
C2431 m1_3870_19890# a_3212_19360# 0.00376f
C2432 a_8248_5320# a_7540_3120# 0
C2433 a_268_18520# a_7540_3120# 0.13491f
C2434 stb a_6984_18520# 0
C2435 mreset vdd 0.32367f
C2436 a_8240_16974# a_3136_4480# 0.14903f
C2437 vbp_st a_3048_11000# 0.30938f
C2438 hold a_2492_18520# 0
C2439 m1_1946_330# a_3272_6334# 0.00158f
C2440 m1_2062_6980# a_6884_4480# 0.11982f
C2441 a_5524_11840# en 0.40621f
C2442 a_3048_11000# a_2592_8154# 0.4648f
C2443 a_5524_11840# sta 0.13894f
C2444 tb3 ta0 0.00293f
C2445 a_3048_3120# a_5524_5520# 0.0024f
C2446 m1_2062_6980# spk 0.00231f
C2447 vdd a_488_12040# 1.92238f
C2448 a_3136_4480# sel1 0
C2449 m1_3680_6970# a_5524_5520# 0.20525f
C2450 a_488_5520# m1_1300_2620# 0.00121f
C2451 a_6672_14314# ta0 0.04289f
C2452 hold vbp_st 0.24224f
C2453 a_6672_14314# tb3 0.00521f
C2454 a_6594_420# mreset 0.11183f
C2455 m1_8466_10270# a_6140_9234# 0
C2456 a_5524_16920# a_488_12040# 0
C2457 hold a_2592_8154# 0.27025f
C2458 m1_1046_17880# vbn_leak 0.07358f
C2459 tb0 m1_8326_19030# 0.32963f
C2460 m1_4882_3750# a_6884_4480# 0.03783f
C2461 a_4588_13668# m1_2678_13100# 0
C2462 vbp_syn el 0.30548f
C2463 stb m1_2470_19900# 0.03356f
C2464 a_8240_16974# a_6140_14314# 0.44439f
C2465 m1_2062_6980# m1_4330_6980# 0.2132f
C2466 vdd m1_5190_10190# 0.00427f
C2467 vbp_st m1_7206_17740# 0.01216f
C2468 m1_7206_17740# a_2592_8154# 0.36381f
C2469 a_6984_3120# a_3136_4480# 0.09998f
C2470 hold a_2800_5520# 0.00115f
C2471 d2 m1_2862_14560# 0.07299f
C2472 m1_2112_14220# a_3048_16080# 0
C2473 m1_9090_16790# vdd 0.08526f
C2474 a_3272_6334# a_7540_3120# 0.07804f
C2475 a_4096_6334# a_7540_3120# 0.1758f
C2476 a_6140_14314# sel1 0.47746f
C2477 a_5268_9138# m1_7702_12990# 0
C2478 vsrc el 0.2163f
C2479 a_2492_11000# vbn_leak 0.00162f
C2480 el vbn_ref 0.04769f
C2481 a_5524_16920# m1_9090_16790# 0.06364f
C2482 vbn_leak m1_7150_9150# 0
C2483 a_5516_15680# vsrcp 0
C2484 sel1 a_2180_13234# 0.02494f
C2485 vsrc vreset 0.54408f
C2486 a_6328_4480# m1_3680_6970# 0
C2487 a_824_11000# a_488_12040# 0.3511f
C2488 vbp_st m1_6716_15540# 0.00147f
C2489 vreset vbn_ref 4.26777f
C2490 a_488_5520# a_824_3120# 0.01593f
C2491 m1_7930_11710# d1 0.00685f
C2492 pl_en m1_5428_15340# 0.07932f
C2493 a_2800_17120# m1_5428_15340# 0
C2494 a_5316_3120# m1_4882_3750# 0.02383f
C2495 ta1 m1_3680_6970# 0.06583f
C2496 m1_6716_15540# a_2592_8154# 0.05221f
C2497 m1_3870_19890# a_5316_18520# 0
C2498 vbn_ax vbn_leak 0.15403f
C2499 a_3048_11000# vdd 1.95737f
C2500 m1_2062_6980# vs 0.08909f
C2501 m1_2112_9090# a_5268_9138# 0
C2502 m1_7790_19900# m1_8326_19030# 0.07791f
C2503 a_6328_4480# m1_5808_2480# 0.00274f
C2504 a_6672_14314# vbn_prb 0.04696f
C2505 a_4588_8588# m1_6440_6140# 0
C2506 m1_7702_10190# abus 0.09217f
C2507 a_3048_11000# a_5524_16920# 0.00107f
C2508 m1_6184_19890# sel1 0.03297f
C2509 m1_6494_7910# m1_5946_6980# 0
C2510 m1_3870_19890# m1_8326_19030# 0
C2511 ta1 d2 0.02191f
C2512 vbp_st chain 0.4833f
C2513 a_2592_8154# chain 0.04437f
C2514 m1_3680_6970# m1_2712_6970# 0.0939f
C2515 m1_6494_7910# a_6672_9234# 0
C2516 hold vdd 3.5354f
C2517 m1_5286_6980# a_4588_8588# 0.02139f
C2518 d2 a_824_16080# 0.02393f
C2519 a_5516_15680# a_3048_16080# 0.107f
C2520 a_6984_3120# a_6884_4480# 0.01932f
C2521 d1 m1_7150_9150# 0.12785f
C2522 hold a_5524_16920# 0.03163f
C2523 a_6984_3120# spk 0
C2524 mreset a_7540_3120# 0.2438f
C2525 m1_4882_3750# vs 0.05038f
C2526 a_4588_13668# ta0 0.00385f
C2527 vbn_ax d1 0.03168f
C2528 a_2800_5520# chain 0.15369f
C2529 m1_1860_10650# a_2492_11000# 0.37512f
C2530 m1_7206_17740# vdd 0.03676f
C2531 a_6594_420# hold 0
C2532 m1_2062_6980# a_1480_3834# 0
C2533 a_2592_8154# m1_2236_8010# 0.14414f
C2534 vsrcp m1_7702_12990# 0.01207f
C2535 a_6672_14314# a_4588_13668# 0
C2536 ta1 a_6984_18520# 0.03559f
C2537 a_5516_15680# ta3 0
C2538 m1_7702_7950# a_2592_8154# 0
C2539 m1_6440_6140# a_6140_9234# 0.00725f
C2540 m1_7206_17740# a_5524_16920# 0
C2541 m1_6968_10270# a_2592_8154# 0.1028f
C2542 el a_6672_9234# 0.0266f
C2543 en m1_5428_15340# 0.03375f
C2544 a_8240_16974# vsrcp 0.50905f
C2545 a_5516_15680# a_268_18520# 0
C2546 a_1892_3934# el 0.02713f
C2547 m1_5428_15340# sta 0.04089f
C2548 hold a_672_20034# 0.01055f
C2549 m1_2112_9090# vsrcp 0
C2550 a_6140_14314# tb0 0
C2551 a_5316_3120# a_6984_3120# 0.01025f
C2552 ta3 m1_2062_6980# 0.3002f
C2553 vdd m1_6716_15540# 0.00818f
C2554 ta1 a_488_17120# 0.00602f
C2555 vbn_ax m1_2792_6140# 0.28304f
C2556 m1_5286_6980# a_6140_9234# 0.00821f
C2557 vsrcp sel1 0
C2558 hold a_824_11000# 0.00422f
C2559 a_4588_8588# ta0 0.02475f
C2560 a_5524_16920# m1_6716_15540# 0.10677f
C2561 tb3 m1_8326_19030# 0.20701f
C2562 a_488_17120# a_824_16080# 0.18622f
C2563 a_2800_17120# a_2492_18520# 0.00237f
C2564 a_3048_18520# m1_2956_19890# 0.00326f
C2565 a_2492_3120# m1_1300_2620# 0.31927f
C2566 ta2 a_5524_5520# 0.0015f
C2567 a_3136_4480# m1_6440_6140# 0.00189f
C2568 m1_9090_11710# el 0
C2569 a_5524_11840# a_6672_9234# 0.72687f
C2570 m1_7206_17740# a_672_20034# 0
C2571 ta1 m1_7148_12980# 0.02875f
C2572 a_6672_14314# m1_8326_19030# 0.01609f
C2573 vdd chain 1.33515f
C2574 vbn_leak a_3048_3120# 0.05895f
C2575 vbn_prb sel2 0.52512f
C2576 m1_7096_14156# ta0 0.02794f
C2577 a_8240_16974# a_3048_16080# 0.04729f
C2578 m1_3680_6970# vbn_leak 0.26757f
C2579 m1_5512_19890# a_2592_8154# 0.00302f
C2580 m1_2956_19890# a_2180_13234# 0
C2581 m1_6184_19890# tb0 0.00164f
C2582 vbp_st m1_7130_19630# 0
C2583 ta2 m1_7702_10190# 0
C2584 a_5524_16920# chain 0.0451f
C2585 vbp_st pl_en 0.00397f
C2586 a_6984_3120# vs 0
C2587 pl_en a_2592_8154# 0.1652f
C2588 ta3 m1_7702_12990# 0.0028f
C2589 a_2800_17120# a_2592_8154# 0.00127f
C2590 a_5316_18520# a_3212_19360# 0.00107f
C2591 m1_7130_19630# a_2592_8154# 0.10215f
C2592 vbn_prb m1_1300_2620# 0
C2593 m1_4882_3750# a_8248_5320# 0.00325f
C2594 m1_9090_11710# a_5524_11840# 0.05368f
C2595 m1_6716_16790# d2 0.00405f
C2596 vbn_leak m1_5808_2480# 0
C2597 m1_4882_3750# a_268_18520# 0.06557f
C2598 m1_2062_6980# a_728_3738# 0.00689f
C2599 a_3048_16080# sel1 0.04716f
C2600 a_6672_14314# m1_7096_14156# 0.00469f
C2601 m1_2862_14560# a_2800_12040# 0
C2602 vbp_syn m1_5428_15340# 0.00653f
C2603 a_268_18520# m1_7702_12990# 0
C2604 ta3 a_8240_16974# 0.27028f
C2605 vbn_leak d2 0.28303f
C2606 a_6594_420# chain 0.04796f
C2607 ta0 a_6140_9234# 0.04936f
C2608 vdd m1_2236_8010# 0.19966f
C2609 m1_3870_19890# a_6140_14314# 0
C2610 m1_2678_13100# a_2180_13234# 0.00489f
C2611 a_8240_16974# a_268_18520# 0.17352f
C2612 ta3 sel1 0.0764f
C2613 m1_6968_10270# vdd 0.00215f
C2614 d1 a_3048_3120# 0.08382f
C2615 hold a_7540_3120# 0.01433f
C2616 chain a_672_20034# 0.04597f
C2617 a_1892_3934# m1_2122_6150# 0
C2618 m1_6716_16790# a_6984_18520# 0
C2619 m1_2062_6980# a_3272_6334# 0.00194f
C2620 a_824_3120# a_2492_3120# 0.01033f
C2621 m1_3680_6970# d1 0.18731f
C2622 m1_3870_19890# a_2180_13234# 0.04661f
C2623 m1_6440_6140# a_6884_4480# 0
C2624 m1_2062_6980# a_4096_6334# 0.00877f
C2625 hold a_2492_16080# 0.03417f
C2626 tb0 tb2 0.28782f
C2627 ta1 ta2 2.90161f
C2628 a_268_18520# sel1 0.13676f
C2629 vbn_leak a_6984_18520# 0.00172f
C2630 a_3136_4480# ta0 0.03479f
C2631 m1_6184_19890# m1_7790_19900# -0.00609f
C2632 d1 m1_5808_2480# 0.01933f
C2633 vbn_leak abus 0.31358f
C2634 a_5524_5520# a_4660_4480# 0.13597f
C2635 a_2492_3120# vss 0.16748f
C2636 a_6328_4480# vss -0.04921f
C2637 a_3136_4480# vss 2.82007f
C2638 a_488_19360# vss 0.21283f
C2639 m1_2712_6970# vss 0.10737f
C2640 a_6594_420# vss 1.7279f
C2641 a_3272_6334# vss 2.65487f
C2642 a_2492_11000# vss -0.06172f
C2643 m1_6968_10270# vss 0.01309f
C2644 a_2492_18520# vss -0.12051f
C2645 a_7540_3120# vss 0.53445f
C2646 a_6984_18520# vss -0.14486f
C2647 vs vss 4.77792f
C2648 a_672_20034# vss 3.40226f
C2649 d1_bsel vss 1.8411f
C2650 a_2800_5520# vss -0.24352f
C2651 a_2492_16080# vss -0.02937f
C2652 hold vss 2.04836f
C2653 vbn_ax vss 3.59664f
C2654 m1_3870_19890# vss 1.71315f
C2655 tb3 vss 0.87636f
C2656 a_6672_9234# vss 1.26758f
C2657 m1_2112_14220# vss -0.08261f
C2658 a_5316_3120# vss 0.03086f
C2659 m1_5512_19890# vss 1.04336f
C2660 tb2 vss 0.18375f
C2661 chain vss 1.12252f
C2662 a_6140_9234# vss 1.36837f
C2663 a_7540_18520# vss 0.28366f
C2664 m1_7130_19630# vss 0.57085f
C2665 tb1 vss 0.59181f
C2666 m1_5808_2480# vss 0.392f
C2667 m1_7702_10190# vss 0.42184f
C2668 a_5316_18520# vss -0.13999f
C2669 m1_8326_19030# vss 0.21825f
C2670 tb0 vss 0.68689f
C2671 m1_4882_3750# vss -0.03398f
C2672 m1_8466_10270# vss 0.08409f
C2673 m1_7790_19900# vss 0.17708f
C2674 a_5516_10600# vss 0.11999f
C2675 m1_6184_19890# vss 0.20945f
C2676 abus vss 3.78506f
C2677 sel0 vss 2.01868f
C2678 a_2800_12040# vss -0.07568f
C2679 m1_9090_11710# vss -0.0906f
C2680 a_3212_19360# vss -0.33857f
C2681 m1_4568_19890# vss 0.06656f
C2682 a_824_16080# vss 0.04385f
C2683 a_488_17120# vss 1.09151f
C2684 m1_6716_11710# vss -0.08932f
C2685 m1_7930_11710# vss -0.09114f
C2686 m1_1300_2620# vss 0.18485f
C2687 pl_en vss 1.37161f
C2688 a_6884_4480# vss -0.02673f
C2689 a_4096_6334# vss 0.76154f
C2690 spk vss 6.5248f
C2691 a_3048_16080# vss 1.01069f
C2692 m1_7702_7950# vss 0.05045f
C2693 a_4660_4480# vss -0.0525f
C2694 a_5524_5520# vss -0.36934f
C2695 m1_5190_10190# vss 0.43597f
C2696 m1_7130_7810# vss 0.16554f
C2697 a_6672_14314# vss 1.01551f
C2698 d1 vss 5.0117f
C2699 a_6140_14314# vss 0.95821f
C2700 m1_2112_9090# vss -0.06886f
C2701 m1_6494_7910# vss 0.03149f
C2702 a_5524_11840# vss 1.94493f
C2703 a_1480_3834# vss 0.32551f
C2704 m1_1046_17880# vss -0.15997f
C2705 m1_7206_17740# vss -0.21747f
C2706 m1_1860_10650# vss 0.22498f
C2707 a_824_11000# vss 0.04308f
C2708 m1_1096_6970# vss 0.09852f
C2709 m1_642_6980# vss 0.03108f
C2710 a_5268_9138# vss 1.4582f
C2711 vsrcp vss 2.34539f
C2712 m1_2712_15340# vss -0.10484f
C2713 m1_9090_16790# vss -0.08901f
C2714 a_5516_15680# vss 0.20905f
C2715 m1_2668_7940# vss 0.63614f
C2716 a_2592_8154# vss 1.7791f
C2717 m1_7150_9150# vss 0.09097f
C2718 m1_6716_16790# vss -0.09022f
C2719 m1_7930_16790# vss -0.08881f
C2720 vdd vss 99.07597f
C2721 m1_1946_330# vss 0.58008f
C2722 sel1 vss 0.66194f
C2723 m1_5428_15340# vss 0.44783f
C2724 a_2800_17120# vss -0.11307f
C2725 m1_2236_8010# vss 0.20558f
C2726 sta vss 1.40173f
C2727 m1_2792_6140# vss 0.60494f
C2728 vbp_st vss 1.45671f
C2729 m1_2708_380# vss 0.07103f
C2730 en vss 2.28287f
C2731 m1_2122_6150# vss -0.07663f
C2732 m1_910_6150# vss -0.08679f
C2733 m1_6716_15540# vss 0.51187f
C2734 a_5524_16920# vss 1.87728f
C2735 m1_7702_12990# vss 0.47373f
C2736 vbn_prb vss 3.3053f
C2737 a_4588_13668# vss 2.46483f
C2738 m1_7148_12980# vss -0.0446f
C2739 mreset vss 2.10821f
C2740 a_6984_3120# vss 0.01496f
C2741 m1_2062_6980# vss 0.85377f
C2742 m1_3680_6970# vss 0.41105f
C2743 m1_6494_12990# vss -0.06082f
C2744 a_488_12040# vss 1.4513f
C2745 m1_5286_6980# vss 1.17416f
C2746 a_8240_16974# vss 1.52842f
C2747 m1_7096_14156# vss 0.02634f
C2748 m1_2956_19890# vss 0.06807f
C2749 vbp_syn vss 0.57941f
C2750 a_728_3738# vss 0.541f
C2751 vsrc vss 2.46533f
C2752 m1_2470_19900# vss -0.00398f
C2753 m1_2678_13100# vss 0.48662f
C2754 stb vss 0.51701f
C2755 a_4588_8588# vss 1.61497f
C2756 a_3048_11000# vss 1.35539f
C2757 ta3 vss 0.81129f
C2758 sel2 vss 2.2451f
C2759 m1_7702_15230# vss 0.42635f
C2760 vreset vss 1.98193f
C2761 vbn_ref vss 0.19995f
C2762 m1_2862_14560# vss 0.10355f
C2763 d2 vss 3.28672f
C2764 a_2180_13234# vss 1.13845f
C2765 a_824_18520# vss -0.11439f
C2766 ta2 vss 1.25591f
C2767 a_3048_3120# vss 0.18f
C2768 m1_8466_15350# vss 0.0852f
C2769 m1_5946_6980# vss 0.0748f
C2770 ta1 vss 0.48352f
C2771 a_824_3120# vss 0.02943f
C2772 a_488_5520# vss 0.32701f
C2773 el vss 4.04412f
C2774 a_3048_18520# vss -0.05069f
C2775 m1_4330_6980# vss 0.38266f
C2776 m1_6440_6140# vss 0.16427f
C2777 ta0 vss 0.75807f
C2778 a_268_18520# vss 1.29196f
C2779 a_1892_3934# vss 0.23537f
C2780 vbn_leak vss 15.39414f
C2781 a_8248_5320# vss 0.32241f
.ends
