* NGSPICE file created from dend_d1.ext - technology: gf180mcuD

.subckt n_w4_l0p5_k1 a_n188_n400# a_50_n400# a_n50_n444# VSUBS
X0 a_50_n400# a_n50_n444# a_n188_n400# VSUBS nfet_03v3 ad=2.76p pd=9.38u as=2.76p ps=9.38u w=4u l=0.5u
.ends

.subckt n_w2_l4 a_400_n200# a_n400_n244# a_n488_n200# VSUBS
X0 a_400_n200# a_n400_n244# a_n488_n200# VSUBS nfet_03v3 ad=0.88p pd=4.88u as=0.88p ps=4.88u w=2u l=4u
.ends

.subckt n_w1_l0p28 a_28_n100# a_n28_n144# a_n116_n100# VSUBS
X0 a_28_n100# a_n28_n144# a_n116_n100# VSUBS nfet_03v3 ad=0.44p pd=2.88u as=0.44p ps=2.88u w=1u l=0.28u
.ends

.subckt p_w1_l0p28 w_n202_n230# a_28_n100# a_n28_n144# a_n116_n100#
X0 a_28_n100# a_n28_n144# a_n116_n100# w_n202_n230# pfet_03v3 ad=0.44p pd=2.88u as=0.44p ps=2.88u w=1u l=0.28u
.ends

.subckt p_w0p22_l1 a_100_n22# a_n100_n66# w_n278_n159# a_n192_n36#
X0 a_100_n22# a_n100_n66# a_n192_n36# w_n278_n159# pfet_03v3 ad=0.1516p pd=1.64u as=0.1516p ps=1.64u w=0.22u l=1u
.ends

.subckt n_w0p5_l1p5 a_150_n50# a_n238_n50# a_n150_n94# VSUBS
X0 a_150_n50# a_n150_n94# a_n238_n50# VSUBS nfet_03v3 ad=0.22p pd=1.88u as=0.22p ps=1.88u w=0.5u l=1.5u
.ends

.subckt p_w2_l4 a_400_n200# a_n400_n244# w_n574_n330# a_n488_n200#
X0 a_400_n200# a_n400_n244# a_n488_n200# w_n574_n330# pfet_03v3 ad=0.88p pd=4.88u as=0.88p ps=4.88u w=2u l=4u
.ends

.subckt p_w1_l0p5 a_n138_n100# a_50_n100# a_n50_n144# w_n224_n230#
X0 a_50_n100# a_n50_n144# a_n138_n100# w_n224_n230# pfet_03v3 ad=0.44p pd=2.88u as=0.44p ps=2.88u w=1u l=0.5u
.ends

.subckt p_w1_l2 w_n374_n230# a_n288_n100# a_200_n100# a_n200_n144#
X0 a_200_n100# a_n200_n144# a_n288_n100# w_n374_n230# pfet_03v3 ad=0.44p pd=2.88u as=0.44p ps=2.88u w=1u l=2u
.ends

.subckt n_w0p5_l0p28 a_n28_n94# a_n116_n50# a_28_n50# VSUBS
X0 a_28_n50# a_n28_n94# a_n116_n50# VSUBS nfet_03v3 ad=0.22p pd=1.88u as=0.22p ps=1.88u w=0.5u l=0.28u
.ends

.subckt n_w0p5_l0p5 a_n138_n50# a_50_n50# a_n50_n94# VSUBS
X0 a_50_n50# a_n50_n94# a_n138_n50# VSUBS nfet_03v3 ad=0.22p pd=1.88u as=0.22p ps=1.88u w=0.5u l=0.5u
.ends

.subckt n_w4_l2 a_n288_n400# a_200_n400# a_n200_n444# VSUBS
X0 a_200_n400# a_n200_n444# a_n288_n400# VSUBS nfet_03v3 ad=1.76p pd=8.88u as=1.76p ps=8.88u w=4u l=2u
.ends

.subckt n_w3p54_l3p54 a_354_n354# a_n354_n398# a_n442_n354# VSUBS
X0 a_354_n354# a_n354_n398# a_n442_n354# VSUBS nfet_03v3 ad=1.5576p pd=7.96u as=1.5576p ps=7.96u w=3.54u l=3.54u
.ends

.subckt n_w0p5_l0p6 a_n148_n50# a_60_n50# a_n60_n94# VSUBS
X0 a_60_n50# a_n60_n94# a_n148_n50# VSUBS nfet_03v3 ad=0.22p pd=1.88u as=0.22p ps=1.88u w=0.5u l=0.6u
.ends

.subckt n_w1_l0p5 a_n138_n100# a_50_n100# a_n50_n144# VSUBS
X0 a_50_n100# a_n50_n144# a_n138_n100# VSUBS nfet_03v3 ad=0.44p pd=2.88u as=0.44p ps=2.88u w=1u l=0.5u
.ends

.subckt n_w0p5_l3 a_n388_n50# a_300_n50# a_n300_n94# VSUBS
X0 a_300_n50# a_n300_n94# a_n388_n50# VSUBS nfet_03v3 ad=0.22p pd=1.88u as=0.22p ps=1.88u w=0.5u l=3u
.ends

.subckt n_w1_l1 a_n188_n100# a_100_n100# a_n100_n144# VSUBS
X0 a_100_n100# a_n100_n144# a_n188_n100# VSUBS nfet_03v3 ad=0.44p pd=2.88u as=0.44p ps=2.88u w=1u l=1u
.ends

.subckt p_w0p22_l4 a_n400_n66# a_n492_n36# w_n578_n159# a_400_n22#
X0 a_400_n22# a_n400_n66# a_n492_n36# w_n578_n159# pfet_03v3 ad=0.1516p pd=1.64u as=0.1516p ps=1.64u w=0.22u l=4u
.ends

.subckt n_w1_l4 a_n488_n100# a_400_n100# a_n400_n144# VSUBS
X0 a_400_n100# a_n400_n144# a_n488_n100# VSUBS nfet_03v3 ad=0.44p pd=2.88u as=0.44p ps=2.88u w=1u l=4u
.ends

.subckt n_w2_l2 a_n288_n200# a_200_n200# a_n200_n244# VSUBS
X0 a_200_n200# a_n200_n244# a_n288_n200# VSUBS nfet_03v3 ad=0.88p pd=4.88u as=0.88p ps=4.88u w=2u l=2u
.ends

.subckt n_w0p22_l2 a_200_n22# a_n200_n66# a_n292_n36# VSUBS
X0 a_200_n22# a_n200_n66# a_n292_n36# VSUBS nfet_03v3 ad=0.1516p pd=1.64u as=0.1516p ps=1.64u w=0.22u l=2u
.ends

.subckt n_w7p07_l7p07 a_707_n707# a_n795_n707# a_n707_n751# VSUBS
X0 a_707_n707# a_n707_n751# a_n795_n707# VSUBS nfet_03v3 ad=3.1108p pd=15.02u as=3.1108p ps=15.02u w=7.07u l=7.07u
.ends

.subckt n_w4_l1 a_n188_n400# a_100_n400# a_n100_n444# VSUBS
X0 a_100_n400# a_n100_n444# a_n188_n400# VSUBS nfet_03v3 ad=1.76p pd=8.88u as=1.76p ps=8.88u w=4u l=1u
.ends

.subckt dend_d1 vdd vss el vbn_leak vsrc vsrcp vbp_st vbn_ax vbn_ref vreset vbn_prb
+ abus sel0 sel2 mreset spk en pl_en chain sel1 d1_bsel sta stb hold ta0 ta1 ta2 ta3
+ tb0 tb1 tb2 tb3 vbp_syn d1 d2 vs
XXL1_XM2 a_2542_11000# a_3098_11000# a_3098_11000# vss n_w4_l0p5_k1
XXEP_XS a_8248_5320# vbn_leak vss vss n_w2_l4
XXS_XL_XMT m1_2722_2630# vbn_leak vss vss n_w2_l4
XXWS a_318_18520# a_1892_3934# vs vss n_w1_l0p28
XXS_XD_Xi4_XP vdd spk a_3272_6334# vdd p_w1_l0p28
XXP1_XDT_XK a_6672_9234# a_5524_11840# vdd vdd p_w0p22_l1
XXR1_XP0 vdd a_3098_11000# ta0 m1_6494_5850# p_w1_l0p28
XXR1_XR2 m1_4282_6970# m1_2712_6970# vbn_leak vss n_w0p5_l1p5
XXA2_XA_XP2 a_3098_18520# a_488_19360# vdd vdd p_w2_l4
XXY2_XQB vdd vss vss m1_2678_13100# p_w1_l0p28
XXS_XL_XM1 a_488_5520# a_874_3120# el vss n_w4_l0p5_k1
XXA2_XA_XMT m1_1046_17880# vbn_ax vss vss n_w2_l4
XXA2_XA_XHO vdd d2 hold a_3098_18520# p_w1_l0p28
XXR1_XP1 vdd a_3098_11000# ta1 m1_5286_6830# p_w1_l0p28
XXR1_XR3 m1_5942_6980# m1_4282_6970# vbn_leak vss n_w0p5_l1p5
XXT1_XME m1_7702_15650# en m1_8466_15350# vss n_w1_l0p28
XXS_XL_XM2 a_2542_3120# a_3098_3120# a_3098_3120# vss n_w4_l0p5_k1
XXP2_XDT_XNE m1_6940_14170# a_5524_16920# vsrcp vss n_w1_l0p28
XXS_XD_XPI m1_910_6150# a_728_3738# vs vdd p_w1_l0p5
XXR1_XP2 vdd a_3098_11000# ta2 m1_3676_6970# p_w1_l0p28
XXEP_XPD vdd vdd a_8248_5320# a_8248_5320# p_w1_l2
XXR1_XN0 ta0 m1_6494_5850# a_488_12040# vss n_w0p5_l0p28
XXA2_XA_XM1 a_488_19360# a_874_18520# a_318_18520# vss n_w4_l0p5_k1
XXY2_XNA a_2180_13234# d2 m1_2862_14560# vss n_w0p5_l0p28
XXS_XR_XNR a_6594_420# vbn_ref vss vss n_w2_l4
XXS_XR_XSW vreset vs a_6594_420# vss n_w0p5_l0p5
XXT1_XMF m1_7702_15650# vdd d2 vss n_w4_l2
XXT2_XSW m1_7702_10190# sel2 abus vss n_w1_l0p28
XXP2_XTP vdd vdd a_4588_13668# a_5524_16920# p_w1_l2
XXS_XL_XD2_a m1_2722_2630# a_2542_3120# a_2542_3120# vss n_w4_l0p5_k1
XXR1_XP3 vdd a_3098_11000# ta3 m1_2062_6980# p_w1_l0p28
XXP1_XCT_XC vss a_4588_8588# vss vss n_w3p54_l3p54
XXR1_XN1 ta1 m1_5286_6830# a_488_12040# vss n_w0p5_l0p28
XXB_XP1 vdd a_2592_8154# d1_bsel stb p_w1_l0p28
XXA2_XA_XM2 a_2542_18520# a_3098_18520# a_3098_18520# vss n_w4_l0p5_k1
XXY2_XNB vss d2 m1_2678_13100# vss n_w0p5_l0p28
XXR2_XRA vss m1_2470_19900# vbn_leak vss n_w0p5_l0p6
XXP2_XDT_XPI m1_6716_16790# a_5268_14218# d2 vdd p_w1_l0p5
XXS_XL_XD2_b a_2542_3120# m1_2722_2630# a_2542_3120# vss n_w4_l0p5_k1
XXS_XD_XNI vsrc a_728_3738# vs vss n_w1_l0p5
XXR1_XL0 m1_5942_6980# m1_6494_5850# vbn_leak vss n_w0p5_l3
XXR1_XLT m1_5942_6980# vdd vbn_leak vss n_w0p5_l3
XXR1_XN2 ta2 m1_3676_6970# a_488_12040# vss n_w0p5_l0p28
XXY1_XWA m1_2236_8010# vbp_syn vdd m1_2112_9090# p_w2_l4
XXB_XP2 vdd a_2180_13234# a_672_20034# stb p_w1_l0p28
XXR2_XRB m1_2470_19900# m1_2956_19890# vbn_leak vss n_w0p5_l0p6
XXP2_XDT_XNH m1_6940_14170# a_5268_14218# d2 vss n_w1_l1
XXR1_XL1 m1_4282_6970# m1_5286_6830# vbn_leak vss n_w0p5_l3
XXR1_XN3 ta3 m1_2062_6980# a_488_12040# vss n_w0p5_l0p28
XXB_XN1 a_672_20034# stb a_2592_8154# vss n_w0p5_l0p28
XXY1_XWB m1_2668_7940# vbp_syn vdd m1_2112_9090# p_w2_l4
XXP2_XDT_XNI vsrcp a_5268_14218# d2 vss n_w1_l0p5
XXP1_XDT_XQ a_6140_9234# vdd vdd a_6672_9234# p_w0p22_l4
XXP2_XTS a_4588_13668# a_5524_16920# m1_6494_13030# vss n_w1_l0p28
XXR1_XL2 m1_2712_6970# m1_3676_6970# vbn_leak vss n_w0p5_l3
XXB_XN2 d1_bsel stb a_2180_13234# vss n_w0p5_l0p28
XXP2_XDT_XK a_6672_14314# a_5524_16920# vdd vdd p_w0p22_l1
XXA1_XB_XD2_a m1_4882_3700# a_6378_4480# a_6378_4480# vss n_w4_l0p5_k1
XXR1_XL3 m1_1080_6970# m1_2062_6980# vbn_leak vss n_w0p5_l3
XXY2_XPH vdd vdd m1_2112_14220# hold p_w1_l2
XXP1_XTI vss m1_6494_7910# vbn_leak vss n_w1_l4
XXA1_XB_XD2_b a_6378_4480# m1_4882_3700# a_6378_4480# vss n_w4_l0p5_k1
XXA1_XA_XD2_a m1_7206_2340# a_7034_3120# a_7034_3120# vss n_w4_l0p5_k1
XXMR mreset a_6594_420# vdd vss n_w0p5_l0p28
XXP2_XS1 m1_7158_13030# m1_5190_15350# a_5524_16920# vss n_w1_l1
XXA1_XA_XD2_b a_7034_3120# m1_7206_2340# a_7034_3120# vss n_w4_l0p5_k1
XXP2_XCT_XC vss a_4588_13668# vss vss n_w3p54_l3p54
XXT0_XMB vss m1_2708_380# vbn_prb vss n_w2_l2
XXP2_XS2 m1_7702_12990# m1_7158_13030# a_4588_13668# vss n_w1_l1
XXP2_XDT_XON a_6672_14314# vss a_5524_16920# vss n_w0p5_l0p28
XXY1_XQA vdd vss sta m1_2236_8010# p_w1_l0p28
XXP2_XOP1 a_2800_17120# a_2800_17120# vdd vdd p_w2_l4
XXEP_XPM vdd vdd a_3136_4480# a_8248_5320# p_w1_l2
XXP2_XS3 m1_6968_15350# m1_7702_12990# pl_en vss n_w1_l1
XXP1_XDT_XNE m1_7150_9086# a_5524_11840# vsrcp vss n_w1_l0p28
XXY1_XQB vdd vss a_2592_8154# m1_2668_7940# p_w1_l0p28
XXP2_XOP2 a_5516_15680# a_2800_17120# vdd vdd p_w2_l4
XXP2_XDT_XOP vdd a_5524_16920# a_6672_14314# vdd p_w1_l0p28
XXS_XD_XPS vdd vdd m1_910_6150# vbp_st p_w1_l2
XXS_XD_XS2 vdd vdd m1_2122_6150# vbp_st p_w1_l2
XXP2_XDT_XQ a_6140_14314# vdd vdd a_6672_14314# p_w0p22_l4
XXT0_XME m1_1968_380# en m1_2708_380# vss n_w1_l0p28
XXP1_XDT_XPI m1_6716_11710# a_5268_9138# d1 vdd p_w1_l0p5
XXS_XD_XS3 vdd vdd m1_2792_6140# vbp_st p_w1_l2
XXY1_XNA sta d1 m1_2236_8010# vss n_w0p5_l0p28
XXP2_XOM1 a_2800_17120# m1_5190_15350# a_3136_4480# vss n_w2_l2
XXT1_XSW m1_7702_15650# sel1 abus vss n_w1_l0p28
XXT0_XMF m1_1968_380# vdd vs vss n_w4_l2
XXP2_XDT_XS2 vdd vdd m1_7930_16790# vbp_st p_w1_l2
XXP2_XDT_XPS vdd vdd m1_6716_16790# vbp_st p_w1_l2
XXP1_XTP vdd vdd a_4588_8588# a_5524_11840# p_w1_l2
XXP1_XDT_XNH m1_7150_9086# a_5268_9138# d1 vss n_w1_l1
XXY1_XNB a_2592_8154# d1 m1_2668_7940# vss n_w0p5_l0p28
XXP2_XOM2 m1_5190_15350# a_5516_15680# a_5516_15680# vss n_w2_l2
XXP2_XDT_XS3 vdd vdd m1_9090_16790# vbp_st p_w1_l2
XXP2_XHP vdd d2 hold a_5516_15680# p_w1_l0p28
XXL2_XD1_a a_874_16080# m1_2712_15340# a_874_16080# vss n_w4_l0p5_k1
XXP1_XDT_XNI vsrcp a_5268_9138# d1 vss n_w1_l0p5
XXS_XD_XP2 vdd a_1480_3834# a_728_3738# m1_2122_6150# p_w1_l0p28
XXR1_XRA vss m1_642_6980# vbn_leak vss n_w0p5_l0p6
XXB_XD1 d1_bsel vss a_2592_8154# vss n_w0p5_l0p28
XXA2_XB_XD1_a a_5366_18520# m1_7206_18030# a_5366_18520# vss n_w4_l0p5_k1
XXL2_XD1_b m1_2712_15340# a_874_16080# a_874_16080# vss n_w4_l0p5_k1
XXS_XD_XP3 vdd a_3272_6334# a_1480_3834# m1_2792_6140# p_w1_l0p28
XXR1_XRB m1_642_6980# m1_1080_6970# vbn_leak vss n_w0p5_l0p6
XXB_XD2 a_672_20034# vss a_2180_13234# vss n_w0p5_l0p28
XXL1_XD1_a a_874_11000# m1_1046_10270# a_874_11000# vss n_w4_l0p5_k1
XXS_XD_XK a_3272_6334# spk vdd vdd p_w0p22_l1
XXA2_XB_XD1_b m1_7206_18030# a_5366_18520# a_5366_18520# vss n_w4_l0p5_k1
XXA2_XA_XD1_a a_874_18520# m1_1046_17880# a_874_18520# vss n_w4_l0p5_k1
XXP2_XDT_XP2 vdd a_6140_14314# a_5268_14218# m1_7930_16790# p_w1_l0p28
XXS_XD_XN2 a_1480_3834# a_728_3738# vsrc vss n_w0p22_l2
XXP1_XTS a_4588_8588# a_5524_11840# m1_6494_7910# vss n_w1_l0p28
XXL1_XD1_b m1_1046_10270# a_874_11000# a_874_11000# vss n_w4_l0p5_k1
XXA1_XB_XP1 a_6680_5520# a_6680_5520# vdd vdd p_w2_l4
XXP2_XDT_XP3 vdd a_6672_14314# a_6140_14314# m1_9090_16790# p_w1_l0p28
XXS_XD_XN3 a_1480_3834# vsrc a_3272_6334# vss n_w0p5_l0p28
XXA2_XA_XD1_b m1_1046_17880# a_874_18520# a_874_18520# vss n_w4_l0p5_k1
XXY1_XPH vdd vdd m1_2112_9090# hold p_w1_l2
XXA1_XB_XP2 a_6934_4480# a_6680_5520# vdd vdd p_w2_l4
XXY2_XHL vdd d2 hold a_3098_16080# p_w1_l0p28
XXP2_XDT_XN2 a_6140_14314# a_5268_14218# vsrcp vss n_w0p22_l2
XXP1_XDT_XON a_6672_9234# vss a_5524_11840# vss n_w0p5_l0p28
XXWC a_318_18520# chain d1 vss n_w1_l0p28
XXA1_XB_XMT m1_4882_3700# vbn_ax vss vss n_w2_l4
XXA1_XB_XHO vdd d1 hold a_6934_4480# p_w1_l0p28
XXP2_XDT_XN3 a_6140_14314# vsrcp a_6672_14314# vss n_w0p5_l0p28
XXY2_XMR vss vss vdd vss n_w0p5_l0p28
XXP1_XS1 m1_7158_7910# m1_5432_10260# a_5524_11840# vss n_w1_l1
XXL2_XP1 a_488_17120# a_488_17120# vdd vdd p_w2_l4
XXA1_XB_XM1 a_6680_5520# a_4710_4480# vs vss n_w4_l0p5_k1
XXP1_XDT_XOP vdd a_5524_11840# a_6672_9234# vdd p_w1_l0p28
XXS_XR_XPC vdd a_6594_420# a_4096_6334# vdd p_w1_l0p28
XXP1_XS2 m1_7684_7940# m1_7158_7910# a_4588_8588# vss n_w1_l1
XXL2_XP2 a_3098_16080# a_488_17120# vdd vdd p_w2_l4
XXP1_XOP1 a_2800_12040# a_2800_12040# vdd vdd p_w2_l4
XXS_XR_Xi_XN spk vss a_4096_6334# vss n_w0p5_l0p28
XXA1_XB_XM2 a_6378_4480# a_6934_4480# a_6934_4480# vss n_w4_l0p5_k1
XXP1_XS3 m1_6968_10190# m1_7684_7940# pl_en vss n_w1_l1
XXP2_XOTA vss m1_6968_15350# vbn_leak vss n_w4_l2
XXL2_XMT m1_2712_15340# vbn_leak vss vss n_w2_l4
XXS_XL_XD1_a a_874_3120# m1_2722_2630# a_874_3120# vss n_w4_l0p5_k1
XXP1_XOP2 a_5516_10600# a_2800_12040# vdd vdd p_w2_l4
XXC1_XC vss vss d1 vss n_w7p07_l7p07
XXP1_XDT_XS2 vdd vdd m1_7930_11710# vbp_st p_w1_l2
XXP1_XDT_XPS vdd vdd m1_6716_11710# vbp_st p_w1_l2
XXP2_XOTB m1_6968_15350# vss vbn_leak vss n_w4_l2
XXL2_XM1 a_488_17120# a_874_16080# el vss n_w4_l0p5_k1
XXS_XL_XD1_b m1_2722_2630# a_874_3120# a_874_3120# vss n_w4_l0p5_k1
XXT2_XMB vss m1_8466_10270# vbn_prb vss n_w2_l2
XXS_XR_Xi_XP vdd a_4096_6334# spk vdd p_w1_l0p28
XXR2_XR1 m1_4568_19890# m1_2956_19890# vbn_leak vss n_w0p5_l1p5
XXA2_XB_XP1 a_3212_19360# a_3212_19360# vdd vdd p_w2_l4
XXP1_XDT_XS3 vdd vdd m1_9090_11710# vbp_st p_w1_l2
XXL2_XM2 a_2542_16080# a_3098_16080# a_3098_16080# vss n_w4_l0p5_k1
XXP1_XOM1 a_2800_12040# m1_5432_10260# a_3136_4480# vss n_w2_l2
XXT0_XSW m1_1968_380# sel0 abus vss n_w1_l0p28
XXR2_XR2 m1_6190_19900# m1_4568_19890# vbn_leak vss n_w0p5_l1p5
XXR2_XP0 vdd a_3098_16080# tb0 m1_8326_19030# p_w1_l0p28
XXA2_XB_XP2 a_7590_18520# a_3212_19360# vdd vdd p_w2_l4
XXP1_XOM2 m1_5432_10260# a_5516_10600# a_5516_10600# vss n_w2_l2
XXR2_XR3 m1_7790_19900# m1_6190_19900# vbn_leak vss n_w0p5_l1p5
XXR2_XP1 vdd a_3098_16080# tb1 m1_7130_19630# p_w1_l0p28
XXA2_XB_XMT m1_7206_18030# vbn_ax vss vss n_w2_l4
XXA2_XB_XHO vdd a_318_18520# hold a_7590_18520# p_w1_l0p28
XXP1_XDT_XP2 vdd a_6140_9234# a_5268_9138# m1_7930_11710# p_w1_l0p28
XXP1_XHP vdd d1 hold a_5516_10600# p_w1_l0p28
XXT2_XME m1_7702_10190# en m1_8466_10270# vss n_w1_l0p28
XXA1_XB_XD1_a a_4710_4480# m1_4882_3700# a_4710_4480# vss n_w4_l0p5_k1
XXR2_XN0 tb0 m1_8326_19030# a_488_17120# vss n_w0p5_l0p28
XXR2_XP2 vdd a_3098_16080# tb2 m1_5504_19890# p_w1_l0p28
XXA2_XB_XM1 a_3212_19360# a_5366_18520# d2 vss n_w4_l0p5_k1
XXP1_XDT_XP3 vdd a_6672_9234# a_6140_9234# m1_9090_11710# p_w1_l0p28
XXA1_XB_XD1_b m1_4882_3700# a_4710_4480# a_4710_4480# vss n_w4_l0p5_k1
XXT2_XMF m1_7702_10190# vdd d1 vss n_w4_l2
XXA1_XA_XD1_a a_5366_3120# m1_7206_2340# a_5366_3120# vss n_w4_l0p5_k1
XXR2_XN1 tb1 m1_7130_19630# a_488_17120# vss n_w0p5_l0p28
XXR2_XP3 vdd a_3098_16080# tb3 m1_3902_19900# p_w1_l0p28
XXA2_XB_XM2 a_7034_18520# a_7590_18520# a_7590_18520# vss n_w4_l0p5_k1
XXP1_XDT_XN2 a_6140_9234# a_5268_9138# vsrcp vss n_w0p22_l2
XXI_XN chain vss a_1892_3934# vss n_w0p5_l0p28
XXR2_XLT m1_7790_19900# vdd vbn_leak vss n_w0p5_l3
XXR2_XL0 m1_7790_19900# m1_8326_19030# vbn_leak vss n_w0p5_l3
XXR2_XN2 tb2 m1_5504_19890# a_488_17120# vss n_w0p5_l0p28
XXA1_XA_XD1_b m1_7206_2340# a_5366_3120# a_5366_3120# vss n_w4_l0p5_k1
XXA1_XA_XP1 a_2800_5520# a_2800_5520# vdd vdd p_w2_l4
XXY2_XWA m1_2862_14560# vbp_syn vdd m1_2112_14220# p_w2_l4
XXP1_XDT_XN3 a_6140_9234# vsrcp a_6672_9234# vss n_w0p5_l0p28
XXA1_XA_XP2 a_7590_3120# a_2800_5520# vdd vdd p_w2_l4
XXR2_XL1 m1_6190_19900# m1_7130_19630# vbn_leak vss n_w0p5_l3
XXB_XI_XN d1_bsel vss a_672_20034# vss n_w0p5_l0p28
XXR2_XN3 tb3 m1_3902_19900# a_488_17120# vss n_w0p5_l0p28
XXY2_XWB m1_2678_13100# vbp_syn vdd m1_2112_14220# p_w2_l4
XXY1_XHL vdd d1 hold a_3098_11000# p_w1_l0p28
XXEP_XN el a_3136_4480# a_3136_4480# vss n_w4_l1
XXS_XHL vdd vs hold a_3098_3120# p_w1_l0p28
XXR2_XL2 m1_4568_19890# m1_5504_19890# vbn_leak vss n_w0p5_l3
XXA1_XA_XMT m1_7206_2340# vbn_ax vss vss n_w2_l4
XXA1_XA_XHO vdd vs hold a_7590_3120# p_w1_l0p28
XXI_XP vdd a_1892_3934# chain vdd p_w1_l0p28
XXY1_XMR vss vss vdd vss n_w0p5_l0p28
XXL2_XD2_a m1_2712_15340# a_2542_16080# a_2542_16080# vss n_w4_l0p5_k1
XXL1_XP1 a_488_12040# a_488_12040# vdd vdd p_w2_l4
XXA1_XA_XM1 a_2800_5520# a_5366_3120# d1 vss n_w4_l0p5_k1
XXR2_XL3 m1_2956_19890# m1_3902_19900# vbn_leak vss n_w0p5_l3
XXB_XI_XP vdd a_672_20034# d1_bsel vdd p_w1_l0p28
XXS_XC_XC vss vss vs vss n_w7p07_l7p07
XXA2_XB_XD2_a m1_7206_18030# a_7034_18520# a_7034_18520# vss n_w4_l0p5_k1
XXP2_XTI vss m1_6494_13030# vbn_leak vss n_w1_l4
XXL2_XD2_b a_2542_16080# m1_2712_15340# a_2542_16080# vss n_w4_l0p5_k1
XXL1_XP2 a_3098_11000# a_488_12040# vdd vdd p_w2_l4
XXL1_XD2_a m1_1046_10270# a_2542_11000# a_2542_11000# vss n_w4_l0p5_k1
XXA1_XA_XM2 a_7034_3120# a_7590_3120# a_7590_3120# vss n_w4_l0p5_k1
XXA2_XB_XD2_b a_7034_18520# m1_7206_18030# a_7034_18520# vss n_w4_l0p5_k1
XXA2_XA_XD2_a m1_1046_17880# a_2542_18520# a_2542_18520# vss n_w4_l0p5_k1
XXP1_XOTA vss m1_6968_10190# vbn_leak vss n_w4_l2
XXL1_XMT m1_1046_10270# vbn_leak vss vss n_w2_l4
XXL1_XD2_b a_2542_11000# m1_1046_10270# a_2542_11000# vss n_w4_l0p5_k1
XXS_XD_Xi4_XN a_3272_6334# vss spk vss n_w0p5_l0p28
XXS_XL_XP1 a_488_5520# a_488_5520# vdd vdd p_w2_l4
XXA2_XA_XD2_b a_2542_18520# m1_1046_17880# a_2542_18520# vss n_w4_l0p5_k1
XXP1_XOTB m1_6968_10190# vss vbn_leak vss n_w4_l2
XXL1_XM1 a_488_12040# a_874_11000# el vss n_w4_l0p5_k1
XXT1_XMB vss m1_8466_15350# vbn_prb vss n_w2_l2
XXS_XL_XP2 a_3098_3120# a_488_5520# vdd vdd p_w2_l4
XXY2_XQA vdd vss a_2180_13234# m1_2862_14560# p_w1_l0p28
XXC2_XC vss vss d2 vss n_w7p07_l7p07
XXS_XR_XCR_XC vss a_6594_420# vss vss n_w3p54_l3p54
XXR1_XR1 m1_2712_6970# m1_1080_6970# vbn_leak vss n_w0p5_l1p5
XXA2_XA_XP1 a_488_19360# a_488_19360# vdd vdd p_w2_l4
.ends
