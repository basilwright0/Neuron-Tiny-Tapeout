* NGSPICE file created from dend_d1.ext - technology: gf180mcuD

.subckt n_w2_l4 a_400_n200# a_n400_n244# a_n488_n200# VSUBS
X0 a_400_n200# a_n400_n244# a_n488_n200# VSUBS nfet_03v3 ad=0.88p pd=4.88u as=0.88p ps=4.88u w=2u l=4u
.ends

.subckt n_w1_l0p28 a_28_n100# a_n28_n144# a_n116_n100# VSUBS
X0 a_28_n100# a_n28_n144# a_n116_n100# VSUBS nfet_03v3 ad=0.44p pd=2.88u as=0.44p ps=2.88u w=1u l=0.28u
.ends

.subckt p_w1_l0p28 w_n202_n230# a_28_n100# a_n28_n144# a_n116_n100#
X0 a_28_n100# a_n28_n144# a_n116_n100# w_n202_n230# pfet_03v3 ad=0.44p pd=2.88u as=0.44p ps=2.88u w=1u l=0.28u
.ends

.subckt n_w2_l2 a_n288_n200# a_200_n200# a_n200_n244# VSUBS
X0 a_200_n200# a_n200_n244# a_n288_n200# VSUBS nfet_03v3 ad=0.88p pd=4.88u as=0.88p ps=4.88u w=2u l=2u
.ends

.subckt p_w2_l4 a_400_n200# a_n400_n244# w_n574_n330# a_n488_n200#
X0 a_400_n200# a_n400_n244# a_n488_n200# w_n574_n330# pfet_03v3 ad=0.88p pd=4.88u as=0.88p ps=4.88u w=2u l=4u
.ends

.subckt p_w1_l0p5 a_n138_n100# a_50_n100# a_n50_n144# w_n224_n230#
X0 a_50_n100# a_n50_n144# a_n138_n100# w_n224_n230# pfet_03v3 ad=0.44p pd=2.88u as=0.44p ps=2.88u w=1u l=0.5u
.ends

.subckt p_w1_l2 w_n374_n230# a_n288_n100# a_200_n100# a_n200_n144#
X0 a_200_n100# a_n200_n144# a_n288_n100# w_n374_n230# pfet_03v3 ad=0.44p pd=2.88u as=0.44p ps=2.88u w=1u l=2u
.ends

.subckt n_w0p5_l0p28 a_n28_n94# a_n116_n50# a_28_n50# VSUBS
X0 a_28_n50# a_n28_n94# a_n116_n50# VSUBS nfet_03v3 ad=0.22p pd=1.88u as=0.22p ps=1.88u w=0.5u l=0.28u
.ends

.subckt n_w0p5_l0p5 a_n138_n50# a_50_n50# a_n50_n94# VSUBS
X0 a_50_n50# a_n50_n94# a_n138_n50# VSUBS nfet_03v3 ad=0.22p pd=1.88u as=0.22p ps=1.88u w=0.5u l=0.5u
.ends

.subckt n_w4_l2 a_n288_n400# a_200_n400# a_n200_n444# VSUBS
X0 a_200_n400# a_n200_n444# a_n288_n400# VSUBS nfet_03v3 ad=1.76p pd=8.88u as=1.76p ps=8.88u w=4u l=2u
.ends

.subckt n_w3p54_l3p54 a_354_n354# a_n354_n398# a_n442_n354# VSUBS
X0 a_354_n354# a_n354_n398# a_n442_n354# VSUBS nfet_03v3 ad=1.5576p pd=7.96u as=1.5576p ps=7.96u w=3.54u l=3.54u
.ends

.subckt n_w1_l0p5 a_n138_n100# a_50_n100# a_n50_n144# VSUBS
X0 a_50_n100# a_n50_n144# a_n138_n100# VSUBS nfet_03v3 ad=0.44p pd=2.88u as=0.44p ps=2.88u w=1u l=0.5u
.ends

.subckt n_w1_l1 a_n188_n100# a_100_n100# a_n100_n144# VSUBS
X0 a_100_n100# a_n100_n144# a_n188_n100# VSUBS nfet_03v3 ad=0.44p pd=2.88u as=0.44p ps=2.88u w=1u l=1u
.ends

.subckt n_w1_l4 a_n488_n100# a_400_n100# a_n400_n144# VSUBS
X0 a_400_n100# a_n400_n144# a_n488_n100# VSUBS nfet_03v3 ad=0.44p pd=2.88u as=0.44p ps=2.88u w=1u l=4u
.ends

.subckt n_w0p22_l2 a_200_n22# a_n200_n66# a_n292_n36# VSUBS
X0 a_200_n22# a_n200_n66# a_n292_n36# VSUBS nfet_03v3 ad=0.1516p pd=1.64u as=0.1516p ps=1.64u w=0.22u l=2u
.ends

.subckt n_w7p07_l7p07 a_707_n707# a_n795_n707# a_n707_n751# VSUBS
X0 a_707_n707# a_n707_n751# a_n795_n707# VSUBS nfet_03v3 ad=3.1108p pd=15.02u as=3.1108p ps=15.02u w=7.07u l=7.07u
.ends

.subckt n_w4_l1 a_n188_n400# a_100_n400# a_n100_n444# VSUBS
X0 a_100_n400# a_n100_n444# a_n188_n400# VSUBS nfet_03v3 ad=1.76p pd=8.88u as=1.76p ps=8.88u w=4u l=1u
.ends

.subckt dend_d1 vdd vss el vbn_leak vsrc vsrcp vbp_st vbn_ax vbn_ref vreset vbn_prb
+ abus sel0 sel2 mreset spk en pl_en chain sel1 d1_bsel sta stb hold ta0 ta1 ta2 ta3
+ tb0 tb1 tb2 tb3 vbp_syn la1 dl1 la2 dl2 d1 d2 vs
XXEP_XS a_8248_5320# vbn_leak vss vss n_w2_l4
XXS_XL_XMT m1_1704_2770# vbn_leak vss vss n_w2_l4
XXWS a_268_18120# a_1892_3934# vs vss n_w1_l0p28
XXS_XD_Xi4_XP vdd spk a_3272_6334# vdd p_w1_l0p28
XXL1_XM2 a_1780_10600# dl1 dl1 vss n_w2_l2
XXA2_XB_XD1 a_5204_18120# m1_5626_17750# a_5204_18120# vss n_w2_l2
XXA2_XA_XP2 a_2536_18120# a_488_19200# vdd vdd p_w2_l4
XXY2_XQB vdd vss vss m1_2678_13030# p_w1_l0p28
XXS_XL_XM1 a_488_5520# m1_690_2500# el vss n_w2_l2
XXA2_XB_XD2 m1_5626_17750# a_5960_18120# a_5960_18120# vss n_w2_l2
XXA2_XA_XHO vdd d2 hold a_2536_18120# p_w1_l0p28
XXA2_XA_XMT m1_1704_17750# vbn_ax vss vss n_w2_l4
XXT1_XME m1_7390_15740# en m1_8166_15130# vss n_w1_l0p28
XXS_XL_XM2 a_1780_2880# a_2536_2880# a_2536_2880# vss n_w2_l2
XXP2_XDT_XNE m1_7128_14156# a_5816_16974# vsrcp vss n_w1_l0p28
XXS_XD_XPI m1_910_6150# a_728_3738# vs vdd p_w1_l0p5
XXEP_XPD vdd vdd a_8248_5320# a_8248_5320# p_w1_l2
XXA2_XA_XM1 a_488_19200# m1_690_17890# a_268_18120# vss n_w2_l2
XXY2_XNA a_2180_13234# d2 m1_2220_12980# vss n_w0p5_l0p28
XXS_XR_XNR a_4374_1028# vbn_ref vss vss n_w2_l4
XXS_XR_XSW vreset vs a_4374_1028# vss n_w0p5_l0p5
XXT1_XMF m1_7390_15740# vdd d2 vss n_w4_l2
XXT2_XSW m1_7390_10270# sel2 abus vss n_w1_l0p28
XXP2_XTP vdd a_4588_13668# a_5816_16974# vdd p_w1_l0p28
XXP1_XCT_XC vss a_4588_8588# vss vss n_w3p54_l3p54
XXB_XP1 vdd a_2592_8154# d1_bsel stb p_w1_l0p28
XXA2_XA_XM2 a_1780_18120# a_2536_18120# a_2536_18120# vss n_w2_l2
XXY2_XNB vss d2 m1_2678_13030# vss n_w0p5_l0p28
XXP2_XDT_XPI m1_6726_16790# a_8436_16974# d2 vdd p_w1_l0p5
XXS_XD_XNI vsrc a_728_3738# vs vss n_w1_l0p5
XXY1_XWA m1_2868_9480# vbp_syn vdd m1_2122_9086# p_w2_l4
XXB_XP2 vdd a_2180_13234# a_672_19994# stb p_w1_l0p28
XXA1_XA_XD1 a_5204_2880# m1_5626_2500# a_5204_2880# vss n_w2_l2
XXP2_XDT_XNH m1_7128_14156# a_8436_16974# d2 vss n_w1_l1
XXB_XN1 a_672_19994# stb a_2592_8154# vss n_w0p5_l0p28
XXY1_XWB m1_2678_7950# vbp_syn vdd m1_2122_9086# p_w2_l4
XXP2_XDT_XNI vsrcp a_8436_16974# d2 vss n_w1_l1
XXA1_XA_XD2 m1_5626_2500# a_5960_2880# a_5960_2880# vss n_w2_l2
XXP2_XTS a_4588_13668# a_5816_16974# m1_6474_13030# vss n_w1_l0p28
XXB_XN2 d1_bsel stb a_2180_13234# vss n_w0p5_l0p28
XXY2_XPH vdd vdd m1_2064_14170# hold p_w1_l2
XXP1_XTI vss m1_6474_8020# vbn_leak vss n_w1_l4
XXL1_XD1 m1_690_10190# m1_1704_10270# m1_690_10190# vss n_w2_l2
XXMR mreset a_4374_1028# vdd vss n_w0p5_l0p28
XXL1_XD2 m1_1704_10270# a_1780_10600# a_1780_10600# vss n_w2_l2
XXP2_XS1 m1_7128_13020# m1_5122_15350# a_5816_16974# vss n_w1_l1
XXP2_XCT_XC vss a_4588_13668# vss vss n_w3p54_l3p54
XXT0_XMB vss m1_2702_380# vbn_prb vss n_w2_l2
XXS_XL_XD1 m1_690_2500# m1_1704_2770# m1_690_2500# vss n_w2_l2
XXP2_XS2 m1_7694_12850# m1_7128_13020# a_4588_13668# vss n_w1_l1
XXP2_XDT_XON a_6672_14314# vss a_5816_16974# vss n_w0p5_l0p28
XXY1_XQA vdd vss sta m1_2868_9480# p_w1_l0p28
XXP2_XOP1 a_2920_17120# a_2920_17120# vdd vdd p_w2_l4
XXS_XL_XD2 m1_1704_2770# a_1780_2880# a_1780_2880# vss n_w2_l2
XXEP_XPM vdd vdd a_2724_4480# a_8248_5320# p_w1_l2
XXA2_XA_XD1 m1_690_17890# m1_1704_17750# m1_690_17890# vss n_w2_l2
XXP2_XS3 m1_6390_15350# m1_7694_12850# pl_en vss n_w1_l1
XXY1_XQB vdd vss a_2592_8154# m1_2678_7950# p_w1_l0p28
XXP1_XDT_XNE m1_7138_8930# a_5816_11894# vsrcp vss n_w1_l0p28
XXP2_XOP2 a_5204_15680# a_2920_17120# vdd vdd p_w2_l4
XXP2_XDT_XOP vdd a_5816_16974# a_6672_14314# vdd p_w1_l0p28
XXS_XD_XPS vdd vdd m1_910_6150# vbp_st p_w1_l2
XXS_XD_XS2 vdd vdd m1_2122_6150# vbp_st p_w1_l2
XXA2_XA_XD2 m1_1704_17750# a_1780_18120# a_1780_18120# vss n_w2_l2
XXT0_XME m1_1946_330# en m1_2702_380# vss n_w1_l0p28
XXP1_XDT_XPI m1_6726_11710# a_5268_9138# d1 vdd p_w1_l0p5
XXY1_XNA sta d1 m1_2868_9480# vss n_w0p5_l0p28
XXP2_XOM1 a_2920_17120# m1_5122_15350# a_2724_4480# vss n_w2_l2
XXT1_XSW m1_7390_15740# sel1 abus vss n_w1_l0p28
XXT0_XMF m1_1946_330# vdd vs vss n_w4_l2
XXP2_XDT_XS2 vdd vdd m1_8050_16790# vbp_st p_w1_l2
XXP2_XDT_XPS vdd vdd m1_6726_16790# vbp_st p_w1_l2
XXY1_XNB a_2592_8154# d1 m1_2678_7950# vss n_w0p5_l0p28
XXP1_XDT_XNH m1_7138_8930# a_5268_9138# d1 vss n_w1_l1
XXP1_XTP vdd a_4588_8588# a_5816_11894# vdd p_w1_l0p28
XXP2_XOM2 m1_5122_15350# a_5204_15680# a_5204_15680# vss n_w2_l2
XXP2_XHP vdd d2 hold a_5204_15680# p_w1_l0p28
XXS_XD_XP2 vdd a_1480_3834# a_728_3738# m1_2122_6150# p_w1_l0p28
XXP1_XDT_XNI vsrcp a_5268_9138# d1 vss n_w1_l1
XXB_XD1 d1_bsel vss a_2592_8154# vss n_w0p5_l0p28
XXS_XD_XP3 vdd a_3272_6334# a_1480_3834# vdd p_w1_l0p28
XXB_XD2 a_672_19994# vss a_2180_13234# vss n_w0p5_l0p28
XXP2_XDT_XP2 vdd a_6140_14314# a_8436_16974# m1_8050_16790# p_w1_l0p28
XXS_XD_XN2 a_1480_3834# a_728_3738# vsrc vss n_w0p22_l2
XXP1_XTS a_4588_8588# a_5816_11894# m1_6474_8020# vss n_w1_l0p28
XXA1_XB_XP1 a_5524_5520# a_5524_5520# vdd vdd p_w2_l4
XXP2_XDT_XP3 vdd a_6672_14314# a_6140_14314# vdd p_w1_l0p28
XXS_XD_XN3 a_1480_3834# vsrc a_3272_6334# vss n_w0p5_l0p28
XXY1_XPH vdd vdd m1_2122_9086# hold p_w1_l2
XXA1_XB_XP2 a_5960_4080# a_5524_5520# vdd vdd p_w2_l4
XXY2_XHL vdd d2 hold dl2 p_w1_l0p28
XXP2_XDT_XN2 a_6140_14314# a_8436_16974# vsrcp vss n_w0p22_l2
XXP1_XDT_XON a_6672_9234# vss a_5816_11894# vss n_w0p5_l0p28
XXWC a_268_18120# chain d1 vss n_w1_l0p28
XXA1_XB_XMT m1_4870_3750# vbn_ax vss vss n_w2_l4
XXA1_XB_XHO vdd d1 hold a_5960_4080# p_w1_l0p28
XXP2_XDT_XN3 a_6140_14314# vsrcp a_6672_14314# vss n_w0p5_l0p28
XXY2_XMR vss vss vdd vss n_w0p5_l0p28
XXP1_XS1 m1_7138_8020# m1_5100_10180# a_5816_11894# vss n_w1_l1
XXL2_XP1 la2 la2 vdd vdd p_w2_l4
XXA1_XB_XM1 a_5524_5520# a_4448_4080# vs vss n_w2_l2
XXP1_XDT_XOP vdd a_5816_11894# a_6672_9234# vdd p_w1_l0p28
XXS_XR_XPC vdd a_4374_1028# a_4096_6334# vdd p_w1_l0p28
XXP1_XS2 m1_7684_8010# m1_7138_8020# a_4588_8588# vss n_w1_l1
XXL2_XP2 dl2 la2 vdd vdd p_w2_l4
XXP1_XOP1 a_2920_12040# a_2920_12040# vdd vdd p_w2_l4
XXS_XR_Xi_XN spk vss a_4096_6334# vss n_w0p5_l0p28
XXA1_XB_XM2 a_5204_4080# a_5960_4080# a_5960_4080# vss n_w2_l2
XXP1_XS3 m1_6390_10270# m1_7684_8010# pl_en vss n_w1_l1
XXP2_XOTA vss m1_6390_15350# vbn_leak vss n_w4_l2
XXL2_XMT m1_1704_15350# vbn_leak vss vss n_w2_l4
XXP1_XOP2 a_5204_10600# a_2920_12040# vdd vdd p_w2_l4
XXC1_XC vss vss d1 vss n_w7p07_l7p07
XXP1_XDT_XS2 vdd vdd m1_8050_11710# vbp_st p_w1_l2
XXP1_XDT_XPS vdd vdd m1_6726_11710# vbp_st p_w1_l2
XXP2_XOTB m1_6390_15350# vss vbn_leak vss n_w4_l2
XXL2_XM1 la2 m1_690_15350# el vss n_w2_l2
XXS_XR_Xi_XP vdd a_4096_6334# spk vdd p_w1_l0p28
XXT2_XMB vss m1_8166_10050# vbn_prb vss n_w2_l2
XXA2_XB_XP1 a_3212_19200# a_3212_19200# vdd vdd p_w2_l4
XXL2_XM2 a_1780_15680# dl2 dl2 vss n_w2_l2
XXT0_XSW m1_1946_330# sel0 abus vss n_w1_l0p28
XXP1_XOM1 a_2920_12040# m1_5100_10180# a_2724_4480# vss n_w2_l2
XXA2_XB_XP2 a_6716_18120# a_3212_19200# vdd vdd p_w2_l4
XXP1_XOM2 m1_5100_10180# a_5204_10600# a_5204_10600# vss n_w2_l2
XXA2_XB_XMT m1_5626_17750# vbn_ax vss vss n_w2_l4
XXA2_XB_XHO vdd a_268_18120# hold a_6716_18120# p_w1_l0p28
XXP1_XDT_XP2 vdd a_6140_9234# a_5268_9138# m1_8050_11710# p_w1_l0p28
XXP1_XHP vdd d1 hold a_5204_10600# p_w1_l0p28
XXT2_XME m1_7390_10270# en m1_8166_10050# vss n_w1_l0p28
XXA2_XB_XM1 a_3212_19200# a_5204_18120# d2 vss n_w2_l2
XXP1_XDT_XP3 vdd a_6672_9234# a_6140_9234# vdd p_w1_l0p28
XXT2_XMF m1_7390_10270# vdd d1 vss n_w4_l2
XXA2_XB_XM2 a_5960_18120# a_6716_18120# a_6716_18120# vss n_w2_l2
XXP1_XDT_XN2 a_6140_9234# a_5268_9138# vsrcp vss n_w0p22_l2
XXI_XN chain vss a_1892_3934# vss n_w0p5_l0p28
XXA1_XA_XP1 a_3956_5520# a_3956_5520# vdd vdd p_w2_l4
XXY2_XWA m1_2220_12980# vbp_syn vdd m1_2064_14170# p_w2_l4
XXP1_XDT_XN3 a_6140_9234# vsrcp a_6672_9234# vss n_w0p5_l0p28
XXA1_XB_XD1 a_4448_4080# m1_4870_3750# a_4448_4080# vss n_w2_l2
XXA1_XA_XP2 a_6716_2880# a_3956_5520# vdd vdd p_w2_l4
XXB_XI_XN d1_bsel vss a_672_19994# vss n_w0p5_l0p28
XXY2_XWB m1_2678_13030# vbp_syn vdd m1_2064_14170# p_w2_l4
XXY1_XHL vdd d1 hold dl1 p_w1_l0p28
XXEP_XN el a_2724_4480# a_2724_4480# vss n_w4_l1
XXA1_XB_XD2 m1_4870_3750# a_5204_4080# a_5204_4080# vss n_w2_l2
XXS_XHL vdd vs hold a_2536_2880# p_w1_l0p28
XXA1_XA_XMT m1_5626_2500# vbn_ax vss vss n_w2_l4
XXA1_XA_XHO vdd vs hold a_6716_2880# p_w1_l0p28
XXI_XP vdd a_1892_3934# chain vdd p_w1_l0p28
XXY1_XMR vss vss vdd vss n_w0p5_l0p28
XXA1_XA_XM1 a_3956_5520# a_5204_2880# d1 vss n_w2_l2
XXL1_XP1 la1 la1 vdd vdd p_w2_l4
XXB_XI_XP vdd a_672_19994# d1_bsel vdd p_w1_l0p28
XXS_XC_XC vss vss vs vss n_w7p07_l7p07
XXP2_XTI vss m1_6474_13030# vbn_leak vss n_w1_l4
XXL2_XD1 m1_690_15350# m1_1704_15350# m1_690_15350# vss n_w2_l2
XXL1_XP2 dl1 la1 vdd vdd p_w2_l4
XXA1_XA_XM2 a_5960_2880# a_6716_2880# a_6716_2880# vss n_w2_l2
XXL2_XD2 m1_1704_15350# a_1780_15680# a_1780_15680# vss n_w2_l2
XXS_XD_Xi4_XN a_3272_6334# vss spk vss n_w0p5_l0p28
XXS_XL_XP1 a_488_5520# a_488_5520# vdd vdd p_w2_l4
XXL1_XMT m1_1704_10270# vbn_leak vss vss n_w2_l4
XXP1_XOTA vss m1_6390_10270# vbn_leak vss n_w4_l2
XXL1_XM1 la1 m1_690_10190# el vss n_w2_l2
XXP1_XOTB m1_6390_10270# vss vbn_leak vss n_w4_l2
XXT1_XMB vss m1_8166_15130# vbn_prb vss n_w2_l2
XXS_XL_XP2 a_2536_2880# a_488_5520# vdd vdd p_w2_l4
XXY2_XQA vdd vss a_2180_13234# m1_2220_12980# p_w1_l0p28
XXC2_XC vss vss d2 vss n_w7p07_l7p07
XXS_XR_XCR_XC vss a_4374_1028# vss vss n_w3p54_l3p54
XXA2_XA_XP1 a_488_19200# a_488_19200# vdd vdd p_w2_l4
.ends
