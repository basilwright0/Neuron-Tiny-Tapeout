* LVS reference for dend_d1: flattened from cells/dendrite/dendrite.spice by layout/dendrite/flatten.py
* Cfb (MOM capacitor, value from PEX) omitted: XS.XD.CFB
.subckt dend_d1 vs d1 d2 spk sel0 sel1 sel2 pl_en chain d1_bsel sta stb hold mreset vbp_syn ta0 ta1 ta2 ta3 tb0 tb1 tb2 tb3 el vsrc vsrcp vreset vbn_leak vbp_st vbn_ref vbn_prb vbn_ax en abus vdd vss
XXS_XC_XC vss vs vss vss nfet_03v3 W=7.07u L=7.07u
XXS_XL_XMT XS.XL.t vbn_leak vss vss nfet_03v3 W=2u L=4u
XXS_XL_XM1 XS.XL.a el XS.XL.s1 vss nfet_03v3 W=4u L=0.5u
XXS_XL_XD1 XS.XL.s1 XS.XL.s1 XS.XL.t vss nfet_03v3 W=8u L=0.5u
XXS_XL_XM2 XS.vl XS.vl XS.XL.s2 vss nfet_03v3 W=4u L=0.5u
XXS_XL_XD2 XS.XL.s2 XS.XL.s2 XS.XL.t vss nfet_03v3 W=8u L=0.5u
XXS_XL_XP1 XS.XL.a XS.XL.a vdd vdd pfet_03v3 W=2u L=4u
XXS_XL_XP2 XS.vl XS.XL.a vdd vdd pfet_03v3 W=2u L=4u
XXS_XHL vs hold XS.vl vdd pfet_03v3 W=1u L=0.28u
XXS_XD_XPS XS.XD.s vbp_st vdd vdd pfet_03v3 W=1u L=2u
XXS_XD_XPI XS.XD.n1 vs XS.XD.s vdd pfet_03v3 W=1u L=0.5u
XXS_XD_XNI XS.XD.n1 vs vsrc vss nfet_03v3 W=1u L=0.5u
XXS_XD_XS2 XS.XD.s2 vbp_st vdd vdd pfet_03v3 W=1u L=2u
XXS_XD_XP2 XS.XD.p XS.XD.n1 XS.XD.s2 vdd pfet_03v3 W=1u L=0.28u
XXS_XD_XN2 XS.XD.p XS.XD.n1 vsrc vss nfet_03v3 W=0.22u L=2u
XXS_XD_XS3 XS.XD.s3 vbp_st vdd vdd pfet_03v3 W=1u L=2u
XXS_XD_XP3 XS.XD.pb XS.XD.p XS.XD.s3 vdd pfet_03v3 W=1u L=0.28u
XXS_XD_XN3 XS.XD.pb XS.XD.p vsrc vss nfet_03v3 W=0.5u L=0.28u
XXS_XD_XK XS.XD.pb spk vdd vdd pfet_03v3 W=0.22u L=1u
XXS_XD_Xi4_XN spk XS.XD.pb vss vss nfet_03v3 W=0.5u L=0.28u
XXS_XD_Xi4_XP spk XS.XD.pb vdd vdd pfet_03v3 W=1u L=0.28u
XXS_XR_Xi_XN XS.XR.spkb spk vss vss nfet_03v3 W=0.5u L=0.28u
XXS_XR_Xi_XP XS.XR.spkb spk vdd vdd pfet_03v3 W=1u L=0.28u
XXS_XR_XPC vr XS.XR.spkb vdd vdd pfet_03v3 W=1u L=0.28u
XXS_XR_XNR vr vbn_ref vss vss nfet_03v3 W=2u L=4u
XXS_XR_XCR_XC vss vr vss vss nfet_03v3 W=3.54u L=3.54u
XXS_XR_XSW vs vr vreset vss nfet_03v3 W=0.5u L=0.5u
XXMR vdd mreset vr vss nfet_03v3 W=0.5u L=0.28u
XXC1_XC vss d1 vss vss nfet_03v3 W=7.07u L=7.07u
XXL1_XMT XL1.t vbn_leak vss vss nfet_03v3 W=2u L=4u
XXL1_XM1 la1 el XL1.s1 vss nfet_03v3 W=4u L=0.5u
XXL1_XD1 XL1.s1 XL1.s1 XL1.t vss nfet_03v3 W=8u L=0.5u
XXL1_XM2 dl1 dl1 XL1.s2 vss nfet_03v3 W=4u L=0.5u
XXL1_XD2 XL1.s2 XL1.s2 XL1.t vss nfet_03v3 W=8u L=0.5u
XXL1_XP1 la1 la1 vdd vdd pfet_03v3 W=2u L=4u
XXL1_XP2 dl1 la1 vdd vdd pfet_03v3 W=2u L=4u
XXY1_XPH XY1.h hold vdd vdd pfet_03v3 W=1u L=2u
XXY1_XWA XY1.da vbp_syn XY1.h vdd pfet_03v3 W=2u L=4u
XXY1_XWB XY1.db vbp_syn XY1.h vdd pfet_03v3 W=2u L=4u
XXY1_XNA XY1.da sta d1 vss nfet_03v3 W=0.5u L=0.28u
XXY1_XNB XY1.db b1 d1 vss nfet_03v3 W=0.5u L=0.28u
XXY1_XQA vss sta XY1.da vdd pfet_03v3 W=1u L=0.28u
XXY1_XQB vss b1 XY1.db vdd pfet_03v3 W=1u L=0.28u
XXY1_XHL d1 hold dl1 vdd pfet_03v3 W=1u L=0.28u
XXY1_XMR vdd vss vss vss nfet_03v3 W=0.5u L=0.28u
XXC2_XC vss d2 vss vss nfet_03v3 W=7.07u L=7.07u
XXL2_XMT XL2.t vbn_leak vss vss nfet_03v3 W=2u L=4u
XXL2_XM1 la2 el XL2.s1 vss nfet_03v3 W=4u L=0.5u
XXL2_XD1 XL2.s1 XL2.s1 XL2.t vss nfet_03v3 W=8u L=0.5u
XXL2_XM2 dl2 dl2 XL2.s2 vss nfet_03v3 W=4u L=0.5u
XXL2_XD2 XL2.s2 XL2.s2 XL2.t vss nfet_03v3 W=8u L=0.5u
XXL2_XP1 la2 la2 vdd vdd pfet_03v3 W=2u L=4u
XXL2_XP2 dl2 la2 vdd vdd pfet_03v3 W=2u L=4u
XXY2_XPH XY2.h hold vdd vdd pfet_03v3 W=1u L=2u
XXY2_XWA XY2.da vbp_syn XY2.h vdd pfet_03v3 W=2u L=4u
XXY2_XWB XY2.db vbp_syn XY2.h vdd pfet_03v3 W=2u L=4u
XXY2_XNA XY2.da b2 d2 vss nfet_03v3 W=0.5u L=0.28u
XXY2_XNB XY2.db vss d2 vss nfet_03v3 W=0.5u L=0.28u
XXY2_XQA vss b2 XY2.da vdd pfet_03v3 W=1u L=0.28u
XXY2_XQB vss vss XY2.db vdd pfet_03v3 W=1u L=0.28u
XXY2_XHL d2 hold dl2 vdd pfet_03v3 W=1u L=0.28u
XXY2_XMR vdd vss vss vss nfet_03v3 W=0.5u L=0.28u
XXB_XI_XN XB.bselb d1_bsel vss vss nfet_03v3 W=0.5u L=0.28u
XXB_XI_XP XB.bselb d1_bsel vdd vdd pfet_03v3 W=1u L=0.28u
XXB_XN1 b1 XB.bselb stb vss nfet_03v3 W=0.5u L=0.28u
XXB_XP1 b1 d1_bsel stb vdd pfet_03v3 W=1u L=0.28u
XXB_XD1 b1 d1_bsel vss vss nfet_03v3 W=0.5u L=0.28u
XXB_XN2 b2 d1_bsel stb vss nfet_03v3 W=0.5u L=0.28u
XXB_XP2 b2 XB.bselb stb vdd pfet_03v3 W=1u L=0.28u
XXB_XD2 b2 XB.bselb vss vss nfet_03v3 W=0.5u L=0.28u
XXA1_XA_XMT XA1.XA.t vbn_ax vss vss nfet_03v3 W=2u L=4u
XXA1_XA_XM1 XA1.XA.a d1 XA1.XA.s1 vss nfet_03v3 W=4u L=0.5u
XXA1_XA_XD1 XA1.XA.s1 XA1.XA.s1 XA1.XA.t vss nfet_03v3 W=8u L=0.5u
XXA1_XA_XM2 XA1.XA.o XA1.XA.o XA1.XA.s2 vss nfet_03v3 W=4u L=0.5u
XXA1_XA_XD2 XA1.XA.s2 XA1.XA.s2 XA1.XA.t vss nfet_03v3 W=8u L=0.5u
XXA1_XA_XP1 XA1.XA.a XA1.XA.a vdd vdd pfet_03v3 W=2u L=4u
XXA1_XA_XP2 XA1.XA.o XA1.XA.a vdd vdd pfet_03v3 W=2u L=4u
XXA1_XA_XHO vs hold XA1.XA.o vdd pfet_03v3 W=1u L=0.28u
XXA1_XB_XMT XA1.XB.t vbn_ax vss vss nfet_03v3 W=2u L=4u
XXA1_XB_XM1 XA1.XB.a vs XA1.XB.s1 vss nfet_03v3 W=4u L=0.5u
XXA1_XB_XD1 XA1.XB.s1 XA1.XB.s1 XA1.XB.t vss nfet_03v3 W=8u L=0.5u
XXA1_XB_XM2 XA1.XB.o XA1.XB.o XA1.XB.s2 vss nfet_03v3 W=4u L=0.5u
XXA1_XB_XD2 XA1.XB.s2 XA1.XB.s2 XA1.XB.t vss nfet_03v3 W=8u L=0.5u
XXA1_XB_XP1 XA1.XB.a XA1.XB.a vdd vdd pfet_03v3 W=2u L=4u
XXA1_XB_XP2 XA1.XB.o XA1.XB.a vdd vdd pfet_03v3 W=2u L=4u
XXA1_XB_XHO d1 hold XA1.XB.o vdd pfet_03v3 W=1u L=0.28u
XXI_XN chainb chain vss vss nfet_03v3 W=0.5u L=0.28u
XXI_XP chainb chain vdd vdd pfet_03v3 W=1u L=0.28u
XXA2_XA_XMT XA2.XA.t vbn_ax vss vss nfet_03v3 W=2u L=4u
XXA2_XA_XM1 XA2.XA.a y2 XA2.XA.s1 vss nfet_03v3 W=4u L=0.5u
XXA2_XA_XD1 XA2.XA.s1 XA2.XA.s1 XA2.XA.t vss nfet_03v3 W=8u L=0.5u
XXA2_XA_XM2 XA2.XA.o XA2.XA.o XA2.XA.s2 vss nfet_03v3 W=4u L=0.5u
XXA2_XA_XD2 XA2.XA.s2 XA2.XA.s2 XA2.XA.t vss nfet_03v3 W=8u L=0.5u
XXA2_XA_XP1 XA2.XA.a XA2.XA.a vdd vdd pfet_03v3 W=2u L=4u
XXA2_XA_XP2 XA2.XA.o XA2.XA.a vdd vdd pfet_03v3 W=2u L=4u
XXA2_XA_XHO d2 hold XA2.XA.o vdd pfet_03v3 W=1u L=0.28u
XXA2_XB_XMT XA2.XB.t vbn_ax vss vss nfet_03v3 W=2u L=4u
XXA2_XB_XM1 XA2.XB.a d2 XA2.XB.s1 vss nfet_03v3 W=4u L=0.5u
XXA2_XB_XD1 XA2.XB.s1 XA2.XB.s1 XA2.XB.t vss nfet_03v3 W=8u L=0.5u
XXA2_XB_XM2 XA2.XB.o XA2.XB.o XA2.XB.s2 vss nfet_03v3 W=4u L=0.5u
XXA2_XB_XD2 XA2.XB.s2 XA2.XB.s2 XA2.XB.t vss nfet_03v3 W=8u L=0.5u
XXA2_XB_XP1 XA2.XB.a XA2.XB.a vdd vdd pfet_03v3 W=2u L=4u
XXA2_XB_XP2 XA2.XB.o XA2.XB.a vdd vdd pfet_03v3 W=2u L=4u
XXA2_XB_XHO y2 hold XA2.XB.o vdd pfet_03v3 W=1u L=0.28u
XXWS y2 chainb vs vss nfet_03v3 W=1u L=0.28u
XXWC y2 chain d1 vss nfet_03v3 W=1u L=0.28u
XXEP_XS XEP.m vbn_leak vss vss nfet_03v3 W=2u L=4u
XXEP_XPD XEP.m XEP.m vdd vdd pfet_03v3 W=1u L=2u
XXEP_XPM vep XEP.m vdd vdd pfet_03v3 W=1u L=2u
XXEP_XN vep vep el vss nfet_03v3 W=4u L=1u
XXP1_XDT_XPS XP1.XDT.s vbp_st vdd vdd pfet_03v3 W=1u L=2u
XXP1_XDT_XPI XP1.XDT.n1 d1 XP1.XDT.s vdd pfet_03v3 W=1u L=0.5u
XXP1_XDT_XNI XP1.XDT.n1 d1 vsrcp vss nfet_03v3 W=1u L=0.5u
XXP1_XDT_XS2 XP1.XDT.s2 vbp_st vdd vdd pfet_03v3 W=1u L=2u
XXP1_XDT_XP2 XP1.XDT.p XP1.XDT.n1 XP1.XDT.s2 vdd pfet_03v3 W=1u L=0.28u
XXP1_XDT_XN2 XP1.XDT.p XP1.XDT.n1 vsrcp vss nfet_03v3 W=0.22u L=2u
XXP1_XDT_XS3 XP1.XDT.s3 vbp_st vdd vdd pfet_03v3 W=1u L=2u
XXP1_XDT_XP3 XP1.XDT.pb XP1.XDT.p XP1.XDT.s3 vdd pfet_03v3 W=1u L=0.28u
XXP1_XDT_XN3 XP1.XDT.pb XP1.XDT.p vsrcp vss nfet_03v3 W=0.5u L=0.28u
XXP1_XDT_XK XP1.XDT.pb XP1.xb vdd vdd pfet_03v3 W=0.22u L=1u
XXP1_XDT_XQ XP1.XDT.pb XP1.XDT.p vdd vdd pfet_03v3 W=0.22u L=4u
XXP1_XDT_XON XP1.xb XP1.XDT.pb vss vss nfet_03v3 W=0.5u L=0.28u
XXP1_XDT_XOP XP1.xb XP1.XDT.pb vdd vdd pfet_03v3 W=1u L=0.28u
XXP1_XDT_XNH XP1.XDT.n1 d1 XP1.XDT.h vss nfet_03v3 W=1u L=1u
XXP1_XDT_XNE XP1.XDT.h XP1.xb vsrcp vss nfet_03v3 W=1u L=0.28u
XXP1_XTP XP1.vt XP1.xb vdd vdd pfet_03v3 W=1u L=2u
XXP1_XTS XP1.vt XP1.xb XP1.ti vss nfet_03v3 W=1u L=0.28u
XXP1_XTI XP1.ti vbn_leak vss vss nfet_03v3 W=1u L=4u
XXP1_XCT_XC vss XP1.vt vss vss nfet_03v3 W=3.54u L=3.54u
XXP1_XOM1 XP1.oa vep XP1.ot vss nfet_03v3 W=2u L=2u
XXP1_XOM2 XP1.vo XP1.vo XP1.ot vss nfet_03v3 W=2u L=2u
XXP1_XOP1 XP1.oa XP1.oa vdd vdd pfet_03v3 W=2u L=4u
XXP1_XOP2 XP1.vo XP1.oa vdd vdd pfet_03v3 W=2u L=4u
XXP1_XHP d1 hold XP1.vo vdd pfet_03v3 W=1u L=0.28u
XXP1_XS1 XP1.ot XP1.xb XP1.o1 vss nfet_03v3 W=1u L=1u
XXP1_XS2 XP1.o1 XP1.vt XP1.o2 vss nfet_03v3 W=1u L=1u
XXP1_XS3 XP1.o2 pl_en XP1.o3 vss nfet_03v3 W=1u L=1u
XXP1_XOTA XP1.o3 vbn_leak vss vss nfet_03v3 W=4u L=2u
XXP1_XOTB XP1.o3 vbn_leak vss vss nfet_03v3 W=4u L=2u
XXP2_XDT_XPS XP2.XDT.s vbp_st vdd vdd pfet_03v3 W=1u L=2u
XXP2_XDT_XPI XP2.XDT.n1 d2 XP2.XDT.s vdd pfet_03v3 W=1u L=0.5u
XXP2_XDT_XNI XP2.XDT.n1 d2 vsrcp vss nfet_03v3 W=1u L=0.5u
XXP2_XDT_XS2 XP2.XDT.s2 vbp_st vdd vdd pfet_03v3 W=1u L=2u
XXP2_XDT_XP2 XP2.XDT.p XP2.XDT.n1 XP2.XDT.s2 vdd pfet_03v3 W=1u L=0.28u
XXP2_XDT_XN2 XP2.XDT.p XP2.XDT.n1 vsrcp vss nfet_03v3 W=0.22u L=2u
XXP2_XDT_XS3 XP2.XDT.s3 vbp_st vdd vdd pfet_03v3 W=1u L=2u
XXP2_XDT_XP3 XP2.XDT.pb XP2.XDT.p XP2.XDT.s3 vdd pfet_03v3 W=1u L=0.28u
XXP2_XDT_XN3 XP2.XDT.pb XP2.XDT.p vsrcp vss nfet_03v3 W=0.5u L=0.28u
XXP2_XDT_XK XP2.XDT.pb XP2.xb vdd vdd pfet_03v3 W=0.22u L=1u
XXP2_XDT_XQ XP2.XDT.pb XP2.XDT.p vdd vdd pfet_03v3 W=0.22u L=4u
XXP2_XDT_XON XP2.xb XP2.XDT.pb vss vss nfet_03v3 W=0.5u L=0.28u
XXP2_XDT_XOP XP2.xb XP2.XDT.pb vdd vdd pfet_03v3 W=1u L=0.28u
XXP2_XDT_XNH XP2.XDT.n1 d2 XP2.XDT.h vss nfet_03v3 W=1u L=1u
XXP2_XDT_XNE XP2.XDT.h XP2.xb vsrcp vss nfet_03v3 W=1u L=0.28u
XXP2_XTP XP2.vt XP2.xb vdd vdd pfet_03v3 W=1u L=2u
XXP2_XTS XP2.vt XP2.xb XP2.ti vss nfet_03v3 W=1u L=0.28u
XXP2_XTI XP2.ti vbn_leak vss vss nfet_03v3 W=1u L=4u
XXP2_XCT_XC vss XP2.vt vss vss nfet_03v3 W=3.54u L=3.54u
XXP2_XOM1 XP2.oa vep XP2.ot vss nfet_03v3 W=2u L=2u
XXP2_XOM2 XP2.vo XP2.vo XP2.ot vss nfet_03v3 W=2u L=2u
XXP2_XOP1 XP2.oa XP2.oa vdd vdd pfet_03v3 W=2u L=4u
XXP2_XOP2 XP2.vo XP2.oa vdd vdd pfet_03v3 W=2u L=4u
XXP2_XHP d2 hold XP2.vo vdd pfet_03v3 W=1u L=0.28u
XXP2_XS1 XP2.ot XP2.xb XP2.o1 vss nfet_03v3 W=1u L=1u
XXP2_XS2 XP2.o1 XP2.vt XP2.o2 vss nfet_03v3 W=1u L=1u
XXP2_XS3 XP2.o2 pl_en XP2.o3 vss nfet_03v3 W=1u L=1u
XXP2_XOTA XP2.o3 vbn_leak vss vss nfet_03v3 W=4u L=2u
XXP2_XOTB XP2.o3 vbn_leak vss vss nfet_03v3 W=4u L=2u
XXT0_XMF vdd vs XT0.prb vss nfet_03v3 W=4u L=2u
XXT0_XME XT0.prb en XT0.s vss nfet_03v3 W=1u L=0.28u
XXT0_XMB XT0.s vbn_prb vss vss nfet_03v3 W=2u L=2u
XXT0_XSW XT0.prb sel0 abus vss nfet_03v3 W=1u L=0.28u
XXT1_XMF vdd d2 XT1.prb vss nfet_03v3 W=4u L=2u
XXT1_XME XT1.prb en XT1.s vss nfet_03v3 W=1u L=0.28u
XXT1_XMB XT1.s vbn_prb vss vss nfet_03v3 W=2u L=2u
XXT1_XSW XT1.prb sel1 abus vss nfet_03v3 W=1u L=0.28u
XXT2_XMF vdd d1 XT2.prb vss nfet_03v3 W=4u L=2u
XXT2_XME XT2.prb en XT2.s vss nfet_03v3 W=1u L=0.28u
XXT2_XMB XT2.s vbn_prb vss vss nfet_03v3 W=2u L=2u
XXT2_XSW XT2.prb sel2 abus vss nfet_03v3 W=1u L=0.28u
XXR1_XRA XR1.nr vbn_leak vss vss nfet_03v3 W=0.5u L=0.6u
XXR1_XRB XR1.n1 vbn_leak XR1.nr vss nfet_03v3 W=0.5u L=0.6u
XXR1_XL3 XR1.o3 vbn_leak XR1.n1 vss nfet_03v3 W=0.5u L=3u
XXR1_XR1 XR1.n2 vbn_leak XR1.n1 vss nfet_03v3 W=0.5u L=1.5u
XXR1_XL2 XR1.o2 vbn_leak XR1.n2 vss nfet_03v3 W=0.5u L=3u
XXR1_XR2 XR1.n3 vbn_leak XR1.n2 vss nfet_03v3 W=0.5u L=1.5u
XXR1_XL1 XR1.o1 vbn_leak XR1.n3 vss nfet_03v3 W=0.5u L=3u
XXR1_XR3 XR1.n4 vbn_leak XR1.n3 vss nfet_03v3 W=0.5u L=1.5u
XXR1_XL0 XR1.o0 vbn_leak XR1.n4 vss nfet_03v3 W=0.5u L=3u
XXR1_XLT vdd vbn_leak XR1.n4 vss nfet_03v3 W=0.5u L=3u
XXR1_XN3 la1 ta3 XR1.o3 vss nfet_03v3 W=0.5u L=0.28u
XXR1_XN2 la1 ta2 XR1.o2 vss nfet_03v3 W=0.5u L=0.28u
XXR1_XN1 la1 ta1 XR1.o1 vss nfet_03v3 W=0.5u L=0.28u
XXR1_XN0 la1 ta0 XR1.o0 vss nfet_03v3 W=0.5u L=0.28u
XXR1_XP3 dl1 ta3 XR1.o3 vdd pfet_03v3 W=1u L=0.28u
XXR1_XP2 dl1 ta2 XR1.o2 vdd pfet_03v3 W=1u L=0.28u
XXR1_XP1 dl1 ta1 XR1.o1 vdd pfet_03v3 W=1u L=0.28u
XXR1_XP0 dl1 ta0 XR1.o0 vdd pfet_03v3 W=1u L=0.28u
XXR2_XRA XR2.nr vbn_leak vss vss nfet_03v3 W=0.5u L=0.6u
XXR2_XRB XR2.n1 vbn_leak XR2.nr vss nfet_03v3 W=0.5u L=0.6u
XXR2_XL3 XR2.o3 vbn_leak XR2.n1 vss nfet_03v3 W=0.5u L=3u
XXR2_XR1 XR2.n2 vbn_leak XR2.n1 vss nfet_03v3 W=0.5u L=1.5u
XXR2_XL2 XR2.o2 vbn_leak XR2.n2 vss nfet_03v3 W=0.5u L=3u
XXR2_XR2 XR2.n3 vbn_leak XR2.n2 vss nfet_03v3 W=0.5u L=1.5u
XXR2_XL1 XR2.o1 vbn_leak XR2.n3 vss nfet_03v3 W=0.5u L=3u
XXR2_XR3 XR2.n4 vbn_leak XR2.n3 vss nfet_03v3 W=0.5u L=1.5u
XXR2_XL0 XR2.o0 vbn_leak XR2.n4 vss nfet_03v3 W=0.5u L=3u
XXR2_XLT vdd vbn_leak XR2.n4 vss nfet_03v3 W=0.5u L=3u
XXR2_XN3 la2 tb3 XR2.o3 vss nfet_03v3 W=0.5u L=0.28u
XXR2_XN2 la2 tb2 XR2.o2 vss nfet_03v3 W=0.5u L=0.28u
XXR2_XN1 la2 tb1 XR2.o1 vss nfet_03v3 W=0.5u L=0.28u
XXR2_XN0 la2 tb0 XR2.o0 vss nfet_03v3 W=0.5u L=0.28u
XXR2_XP3 dl2 tb3 XR2.o3 vdd pfet_03v3 W=1u L=0.28u
XXR2_XP2 dl2 tb2 XR2.o2 vdd pfet_03v3 W=1u L=0.28u
XXR2_XP1 dl2 tb1 XR2.o1 vdd pfet_03v3 W=1u L=0.28u
XXR2_XP0 dl2 tb0 XR2.o0 vdd pfet_03v3 W=1u L=0.28u
.ends dend_d1
